* NGSPICE file created from spi_regs.ext - technology: gf180mcuD

* Black-box entry subcircuit for gf180mcu_fd_sc_mcu7t5v0__fillcap_4 abstract view
.subckt gf180mcu_fd_sc_mcu7t5v0__fillcap_4 VDD VNW VPW VSS
.ends

* Black-box entry subcircuit for gf180mcu_fd_sc_mcu7t5v0__fillcap_8 abstract view
.subckt gf180mcu_fd_sc_mcu7t5v0__fillcap_8 VDD VNW VPW VSS
.ends

* Black-box entry subcircuit for gf180mcu_fd_sc_mcu7t5v0__fill_1 abstract view
.subckt gf180mcu_fd_sc_mcu7t5v0__fill_1 VDD VNW VPW VSS
.ends

* Black-box entry subcircuit for gf180mcu_fd_sc_mcu7t5v0__filltie abstract view
.subckt gf180mcu_fd_sc_mcu7t5v0__filltie VDD VSS
.ends

* Black-box entry subcircuit for gf180mcu_fd_sc_mcu7t5v0__dlyb_1 abstract view
.subckt gf180mcu_fd_sc_mcu7t5v0__dlyb_1 I Z VDD VNW VPW VSS
.ends

* Black-box entry subcircuit for gf180mcu_fd_sc_mcu7t5v0__endcap abstract view
.subckt gf180mcu_fd_sc_mcu7t5v0__endcap VDD VSS
.ends

* Black-box entry subcircuit for gf180mcu_fd_sc_mcu7t5v0__nor3_4 abstract view
.subckt gf180mcu_fd_sc_mcu7t5v0__nor3_4 A1 A2 A3 ZN VDD VNW VPW VSS
.ends

* Black-box entry subcircuit for gf180mcu_fd_sc_mcu7t5v0__fillcap_32 abstract view
.subckt gf180mcu_fd_sc_mcu7t5v0__fillcap_32 VDD VNW VPW VSS
.ends

* Black-box entry subcircuit for gf180mcu_fd_sc_mcu7t5v0__nor3_2 abstract view
.subckt gf180mcu_fd_sc_mcu7t5v0__nor3_2 A1 A2 A3 ZN VDD VNW VPW VSS
.ends

* Black-box entry subcircuit for gf180mcu_fd_sc_mcu7t5v0__buf_2 abstract view
.subckt gf180mcu_fd_sc_mcu7t5v0__buf_2 I Z VDD VNW VPW VSS
.ends

* Black-box entry subcircuit for gf180mcu_fd_sc_mcu7t5v0__dffrnq_1 abstract view
.subckt gf180mcu_fd_sc_mcu7t5v0__dffrnq_1 D RN CLK Q VDD VNW VPW VSS
.ends

* Black-box entry subcircuit for gf180mcu_fd_sc_mcu7t5v0__mux2_2 abstract view
.subckt gf180mcu_fd_sc_mcu7t5v0__mux2_2 I0 I1 S Z VDD VNW VPW VSS
.ends

* Black-box entry subcircuit for gf180mcu_fd_sc_mcu7t5v0__fillcap_64 abstract view
.subckt gf180mcu_fd_sc_mcu7t5v0__fillcap_64 VDD VNW VPW VSS
.ends

* Black-box entry subcircuit for gf180mcu_fd_sc_mcu7t5v0__fill_2 abstract view
.subckt gf180mcu_fd_sc_mcu7t5v0__fill_2 VDD VNW VPW VSS
.ends

* Black-box entry subcircuit for gf180mcu_fd_sc_mcu7t5v0__nand2_1 abstract view
.subckt gf180mcu_fd_sc_mcu7t5v0__nand2_1 A1 A2 ZN VDD VNW VPW VSS
.ends

* Black-box entry subcircuit for gf180mcu_fd_sc_mcu7t5v0__nand2_4 abstract view
.subckt gf180mcu_fd_sc_mcu7t5v0__nand2_4 A1 A2 ZN VDD VNW VPW VSS
.ends

* Black-box entry subcircuit for gf180mcu_fd_sc_mcu7t5v0__nand4_4 abstract view
.subckt gf180mcu_fd_sc_mcu7t5v0__nand4_4 A1 A2 A3 A4 ZN VDD VNW VPW VSS
.ends

* Black-box entry subcircuit for gf180mcu_fd_sc_mcu7t5v0__oai211_1 abstract view
.subckt gf180mcu_fd_sc_mcu7t5v0__oai211_1 A1 A2 B C ZN VDD VNW VPW VSS
.ends

* Black-box entry subcircuit for gf180mcu_fd_sc_mcu7t5v0__nand3_4 abstract view
.subckt gf180mcu_fd_sc_mcu7t5v0__nand3_4 A1 A2 A3 ZN VDD VNW VPW VSS
.ends

* Black-box entry subcircuit for gf180mcu_fd_sc_mcu7t5v0__nand4_1 abstract view
.subckt gf180mcu_fd_sc_mcu7t5v0__nand4_1 A1 A2 A3 A4 ZN VDD VNW VPW VSS
.ends

* Black-box entry subcircuit for gf180mcu_fd_sc_mcu7t5v0__buf_1 abstract view
.subckt gf180mcu_fd_sc_mcu7t5v0__buf_1 I Z VDD VNW VPW VSS
.ends

* Black-box entry subcircuit for gf180mcu_fd_sc_mcu7t5v0__clkbuf_2 abstract view
.subckt gf180mcu_fd_sc_mcu7t5v0__clkbuf_2 I Z VDD VNW VPW VSS
.ends

* Black-box entry subcircuit for gf180mcu_fd_sc_mcu7t5v0__aoi222_2 abstract view
.subckt gf180mcu_fd_sc_mcu7t5v0__aoi222_2 A1 A2 B1 B2 C1 C2 ZN VDD VNW VPW VSS
.ends

* Black-box entry subcircuit for gf180mcu_fd_sc_mcu7t5v0__aoi222_4 abstract view
.subckt gf180mcu_fd_sc_mcu7t5v0__aoi222_4 A1 A2 B1 B2 C1 C2 ZN VDD VNW VPW VSS
.ends

* Black-box entry subcircuit for gf180mcu_fd_sc_mcu7t5v0__fillcap_16 abstract view
.subckt gf180mcu_fd_sc_mcu7t5v0__fillcap_16 VDD VNW VPW VSS
.ends

* Black-box entry subcircuit for gf180mcu_fd_sc_mcu7t5v0__aoi221_2 abstract view
.subckt gf180mcu_fd_sc_mcu7t5v0__aoi221_2 A1 A2 B1 B2 C ZN VDD VNW VPW VSS
.ends

* Black-box entry subcircuit for gf180mcu_fd_sc_mcu7t5v0__aoi21_1 abstract view
.subckt gf180mcu_fd_sc_mcu7t5v0__aoi21_1 A1 A2 B ZN VDD VNW VPW VSS
.ends

* Black-box entry subcircuit for gf180mcu_fd_sc_mcu7t5v0__clkinv_1 abstract view
.subckt gf180mcu_fd_sc_mcu7t5v0__clkinv_1 I ZN VDD VNW VPW VSS
.ends

* Black-box entry subcircuit for gf180mcu_fd_sc_mcu7t5v0__clkbuf_1 abstract view
.subckt gf180mcu_fd_sc_mcu7t5v0__clkbuf_1 I Z VDD VNW VPW VSS
.ends

* Black-box entry subcircuit for gf180mcu_fd_sc_mcu7t5v0__aoi22_1 abstract view
.subckt gf180mcu_fd_sc_mcu7t5v0__aoi22_1 A1 A2 B1 B2 ZN VDD VNW VPW VSS
.ends

* Black-box entry subcircuit for gf180mcu_fd_sc_mcu7t5v0__dffrnq_2 abstract view
.subckt gf180mcu_fd_sc_mcu7t5v0__dffrnq_2 D RN CLK Q VDD VNW VPW VSS
.ends

* Black-box entry subcircuit for gf180mcu_fd_sc_mcu7t5v0__oai21_1 abstract view
.subckt gf180mcu_fd_sc_mcu7t5v0__oai21_1 A1 A2 B ZN VDD VNW VPW VSS
.ends

* Black-box entry subcircuit for gf180mcu_fd_sc_mcu7t5v0__and3_4 abstract view
.subckt gf180mcu_fd_sc_mcu7t5v0__and3_4 A1 A2 A3 Z VDD VNW VPW VSS
.ends

* Black-box entry subcircuit for gf180mcu_fd_sc_mcu7t5v0__and2_2 abstract view
.subckt gf180mcu_fd_sc_mcu7t5v0__and2_2 A1 A2 Z VDD VNW VPW VSS
.ends

* Black-box entry subcircuit for gf180mcu_fd_sc_mcu7t5v0__nor2_4 abstract view
.subckt gf180mcu_fd_sc_mcu7t5v0__nor2_4 A1 A2 ZN VDD VNW VPW VSS
.ends

* Black-box entry subcircuit for gf180mcu_fd_sc_mcu7t5v0__nor3_1 abstract view
.subckt gf180mcu_fd_sc_mcu7t5v0__nor3_1 A1 A2 A3 ZN VDD VNW VPW VSS
.ends

* Black-box entry subcircuit for gf180mcu_fd_sc_mcu7t5v0__inv_1 abstract view
.subckt gf180mcu_fd_sc_mcu7t5v0__inv_1 I ZN VDD VNW VPW VSS
.ends

* Black-box entry subcircuit for gf180mcu_fd_sc_mcu7t5v0__nand4_2 abstract view
.subckt gf180mcu_fd_sc_mcu7t5v0__nand4_2 A1 A2 A3 A4 ZN VDD VNW VPW VSS
.ends

* Black-box entry subcircuit for gf180mcu_fd_sc_mcu7t5v0__aoi22_2 abstract view
.subckt gf180mcu_fd_sc_mcu7t5v0__aoi22_2 A1 A2 B1 B2 ZN VDD VNW VPW VSS
.ends

* Black-box entry subcircuit for gf180mcu_fd_sc_mcu7t5v0__oai31_1 abstract view
.subckt gf180mcu_fd_sc_mcu7t5v0__oai31_1 A1 A2 A3 B ZN VDD VNW VPW VSS
.ends

* Black-box entry subcircuit for gf180mcu_fd_sc_mcu7t5v0__nor2_2 abstract view
.subckt gf180mcu_fd_sc_mcu7t5v0__nor2_2 A1 A2 ZN VDD VNW VPW VSS
.ends

* Black-box entry subcircuit for gf180mcu_fd_sc_mcu7t5v0__oai221_1 abstract view
.subckt gf180mcu_fd_sc_mcu7t5v0__oai221_1 A1 A2 B1 B2 C ZN VDD VNW VPW VSS
.ends

* Black-box entry subcircuit for gf180mcu_fd_sc_mcu7t5v0__buf_4 abstract view
.subckt gf180mcu_fd_sc_mcu7t5v0__buf_4 I Z VDD VNW VPW VSS
.ends

* Black-box entry subcircuit for gf180mcu_fd_sc_mcu7t5v0__nor2_1 abstract view
.subckt gf180mcu_fd_sc_mcu7t5v0__nor2_1 A1 A2 ZN VDD VNW VPW VSS
.ends

* Black-box entry subcircuit for gf180mcu_fd_sc_mcu7t5v0__aoi22_4 abstract view
.subckt gf180mcu_fd_sc_mcu7t5v0__aoi22_4 A1 A2 B1 B2 ZN VDD VNW VPW VSS
.ends

* Black-box entry subcircuit for gf180mcu_fd_sc_mcu7t5v0__nor4_2 abstract view
.subckt gf180mcu_fd_sc_mcu7t5v0__nor4_2 A1 A2 A3 A4 ZN VDD VNW VPW VSS
.ends

* Black-box entry subcircuit for gf180mcu_fd_sc_mcu7t5v0__clkbuf_4 abstract view
.subckt gf180mcu_fd_sc_mcu7t5v0__clkbuf_4 I Z VDD VNW VPW VSS
.ends

* Black-box entry subcircuit for gf180mcu_fd_sc_mcu7t5v0__and4_1 abstract view
.subckt gf180mcu_fd_sc_mcu7t5v0__and4_1 A1 A2 A3 A4 Z VDD VNW VPW VSS
.ends

* Black-box entry subcircuit for gf180mcu_fd_sc_mcu7t5v0__or4_1 abstract view
.subckt gf180mcu_fd_sc_mcu7t5v0__or4_1 A1 A2 A3 A4 Z VDD VNW VPW VSS
.ends

* Black-box entry subcircuit for gf180mcu_fd_sc_mcu7t5v0__clkbuf_8 abstract view
.subckt gf180mcu_fd_sc_mcu7t5v0__clkbuf_8 I Z VDD VNW VPW VSS
.ends

* Black-box entry subcircuit for gf180mcu_fd_sc_mcu7t5v0__aoi221_1 abstract view
.subckt gf180mcu_fd_sc_mcu7t5v0__aoi221_1 A1 A2 B1 B2 C ZN VDD VNW VPW VSS
.ends

* Black-box entry subcircuit for gf180mcu_fd_sc_mcu7t5v0__clkinv_2 abstract view
.subckt gf180mcu_fd_sc_mcu7t5v0__clkinv_2 I ZN VDD VNW VPW VSS
.ends

* Black-box entry subcircuit for gf180mcu_fd_sc_mcu7t5v0__nand3_1 abstract view
.subckt gf180mcu_fd_sc_mcu7t5v0__nand3_1 A1 A2 A3 ZN VDD VNW VPW VSS
.ends

* Black-box entry subcircuit for gf180mcu_fd_sc_mcu7t5v0__and3_2 abstract view
.subckt gf180mcu_fd_sc_mcu7t5v0__and3_2 A1 A2 A3 Z VDD VNW VPW VSS
.ends

* Black-box entry subcircuit for gf180mcu_fd_sc_mcu7t5v0__inv_4 abstract view
.subckt gf180mcu_fd_sc_mcu7t5v0__inv_4 I ZN VDD VNW VPW VSS
.ends

* Black-box entry subcircuit for gf180mcu_fd_sc_mcu7t5v0__nand3_2 abstract view
.subckt gf180mcu_fd_sc_mcu7t5v0__nand3_2 A1 A2 A3 ZN VDD VNW VPW VSS
.ends

* Black-box entry subcircuit for gf180mcu_fd_sc_mcu7t5v0__clkbuf_16 abstract view
.subckt gf180mcu_fd_sc_mcu7t5v0__clkbuf_16 I Z VDD VNW VPW VSS
.ends

* Black-box entry subcircuit for gf180mcu_fd_sc_mcu7t5v0__nor4_4 abstract view
.subckt gf180mcu_fd_sc_mcu7t5v0__nor4_4 A1 A2 A3 A4 ZN VDD VNW VPW VSS
.ends

* Black-box entry subcircuit for gf180mcu_fd_sc_mcu7t5v0__xor2_1 abstract view
.subckt gf180mcu_fd_sc_mcu7t5v0__xor2_1 A1 A2 Z VDD VNW VPW VSS
.ends

* Black-box entry subcircuit for gf180mcu_fd_sc_mcu7t5v0__or3_1 abstract view
.subckt gf180mcu_fd_sc_mcu7t5v0__or3_1 A1 A2 A3 Z VDD VNW VPW VSS
.ends

* Black-box entry subcircuit for gf180mcu_fd_sc_mcu7t5v0__nand2_2 abstract view
.subckt gf180mcu_fd_sc_mcu7t5v0__nand2_2 A1 A2 ZN VDD VNW VPW VSS
.ends

* Black-box entry subcircuit for gf180mcu_fd_sc_mcu7t5v0__inv_3 abstract view
.subckt gf180mcu_fd_sc_mcu7t5v0__inv_3 I ZN VDD VNW VPW VSS
.ends

* Black-box entry subcircuit for gf180mcu_fd_sc_mcu7t5v0__aoi221_4 abstract view
.subckt gf180mcu_fd_sc_mcu7t5v0__aoi221_4 A1 A2 B1 B2 C ZN VDD VNW VPW VSS
.ends

* Black-box entry subcircuit for gf180mcu_fd_sc_mcu7t5v0__nor4_1 abstract view
.subckt gf180mcu_fd_sc_mcu7t5v0__nor4_1 A1 A2 A3 A4 ZN VDD VNW VPW VSS
.ends

* Black-box entry subcircuit for gf180mcu_fd_sc_mcu7t5v0__and3_1 abstract view
.subckt gf180mcu_fd_sc_mcu7t5v0__and3_1 A1 A2 A3 Z VDD VNW VPW VSS
.ends

* Black-box entry subcircuit for gf180mcu_fd_sc_mcu7t5v0__inv_2 abstract view
.subckt gf180mcu_fd_sc_mcu7t5v0__inv_2 I ZN VDD VNW VPW VSS
.ends

* Black-box entry subcircuit for gf180mcu_fd_sc_mcu7t5v0__aoi21_4 abstract view
.subckt gf180mcu_fd_sc_mcu7t5v0__aoi21_4 A1 A2 B ZN VDD VNW VPW VSS
.ends

* Black-box entry subcircuit for gf180mcu_fd_sc_mcu7t5v0__or2_1 abstract view
.subckt gf180mcu_fd_sc_mcu7t5v0__or2_1 A1 A2 Z VDD VNW VPW VSS
.ends

* Black-box entry subcircuit for gf180mcu_fd_sc_mcu7t5v0__aoi222_1 abstract view
.subckt gf180mcu_fd_sc_mcu7t5v0__aoi222_1 A1 A2 B1 B2 C1 C2 ZN VDD VNW VPW VSS
.ends

* Black-box entry subcircuit for gf180mcu_fd_sc_mcu7t5v0__dffsnq_1 abstract view
.subckt gf180mcu_fd_sc_mcu7t5v0__dffsnq_1 D SETN CLK Q VDD VNW VPW VSS
.ends

* Black-box entry subcircuit for gf180mcu_fd_sc_mcu7t5v0__dffrnq_4 abstract view
.subckt gf180mcu_fd_sc_mcu7t5v0__dffrnq_4 D RN CLK Q VDD VNW VPW VSS
.ends

* Black-box entry subcircuit for gf180mcu_fd_sc_mcu7t5v0__or3_2 abstract view
.subckt gf180mcu_fd_sc_mcu7t5v0__or3_2 A1 A2 A3 Z VDD VNW VPW VSS
.ends

.subckt spi_regs VDD VSS boot_complete cal_dir_x cal_dir_y cal_done_x cal_done_y cal_phase0_offset_x[0]
+ cal_phase0_offset_x[10] cal_phase0_offset_x[11] cal_phase0_offset_x[12] cal_phase0_offset_x[13]
+ cal_phase0_offset_x[14] cal_phase0_offset_x[15] cal_phase0_offset_x[16] cal_phase0_offset_x[17]
+ cal_phase0_offset_x[18] cal_phase0_offset_x[19] cal_phase0_offset_x[1] cal_phase0_offset_x[20]
+ cal_phase0_offset_x[2] cal_phase0_offset_x[3] cal_phase0_offset_x[4] cal_phase0_offset_x[5]
+ cal_phase0_offset_x[6] cal_phase0_offset_x[7] cal_phase0_offset_x[8] cal_phase0_offset_x[9]
+ cal_phase0_offset_y[0] cal_phase0_offset_y[10] cal_phase0_offset_y[11] cal_phase0_offset_y[12]
+ cal_phase0_offset_y[13] cal_phase0_offset_y[14] cal_phase0_offset_y[15] cal_phase0_offset_y[16]
+ cal_phase0_offset_y[17] cal_phase0_offset_y[18] cal_phase0_offset_y[19] cal_phase0_offset_y[1]
+ cal_phase0_offset_y[20] cal_phase0_offset_y[2] cal_phase0_offset_y[3] cal_phase0_offset_y[4]
+ cal_phase0_offset_y[5] cal_phase0_offset_y[6] cal_phase0_offset_y[7] cal_phase0_offset_y[8]
+ cal_phase0_offset_y[9] cal_phase270_offset_x[0] cal_phase270_offset_x[10] cal_phase270_offset_x[11]
+ cal_phase270_offset_x[12] cal_phase270_offset_x[13] cal_phase270_offset_x[14] cal_phase270_offset_x[15]
+ cal_phase270_offset_x[16] cal_phase270_offset_x[17] cal_phase270_offset_x[18] cal_phase270_offset_x[19]
+ cal_phase270_offset_x[1] cal_phase270_offset_x[20] cal_phase270_offset_x[2] cal_phase270_offset_x[3]
+ cal_phase270_offset_x[4] cal_phase270_offset_x[5] cal_phase270_offset_x[6] cal_phase270_offset_x[7]
+ cal_phase270_offset_x[8] cal_phase270_offset_x[9] cal_phase270_offset_y[0] cal_phase270_offset_y[10]
+ cal_phase270_offset_y[11] cal_phase270_offset_y[12] cal_phase270_offset_y[13] cal_phase270_offset_y[14]
+ cal_phase270_offset_y[15] cal_phase270_offset_y[16] cal_phase270_offset_y[17] cal_phase270_offset_y[18]
+ cal_phase270_offset_y[19] cal_phase270_offset_y[1] cal_phase270_offset_y[20] cal_phase270_offset_y[2]
+ cal_phase270_offset_y[3] cal_phase270_offset_y[4] cal_phase270_offset_y[5] cal_phase270_offset_y[6]
+ cal_phase270_offset_y[7] cal_phase270_offset_y[8] cal_phase270_offset_y[9] cal_phase90_offset_x[0]
+ cal_phase90_offset_x[10] cal_phase90_offset_x[11] cal_phase90_offset_x[12] cal_phase90_offset_x[13]
+ cal_phase90_offset_x[14] cal_phase90_offset_x[15] cal_phase90_offset_x[16] cal_phase90_offset_x[17]
+ cal_phase90_offset_x[18] cal_phase90_offset_x[19] cal_phase90_offset_x[1] cal_phase90_offset_x[20]
+ cal_phase90_offset_x[2] cal_phase90_offset_x[3] cal_phase90_offset_x[4] cal_phase90_offset_x[5]
+ cal_phase90_offset_x[6] cal_phase90_offset_x[7] cal_phase90_offset_x[8] cal_phase90_offset_x[9]
+ cal_phase90_offset_y[0] cal_phase90_offset_y[10] cal_phase90_offset_y[11] cal_phase90_offset_y[12]
+ cal_phase90_offset_y[13] cal_phase90_offset_y[14] cal_phase90_offset_y[15] cal_phase90_offset_y[16]
+ cal_phase90_offset_y[17] cal_phase90_offset_y[18] cal_phase90_offset_y[19] cal_phase90_offset_y[1]
+ cal_phase90_offset_y[20] cal_phase90_offset_y[2] cal_phase90_offset_y[3] cal_phase90_offset_y[4]
+ cal_phase90_offset_y[5] cal_phase90_offset_y[6] cal_phase90_offset_y[7] cal_phase90_offset_y[8]
+ cal_phase90_offset_y[9] cal_timeout_x cal_timeout_y cfg_done cfg_f_MEMS_fcw_x[0]
+ cfg_f_MEMS_fcw_x[10] cfg_f_MEMS_fcw_x[11] cfg_f_MEMS_fcw_x[12] cfg_f_MEMS_fcw_x[13]
+ cfg_f_MEMS_fcw_x[14] cfg_f_MEMS_fcw_x[15] cfg_f_MEMS_fcw_x[1] cfg_f_MEMS_fcw_x[2]
+ cfg_f_MEMS_fcw_x[3] cfg_f_MEMS_fcw_x[4] cfg_f_MEMS_fcw_x[5] cfg_f_MEMS_fcw_x[6]
+ cfg_f_MEMS_fcw_x[7] cfg_f_MEMS_fcw_x[8] cfg_f_MEMS_fcw_x[9] cfg_f_MEMS_fcw_y[0]
+ cfg_f_MEMS_fcw_y[10] cfg_f_MEMS_fcw_y[11] cfg_f_MEMS_fcw_y[12] cfg_f_MEMS_fcw_y[13]
+ cfg_f_MEMS_fcw_y[14] cfg_f_MEMS_fcw_y[15] cfg_f_MEMS_fcw_y[1] cfg_f_MEMS_fcw_y[2]
+ cfg_f_MEMS_fcw_y[3] cfg_f_MEMS_fcw_y[4] cfg_f_MEMS_fcw_y[5] cfg_f_MEMS_fcw_y[6]
+ cfg_f_MEMS_fcw_y[7] cfg_f_MEMS_fcw_y[8] cfg_f_MEMS_fcw_y[9] cfg_phase0_offset_x[0]
+ cfg_phase0_offset_x[10] cfg_phase0_offset_x[11] cfg_phase0_offset_x[12] cfg_phase0_offset_x[13]
+ cfg_phase0_offset_x[14] cfg_phase0_offset_x[15] cfg_phase0_offset_x[16] cfg_phase0_offset_x[17]
+ cfg_phase0_offset_x[18] cfg_phase0_offset_x[19] cfg_phase0_offset_x[1] cfg_phase0_offset_x[20]
+ cfg_phase0_offset_x[2] cfg_phase0_offset_x[3] cfg_phase0_offset_x[4] cfg_phase0_offset_x[5]
+ cfg_phase0_offset_x[6] cfg_phase0_offset_x[7] cfg_phase0_offset_x[8] cfg_phase0_offset_x[9]
+ cfg_phase0_offset_y[0] cfg_phase0_offset_y[10] cfg_phase0_offset_y[11] cfg_phase0_offset_y[12]
+ cfg_phase0_offset_y[13] cfg_phase0_offset_y[14] cfg_phase0_offset_y[15] cfg_phase0_offset_y[16]
+ cfg_phase0_offset_y[17] cfg_phase0_offset_y[18] cfg_phase0_offset_y[19] cfg_phase0_offset_y[1]
+ cfg_phase0_offset_y[20] cfg_phase0_offset_y[2] cfg_phase0_offset_y[3] cfg_phase0_offset_y[4]
+ cfg_phase0_offset_y[5] cfg_phase0_offset_y[6] cfg_phase0_offset_y[7] cfg_phase0_offset_y[8]
+ cfg_phase0_offset_y[9] cfg_phase270_offset_x[0] cfg_phase270_offset_x[10] cfg_phase270_offset_x[11]
+ cfg_phase270_offset_x[12] cfg_phase270_offset_x[13] cfg_phase270_offset_x[14] cfg_phase270_offset_x[15]
+ cfg_phase270_offset_x[16] cfg_phase270_offset_x[17] cfg_phase270_offset_x[18] cfg_phase270_offset_x[19]
+ cfg_phase270_offset_x[1] cfg_phase270_offset_x[20] cfg_phase270_offset_x[2] cfg_phase270_offset_x[3]
+ cfg_phase270_offset_x[4] cfg_phase270_offset_x[5] cfg_phase270_offset_x[6] cfg_phase270_offset_x[7]
+ cfg_phase270_offset_x[8] cfg_phase270_offset_x[9] cfg_phase270_offset_y[0] cfg_phase270_offset_y[10]
+ cfg_phase270_offset_y[11] cfg_phase270_offset_y[12] cfg_phase270_offset_y[13] cfg_phase270_offset_y[14]
+ cfg_phase270_offset_y[15] cfg_phase270_offset_y[16] cfg_phase270_offset_y[17] cfg_phase270_offset_y[18]
+ cfg_phase270_offset_y[19] cfg_phase270_offset_y[1] cfg_phase270_offset_y[20] cfg_phase270_offset_y[2]
+ cfg_phase270_offset_y[3] cfg_phase270_offset_y[4] cfg_phase270_offset_y[5] cfg_phase270_offset_y[6]
+ cfg_phase270_offset_y[7] cfg_phase270_offset_y[8] cfg_phase270_offset_y[9] cfg_phase90_offset_x[0]
+ cfg_phase90_offset_x[10] cfg_phase90_offset_x[11] cfg_phase90_offset_x[12] cfg_phase90_offset_x[13]
+ cfg_phase90_offset_x[14] cfg_phase90_offset_x[15] cfg_phase90_offset_x[16] cfg_phase90_offset_x[17]
+ cfg_phase90_offset_x[18] cfg_phase90_offset_x[19] cfg_phase90_offset_x[1] cfg_phase90_offset_x[20]
+ cfg_phase90_offset_x[2] cfg_phase90_offset_x[3] cfg_phase90_offset_x[4] cfg_phase90_offset_x[5]
+ cfg_phase90_offset_x[6] cfg_phase90_offset_x[7] cfg_phase90_offset_x[8] cfg_phase90_offset_x[9]
+ cfg_phase90_offset_y[0] cfg_phase90_offset_y[10] cfg_phase90_offset_y[11] cfg_phase90_offset_y[12]
+ cfg_phase90_offset_y[13] cfg_phase90_offset_y[14] cfg_phase90_offset_y[15] cfg_phase90_offset_y[16]
+ cfg_phase90_offset_y[17] cfg_phase90_offset_y[18] cfg_phase90_offset_y[19] cfg_phase90_offset_y[1]
+ cfg_phase90_offset_y[20] cfg_phase90_offset_y[2] cfg_phase90_offset_y[3] cfg_phase90_offset_y[4]
+ cfg_phase90_offset_y[5] cfg_phase90_offset_y[6] cfg_phase90_offset_y[7] cfg_phase90_offset_y[8]
+ cfg_phase90_offset_y[9] clk delay_wave_cycle_x[0] delay_wave_cycle_x[1] delay_wave_cycle_x[2]
+ delay_wave_cycle_x[3] delay_wave_cycle_x[4] delay_wave_cycle_x[5] delay_wave_cycle_x[6]
+ delay_wave_cycle_x[7] delay_wave_cycle_y[0] delay_wave_cycle_y[1] delay_wave_cycle_y[2]
+ delay_wave_cycle_y[3] delay_wave_cycle_y[4] delay_wave_cycle_y[5] delay_wave_cycle_y[6]
+ delay_wave_cycle_y[7] jitter_flag_x jitter_flag_y latch_error_x latch_error_y phase_offset_imported
+ phase_state_x[0] phase_state_x[1] phase_state_y[0] phase_state_y[1] raw_edge1_x[0]
+ raw_edge1_x[10] raw_edge1_x[11] raw_edge1_x[12] raw_edge1_x[13] raw_edge1_x[14]
+ raw_edge1_x[15] raw_edge1_x[16] raw_edge1_x[17] raw_edge1_x[18] raw_edge1_x[19]
+ raw_edge1_x[1] raw_edge1_x[20] raw_edge1_x[2] raw_edge1_x[3] raw_edge1_x[4] raw_edge1_x[5]
+ raw_edge1_x[6] raw_edge1_x[7] raw_edge1_x[8] raw_edge1_x[9] raw_edge1_y[0] raw_edge1_y[10]
+ raw_edge1_y[11] raw_edge1_y[12] raw_edge1_y[13] raw_edge1_y[14] raw_edge1_y[15]
+ raw_edge1_y[16] raw_edge1_y[17] raw_edge1_y[18] raw_edge1_y[19] raw_edge1_y[1] raw_edge1_y[20]
+ raw_edge1_y[2] raw_edge1_y[3] raw_edge1_y[4] raw_edge1_y[5] raw_edge1_y[6] raw_edge1_y[7]
+ raw_edge1_y[8] raw_edge1_y[9] raw_edge2_x[0] raw_edge2_x[10] raw_edge2_x[11] raw_edge2_x[12]
+ raw_edge2_x[13] raw_edge2_x[14] raw_edge2_x[15] raw_edge2_x[16] raw_edge2_x[17]
+ raw_edge2_x[18] raw_edge2_x[19] raw_edge2_x[1] raw_edge2_x[20] raw_edge2_x[2] raw_edge2_x[3]
+ raw_edge2_x[4] raw_edge2_x[5] raw_edge2_x[6] raw_edge2_x[7] raw_edge2_x[8] raw_edge2_x[9]
+ raw_edge2_y[0] raw_edge2_y[10] raw_edge2_y[11] raw_edge2_y[12] raw_edge2_y[13] raw_edge2_y[14]
+ raw_edge2_y[15] raw_edge2_y[16] raw_edge2_y[17] raw_edge2_y[18] raw_edge2_y[19]
+ raw_edge2_y[1] raw_edge2_y[20] raw_edge2_y[2] raw_edge2_y[3] raw_edge2_y[4] raw_edge2_y[5]
+ raw_edge2_y[6] raw_edge2_y[7] raw_edge2_y[8] raw_edge2_y[9] raw_edge3_x[0] raw_edge3_x[10]
+ raw_edge3_x[11] raw_edge3_x[12] raw_edge3_x[13] raw_edge3_x[14] raw_edge3_x[15]
+ raw_edge3_x[16] raw_edge3_x[17] raw_edge3_x[18] raw_edge3_x[19] raw_edge3_x[1] raw_edge3_x[20]
+ raw_edge3_x[2] raw_edge3_x[3] raw_edge3_x[4] raw_edge3_x[5] raw_edge3_x[6] raw_edge3_x[7]
+ raw_edge3_x[8] raw_edge3_x[9] raw_edge3_y[0] raw_edge3_y[10] raw_edge3_y[11] raw_edge3_y[12]
+ raw_edge3_y[13] raw_edge3_y[14] raw_edge3_y[15] raw_edge3_y[16] raw_edge3_y[17]
+ raw_edge3_y[18] raw_edge3_y[19] raw_edge3_y[1] raw_edge3_y[20] raw_edge3_y[2] raw_edge3_y[3]
+ raw_edge3_y[4] raw_edge3_y[5] raw_edge3_y[6] raw_edge3_y[7] raw_edge3_y[8] raw_edge3_y[9]
+ rst_n soft_rst spi_cs_n spi_miso spi_miso_oe spi_mosi spi_sclk state_o[0] state_o[1]
+ state_o[2] votes_in_phase_x[0] votes_in_phase_x[1] votes_in_phase_x[2] votes_in_phase_x[3]
+ votes_in_phase_y[0] votes_in_phase_y[1] votes_in_phase_y[2] votes_in_phase_y[3]
+ votes_out_phase_x[0] votes_out_phase_x[1] votes_out_phase_x[2] votes_out_phase_x[3]
+ votes_out_phase_y[0] votes_out_phase_y[1] votes_out_phase_y[2] votes_out_phase_y[3]
XFILLER_54_247 VDD VDD VSS VSS gf180mcu_fd_sc_mcu7t5v0__fillcap_4
XFILLER_54_225 VDD VDD VSS VSS gf180mcu_fd_sc_mcu7t5v0__fillcap_4
XFILLER_39_255 VDD VDD VSS VSS gf180mcu_fd_sc_mcu7t5v0__fillcap_8
XFILLER_35_483 VDD VDD VSS VSS gf180mcu_fd_sc_mcu7t5v0__fill_1
XFILLER_22_177 VDD VDD VSS VSS gf180mcu_fd_sc_mcu7t5v0__fillcap_4
XFILLER_2_527 VDD VDD VSS VSS gf180mcu_fd_sc_mcu7t5v0__fillcap_8
XTAP_TAPCELL_ROW_20_334 VDD VSS gf180mcu_fd_sc_mcu7t5v0__filltie
Xfanout864 _1582_/RN wire867/I VDD VDD VSS VSS gf180mcu_fd_sc_mcu7t5v0__dlyb_1
XTAP_TAPCELL_ROW_71_746 VDD VSS gf180mcu_fd_sc_mcu7t5v0__filltie
XFILLER_60_228 VDD VDD VSS VSS gf180mcu_fd_sc_mcu7t5v0__fillcap_8
XFILLER_45_258 VDD VDD VSS VSS gf180mcu_fd_sc_mcu7t5v0__fillcap_8
XFILLER_41_431 VDD VDD VSS VSS gf180mcu_fd_sc_mcu7t5v0__fillcap_4
XTAP_TAPCELL_ROW_28_401 VDD VSS gf180mcu_fd_sc_mcu7t5v0__filltie
XPHY_EDGE_ROW_39_Left_121 VDD VSS gf180mcu_fd_sc_mcu7t5v0__endcap
XPHY_EDGE_ROW_48_Left_130 VDD VSS gf180mcu_fd_sc_mcu7t5v0__endcap
X_1270_ _1581_/Q _1580_/Q _1582_/Q _1373_/A3 VDD VDD VSS VSS gf180mcu_fd_sc_mcu7t5v0__nor3_4
XFILLER_80_2 VDD VDD VSS VSS gf180mcu_fd_sc_mcu7t5v0__fillcap_32
XTAP_TAPCELL_ROW_34_448 VDD VSS gf180mcu_fd_sc_mcu7t5v0__filltie
X_0985_ _0985_/A1 _0985_/A2 _0985_/A3 wire470/I VDD VDD VSS VSS gf180mcu_fd_sc_mcu7t5v0__nor3_2
Xoutput401 _1475_/Q cfg_phase270_offset_x[8] VDD VDD VSS VSS gf180mcu_fd_sc_mcu7t5v0__buf_2
Xoutput423 _1534_/Q cfg_phase270_offset_y[9] VDD VDD VSS VSS gf180mcu_fd_sc_mcu7t5v0__buf_2
Xoutput412 _1543_/Q cfg_phase270_offset_y[18] VDD VDD VSS VSS gf180mcu_fd_sc_mcu7t5v0__buf_2
X_1606_ _1606_/D _1616_/RN _1674_/CLK _1606_/Q VDD VDD VSS VSS gf180mcu_fd_sc_mcu7t5v0__dffrnq_1
Xoutput434 _1657_/Q cfg_phase90_offset_x[19] VDD VDD VSS VSS gf180mcu_fd_sc_mcu7t5v0__buf_2
Xoutput467 _1591_/Q soft_rst VDD VDD VSS VSS gf180mcu_fd_sc_mcu7t5v0__buf_2
X_1537_ _1537_/D _1539_/RN _1587_/CLK _1537_/Q VDD VDD VSS VSS gf180mcu_fd_sc_mcu7t5v0__dffrnq_1
X_1399_ _1480_/Q _1399_/I1 _1400_/S _1480_/D VDD VDD VSS VSS gf180mcu_fd_sc_mcu7t5v0__mux2_2
X_1468_ _1468_/D wire794/I clkload1/I _1468_/Q VDD VDD VSS VSS gf180mcu_fd_sc_mcu7t5v0__dffrnq_1
Xoutput456 _1510_/Q cfg_phase90_offset_y[1] VDD VDD VSS VSS gf180mcu_fd_sc_mcu7t5v0__buf_2
Xoutput445 _1509_/Q cfg_phase90_offset_y[0] VDD VDD VSS VSS gf180mcu_fd_sc_mcu7t5v0__buf_2
XFILLER_42_239 VDD VDD VSS VSS gf180mcu_fd_sc_mcu7t5v0__fillcap_4
Xwire539 wire539/I wire539/Z VDD VDD VSS VSS gf180mcu_fd_sc_mcu7t5v0__buf_2
XFILLER_6_107 VDD VDD VSS VSS gf180mcu_fd_sc_mcu7t5v0__fillcap_64
XFILLER_10_169 VDD VDD VSS VSS gf180mcu_fd_sc_mcu7t5v0__fillcap_4
XFILLER_12_76 VDD VDD VSS VSS gf180mcu_fd_sc_mcu7t5v0__fillcap_8
XFILLER_77_136 VDD VDD VSS VSS gf180mcu_fd_sc_mcu7t5v0__fillcap_4
XFILLER_18_247 VDD VDD VSS VSS gf180mcu_fd_sc_mcu7t5v0__fillcap_4
X_0770_ _0770_/I0 _1540_/Q _1466_/S _1540_/D VDD VDD VSS VSS gf180mcu_fd_sc_mcu7t5v0__mux2_2
XFILLER_68_147 VDD VDD VSS VSS gf180mcu_fd_sc_mcu7t5v0__fill_2
X_1253_ _1579_/Q _0762_/I _1254_/B VDD VDD VSS VSS gf180mcu_fd_sc_mcu7t5v0__nand2_1
X_1322_ _1638_/Q _1364_/I1 _1330_/S _1638_/D VDD VDD VSS VSS gf180mcu_fd_sc_mcu7t5v0__mux2_2
X_1184_ input10/Z _1231_/A2 _1190_/A1 VDD VDD VSS VSS gf180mcu_fd_sc_mcu7t5v0__nand2_1
XFILLER_49_383 VDD VDD VSS VSS gf180mcu_fd_sc_mcu7t5v0__fill_1
XTAP_TAPCELL_ROW_47_551 VDD VSS gf180mcu_fd_sc_mcu7t5v0__filltie
X_0968_ _1549_/Q _0968_/A2 _1235_/B VDD VDD VSS VSS gf180mcu_fd_sc_mcu7t5v0__nand2_4
X_0899_ _1555_/Q _1248_/A1 _1252_/A1 _1557_/Q _0916_/A2 VDD VDD VSS VSS gf180mcu_fd_sc_mcu7t5v0__nand4_4
XFILLER_28_523 VDD VDD VSS VSS gf180mcu_fd_sc_mcu7t5v0__fill_2
XTAP_TAPCELL_ROW_81_830 VDD VSS gf180mcu_fd_sc_mcu7t5v0__filltie
XTAP_TAPCELL_ROW_53_598 VDD VSS gf180mcu_fd_sc_mcu7t5v0__filltie
XFILLER_43_515 VDD VDD VSS VSS gf180mcu_fd_sc_mcu7t5v0__fill_1
XFILLER_23_261 VDD VDD VSS VSS gf180mcu_fd_sc_mcu7t5v0__fill_1
XFILLER_7_416 VDD VDD VSS VSS gf180mcu_fd_sc_mcu7t5v0__fillcap_4
XFILLER_23_97 VDD VDD VSS VSS gf180mcu_fd_sc_mcu7t5v0__fillcap_32
XFILLER_61_334 VDD VDD VSS VSS gf180mcu_fd_sc_mcu7t5v0__fillcap_8
X_0822_ _1257_/A1 _0822_/A2 _0822_/B _1560_/Q _0826_/A1 VDD VDD VSS VSS gf180mcu_fd_sc_mcu7t5v0__oai211_1
XFILLER_9_88 VDD VDD VSS VSS gf180mcu_fd_sc_mcu7t5v0__fill_2
XFILLER_43_2 VDD VDD VSS VSS gf180mcu_fd_sc_mcu7t5v0__fillcap_4
X_0753_ _1578_/Q _0749_/Z _1428_/A3 _0781_/S VDD VDD VSS VSS gf180mcu_fd_sc_mcu7t5v0__nand3_4
Xload_slew875 wire876/Z _1564_/RN VDD VDD VSS VSS gf180mcu_fd_sc_mcu7t5v0__buf_2
Xload_slew886 wire887/Z fanout884/I VDD VDD VSS VSS gf180mcu_fd_sc_mcu7t5v0__buf_2
X_1236_ _1236_/A1 _1236_/A2 _1236_/A3 _1236_/A4 _1243_/A2 VDD VDD VSS VSS gf180mcu_fd_sc_mcu7t5v0__nand4_1
Xload_slew820 _1476_/RN _1677_/RN VDD VDD VSS VSS gf180mcu_fd_sc_mcu7t5v0__buf_1
Xload_slew831 _1508_/RN _1510_/RN VDD VDD VSS VSS gf180mcu_fd_sc_mcu7t5v0__clkbuf_2
X_1305_ _1409_/I1 _1625_/Q _1313_/S _1625_/D VDD VDD VSS VSS gf180mcu_fd_sc_mcu7t5v0__mux2_2
Xload_slew842 wire843/I _1621_/RN VDD VDD VSS VSS gf180mcu_fd_sc_mcu7t5v0__clkbuf_2
Xload_slew853 _1521_/RN _1515_/RN VDD VDD VSS VSS gf180mcu_fd_sc_mcu7t5v0__clkbuf_2
X_1167_ _1167_/A1 wire586/Z _1185_/B1 _1167_/B2 _1229_/B1 _1664_/Q _1171_/A1 VDD VDD
+ VSS VSS gf180mcu_fd_sc_mcu7t5v0__aoi222_2
X_1098_ _1098_/A1 wire573/Z _1205_/A2 _1499_/Q wire515/Z _1098_/C2 wire493/I VDD VDD
+ VSS VSS gf180mcu_fd_sc_mcu7t5v0__aoi222_4
XFILLER_37_397 VDD VDD VSS VSS gf180mcu_fd_sc_mcu7t5v0__fillcap_4
XFILLER_25_515 VDD VDD VSS VSS gf180mcu_fd_sc_mcu7t5v0__fill_1
XTAP_TAPCELL_ROW_50_579 VDD VSS gf180mcu_fd_sc_mcu7t5v0__filltie
XTAP_TAPCELL_ROW_7_235 VDD VSS gf180mcu_fd_sc_mcu7t5v0__filltie
XFILLER_55_150 VDD VDD VSS VSS gf180mcu_fd_sc_mcu7t5v0__fillcap_16
XFILLER_47_139 VDD VDD VSS VSS gf180mcu_fd_sc_mcu7t5v0__fill_1
XFILLER_18_53 VDD VDD VSS VSS gf180mcu_fd_sc_mcu7t5v0__fillcap_4
XTAP_TAPCELL_ROW_41_502 VDD VSS gf180mcu_fd_sc_mcu7t5v0__filltie
XFILLER_34_52 VDD VDD VSS VSS gf180mcu_fd_sc_mcu7t5v0__fillcap_4
XFILLER_50_73 VDD VDD VSS VSS gf180mcu_fd_sc_mcu7t5v0__fillcap_32
XFILLER_81_407 VDD VDD VSS VSS gf180mcu_fd_sc_mcu7t5v0__fill_1
XFILLER_61_153 VDD VDD VSS VSS gf180mcu_fd_sc_mcu7t5v0__fillcap_8
X_1021_ _1021_/A1 _1070_/B1 wire547/Z input60/Z _1177_/B _1022_/A2 VDD VDD VSS VSS
+ gf180mcu_fd_sc_mcu7t5v0__aoi221_2
XFILLER_15_570 VDD VDD VSS VSS gf180mcu_fd_sc_mcu7t5v0__fillcap_4
X_0805_ _1556_/Q _0806_/A2 _0805_/B _0806_/B VDD VDD VSS VSS gf180mcu_fd_sc_mcu7t5v0__aoi21_1
XTAP_TAPCELL_ROW_12_270 VDD VSS gf180mcu_fd_sc_mcu7t5v0__filltie
Xload_slew650 _0913_/A1 _0903_/A1 VDD VDD VSS VSS gf180mcu_fd_sc_mcu7t5v0__buf_2
X_0736_ _1586_/Q _0736_/ZN VDD VDD VSS VSS gf180mcu_fd_sc_mcu7t5v0__clkinv_1
XTAP_TAPCELL_ROW_4_205 VDD VSS gf180mcu_fd_sc_mcu7t5v0__filltie
Xload_slew683 _0907_/A2 _0866_/A1 VDD VDD VSS VSS gf180mcu_fd_sc_mcu7t5v0__buf_2
XFILLER_65_492 VDD VDD VSS VSS gf180mcu_fd_sc_mcu7t5v0__fillcap_4
Xload_slew661 _0878_/A2 _0874_/A1 VDD VDD VSS VSS gf180mcu_fd_sc_mcu7t5v0__buf_2
Xload_slew672 wire674/Z _0892_/A1 VDD VDD VSS VSS gf180mcu_fd_sc_mcu7t5v0__clkbuf_1
XTAP_TAPCELL_ROW_55_616 VDD VSS gf180mcu_fd_sc_mcu7t5v0__filltie
X_1219_ input74/Z _1219_/A2 _1219_/B1 _1503_/Q _1239_/A1 VDD VDD VSS VSS gf180mcu_fd_sc_mcu7t5v0__aoi22_1
Xload_slew694 _1460_/A1 fanout684/I VDD VDD VSS VSS gf180mcu_fd_sc_mcu7t5v0__buf_1
XTAP_TAPCELL_ROW_63_682 VDD VSS gf180mcu_fd_sc_mcu7t5v0__filltie
XFILLER_21_551 VDD VDD VSS VSS gf180mcu_fd_sc_mcu7t5v0__fill_1
XFILLER_21_562 VDD VDD VSS VSS gf180mcu_fd_sc_mcu7t5v0__fillcap_4
XFILLER_75_212 VDD VDD VSS VSS gf180mcu_fd_sc_mcu7t5v0__fillcap_64
Xinput301 votes_out_phase_x[3] _1099_/A1 VDD VDD VSS VSS gf180mcu_fd_sc_mcu7t5v0__buf_1
XFILLER_0_444 VDD VDD VSS VSS gf180mcu_fd_sc_mcu7t5v0__fillcap_32
XFILLER_71_440 VDD VDD VSS VSS gf180mcu_fd_sc_mcu7t5v0__fillcap_8
XFILLER_43_142 VDD VDD VSS VSS gf180mcu_fd_sc_mcu7t5v0__fillcap_4
XFILLER_43_120 VDD VDD VSS VSS gf180mcu_fd_sc_mcu7t5v0__fill_2
XFILLER_28_150 VDD VDD VSS VSS gf180mcu_fd_sc_mcu7t5v0__fillcap_4
XFILLER_16_312 VDD VDD VSS VSS gf180mcu_fd_sc_mcu7t5v0__fill_2
XTAP_TAPCELL_ROW_18_318 VDD VSS gf180mcu_fd_sc_mcu7t5v0__filltie
XFILLER_61_72 VDD VDD VSS VSS gf180mcu_fd_sc_mcu7t5v0__fillcap_64
XFILLER_6_34 VDD VDD VSS VSS gf180mcu_fd_sc_mcu7t5v0__fill_1
XPHY_EDGE_ROW_20_Left_102 VDD VSS gf180mcu_fd_sc_mcu7t5v0__endcap
XTAP_TAPCELL_ROW_26_384 VDD VSS gf180mcu_fd_sc_mcu7t5v0__filltie
X_1570_ _1570_/D _1571_/RN _1575_/CLK _1570_/Q VDD VDD VSS VSS gf180mcu_fd_sc_mcu7t5v0__dffrnq_1
XFILLER_6_45 VDD VDD VSS VSS gf180mcu_fd_sc_mcu7t5v0__fillcap_32
XFILLER_3_282 VDD VDD VSS VSS gf180mcu_fd_sc_mcu7t5v0__fillcap_64
XFILLER_81_237 VDD VDD VSS VSS gf180mcu_fd_sc_mcu7t5v0__fill_1
XFILLER_79_562 VDD VDD VSS VSS gf180mcu_fd_sc_mcu7t5v0__fillcap_8
XFILLER_47_492 VDD VDD VSS VSS gf180mcu_fd_sc_mcu7t5v0__fillcap_16
XFILLER_62_473 VDD VDD VSS VSS gf180mcu_fd_sc_mcu7t5v0__fill_2
XTAP_TAPCELL_ROW_60_652 VDD VSS gf180mcu_fd_sc_mcu7t5v0__filltie
X_1004_ _1618_/Q wire604/Z wire558/Z _1004_/B2 _1005_/A4 VDD VDD VSS VSS gf180mcu_fd_sc_mcu7t5v0__aoi22_1
XFILLER_34_164 VDD VDD VSS VSS gf180mcu_fd_sc_mcu7t5v0__fillcap_8
XFILLER_57_212 VDD VDD VSS VSS gf180mcu_fd_sc_mcu7t5v0__fillcap_8
XFILLER_57_278 VDD VDD VSS VSS gf180mcu_fd_sc_mcu7t5v0__fill_2
XFILLER_53_440 VDD VDD VSS VSS gf180mcu_fd_sc_mcu7t5v0__fill_2
XPHY_EDGE_ROW_11_Left_93 VDD VSS gf180mcu_fd_sc_mcu7t5v0__endcap
XFILLER_25_142 VDD VDD VSS VSS gf180mcu_fd_sc_mcu7t5v0__fill_1
XFILLER_15_87 VDD VDD VSS VSS gf180mcu_fd_sc_mcu7t5v0__fillcap_8
Xinput153 phase_state_x[0] _0954_/A1 VDD VDD VSS VSS gf180mcu_fd_sc_mcu7t5v0__buf_1
Xinput131 cal_timeout_x _1052_/A1 VDD VDD VSS VSS gf180mcu_fd_sc_mcu7t5v0__buf_1
Xinput120 cal_phase90_offset_y[19] _1094_/B2 VDD VDD VSS VSS gf180mcu_fd_sc_mcu7t5v0__buf_1
XFILLER_48_267 VDD VDD VSS VSS gf180mcu_fd_sc_mcu7t5v0__fillcap_32
XFILLER_48_223 VDD VDD VSS VSS gf180mcu_fd_sc_mcu7t5v0__fillcap_16
Xinput175 raw_edge1_x[7] _1241_/A1 VDD VDD VSS VSS gf180mcu_fd_sc_mcu7t5v0__buf_1
Xinput164 raw_edge1_x[16] _0947_/B2 VDD VDD VSS VSS gf180mcu_fd_sc_mcu7t5v0__buf_1
Xinput142 delay_wave_cycle_y[1] _0981_/B2 VDD VDD VSS VSS gf180mcu_fd_sc_mcu7t5v0__buf_1
XFILLER_0_274 VDD VDD VSS VSS gf180mcu_fd_sc_mcu7t5v0__fillcap_32
Xinput197 raw_edge1_y[8] _0932_/B2 VDD VDD VSS VSS gf180mcu_fd_sc_mcu7t5v0__buf_1
Xinput186 raw_edge1_y[17] _0972_/A1 VDD VDD VSS VSS gf180mcu_fd_sc_mcu7t5v0__buf_1
XTAP_TAPCELL_ROW_74_766 VDD VSS gf180mcu_fd_sc_mcu7t5v0__filltie
XFILLER_16_164 VDD VDD VSS VSS gf180mcu_fd_sc_mcu7t5v0__fillcap_8
X_1622_ _1622_/D _1628_/RN _1624_/CLK _1622_/Q VDD VDD VSS VSS gf180mcu_fd_sc_mcu7t5v0__dffrnq_1
X_1553_ _1553_/D wire876/Z clkload7/I _1553_/Q VDD VDD VSS VSS gf180mcu_fd_sc_mcu7t5v0__dffrnq_1
XFILLER_39_223 VDD VDD VSS VSS gf180mcu_fd_sc_mcu7t5v0__fillcap_32
X_1484_ _1484_/D wire828/Z _1629_/CLK _1484_/Q VDD VDD VSS VSS gf180mcu_fd_sc_mcu7t5v0__dffrnq_2
XTAP_TAPCELL_ROW_37_468 VDD VSS gf180mcu_fd_sc_mcu7t5v0__filltie
XTAP_TAPCELL_ROW_20_335 VDD VSS gf180mcu_fd_sc_mcu7t5v0__filltie
XFILLER_2_539 VDD VDD VSS VSS gf180mcu_fd_sc_mcu7t5v0__fill_2
XFILLER_73_524 VDD VDD VSS VSS gf180mcu_fd_sc_mcu7t5v0__fillcap_16
Xfanout821 wire887/Z wire824/I VDD VDD VSS VSS gf180mcu_fd_sc_mcu7t5v0__dlyb_1
XFILLER_58_510 VDD VDD VSS VSS gf180mcu_fd_sc_mcu7t5v0__fill_1
XTAP_TAPCELL_ROW_28_402 VDD VSS gf180mcu_fd_sc_mcu7t5v0__filltie
Xfanout832 wire840/Z _1495_/RN VDD VDD VSS VSS gf180mcu_fd_sc_mcu7t5v0__dlyb_1
XTAP_TAPCELL_ROW_71_747 VDD VSS gf180mcu_fd_sc_mcu7t5v0__filltie
XFILLER_60_207 VDD VDD VSS VSS gf180mcu_fd_sc_mcu7t5v0__fillcap_4
XFILLER_42_96 VDD VDD VSS VSS gf180mcu_fd_sc_mcu7t5v0__fillcap_8
XFILLER_41_487 VDD VDD VSS VSS gf180mcu_fd_sc_mcu7t5v0__fill_2
XFILLER_64_535 VDD VDD VSS VSS gf180mcu_fd_sc_mcu7t5v0__fill_2
XFILLER_64_524 VDD VDD VSS VSS gf180mcu_fd_sc_mcu7t5v0__fill_1
XFILLER_36_259 VDD VDD VSS VSS gf180mcu_fd_sc_mcu7t5v0__fill_2
X_0984_ _0984_/A1 _0984_/A2 _0984_/A3 _0984_/A4 _0985_/A3 VDD VDD VSS VSS gf180mcu_fd_sc_mcu7t5v0__nand4_1
XTAP_TAPCELL_ROW_34_449 VDD VSS gf180mcu_fd_sc_mcu7t5v0__filltie
Xoutput468 _1575_/Q spi_miso VDD VDD VSS VSS gf180mcu_fd_sc_mcu7t5v0__buf_2
X_1536_ _1536_/D wire861/Z clkload4/I _1536_/Q VDD VDD VSS VSS gf180mcu_fd_sc_mcu7t5v0__dffrnq_1
X_1605_ _1605_/D wire785/Z _1670_/CLK _1605_/Q VDD VDD VSS VSS gf180mcu_fd_sc_mcu7t5v0__dffrnq_1
XFILLER_8_171 VDD VDD VSS VSS gf180mcu_fd_sc_mcu7t5v0__fillcap_4
Xoutput457 _1508_/Q cfg_phase90_offset_y[20] VDD VDD VSS VSS gf180mcu_fd_sc_mcu7t5v0__buf_2
Xoutput424 _1659_/Q cfg_phase90_offset_x[0] VDD VDD VSS VSS gf180mcu_fd_sc_mcu7t5v0__buf_2
Xoutput446 _1519_/Q cfg_phase90_offset_y[10] VDD VDD VSS VSS gf180mcu_fd_sc_mcu7t5v0__buf_2
Xoutput435 _1660_/Q cfg_phase90_offset_x[1] VDD VDD VSS VSS gf180mcu_fd_sc_mcu7t5v0__buf_2
Xoutput402 _1476_/Q cfg_phase270_offset_x[9] VDD VDD VSS VSS gf180mcu_fd_sc_mcu7t5v0__buf_2
Xoutput413 _1544_/Q cfg_phase270_offset_y[19] VDD VDD VSS VSS gf180mcu_fd_sc_mcu7t5v0__buf_2
X_1467_ _1467_/I0 _1535_/Q _1467_/S _1535_/D VDD VDD VSS VSS gf180mcu_fd_sc_mcu7t5v0__mux2_2
X_1398_ _1479_/Q wire737/Z _1400_/S _1479_/D VDD VDD VSS VSS gf180mcu_fd_sc_mcu7t5v0__mux2_2
XFILLER_70_527 VDD VDD VSS VSS gf180mcu_fd_sc_mcu7t5v0__fillcap_16
XFILLER_55_557 VDD VDD VSS VSS gf180mcu_fd_sc_mcu7t5v0__fill_2
Xwire529 wire529/I wire529/Z VDD VDD VSS VSS gf180mcu_fd_sc_mcu7t5v0__buf_2
XFILLER_10_104 VDD VDD VSS VSS gf180mcu_fd_sc_mcu7t5v0__fill_1
XFILLER_10_126 VDD VDD VSS VSS gf180mcu_fd_sc_mcu7t5v0__fill_1
XFILLER_12_88 VDD VDD VSS VSS gf180mcu_fd_sc_mcu7t5v0__fill_2
Xfanout640 wire645/Z _1152_/S VDD VDD VSS VSS gf180mcu_fd_sc_mcu7t5v0__dlyb_1
Xfanout662 wire668/I wire667/I VDD VDD VSS VSS gf180mcu_fd_sc_mcu7t5v0__dlyb_1
XFILLER_73_376 VDD VDD VSS VSS gf180mcu_fd_sc_mcu7t5v0__fill_2
XFILLER_37_63 VDD VDD VSS VSS gf180mcu_fd_sc_mcu7t5v0__fill_1
Xfanout684 fanout684/I _1397_/A1 VDD VDD VSS VSS gf180mcu_fd_sc_mcu7t5v0__dlyb_1
XFILLER_14_454 VDD VDD VSS VSS gf180mcu_fd_sc_mcu7t5v0__fill_1
X_1252_ _1252_/A1 _1254_/A2 _1252_/B _1578_/D VDD VDD VSS VSS gf180mcu_fd_sc_mcu7t5v0__oai21_1
X_1321_ _1455_/A2 _1435_/A2 _1331_/A3 _1330_/S VDD VDD VSS VSS gf180mcu_fd_sc_mcu7t5v0__and3_4
X_1183_ _1574_/Q wire644/Z _1214_/B VDD VDD VSS VSS gf180mcu_fd_sc_mcu7t5v0__nand2_1
XFILLER_52_516 VDD VDD VSS VSS gf180mcu_fd_sc_mcu7t5v0__fill_2
XTAP_TAPCELL_ROW_47_552 VDD VSS gf180mcu_fd_sc_mcu7t5v0__filltie
X_0967_ _1549_/Q _0968_/A2 _0967_/Z VDD VDD VSS VSS gf180mcu_fd_sc_mcu7t5v0__and2_2
X_0898_ _0898_/A1 _0898_/A2 wire548/I VDD VDD VSS VSS gf180mcu_fd_sc_mcu7t5v0__nor2_4
XPHY_EDGE_ROW_12_Right_12 VDD VSS gf180mcu_fd_sc_mcu7t5v0__endcap
X_1519_ _1519_/D _1526_/RN clkload6/I _1519_/Q VDD VDD VSS VSS gf180mcu_fd_sc_mcu7t5v0__dffrnq_2
XFILLER_74_107 VDD VDD VSS VSS gf180mcu_fd_sc_mcu7t5v0__fillcap_64
XFILLER_74_28 VDD VDD VSS VSS gf180mcu_fd_sc_mcu7t5v0__fillcap_4
XFILLER_55_321 VDD VDD VSS VSS gf180mcu_fd_sc_mcu7t5v0__fill_1
XTAP_TAPCELL_ROW_2_188 VDD VSS gf180mcu_fd_sc_mcu7t5v0__filltie
XFILLER_15_207 VDD VDD VSS VSS gf180mcu_fd_sc_mcu7t5v0__fill_2
XPHY_EDGE_ROW_21_Right_21 VDD VSS gf180mcu_fd_sc_mcu7t5v0__endcap
XTAP_TAPCELL_ROW_81_831 VDD VSS gf180mcu_fd_sc_mcu7t5v0__filltie
XTAP_TAPCELL_ROW_81_820 VDD VSS gf180mcu_fd_sc_mcu7t5v0__filltie
XPHY_EDGE_ROW_67_Left_149 VDD VSS gf180mcu_fd_sc_mcu7t5v0__endcap
XTAP_TAPCELL_ROW_53_599 VDD VSS gf180mcu_fd_sc_mcu7t5v0__filltie
XFILLER_51_571 VDD VDD VSS VSS gf180mcu_fd_sc_mcu7t5v0__fill_2
XPHY_EDGE_ROW_30_Right_30 VDD VSS gf180mcu_fd_sc_mcu7t5v0__endcap
XFILLER_78_457 VDD VDD VSS VSS gf180mcu_fd_sc_mcu7t5v0__fill_1
XFILLER_78_413 VDD VDD VSS VSS gf180mcu_fd_sc_mcu7t5v0__fill_1
XPHY_EDGE_ROW_76_Left_158 VDD VSS gf180mcu_fd_sc_mcu7t5v0__endcap
XFILLER_2_177 VDD VDD VSS VSS gf180mcu_fd_sc_mcu7t5v0__fillcap_64
XFILLER_34_527 VDD VDD VSS VSS gf180mcu_fd_sc_mcu7t5v0__fillcap_4
XFILLER_0_36 VDD VDD VSS VSS gf180mcu_fd_sc_mcu7t5v0__fillcap_32
X_0821_ _0821_/I _1559_/D VDD VDD VSS VSS gf180mcu_fd_sc_mcu7t5v0__clkinv_1
X_0752_ _1579_/Q _0752_/A2 _1428_/A3 VDD VDD VSS VSS gf180mcu_fd_sc_mcu7t5v0__nor2_4
XFILLER_9_67 VDD VDD VSS VSS gf180mcu_fd_sc_mcu7t5v0__fill_2
XFILLER_14_262 VDD VDD VSS VSS gf180mcu_fd_sc_mcu7t5v0__fill_2
Xwire871 wire871/I wire871/Z VDD VDD VSS VSS gf180mcu_fd_sc_mcu7t5v0__buf_1
XFILLER_69_402 VDD VDD VSS VSS gf180mcu_fd_sc_mcu7t5v0__fillcap_8
XFILLER_36_2 VDD VDD VSS VSS gf180mcu_fd_sc_mcu7t5v0__fill_1
Xload_slew810 _1654_/RN _1634_/RN VDD VDD VSS VSS gf180mcu_fd_sc_mcu7t5v0__buf_1
XFILLER_64_151 VDD VDD VSS VSS gf180mcu_fd_sc_mcu7t5v0__fillcap_4
XFILLER_56_107 VDD VDD VSS VSS gf180mcu_fd_sc_mcu7t5v0__fill_2
X_1166_ wire491/Z _1166_/A2 _1179_/A1 VDD VDD VSS VSS gf180mcu_fd_sc_mcu7t5v0__nand2_1
X_1235_ _1632_/Q wire548/Z _1235_/B _1236_/A4 VDD VDD VSS VSS gf180mcu_fd_sc_mcu7t5v0__aoi21_1
Xload_slew854 _1521_/RN _1522_/RN VDD VDD VSS VSS gf180mcu_fd_sc_mcu7t5v0__clkbuf_1
X_1304_ _1428_/A1 _1428_/A3 _1331_/A3 _1310_/S VDD VDD VSS VSS gf180mcu_fd_sc_mcu7t5v0__nand3_4
XFILLER_52_379 VDD VDD VSS VSS gf180mcu_fd_sc_mcu7t5v0__fillcap_4
X_1097_ _1097_/A1 _1218_/A2 wire575/Z _1678_/Q _1133_/A2 _1097_/C2 _1100_/A1 VDD VDD
+ VSS VSS gf180mcu_fd_sc_mcu7t5v0__aoi222_4
XTAP_TAPCELL_ROW_58_636 VDD VSS gf180mcu_fd_sc_mcu7t5v0__filltie
XFILLER_28_343 VDD VDD VSS VSS gf180mcu_fd_sc_mcu7t5v0__fill_1
XTAP_TAPCELL_ROW_41_503 VDD VSS gf180mcu_fd_sc_mcu7t5v0__filltie
XFILLER_11_254 VDD VDD VSS VSS gf180mcu_fd_sc_mcu7t5v0__fill_2
XFILLER_3_486 VDD VDD VSS VSS gf180mcu_fd_sc_mcu7t5v0__fillcap_4
XFILLER_59_72 VDD VDD VSS VSS gf180mcu_fd_sc_mcu7t5v0__fillcap_16
XFILLER_38_107 VDD VDD VSS VSS gf180mcu_fd_sc_mcu7t5v0__fillcap_16
X_1020_ _1535_/Q wire594/Z _1020_/B1 _1611_/Q _1079_/B1 _1485_/Q wire498/I VDD VDD
+ VSS VSS gf180mcu_fd_sc_mcu7t5v0__aoi222_4
XFILLER_61_165 VDD VDD VSS VSS gf180mcu_fd_sc_mcu7t5v0__fill_2
XFILLER_46_173 VDD VDD VSS VSS gf180mcu_fd_sc_mcu7t5v0__fill_2
X_0804_ _1250_/A1 _1248_/A1 _0782_/B _0806_/A2 VDD VDD VSS VSS gf180mcu_fd_sc_mcu7t5v0__nor3_1
XTAP_TAPCELL_ROW_12_271 VDD VSS gf180mcu_fd_sc_mcu7t5v0__filltie
X_0735_ _1578_/Q _1428_/A1 VDD VDD VSS VSS gf180mcu_fd_sc_mcu7t5v0__inv_1
Xwire690 wire690/I wire690/Z VDD VDD VSS VSS gf180mcu_fd_sc_mcu7t5v0__clkbuf_2
XFILLER_69_276 VDD VDD VSS VSS gf180mcu_fd_sc_mcu7t5v0__fillcap_4
Xload_slew673 wire674/Z _0848_/A1 VDD VDD VSS VSS gf180mcu_fd_sc_mcu7t5v0__buf_2
Xload_slew651 _0885_/A1 _0913_/A1 VDD VDD VSS VSS gf180mcu_fd_sc_mcu7t5v0__buf_2
XTAP_TAPCELL_ROW_4_206 VDD VSS gf180mcu_fd_sc_mcu7t5v0__filltie
XFILLER_69_298 VDD VDD VSS VSS gf180mcu_fd_sc_mcu7t5v0__fillcap_8
XTAP_TAPCELL_ROW_55_617 VDD VSS gf180mcu_fd_sc_mcu7t5v0__filltie
XFILLER_52_143 VDD VDD VSS VSS gf180mcu_fd_sc_mcu7t5v0__fill_1
X_1149_ _1149_/A1 _1149_/A2 _1149_/A3 _1149_/A4 _1150_/A4 VDD VDD VSS VSS gf180mcu_fd_sc_mcu7t5v0__nand4_2
X_1218_ _1218_/A1 _1218_/A2 _1218_/B1 _1474_/Q _1242_/A1 VDD VDD VSS VSS gf180mcu_fd_sc_mcu7t5v0__aoi22_1
Xload_slew695 _1655_/Q _0999_/B2 VDD VDD VSS VSS gf180mcu_fd_sc_mcu7t5v0__buf_2
XTAP_TAPCELL_ROW_63_683 VDD VSS gf180mcu_fd_sc_mcu7t5v0__filltie
XFILLER_40_349 VDD VDD VSS VSS gf180mcu_fd_sc_mcu7t5v0__fillcap_16
Xinput302 votes_out_phase_y[0] _0952_/A1 VDD VDD VSS VSS gf180mcu_fd_sc_mcu7t5v0__buf_1
XFILLER_0_478 VDD VDD VSS VSS gf180mcu_fd_sc_mcu7t5v0__fillcap_32
XFILLER_71_452 VDD VDD VSS VSS gf180mcu_fd_sc_mcu7t5v0__fill_2
XFILLER_43_132 VDD VDD VSS VSS gf180mcu_fd_sc_mcu7t5v0__fillcap_8
XFILLER_31_349 VDD VDD VSS VSS gf180mcu_fd_sc_mcu7t5v0__fill_1
XTAP_TAPCELL_ROW_18_319 VDD VSS gf180mcu_fd_sc_mcu7t5v0__filltie
XTAP_TAPCELL_ROW_26_385 VDD VSS gf180mcu_fd_sc_mcu7t5v0__filltie
XFILLER_39_405 VDD VDD VSS VSS gf180mcu_fd_sc_mcu7t5v0__fillcap_4
X_1003_ _1610_/Q _1220_/A2 wire520/Z _1526_/Q _1005_/A3 VDD VDD VSS VSS gf180mcu_fd_sc_mcu7t5v0__aoi22_1
XFILLER_62_452 VDD VDD VSS VSS gf180mcu_fd_sc_mcu7t5v0__fill_2
XTAP_TAPCELL_ROW_60_653 VDD VSS gf180mcu_fd_sc_mcu7t5v0__filltie
XFILLER_34_143 VDD VDD VSS VSS gf180mcu_fd_sc_mcu7t5v0__fillcap_8
XPHY_EDGE_ROW_6_Right_6 VDD VSS gf180mcu_fd_sc_mcu7t5v0__endcap
XTAP_TAPCELL_ROW_68_720 VDD VSS gf180mcu_fd_sc_mcu7t5v0__filltie
XFILLER_13_316 VDD VDD VSS VSS gf180mcu_fd_sc_mcu7t5v0__fillcap_4
XFILLER_25_121 VDD VDD VSS VSS gf180mcu_fd_sc_mcu7t5v0__fillcap_4
XFILLER_25_165 VDD VDD VSS VSS gf180mcu_fd_sc_mcu7t5v0__fillcap_4
XFILLER_31_10 VDD VDD VSS VSS gf180mcu_fd_sc_mcu7t5v0__fill_2
Xinput110 cal_phase90_offset_y[0] _0954_/B2 VDD VDD VSS VSS gf180mcu_fd_sc_mcu7t5v0__buf_1
XTAP_TAPCELL_ROW_74_767 VDD VSS gf180mcu_fd_sc_mcu7t5v0__filltie
Xinput154 phase_state_x[1] _0991_/A1 VDD VDD VSS VSS gf180mcu_fd_sc_mcu7t5v0__buf_1
Xinput132 cal_timeout_y _1083_/B2 VDD VDD VSS VSS gf180mcu_fd_sc_mcu7t5v0__buf_1
Xinput121 cal_phase90_offset_y[1] _1006_/A1 VDD VDD VSS VSS gf180mcu_fd_sc_mcu7t5v0__buf_1
XFILLER_48_213 VDD VDD VSS VSS gf180mcu_fd_sc_mcu7t5v0__fill_1
Xinput165 raw_edge1_x[17] _0975_/B2 VDD VDD VSS VSS gf180mcu_fd_sc_mcu7t5v0__buf_1
Xinput143 delay_wave_cycle_y[2] _1023_/C2 VDD VDD VSS VSS gf180mcu_fd_sc_mcu7t5v0__buf_2
Xinput187 raw_edge1_y[18] _1043_/A1 VDD VDD VSS VSS gf180mcu_fd_sc_mcu7t5v0__buf_1
Xinput176 raw_edge1_x[8] _0956_/A1 VDD VDD VSS VSS gf180mcu_fd_sc_mcu7t5v0__buf_1
XFILLER_16_121 VDD VDD VSS VSS gf180mcu_fd_sc_mcu7t5v0__fill_1
Xinput198 raw_edge1_y[9] _1008_/B2 VDD VDD VSS VSS gf180mcu_fd_sc_mcu7t5v0__buf_1
XFILLER_71_282 VDD VDD VSS VSS gf180mcu_fd_sc_mcu7t5v0__fillcap_64
XPHY_EDGE_ROW_59_Right_59 VDD VSS gf180mcu_fd_sc_mcu7t5v0__endcap
X_1552_ _1552_/D wire871/I _1597_/CLK _1552_/Q VDD VDD VSS VSS gf180mcu_fd_sc_mcu7t5v0__dffrnq_1
X_1621_ _1621_/D _1621_/RN clkload5/I _1621_/Q VDD VDD VSS VSS gf180mcu_fd_sc_mcu7t5v0__dffrnq_1
XPHY_EDGE_ROW_68_Right_68 VDD VSS gf180mcu_fd_sc_mcu7t5v0__endcap
X_1483_ _1483_/D _1485_/RN _1629_/CLK _1483_/Q VDD VDD VSS VSS gf180mcu_fd_sc_mcu7t5v0__dffrnq_1
XTAP_TAPCELL_ROW_37_469 VDD VSS gf180mcu_fd_sc_mcu7t5v0__filltie
XFILLER_35_430 VDD VDD VSS VSS gf180mcu_fd_sc_mcu7t5v0__fill_1
XPHY_EDGE_ROW_77_Right_77 VDD VSS gf180mcu_fd_sc_mcu7t5v0__endcap
XFILLER_10_308 VDD VDD VSS VSS gf180mcu_fd_sc_mcu7t5v0__fillcap_4
XTAP_TAPCELL_ROW_20_336 VDD VSS gf180mcu_fd_sc_mcu7t5v0__filltie
Xfanout811 _1661_/RN _1637_/RN VDD VDD VSS VSS gf180mcu_fd_sc_mcu7t5v0__dlyb_1
XTAP_TAPCELL_ROW_28_403 VDD VSS gf180mcu_fd_sc_mcu7t5v0__filltie
XFILLER_53_282 VDD VDD VSS VSS gf180mcu_fd_sc_mcu7t5v0__fillcap_32
XFILLER_42_53 VDD VDD VSS VSS gf180mcu_fd_sc_mcu7t5v0__fillcap_16
XTAP_TAPCELL_ROW_79_804 VDD VSS gf180mcu_fd_sc_mcu7t5v0__filltie
XFILLER_67_72 VDD VDD VSS VSS gf180mcu_fd_sc_mcu7t5v0__fillcap_64
XFILLER_3_58 VDD VDD VSS VSS gf180mcu_fd_sc_mcu7t5v0__fillcap_8
XFILLER_1_540 VDD VDD VSS VSS gf180mcu_fd_sc_mcu7t5v0__fillcap_4
XFILLER_1_562 VDD VDD VSS VSS gf180mcu_fd_sc_mcu7t5v0__fillcap_4
X_0983_ _0983_/A1 wire568/Z _1219_/B1 _1497_/Q _0984_/A4 VDD VDD VSS VSS gf180mcu_fd_sc_mcu7t5v0__aoi22_2
XFILLER_32_488 VDD VDD VSS VSS gf180mcu_fd_sc_mcu7t5v0__fill_2
Xoutput469 _1592_/Q spi_miso_oe VDD VDD VSS VSS gf180mcu_fd_sc_mcu7t5v0__buf_2
X_1535_ _1535_/D _1545_/RN clkload9/I _1535_/Q VDD VDD VSS VSS gf180mcu_fd_sc_mcu7t5v0__dffrnq_1
Xoutput447 _1520_/Q cfg_phase90_offset_y[11] VDD VDD VSS VSS gf180mcu_fd_sc_mcu7t5v0__buf_2
Xoutput458 _1511_/Q cfg_phase90_offset_y[2] VDD VDD VSS VSS gf180mcu_fd_sc_mcu7t5v0__buf_2
X_1604_ _1604_/D _1646_/RN _1674_/CLK _1604_/Q VDD VDD VSS VSS gf180mcu_fd_sc_mcu7t5v0__dffrnq_2
Xoutput414 _1526_/Q cfg_phase270_offset_y[1] VDD VDD VSS VSS gf180mcu_fd_sc_mcu7t5v0__buf_2
Xoutput425 _1669_/Q cfg_phase90_offset_x[10] VDD VDD VSS VSS gf180mcu_fd_sc_mcu7t5v0__buf_2
Xoutput403 _1525_/Q cfg_phase270_offset_y[0] VDD VDD VSS VSS gf180mcu_fd_sc_mcu7t5v0__buf_2
Xoutput436 _1658_/Q cfg_phase90_offset_x[20] VDD VDD VSS VSS gf180mcu_fd_sc_mcu7t5v0__buf_2
XFILLER_67_352 VDD VDD VSS VSS gf180mcu_fd_sc_mcu7t5v0__fillcap_4
X_1466_ _1466_/I0 _1534_/Q _1466_/S _1534_/D VDD VDD VSS VSS gf180mcu_fd_sc_mcu7t5v0__mux2_2
X_1397_ _1397_/A1 _1400_/S _1397_/B _1478_/D VDD VDD VSS VSS gf180mcu_fd_sc_mcu7t5v0__aoi21_1
XFILLER_50_241 VDD VDD VSS VSS gf180mcu_fd_sc_mcu7t5v0__fillcap_4
XFILLER_35_282 VDD VDD VSS VSS gf180mcu_fd_sc_mcu7t5v0__fill_2
XFILLER_23_422 VDD VDD VSS VSS gf180mcu_fd_sc_mcu7t5v0__fillcap_8
XFILLER_12_45 VDD VDD VSS VSS gf180mcu_fd_sc_mcu7t5v0__fill_1
Xwire508 _1406_/S _1407_/S VDD VDD VSS VSS gf180mcu_fd_sc_mcu7t5v0__clkbuf_2
XFILLER_58_363 VDD VDD VSS VSS gf180mcu_fd_sc_mcu7t5v0__fillcap_4
XFILLER_37_97 VDD VDD VSS VSS gf180mcu_fd_sc_mcu7t5v0__fill_2
XFILLER_53_85 VDD VDD VSS VSS gf180mcu_fd_sc_mcu7t5v0__fill_2
XFILLER_5_142 VDD VDD VSS VSS gf180mcu_fd_sc_mcu7t5v0__fillcap_64
X_1320_ wire733/Z _1320_/I1 _1320_/S _1637_/D VDD VDD VSS VSS gf180mcu_fd_sc_mcu7t5v0__mux2_2
XFILLER_76_171 VDD VDD VSS VSS gf180mcu_fd_sc_mcu7t5v0__fillcap_4
XFILLER_64_333 VDD VDD VSS VSS gf180mcu_fd_sc_mcu7t5v0__fill_2
X_1182_ _1152_/S _1180_/Z _1182_/A3 _1182_/B _1573_/D VDD VDD VSS VSS gf180mcu_fd_sc_mcu7t5v0__oai31_1
XFILLER_49_352 VDD VDD VSS VSS gf180mcu_fd_sc_mcu7t5v0__fill_2
XFILLER_49_330 VDD VDD VSS VSS gf180mcu_fd_sc_mcu7t5v0__fillcap_4
X_1251_ _1578_/Q _1254_/A2 _1252_/B VDD VDD VSS VSS gf180mcu_fd_sc_mcu7t5v0__nand2_1
XFILLER_64_399 VDD VDD VSS VSS gf180mcu_fd_sc_mcu7t5v0__fill_2
XTAP_TAPCELL_ROW_47_553 VDD VSS gf180mcu_fd_sc_mcu7t5v0__filltie
XFILLER_32_263 VDD VDD VSS VSS gf180mcu_fd_sc_mcu7t5v0__fill_1
X_0966_ _1552_/Q _1550_/Q _1551_/Q _0968_/A2 VDD VDD VSS VSS gf180mcu_fd_sc_mcu7t5v0__nor3_4
X_0897_ _0897_/A1 _0924_/A2 _1025_/B1 VDD VDD VSS VSS gf180mcu_fd_sc_mcu7t5v0__nor2_2
XFILLER_9_470 VDD VDD VSS VSS gf180mcu_fd_sc_mcu7t5v0__fillcap_4
XFILLER_9_492 VDD VDD VSS VSS gf180mcu_fd_sc_mcu7t5v0__fillcap_4
X_1518_ _1518_/D _1520_/RN clkload4/I _1518_/Q VDD VDD VSS VSS gf180mcu_fd_sc_mcu7t5v0__dffrnq_1
X_1449_ _1520_/Q _1454_/S _1450_/B VDD VDD VSS VSS gf180mcu_fd_sc_mcu7t5v0__nand2_1
XTAP_TAPCELL_ROW_81_832 VDD VSS gf180mcu_fd_sc_mcu7t5v0__filltie
XTAP_TAPCELL_ROW_81_821 VDD VSS gf180mcu_fd_sc_mcu7t5v0__filltie
XFILLER_70_325 VDD VDD VSS VSS gf180mcu_fd_sc_mcu7t5v0__fillcap_4
XTAP_TAPCELL_ROW_2_189 VDD VSS gf180mcu_fd_sc_mcu7t5v0__filltie
XFILLER_51_550 VDD VDD VSS VSS gf180mcu_fd_sc_mcu7t5v0__fillcap_4
XFILLER_11_403 VDD VDD VSS VSS gf180mcu_fd_sc_mcu7t5v0__fill_2
XFILLER_78_403 VDD VDD VSS VSS gf180mcu_fd_sc_mcu7t5v0__fillcap_8
XFILLER_2_101 VDD VDD VSS VSS gf180mcu_fd_sc_mcu7t5v0__fillcap_4
XFILLER_46_366 VDD VDD VSS VSS gf180mcu_fd_sc_mcu7t5v0__fillcap_16
X_0820_ _1565_/Q _0822_/B _0820_/B1 _1559_/Q _0820_/C _0821_/I VDD VDD VSS VSS gf180mcu_fd_sc_mcu7t5v0__oai221_1
Xmax_cap605 _1091_/A2 _1120_/A2 VDD VDD VSS VSS gf180mcu_fd_sc_mcu7t5v0__buf_4
XFILLER_6_451 VDD VDD VSS VSS gf180mcu_fd_sc_mcu7t5v0__fillcap_4
X_0751_ _1579_/Q _1428_/A1 _1455_/A2 VDD VDD VSS VSS gf180mcu_fd_sc_mcu7t5v0__nor2_4
Xwire861 wire863/Z wire861/Z VDD VDD VSS VSS gf180mcu_fd_sc_mcu7t5v0__buf_1
Xload_slew822 _1571_/RN _1569_/RN VDD VDD VSS VSS gf180mcu_fd_sc_mcu7t5v0__buf_2
Xload_slew800 _1679_/RN _1481_/RN VDD VDD VSS VSS gf180mcu_fd_sc_mcu7t5v0__clkbuf_2
XFILLER_29_2 VDD VDD VSS VSS gf180mcu_fd_sc_mcu7t5v0__fill_2
Xload_slew866 wire867/Z fanout847/I VDD VDD VSS VSS gf180mcu_fd_sc_mcu7t5v0__clkbuf_1
Xload_slew833 _1493_/RN _1629_/RN VDD VDD VSS VSS gf180mcu_fd_sc_mcu7t5v0__clkbuf_2
Xload_slew855 _1521_/RN _1520_/RN VDD VDD VSS VSS gf180mcu_fd_sc_mcu7t5v0__clkbuf_1
X_1303_ _1624_/Q wire710/Z _1303_/S _1624_/D VDD VDD VSS VSS gf180mcu_fd_sc_mcu7t5v0__mux2_2
Xload_slew844 _1509_/RN wire843/I VDD VDD VSS VSS gf180mcu_fd_sc_mcu7t5v0__buf_2
Xload_slew877 wire876/I _1594_/RN VDD VDD VSS VSS gf180mcu_fd_sc_mcu7t5v0__clkbuf_1
XFILLER_64_174 VDD VDD VSS VSS gf180mcu_fd_sc_mcu7t5v0__fill_1
XFILLER_64_185 VDD VDD VSS VSS gf180mcu_fd_sc_mcu7t5v0__fillcap_4
X_1096_ _1096_/A1 _1096_/A2 _1109_/A3 VDD VDD VSS VSS gf180mcu_fd_sc_mcu7t5v0__nor2_1
XFILLER_52_325 VDD VDD VSS VSS gf180mcu_fd_sc_mcu7t5v0__fill_1
X_1234_ _1234_/A1 wire570/I _1234_/B1 _1234_/B2 _1236_/A3 VDD VDD VSS VSS gf180mcu_fd_sc_mcu7t5v0__aoi22_1
X_1165_ _1165_/A1 _1188_/A2 _1165_/B1 _1472_/Q _1166_/A2 VDD VDD VSS VSS gf180mcu_fd_sc_mcu7t5v0__aoi22_1
XFILLER_20_244 VDD VDD VSS VSS gf180mcu_fd_sc_mcu7t5v0__fill_1
X_0949_ _0949_/A1 wire598/Z _1202_/A2 _1475_/Q wire499/I VDD VDD VSS VSS gf180mcu_fd_sc_mcu7t5v0__aoi22_4
XTAP_TAPCELL_ROW_58_637 VDD VSS gf180mcu_fd_sc_mcu7t5v0__filltie
XFILLER_70_177 VDD VDD VSS VSS gf180mcu_fd_sc_mcu7t5v0__fillcap_64
XTAP_TAPCELL_ROW_41_504 VDD VSS gf180mcu_fd_sc_mcu7t5v0__filltie
XFILLER_34_10 VDD VDD VSS VSS gf180mcu_fd_sc_mcu7t5v0__fill_2
XFILLER_50_31 VDD VDD VSS VSS gf180mcu_fd_sc_mcu7t5v0__fillcap_4
XFILLER_59_40 VDD VDD VSS VSS gf180mcu_fd_sc_mcu7t5v0__fillcap_16
XFILLER_75_72 VDD VDD VSS VSS gf180mcu_fd_sc_mcu7t5v0__fillcap_64
XFILLER_42_380 VDD VDD VSS VSS gf180mcu_fd_sc_mcu7t5v0__fillcap_4
XFILLER_42_391 VDD VDD VSS VSS gf180mcu_fd_sc_mcu7t5v0__fill_2
XFILLER_30_531 VDD VDD VSS VSS gf180mcu_fd_sc_mcu7t5v0__fill_1
XFILLER_22_509 VDD VDD VSS VSS gf180mcu_fd_sc_mcu7t5v0__fill_1
X_0803_ _1555_/Q _1554_/Q _0803_/Z VDD VDD VSS VSS gf180mcu_fd_sc_mcu7t5v0__and2_2
X_0734_ _1576_/Q _0771_/A1 VDD VDD VSS VSS gf180mcu_fd_sc_mcu7t5v0__clkinv_1
XTAP_TAPCELL_ROW_12_272 VDD VSS gf180mcu_fd_sc_mcu7t5v0__filltie
Xload_slew663 wire667/Z _0829_/S VDD VDD VSS VSS gf180mcu_fd_sc_mcu7t5v0__clkbuf_2
Xload_slew641 wire642/Z _1014_/A1 VDD VDD VSS VSS gf180mcu_fd_sc_mcu7t5v0__clkbuf_1
Xload_slew630 _0897_/A1 _0884_/A1 VDD VDD VSS VSS gf180mcu_fd_sc_mcu7t5v0__clkbuf_1
Xload_slew652 _0924_/A1 _0885_/A1 VDD VDD VSS VSS gf180mcu_fd_sc_mcu7t5v0__buf_2
Xload_slew696 _1654_/Q _0951_/B2 VDD VDD VSS VSS gf180mcu_fd_sc_mcu7t5v0__buf_2
XTAP_TAPCELL_ROW_4_207 VDD VSS gf180mcu_fd_sc_mcu7t5v0__filltie
XTAP_TAPCELL_ROW_55_618 VDD VSS gf180mcu_fd_sc_mcu7t5v0__filltie
X_1148_ _1537_/Q _1217_/A2 _1234_/B1 _1148_/B2 _1149_/A4 VDD VDD VSS VSS gf180mcu_fd_sc_mcu7t5v0__aoi22_1
XFILLER_40_317 VDD VDD VSS VSS gf180mcu_fd_sc_mcu7t5v0__fillcap_32
XFILLER_37_185 VDD VDD VSS VSS gf180mcu_fd_sc_mcu7t5v0__fill_2
X_1217_ _1540_/Q _1217_/A2 _1217_/B1 _1217_/B2 _1236_/A1 VDD VDD VSS VSS gf180mcu_fd_sc_mcu7t5v0__aoi22_1
X_1079_ _1491_/Q _1143_/B1 _1079_/B1 _1486_/Q _1081_/A3 VDD VDD VSS VSS gf180mcu_fd_sc_mcu7t5v0__aoi22_2
XFILLER_80_497 VDD VDD VSS VSS gf180mcu_fd_sc_mcu7t5v0__fillcap_16
Xinput303 votes_out_phase_y[1] _0999_/A1 VDD VDD VSS VSS gf180mcu_fd_sc_mcu7t5v0__buf_1
XFILLER_20_34 VDD VDD VSS VSS gf180mcu_fd_sc_mcu7t5v0__fill_1
XFILLER_16_314 VDD VDD VSS VSS gf180mcu_fd_sc_mcu7t5v0__fill_1
XFILLER_71_486 VDD VDD VSS VSS gf180mcu_fd_sc_mcu7t5v0__fillcap_4
XFILLER_43_188 VDD VDD VSS VSS gf180mcu_fd_sc_mcu7t5v0__fillcap_8
XFILLER_43_122 VDD VDD VSS VSS gf180mcu_fd_sc_mcu7t5v0__fill_1
XFILLER_24_391 VDD VDD VSS VSS gf180mcu_fd_sc_mcu7t5v0__fill_1
XTAP_TAPCELL_ROW_26_386 VDD VSS gf180mcu_fd_sc_mcu7t5v0__filltie
XFILLER_81_206 VDD VDD VSS VSS gf180mcu_fd_sc_mcu7t5v0__fillcap_16
XFILLER_66_247 VDD VDD VSS VSS gf180mcu_fd_sc_mcu7t5v0__fillcap_8
XFILLER_62_475 VDD VDD VSS VSS gf180mcu_fd_sc_mcu7t5v0__fill_1
XFILLER_47_483 VDD VDD VSS VSS gf180mcu_fd_sc_mcu7t5v0__fillcap_4
X_1002_ input46/Z _1229_/A2 wire553/Z _1002_/B2 _1005_/A2 VDD VDD VSS VSS gf180mcu_fd_sc_mcu7t5v0__aoi22_1
XFILLER_34_155 VDD VDD VSS VSS gf180mcu_fd_sc_mcu7t5v0__fill_2
XFILLER_34_111 VDD VDD VSS VSS gf180mcu_fd_sc_mcu7t5v0__fill_1
XFILLER_19_174 VDD VDD VSS VSS gf180mcu_fd_sc_mcu7t5v0__fillcap_16
XTAP_TAPCELL_ROW_60_654 VDD VSS gf180mcu_fd_sc_mcu7t5v0__filltie
XFILLER_34_177 VDD VDD VSS VSS gf180mcu_fd_sc_mcu7t5v0__fillcap_8
XFILLER_22_317 VDD VDD VSS VSS gf180mcu_fd_sc_mcu7t5v0__fillcap_8
XTAP_TAPCELL_ROW_68_721 VDD VSS gf180mcu_fd_sc_mcu7t5v0__filltie
XFILLER_57_258 VDD VDD VSS VSS gf180mcu_fd_sc_mcu7t5v0__fill_1
Xload_slew482 _1416_/S _1417_/S VDD VDD VSS VSS gf180mcu_fd_sc_mcu7t5v0__buf_4
XTAP_TAPCELL_ROW_23_356 VDD VSS gf180mcu_fd_sc_mcu7t5v0__filltie
Xinput122 cal_phase90_offset_y[20] _1134_/B2 VDD VDD VSS VSS gf180mcu_fd_sc_mcu7t5v0__buf_1
Xinput100 cal_phase90_offset_x[1] _0986_/C2 VDD VDD VSS VSS gf180mcu_fd_sc_mcu7t5v0__buf_1
Xinput111 cal_phase90_offset_y[10] _1046_/C2 VDD VDD VSS VSS gf180mcu_fd_sc_mcu7t5v0__buf_1
Xinput144 delay_wave_cycle_y[3] _1098_/C2 VDD VDD VSS VSS gf180mcu_fd_sc_mcu7t5v0__buf_1
Xinput133 delay_wave_cycle_x[0] _0929_/B2 VDD VDD VSS VSS gf180mcu_fd_sc_mcu7t5v0__buf_2
XTAP_TAPCELL_ROW_74_768 VDD VSS gf180mcu_fd_sc_mcu7t5v0__filltie
Xinput155 phase_state_y[0] _1036_/A1 VDD VDD VSS VSS gf180mcu_fd_sc_mcu7t5v0__buf_1
XFILLER_56_280 VDD VDD VSS VSS gf180mcu_fd_sc_mcu7t5v0__fill_2
XFILLER_48_247 VDD VDD VSS VSS gf180mcu_fd_sc_mcu7t5v0__fillcap_8
Xinput199 raw_edge2_x[0] _0940_/C2 VDD VDD VSS VSS gf180mcu_fd_sc_mcu7t5v0__buf_1
Xinput188 raw_edge1_y[19] _1098_/A1 VDD VDD VSS VSS gf180mcu_fd_sc_mcu7t5v0__buf_1
Xinput177 raw_edge1_x[9] _0988_/C1 VDD VDD VSS VSS gf180mcu_fd_sc_mcu7t5v0__buf_1
Xinput166 raw_edge1_x[18] _1051_/B2 VDD VDD VSS VSS gf180mcu_fd_sc_mcu7t5v0__buf_1
XFILLER_12_383 VDD VDD VSS VSS gf180mcu_fd_sc_mcu7t5v0__fill_2
XFILLER_16_177 VDD VDD VSS VSS gf180mcu_fd_sc_mcu7t5v0__fillcap_8
X_1551_ _1551_/D wire871/I _1597_/CLK _1551_/Q VDD VDD VSS VSS gf180mcu_fd_sc_mcu7t5v0__dffrnq_2
X_1482_ _1482_/D _1677_/RN clkload3/I _1482_/Q VDD VDD VSS VSS gf180mcu_fd_sc_mcu7t5v0__dffrnq_1
XFILLER_8_387 VDD VDD VSS VSS gf180mcu_fd_sc_mcu7t5v0__fillcap_64
X_1620_ _1620_/D _1626_/RN clkload6/I _1620_/Q VDD VDD VSS VSS gf180mcu_fd_sc_mcu7t5v0__dffrnq_2
XTAP_TAPCELL_ROW_20_337 VDD VSS gf180mcu_fd_sc_mcu7t5v0__filltie
Xfanout856 wire863/I _1531_/RN VDD VDD VSS VSS gf180mcu_fd_sc_mcu7t5v0__dlyb_1
Xfanout845 fanout847/I _1526_/RN VDD VDD VSS VSS gf180mcu_fd_sc_mcu7t5v0__dlyb_1
Xfanout878 _1560_/RN wire880/I VDD VDD VSS VSS gf180mcu_fd_sc_mcu7t5v0__dlyb_1
XFILLER_73_548 VDD VDD VSS VSS gf180mcu_fd_sc_mcu7t5v0__fillcap_4
XFILLER_45_228 VDD VDD VSS VSS gf180mcu_fd_sc_mcu7t5v0__fillcap_4
XFILLER_26_33 VDD VDD VSS VSS gf180mcu_fd_sc_mcu7t5v0__fill_2
XFILLER_41_489 VDD VDD VSS VSS gf180mcu_fd_sc_mcu7t5v0__fill_1
XFILLER_13_136 VDD VDD VSS VSS gf180mcu_fd_sc_mcu7t5v0__fillcap_4
XFILLER_5_346 VDD VDD VSS VSS gf180mcu_fd_sc_mcu7t5v0__fillcap_4
XTAP_TAPCELL_ROW_79_805 VDD VSS gf180mcu_fd_sc_mcu7t5v0__filltie
XFILLER_49_534 VDD VDD VSS VSS gf180mcu_fd_sc_mcu7t5v0__fill_1
XFILLER_3_26 VDD VDD VSS VSS gf180mcu_fd_sc_mcu7t5v0__fillcap_32
XFILLER_64_537 VDD VDD VSS VSS gf180mcu_fd_sc_mcu7t5v0__fill_1
XFILLER_51_209 VDD VDD VSS VSS gf180mcu_fd_sc_mcu7t5v0__fill_1
X_0982_ _0982_/A1 _1099_/A2 _1056_/B1 input76/Z _0984_/A3 VDD VDD VSS VSS gf180mcu_fd_sc_mcu7t5v0__aoi22_2
X_1465_ wire774/I _1533_/Q _1466_/S _1533_/D VDD VDD VSS VSS gf180mcu_fd_sc_mcu7t5v0__mux2_2
X_1534_ _1534_/D wire861/Z _1587_/CLK _1534_/Q VDD VDD VSS VSS gf180mcu_fd_sc_mcu7t5v0__dffrnq_1
Xoutput415 _1545_/Q cfg_phase270_offset_y[20] VDD VDD VSS VSS gf180mcu_fd_sc_mcu7t5v0__buf_2
Xoutput437 _1661_/Q cfg_phase90_offset_x[2] VDD VDD VSS VSS gf180mcu_fd_sc_mcu7t5v0__buf_2
Xoutput459 _1512_/Q cfg_phase90_offset_y[3] VDD VDD VSS VSS gf180mcu_fd_sc_mcu7t5v0__buf_2
X_1603_ _1603_/D wire786/Z _1670_/CLK _1603_/Q VDD VDD VSS VSS gf180mcu_fd_sc_mcu7t5v0__dffrnq_1
Xoutput426 _1670_/Q cfg_phase90_offset_x[11] VDD VDD VSS VSS gf180mcu_fd_sc_mcu7t5v0__buf_2
Xoutput448 _1521_/Q cfg_phase90_offset_y[12] VDD VDD VSS VSS gf180mcu_fd_sc_mcu7t5v0__buf_2
Xoutput404 _1535_/Q cfg_phase270_offset_y[10] VDD VDD VSS VSS gf180mcu_fd_sc_mcu7t5v0__buf_2
XFILLER_55_559 VDD VDD VSS VSS gf180mcu_fd_sc_mcu7t5v0__fill_1
XFILLER_42_209 VDD VDD VSS VSS gf180mcu_fd_sc_mcu7t5v0__fillcap_4
X_1396_ _1478_/Q _1401_/S _1397_/B VDD VDD VSS VSS gf180mcu_fd_sc_mcu7t5v0__nor2_1
XTAP_TAPCELL_ROW_33_440 VDD VSS gf180mcu_fd_sc_mcu7t5v0__filltie
XFILLER_73_378 VDD VDD VSS VSS gf180mcu_fd_sc_mcu7t5v0__fill_1
XFILLER_41_220 VDD VDD VSS VSS gf180mcu_fd_sc_mcu7t5v0__fillcap_4
XFILLER_14_467 VDD VDD VSS VSS gf180mcu_fd_sc_mcu7t5v0__fill_2
XFILLER_68_139 VDD VDD VSS VSS gf180mcu_fd_sc_mcu7t5v0__fillcap_8
X_1181_ _1572_/Q _1245_/A2 _1182_/A3 VDD VDD VSS VSS gf180mcu_fd_sc_mcu7t5v0__nor2_1
XFILLER_52_518 VDD VDD VSS VSS gf180mcu_fd_sc_mcu7t5v0__fill_1
XFILLER_49_342 VDD VDD VSS VSS gf180mcu_fd_sc_mcu7t5v0__fillcap_8
XTAP_TAPCELL_ROW_47_554 VDD VSS gf180mcu_fd_sc_mcu7t5v0__filltie
X_1250_ _1250_/A1 _1254_/A2 _1250_/B _1577_/D VDD VDD VSS VSS gf180mcu_fd_sc_mcu7t5v0__oai21_1
XFILLER_20_437 VDD VDD VSS VSS gf180mcu_fd_sc_mcu7t5v0__fill_2
X_0896_ _0896_/A1 _0908_/A2 _0935_/C1 VDD VDD VSS VSS gf180mcu_fd_sc_mcu7t5v0__nor2_4
X_0965_ _0937_/Z _0965_/A2 _0965_/A3 _0964_/Z _0969_/A2 VDD VDD VSS VSS gf180mcu_fd_sc_mcu7t5v0__nor4_2
XFILLER_59_139 VDD VDD VSS VSS gf180mcu_fd_sc_mcu7t5v0__fill_1
X_1517_ _1517_/D _1522_/RN _1624_/CLK _1517_/Q VDD VDD VSS VSS gf180mcu_fd_sc_mcu7t5v0__dffrnq_1
X_1448_ wire746/Z _1448_/I1 _1448_/S _1519_/D VDD VDD VSS VSS gf180mcu_fd_sc_mcu7t5v0__mux2_2
XTAP_TAPCELL_ROW_81_833 VDD VSS gf180mcu_fd_sc_mcu7t5v0__filltie
XTAP_TAPCELL_ROW_81_822 VDD VSS gf180mcu_fd_sc_mcu7t5v0__filltie
X_1379_ _1678_/Q _1381_/S _1380_/B VDD VDD VSS VSS gf180mcu_fd_sc_mcu7t5v0__nor2_1
XFILLER_15_209 VDD VDD VSS VSS gf180mcu_fd_sc_mcu7t5v0__fill_1
XFILLER_51_573 VDD VDD VSS VSS gf180mcu_fd_sc_mcu7t5v0__fill_1
XFILLER_11_426 VDD VDD VSS VSS gf180mcu_fd_sc_mcu7t5v0__fill_2
XFILLER_23_67 VDD VDD VSS VSS gf180mcu_fd_sc_mcu7t5v0__fill_2
XFILLER_73_142 VDD VDD VSS VSS gf180mcu_fd_sc_mcu7t5v0__fillcap_64
XFILLER_46_301 VDD VDD VSS VSS gf180mcu_fd_sc_mcu7t5v0__fillcap_8
Xfanout472 wire476/Z _1255_/S VDD VDD VSS VSS gf180mcu_fd_sc_mcu7t5v0__dlyb_1
XTAP_TAPCELL_ROW_44_524 VDD VSS gf180mcu_fd_sc_mcu7t5v0__filltie
XFILLER_9_69 VDD VDD VSS VSS gf180mcu_fd_sc_mcu7t5v0__fill_1
XFILLER_14_231 VDD VDD VSS VSS gf180mcu_fd_sc_mcu7t5v0__fillcap_8
XTAP_TAPCELL_ROW_52_590 VDD VSS gf180mcu_fd_sc_mcu7t5v0__filltie
XFILLER_50_6 VDD VDD VSS VSS gf180mcu_fd_sc_mcu7t5v0__fill_1
Xwire840 wire840/I wire840/Z VDD VDD VSS VSS gf180mcu_fd_sc_mcu7t5v0__buf_1
X_0750_ _1576_/Q _1577_/Q _0752_/A2 VDD VDD VSS VSS gf180mcu_fd_sc_mcu7t5v0__nand2_1
Xload_slew823 _1573_/RN _1571_/RN VDD VDD VSS VSS gf180mcu_fd_sc_mcu7t5v0__clkbuf_2
XFILLER_56_109 VDD VDD VSS VSS gf180mcu_fd_sc_mcu7t5v0__fill_1
X_1233_ _1233_/A1 _1233_/A2 _1233_/A3 _1233_/A4 _1243_/A1 VDD VDD VSS VSS gf180mcu_fd_sc_mcu7t5v0__nand4_1
Xload_slew801 _1680_/RN _1679_/RN VDD VDD VSS VSS gf180mcu_fd_sc_mcu7t5v0__buf_1
X_1302_ _1623_/Q _1416_/I1 _1303_/S _1623_/D VDD VDD VSS VSS gf180mcu_fd_sc_mcu7t5v0__mux2_2
Xload_slew812 _1653_/RN _1648_/RN VDD VDD VSS VSS gf180mcu_fd_sc_mcu7t5v0__clkbuf_2
Xload_slew834 _1493_/RN _1485_/RN VDD VDD VSS VSS gf180mcu_fd_sc_mcu7t5v0__clkbuf_1
XFILLER_77_492 VDD VDD VSS VSS gf180mcu_fd_sc_mcu7t5v0__fillcap_64
XFILLER_52_304 VDD VDD VSS VSS gf180mcu_fd_sc_mcu7t5v0__fill_2
X_1164_ input84/Z wire579/Z _1234_/B1 _1164_/B2 wire700/Z _1194_/A2 wire491/I VDD
+ VDD VSS VSS gf180mcu_fd_sc_mcu7t5v0__aoi222_4
X_1095_ _1095_/A1 _1095_/A2 _1095_/A3 wire494/Z _1096_/A2 VDD VDD VSS VSS gf180mcu_fd_sc_mcu7t5v0__nand4_2
X_0948_ _0948_/A1 _0948_/A2 _0948_/A3 _0948_/A4 _0964_/A1 VDD VDD VSS VSS gf180mcu_fd_sc_mcu7t5v0__nand4_1
XFILLER_33_562 VDD VDD VSS VSS gf180mcu_fd_sc_mcu7t5v0__fillcap_4
XTAP_TAPCELL_ROW_15_292 VDD VSS gf180mcu_fd_sc_mcu7t5v0__filltie
X_0879_ _0879_/A1 _0910_/A1 wire568/I VDD VDD VSS VSS gf180mcu_fd_sc_mcu7t5v0__nor2_4
XFILLER_75_418 VDD VDD VSS VSS gf180mcu_fd_sc_mcu7t5v0__fill_2
XFILLER_68_481 VDD VDD VSS VSS gf180mcu_fd_sc_mcu7t5v0__fill_2
XTAP_TAPCELL_ROW_58_638 VDD VSS gf180mcu_fd_sc_mcu7t5v0__filltie
XFILLER_18_34 VDD VDD VSS VSS gf180mcu_fd_sc_mcu7t5v0__fill_1
XFILLER_70_101 VDD VDD VSS VSS gf180mcu_fd_sc_mcu7t5v0__fillcap_4
XFILLER_55_197 VDD VDD VSS VSS gf180mcu_fd_sc_mcu7t5v0__fillcap_8
XTAP_TAPCELL_ROW_41_505 VDD VSS gf180mcu_fd_sc_mcu7t5v0__filltie
XFILLER_34_33 VDD VDD VSS VSS gf180mcu_fd_sc_mcu7t5v0__fill_2
XFILLER_50_43 VDD VDD VSS VSS gf180mcu_fd_sc_mcu7t5v0__fillcap_4
XFILLER_3_422 VDD VDD VSS VSS gf180mcu_fd_sc_mcu7t5v0__fillcap_64
XFILLER_75_40 VDD VDD VSS VSS gf180mcu_fd_sc_mcu7t5v0__fillcap_16
XFILLER_74_473 VDD VDD VSS VSS gf180mcu_fd_sc_mcu7t5v0__fillcap_32
XFILLER_59_492 VDD VDD VSS VSS gf180mcu_fd_sc_mcu7t5v0__fillcap_4
XFILLER_19_345 VDD VDD VSS VSS gf180mcu_fd_sc_mcu7t5v0__fillcap_4
X_0802_ _1562_/Q _0805_/B _0807_/A1 VDD VDD VSS VSS gf180mcu_fd_sc_mcu7t5v0__nand2_1
XFILLER_61_167 VDD VDD VSS VSS gf180mcu_fd_sc_mcu7t5v0__fill_1
XFILLER_30_521 VDD VDD VSS VSS gf180mcu_fd_sc_mcu7t5v0__fillcap_4
XTAP_TAPCELL_ROW_12_273 VDD VSS gf180mcu_fd_sc_mcu7t5v0__filltie
Xload_slew664 wire667/Z _0757_/A4 VDD VDD VSS VSS gf180mcu_fd_sc_mcu7t5v0__clkbuf_1
XFILLER_69_212 VDD VDD VSS VSS gf180mcu_fd_sc_mcu7t5v0__fillcap_64
Xload_slew631 _0904_/A1 _0897_/A1 VDD VDD VSS VSS gf180mcu_fd_sc_mcu7t5v0__clkbuf_1
XFILLER_57_418 VDD VDD VSS VSS gf180mcu_fd_sc_mcu7t5v0__fill_2
Xload_slew653 _0860_/A1 _0924_/A1 VDD VDD VSS VSS gf180mcu_fd_sc_mcu7t5v0__buf_2
Xload_slew620 wire621/Z _0845_/A1 VDD VDD VSS VSS gf180mcu_fd_sc_mcu7t5v0__buf_2
XFILLER_37_142 VDD VDD VSS VSS gf180mcu_fd_sc_mcu7t5v0__fillcap_16
X_1216_ _1516_/Q _1216_/A2 wire536/I _1674_/Q _1244_/A1 VDD VDD VSS VSS gf180mcu_fd_sc_mcu7t5v0__aoi22_1
XTAP_TAPCELL_ROW_4_208 VDD VSS gf180mcu_fd_sc_mcu7t5v0__filltie
Xload_slew697 _1637_/Q _1320_/I1 VDD VDD VSS VSS gf180mcu_fd_sc_mcu7t5v0__buf_2
Xload_slew686 _1397_/A1 wire685/I VDD VDD VSS VSS gf180mcu_fd_sc_mcu7t5v0__buf_1
X_1078_ _1078_/A1 _1078_/A2 wire553/Z _1078_/B2 _1081_/A2 VDD VDD VSS VSS gf180mcu_fd_sc_mcu7t5v0__aoi22_2
XTAP_TAPCELL_ROW_55_619 VDD VSS gf180mcu_fd_sc_mcu7t5v0__filltie
XFILLER_52_101 VDD VDD VSS VSS gf180mcu_fd_sc_mcu7t5v0__fillcap_4
X_1147_ _1637_/Q wire585/I _1147_/B1 _1147_/B2 _1149_/A3 VDD VDD VSS VSS gf180mcu_fd_sc_mcu7t5v0__aoi22_1
XFILLER_37_197 VDD VDD VSS VSS gf180mcu_fd_sc_mcu7t5v0__fillcap_8
Xinput304 votes_out_phase_y[2] _1054_/A1 VDD VDD VSS VSS gf180mcu_fd_sc_mcu7t5v0__buf_1
XFILLER_45_10 VDD VDD VSS VSS gf180mcu_fd_sc_mcu7t5v0__fill_1
XFILLER_28_197 VDD VDD VSS VSS gf180mcu_fd_sc_mcu7t5v0__fill_1
XFILLER_71_454 VDD VDD VSS VSS gf180mcu_fd_sc_mcu7t5v0__fill_1
XFILLER_61_64 VDD VDD VSS VSS gf180mcu_fd_sc_mcu7t5v0__fillcap_4
XTAP_TAPCELL_ROW_26_387 VDD VSS gf180mcu_fd_sc_mcu7t5v0__filltie
XFILLER_39_418 VDD VDD VSS VSS gf180mcu_fd_sc_mcu7t5v0__fill_2
XTAP_TAPCELL_ROW_77_788 VDD VSS gf180mcu_fd_sc_mcu7t5v0__filltie
XFILLER_62_454 VDD VDD VSS VSS gf180mcu_fd_sc_mcu7t5v0__fill_1
X_1001_ _1001_/A1 _1001_/A2 _1001_/A3 _1001_/A4 _1011_/A1 VDD VDD VSS VSS gf180mcu_fd_sc_mcu7t5v0__nand4_2
XTAP_TAPCELL_ROW_17_310 VDD VSS gf180mcu_fd_sc_mcu7t5v0__filltie
XFILLER_19_142 VDD VDD VSS VSS gf180mcu_fd_sc_mcu7t5v0__fillcap_32
XFILLER_22_329 VDD VDD VSS VSS gf180mcu_fd_sc_mcu7t5v0__fill_2
XTAP_TAPCELL_ROW_60_655 VDD VSS gf180mcu_fd_sc_mcu7t5v0__filltie
XTAP_TAPCELL_ROW_68_722 VDD VSS gf180mcu_fd_sc_mcu7t5v0__filltie
Xload_slew483 _1389_/S _1391_/S VDD VDD VSS VSS gf180mcu_fd_sc_mcu7t5v0__clkbuf_4
XFILLER_80_295 VDD VDD VSS VSS gf180mcu_fd_sc_mcu7t5v0__fillcap_8
XFILLER_15_68 VDD VDD VSS VSS gf180mcu_fd_sc_mcu7t5v0__fill_2
XTAP_TAPCELL_ROW_23_357 VDD VSS gf180mcu_fd_sc_mcu7t5v0__filltie
XFILLER_25_134 VDD VDD VSS VSS gf180mcu_fd_sc_mcu7t5v0__fillcap_4
XFILLER_31_67 VDD VDD VSS VSS gf180mcu_fd_sc_mcu7t5v0__fill_2
Xinput156 phase_state_y[1] _1105_/A1 VDD VDD VSS VSS gf180mcu_fd_sc_mcu7t5v0__buf_1
Xinput101 cal_phase90_offset_x[20] _1137_/B2 VDD VDD VSS VSS gf180mcu_fd_sc_mcu7t5v0__buf_1
Xinput112 cal_phase90_offset_y[11] _1080_/A1 VDD VDD VSS VSS gf180mcu_fd_sc_mcu7t5v0__buf_1
Xinput123 cal_phase90_offset_y[2] _1038_/A1 VDD VDD VSS VSS gf180mcu_fd_sc_mcu7t5v0__buf_1
Xinput167 raw_edge1_x[19] _1101_/B2 VDD VDD VSS VSS gf180mcu_fd_sc_mcu7t5v0__buf_1
Xinput134 delay_wave_cycle_x[1] _1000_/A1 VDD VDD VSS VSS gf180mcu_fd_sc_mcu7t5v0__buf_1
Xinput145 delay_wave_cycle_y[4] _1123_/C2 VDD VDD VSS VSS gf180mcu_fd_sc_mcu7t5v0__buf_2
Xinput178 raw_edge1_y[0] _0932_/C2 VDD VDD VSS VSS gf180mcu_fd_sc_mcu7t5v0__buf_1
XTAP_TAPCELL_ROW_74_769 VDD VSS gf180mcu_fd_sc_mcu7t5v0__filltie
XFILLER_56_292 VDD VDD VSS VSS gf180mcu_fd_sc_mcu7t5v0__fillcap_16
XFILLER_56_97 VDD VDD VSS VSS gf180mcu_fd_sc_mcu7t5v0__fillcap_8
XFILLER_56_53 VDD VDD VSS VSS gf180mcu_fd_sc_mcu7t5v0__fill_2
XTAP_TAPCELL_ROW_39_490 VDD VSS gf180mcu_fd_sc_mcu7t5v0__filltie
Xinput189 raw_edge1_y[1] _0972_/B2 VDD VDD VSS VSS gf180mcu_fd_sc_mcu7t5v0__buf_1
XFILLER_29_473 VDD VDD VSS VSS gf180mcu_fd_sc_mcu7t5v0__fill_2
XFILLER_75_8 VDD VDD VSS VSS gf180mcu_fd_sc_mcu7t5v0__fillcap_32
XFILLER_8_311 VDD VDD VSS VSS gf180mcu_fd_sc_mcu7t5v0__fillcap_4
X_1550_ _1550_/D wire876/I clkload7/I _1550_/Q VDD VDD VSS VSS gf180mcu_fd_sc_mcu7t5v0__dffrnq_2
X_1481_ _1481_/D _1481_/RN clkload1/I _1481_/Q VDD VDD VSS VSS gf180mcu_fd_sc_mcu7t5v0__dffrnq_1
XFILLER_67_546 VDD VDD VSS VSS gf180mcu_fd_sc_mcu7t5v0__fill_2
XFILLER_39_204 VDD VDD VSS VSS gf180mcu_fd_sc_mcu7t5v0__fillcap_4
XFILLER_62_273 VDD VDD VSS VSS gf180mcu_fd_sc_mcu7t5v0__fillcap_32
XFILLER_30_181 VDD VDD VSS VSS gf180mcu_fd_sc_mcu7t5v0__fill_2
XPHY_EDGE_ROW_15_Left_97 VDD VSS gf180mcu_fd_sc_mcu7t5v0__endcap
XTAP_TAPCELL_ROW_20_338 VDD VSS gf180mcu_fd_sc_mcu7t5v0__filltie
XFILLER_58_535 VDD VDD VSS VSS gf180mcu_fd_sc_mcu7t5v0__fill_1
Xfanout868 fanout884/I _1593_/RN VDD VDD VSS VSS gf180mcu_fd_sc_mcu7t5v0__dlyb_1
X_1679_ _1679_/D _1679_/RN clkload1/I _1679_/Q VDD VDD VSS VSS gf180mcu_fd_sc_mcu7t5v0__dffrnq_1
XFILLER_81_560 VDD VDD VSS VSS gf180mcu_fd_sc_mcu7t5v0__fill_1
XFILLER_45_207 VDD VDD VSS VSS gf180mcu_fd_sc_mcu7t5v0__fill_2
XTAP_TAPCELL_ROW_36_460 VDD VSS gf180mcu_fd_sc_mcu7t5v0__filltie
XFILLER_26_45 VDD VDD VSS VSS gf180mcu_fd_sc_mcu7t5v0__fill_2
XFILLER_26_454 VDD VDD VSS VSS gf180mcu_fd_sc_mcu7t5v0__fill_1
XFILLER_42_77 VDD VDD VSS VSS gf180mcu_fd_sc_mcu7t5v0__fill_1
XFILLER_41_435 VDD VDD VSS VSS gf180mcu_fd_sc_mcu7t5v0__fill_2
XTAP_TAPCELL_ROW_79_806 VDD VSS gf180mcu_fd_sc_mcu7t5v0__filltie
XFILLER_76_387 VDD VDD VSS VSS gf180mcu_fd_sc_mcu7t5v0__fillcap_16
XFILLER_64_527 VDD VDD VSS VSS gf180mcu_fd_sc_mcu7t5v0__fillcap_8
XFILLER_44_295 VDD VDD VSS VSS gf180mcu_fd_sc_mcu7t5v0__fillcap_8
X_0981_ _1476_/Q _1224_/A2 _1023_/C1 _0981_/B2 _0984_/A2 VDD VDD VSS VSS gf180mcu_fd_sc_mcu7t5v0__aoi22_1
X_1602_ _1602_/D wire786/Z _1670_/CLK _1602_/Q VDD VDD VSS VSS gf180mcu_fd_sc_mcu7t5v0__dffrnq_1
XFILLER_12_181 VDD VDD VSS VSS gf180mcu_fd_sc_mcu7t5v0__fill_1
Xoutput416 _1527_/Q cfg_phase270_offset_y[2] VDD VDD VSS VSS gf180mcu_fd_sc_mcu7t5v0__buf_2
Xoutput405 _1536_/Q cfg_phase270_offset_y[11] VDD VDD VSS VSS gf180mcu_fd_sc_mcu7t5v0__buf_2
X_1533_ _1533_/D wire863/Z _1587_/CLK _1533_/Q VDD VDD VSS VSS gf180mcu_fd_sc_mcu7t5v0__dffrnq_2
X_1464_ _1464_/I0 _1532_/Q _1464_/S _1532_/D VDD VDD VSS VSS gf180mcu_fd_sc_mcu7t5v0__mux2_2
X_1395_ _1477_/Q wire742/Z _1401_/S _1477_/D VDD VDD VSS VSS gf180mcu_fd_sc_mcu7t5v0__mux2_2
Xoutput449 _1522_/Q cfg_phase90_offset_y[13] VDD VDD VSS VSS gf180mcu_fd_sc_mcu7t5v0__buf_2
Xoutput438 _1662_/Q cfg_phase90_offset_x[3] VDD VDD VSS VSS gf180mcu_fd_sc_mcu7t5v0__buf_2
Xoutput427 _1671_/Q cfg_phase90_offset_x[12] VDD VDD VSS VSS gf180mcu_fd_sc_mcu7t5v0__buf_2
XFILLER_67_398 VDD VDD VSS VSS gf180mcu_fd_sc_mcu7t5v0__fill_2
XFILLER_35_262 VDD VDD VSS VSS gf180mcu_fd_sc_mcu7t5v0__fillcap_4
XFILLER_50_221 VDD VDD VSS VSS gf180mcu_fd_sc_mcu7t5v0__fill_2
XFILLER_35_284 VDD VDD VSS VSS gf180mcu_fd_sc_mcu7t5v0__fill_1
XTAP_TAPCELL_ROW_33_441 VDD VSS gf180mcu_fd_sc_mcu7t5v0__filltie
XFILLER_2_317 VDD VDD VSS VSS gf180mcu_fd_sc_mcu7t5v0__fillcap_64
Xfanout643 wire645/Z wire644/I VDD VDD VSS VSS gf180mcu_fd_sc_mcu7t5v0__dlyb_1
XFILLER_46_527 VDD VDD VSS VSS gf180mcu_fd_sc_mcu7t5v0__fill_2
XFILLER_73_368 VDD VDD VSS VSS gf180mcu_fd_sc_mcu7t5v0__fillcap_8
XFILLER_73_346 VDD VDD VSS VSS gf180mcu_fd_sc_mcu7t5v0__fillcap_4
XFILLER_37_99 VDD VDD VSS VSS gf180mcu_fd_sc_mcu7t5v0__fill_1
XFILLER_14_457 VDD VDD VSS VSS gf180mcu_fd_sc_mcu7t5v0__fill_2
XFILLER_68_107 VDD VDD VSS VSS gf180mcu_fd_sc_mcu7t5v0__fillcap_32
XFILLER_64_335 VDD VDD VSS VSS gf180mcu_fd_sc_mcu7t5v0__fill_1
XFILLER_64_313 VDD VDD VSS VSS gf180mcu_fd_sc_mcu7t5v0__fill_2
XFILLER_49_354 VDD VDD VSS VSS gf180mcu_fd_sc_mcu7t5v0__fill_1
XTAP_TAPCELL_ROW_47_555 VDD VSS gf180mcu_fd_sc_mcu7t5v0__filltie
X_1180_ _1180_/A1 _1180_/A2 _1180_/A3 _1180_/A4 _1180_/Z VDD VDD VSS VSS gf180mcu_fd_sc_mcu7t5v0__and4_1
X_0964_ _0964_/A1 _0964_/A2 _0964_/A3 _0964_/A4 _0964_/Z VDD VDD VSS VSS gf180mcu_fd_sc_mcu7t5v0__or4_1
Xclkbuf_leaf_12_clk clkbuf_leaf_9_clk/I clkload6/I VDD VDD VSS VSS gf180mcu_fd_sc_mcu7t5v0__clkbuf_8
X_0895_ _0895_/A1 _0898_/A2 wire551/I VDD VDD VSS VSS gf180mcu_fd_sc_mcu7t5v0__nor2_4
X_1516_ _1516_/D _1525_/RN clkload5/I _1516_/Q VDD VDD VSS VSS gf180mcu_fd_sc_mcu7t5v0__dffrnq_1
XFILLER_55_302 VDD VDD VSS VSS gf180mcu_fd_sc_mcu7t5v0__fillcap_4
X_1378_ _1677_/Q wire742/Z _1378_/S _1677_/D VDD VDD VSS VSS gf180mcu_fd_sc_mcu7t5v0__mux2_2
X_1447_ _1457_/I0 _1518_/Q _1454_/S _1518_/D VDD VDD VSS VSS gf180mcu_fd_sc_mcu7t5v0__mux2_2
XPHY_EDGE_ROW_27_Left_109 VDD VSS gf180mcu_fd_sc_mcu7t5v0__endcap
XTAP_TAPCELL_ROW_81_834 VDD VSS gf180mcu_fd_sc_mcu7t5v0__filltie
XTAP_TAPCELL_ROW_81_823 VDD VSS gf180mcu_fd_sc_mcu7t5v0__filltie
XFILLER_23_243 VDD VDD VSS VSS gf180mcu_fd_sc_mcu7t5v0__fillcap_16
XPHY_EDGE_ROW_36_Left_118 VDD VSS gf180mcu_fd_sc_mcu7t5v0__endcap
XFILLER_23_298 VDD VDD VSS VSS gf180mcu_fd_sc_mcu7t5v0__fill_1
XFILLER_58_151 VDD VDD VSS VSS gf180mcu_fd_sc_mcu7t5v0__fillcap_4
XFILLER_46_357 VDD VDD VSS VSS gf180mcu_fd_sc_mcu7t5v0__fill_1
XFILLER_46_313 VDD VDD VSS VSS gf180mcu_fd_sc_mcu7t5v0__fill_2
XPHY_EDGE_ROW_45_Left_127 VDD VSS gf180mcu_fd_sc_mcu7t5v0__endcap
XPHY_EDGE_ROW_54_Left_136 VDD VSS gf180mcu_fd_sc_mcu7t5v0__endcap
XTAP_TAPCELL_ROW_52_591 VDD VSS gf180mcu_fd_sc_mcu7t5v0__filltie
XTAP_TAPCELL_ROW_44_525 VDD VSS gf180mcu_fd_sc_mcu7t5v0__filltie
XFILLER_9_59 VDD VDD VSS VSS gf180mcu_fd_sc_mcu7t5v0__fillcap_8
XTAP_TAPCELL_ROW_1_180 VDD VSS gf180mcu_fd_sc_mcu7t5v0__filltie
XFILLER_14_243 VDD VDD VSS VSS gf180mcu_fd_sc_mcu7t5v0__fill_2
XFILLER_43_6 VDD VDD VSS VSS gf180mcu_fd_sc_mcu7t5v0__fill_1
Xwire863 wire863/I wire863/Z VDD VDD VSS VSS gf180mcu_fd_sc_mcu7t5v0__buf_1
XFILLER_10_493 VDD VDD VSS VSS gf180mcu_fd_sc_mcu7t5v0__fillcap_4
Xload_slew879 wire880/Z _1584_/RN VDD VDD VSS VSS gf180mcu_fd_sc_mcu7t5v0__buf_1
XPHY_EDGE_ROW_63_Left_145 VDD VSS gf180mcu_fd_sc_mcu7t5v0__endcap
X_1232_ _1232_/A1 wire603/Z wire586/Z _1232_/B2 _1233_/A4 VDD VDD VSS VSS gf180mcu_fd_sc_mcu7t5v0__aoi22_1
Xload_slew857 _1530_/RN _1545_/RN VDD VDD VSS VSS gf180mcu_fd_sc_mcu7t5v0__clkbuf_2
Xload_slew802 _1478_/RN _1680_/RN VDD VDD VSS VSS gf180mcu_fd_sc_mcu7t5v0__buf_1
Xclkbuf_leaf_1_clk clkbuf_leaf_3_clk/I clkload1/I VDD VDD VSS VSS gf180mcu_fd_sc_mcu7t5v0__clkbuf_8
X_1301_ _1622_/Q wire729/Z _1303_/S _1622_/D VDD VDD VSS VSS gf180mcu_fd_sc_mcu7t5v0__mux2_2
Xload_slew813 _1653_/RN _1650_/RN VDD VDD VSS VSS gf180mcu_fd_sc_mcu7t5v0__buf_2
Xload_slew835 _1495_/RN _1494_/RN VDD VDD VSS VSS gf180mcu_fd_sc_mcu7t5v0__clkbuf_2
Xload_slew846 _1526_/RN _1525_/RN VDD VDD VSS VSS gf180mcu_fd_sc_mcu7t5v0__buf_2
XPHY_EDGE_ROW_72_Left_154 VDD VSS gf180mcu_fd_sc_mcu7t5v0__endcap
X_1094_ _1094_/A1 _1234_/B1 wire552/Z _1094_/B2 wire494/I VDD VDD VSS VSS gf180mcu_fd_sc_mcu7t5v0__aoi22_2
XFILLER_33_530 VDD VDD VSS VSS gf180mcu_fd_sc_mcu7t5v0__fill_2
X_1163_ _1643_/Q wire600/Z wire598/I _1163_/B2 _1163_/C _1180_/A3 VDD VDD VSS VSS
+ gf180mcu_fd_sc_mcu7t5v0__aoi221_1
XFILLER_60_371 VDD VDD VSS VSS gf180mcu_fd_sc_mcu7t5v0__fillcap_4
X_0947_ _1533_/Q wire594/Z wire535/Z _0947_/B2 _0948_/A4 VDD VDD VSS VSS gf180mcu_fd_sc_mcu7t5v0__aoi22_1
XTAP_TAPCELL_ROW_15_293 VDD VSS gf180mcu_fd_sc_mcu7t5v0__filltie
XPHY_EDGE_ROW_81_Left_163 VDD VSS gf180mcu_fd_sc_mcu7t5v0__endcap
X_0878_ _0893_/A1 _0878_/A2 wire570/I VDD VDD VSS VSS gf180mcu_fd_sc_mcu7t5v0__nor2_4
XTAP_TAPCELL_ROW_7_228 VDD VSS gf180mcu_fd_sc_mcu7t5v0__filltie
XFILLER_68_471 VDD VDD VSS VSS gf180mcu_fd_sc_mcu7t5v0__fill_1
XTAP_TAPCELL_ROW_58_639 VDD VSS gf180mcu_fd_sc_mcu7t5v0__filltie
XTAP_TAPCELL_ROW_41_506 VDD VSS gf180mcu_fd_sc_mcu7t5v0__filltie
XFILLER_34_89 VDD VDD VSS VSS gf180mcu_fd_sc_mcu7t5v0__fillcap_8
XFILLER_34_56 VDD VDD VSS VSS gf180mcu_fd_sc_mcu7t5v0__fill_1
XFILLER_34_12 VDD VDD VSS VSS gf180mcu_fd_sc_mcu7t5v0__fill_1
XFILLER_7_206 VDD VDD VSS VSS gf180mcu_fd_sc_mcu7t5v0__fillcap_4
XFILLER_11_279 VDD VDD VSS VSS gf180mcu_fd_sc_mcu7t5v0__fill_1
Xclkload0 clkload0/I clkload0/ZN VDD VDD VSS VSS gf180mcu_fd_sc_mcu7t5v0__clkinv_2
XFILLER_59_64 VDD VDD VSS VSS gf180mcu_fd_sc_mcu7t5v0__fillcap_4
XPHY_EDGE_ROW_3_Left_85 VDD VSS gf180mcu_fd_sc_mcu7t5v0__endcap
XFILLER_74_430 VDD VDD VSS VSS gf180mcu_fd_sc_mcu7t5v0__fill_1
XFILLER_15_541 VDD VDD VSS VSS gf180mcu_fd_sc_mcu7t5v0__fill_1
X_0801_ _0801_/I _1555_/D VDD VDD VSS VSS gf180mcu_fd_sc_mcu7t5v0__clkinv_1
XFILLER_42_371 VDD VDD VSS VSS gf180mcu_fd_sc_mcu7t5v0__fill_1
XTAP_TAPCELL_ROW_12_274 VDD VSS gf180mcu_fd_sc_mcu7t5v0__filltie
Xload_slew632 _0896_/A1 _0904_/A1 VDD VDD VSS VSS gf180mcu_fd_sc_mcu7t5v0__buf_2
Xload_slew610 _0923_/A1 _0891_/A2 VDD VDD VSS VSS gf180mcu_fd_sc_mcu7t5v0__buf_4
X_1215_ _1575_/Q wire644/Z _1246_/B VDD VDD VSS VSS gf180mcu_fd_sc_mcu7t5v0__nand2_1
Xload_slew665 _0831_/S _0832_/S VDD VDD VSS VSS gf180mcu_fd_sc_mcu7t5v0__clkbuf_2
Xload_slew654 _0864_/A1 _0860_/A1 VDD VDD VSS VSS gf180mcu_fd_sc_mcu7t5v0__buf_2
Xload_slew676 _0849_/A1 wire675/I VDD VDD VSS VSS gf180mcu_fd_sc_mcu7t5v0__buf_2
X_1146_ _1146_/A1 _1146_/A2 _1146_/A3 _1146_/A4 _1150_/A3 VDD VDD VSS VSS gf180mcu_fd_sc_mcu7t5v0__nand4_1
Xload_slew687 _1397_/A1 _1380_/A1 VDD VDD VSS VSS gf180mcu_fd_sc_mcu7t5v0__clkbuf_1
XTAP_TAPCELL_ROW_4_209 VDD VSS gf180mcu_fd_sc_mcu7t5v0__filltie
XFILLER_65_496 VDD VDD VSS VSS gf180mcu_fd_sc_mcu7t5v0__fill_2
XFILLER_37_187 VDD VDD VSS VSS gf180mcu_fd_sc_mcu7t5v0__fill_1
X_1077_ _1636_/Q wire585/Z _1119_/C1 _1077_/B2 _1095_/A3 VDD VDD VSS VSS gf180mcu_fd_sc_mcu7t5v0__aoi22_1
Xinput305 votes_out_phase_y[3] _1083_/A1 VDD VDD VSS VSS gf180mcu_fd_sc_mcu7t5v0__buf_1
XFILLER_71_422 VDD VDD VSS VSS gf180mcu_fd_sc_mcu7t5v0__fill_2
XFILLER_71_400 VDD VDD VSS VSS gf180mcu_fd_sc_mcu7t5v0__fillcap_4
XFILLER_45_66 VDD VDD VSS VSS gf180mcu_fd_sc_mcu7t5v0__fillcap_4
XFILLER_43_146 VDD VDD VSS VSS gf180mcu_fd_sc_mcu7t5v0__fill_2
XFILLER_28_154 VDD VDD VSS VSS gf180mcu_fd_sc_mcu7t5v0__fill_1
XFILLER_61_32 VDD VDD VSS VSS gf180mcu_fd_sc_mcu7t5v0__fillcap_32
XTAP_TAPCELL_ROW_77_789 VDD VSS gf180mcu_fd_sc_mcu7t5v0__filltie
X_1000_ _1000_/A1 _1000_/A2 _1025_/B1 _1000_/B2 _1001_/A4 VDD VDD VSS VSS gf180mcu_fd_sc_mcu7t5v0__aoi22_4
XTAP_TAPCELL_ROW_60_656 VDD VSS gf180mcu_fd_sc_mcu7t5v0__filltie
XFILLER_15_360 VDD VDD VSS VSS gf180mcu_fd_sc_mcu7t5v0__fill_2
XTAP_TAPCELL_ROW_17_311 VDD VSS gf180mcu_fd_sc_mcu7t5v0__filltie
Xwire490 wire490/I wire490/Z VDD VDD VSS VSS gf180mcu_fd_sc_mcu7t5v0__buf_1
XTAP_TAPCELL_ROW_68_723 VDD VSS gf180mcu_fd_sc_mcu7t5v0__filltie
Xload_slew473 _0762_/I _1254_/A2 VDD VDD VSS VSS gf180mcu_fd_sc_mcu7t5v0__clkbuf_2
XFILLER_80_241 VDD VDD VSS VSS gf180mcu_fd_sc_mcu7t5v0__fillcap_4
XFILLER_65_271 VDD VDD VSS VSS gf180mcu_fd_sc_mcu7t5v0__fill_2
XFILLER_57_238 VDD VDD VSS VSS gf180mcu_fd_sc_mcu7t5v0__fill_2
X_1129_ input17/Z _1129_/A2 wire559/Z _1129_/B2 _1130_/A3 VDD VDD VSS VSS gf180mcu_fd_sc_mcu7t5v0__aoi22_1
XFILLER_25_113 VDD VDD VSS VSS gf180mcu_fd_sc_mcu7t5v0__fillcap_8
XFILLER_40_149 VDD VDD VSS VSS gf180mcu_fd_sc_mcu7t5v0__fillcap_16
XFILLER_21_352 VDD VDD VSS VSS gf180mcu_fd_sc_mcu7t5v0__fillcap_4
XTAP_TAPCELL_ROW_23_358 VDD VSS gf180mcu_fd_sc_mcu7t5v0__filltie
XFILLER_63_208 VDD VDD VSS VSS gf180mcu_fd_sc_mcu7t5v0__fill_2
Xinput113 cal_phase90_offset_y[12] _1147_/B2 VDD VDD VSS VSS gf180mcu_fd_sc_mcu7t5v0__buf_1
Xinput124 cal_phase90_offset_y[3] _1076_/B2 VDD VDD VSS VSS gf180mcu_fd_sc_mcu7t5v0__buf_1
Xinput102 cal_phase90_offset_x[2] _1036_/B2 VDD VDD VSS VSS gf180mcu_fd_sc_mcu7t5v0__buf_1
Xinput157 raw_edge1_x[0] _0949_/A1 VDD VDD VSS VSS gf180mcu_fd_sc_mcu7t5v0__buf_1
Xinput146 delay_wave_cycle_y[5] _1170_/B2 VDD VDD VSS VSS gf180mcu_fd_sc_mcu7t5v0__buf_1
Xinput179 raw_edge1_y[10] _1044_/B2 VDD VDD VSS VSS gf180mcu_fd_sc_mcu7t5v0__buf_1
Xinput168 raw_edge1_x[1] _0993_/B2 VDD VDD VSS VSS gf180mcu_fd_sc_mcu7t5v0__buf_1
Xinput135 delay_wave_cycle_x[2] _1017_/A1 VDD VDD VSS VSS gf180mcu_fd_sc_mcu7t5v0__buf_1
XFILLER_56_282 VDD VDD VSS VSS gf180mcu_fd_sc_mcu7t5v0__fill_1
XTAP_TAPCELL_ROW_39_491 VDD VSS gf180mcu_fd_sc_mcu7t5v0__filltie
XFILLER_31_138 VDD VDD VSS VSS gf180mcu_fd_sc_mcu7t5v0__fill_2
XFILLER_16_113 VDD VDD VSS VSS gf180mcu_fd_sc_mcu7t5v0__fillcap_8
XPHY_EDGE_ROW_19_Right_19 VDD VSS gf180mcu_fd_sc_mcu7t5v0__endcap
XFILLER_79_352 VDD VDD VSS VSS gf180mcu_fd_sc_mcu7t5v0__fillcap_64
XPHY_EDGE_ROW_28_Right_28 VDD VSS gf180mcu_fd_sc_mcu7t5v0__endcap
X_1480_ _1480_/D _1481_/RN clkload1/I _1480_/Q VDD VDD VSS VSS gf180mcu_fd_sc_mcu7t5v0__dffrnq_1
XFILLER_47_282 VDD VDD VSS VSS gf180mcu_fd_sc_mcu7t5v0__fillcap_16
XPHY_EDGE_ROW_37_Right_37 VDD VSS gf180mcu_fd_sc_mcu7t5v0__endcap
XTAP_TAPCELL_ROW_20_339 VDD VSS gf180mcu_fd_sc_mcu7t5v0__filltie
XPHY_EDGE_ROW_46_Right_46 VDD VSS gf180mcu_fd_sc_mcu7t5v0__endcap
X_1678_ _1678_/D _1678_/RN clkload1/I _1678_/Q VDD VDD VSS VSS gf180mcu_fd_sc_mcu7t5v0__dffrnq_1
XPHY_EDGE_ROW_55_Right_55 VDD VSS gf180mcu_fd_sc_mcu7t5v0__endcap
Xfanout803 wire824/Z wire805/I VDD VDD VSS VSS gf180mcu_fd_sc_mcu7t5v0__dlyb_1
Xfanout847 fanout847/I _1632_/RN VDD VDD VSS VSS gf180mcu_fd_sc_mcu7t5v0__dlyb_1
XTAP_TAPCELL_ROW_36_461 VDD VSS gf180mcu_fd_sc_mcu7t5v0__filltie
XPHY_EDGE_ROW_64_Right_64 VDD VSS gf180mcu_fd_sc_mcu7t5v0__endcap
XFILLER_42_34 VDD VDD VSS VSS gf180mcu_fd_sc_mcu7t5v0__fill_1
XTAP_TAPCELL_ROW_79_807 VDD VSS gf180mcu_fd_sc_mcu7t5v0__filltie
XFILLER_76_311 VDD VDD VSS VSS gf180mcu_fd_sc_mcu7t5v0__fillcap_4
XPHY_EDGE_ROW_73_Right_73 VDD VSS gf180mcu_fd_sc_mcu7t5v0__endcap
XFILLER_44_241 VDD VDD VSS VSS gf180mcu_fd_sc_mcu7t5v0__fillcap_4
XFILLER_29_282 VDD VDD VSS VSS gf180mcu_fd_sc_mcu7t5v0__fill_2
XFILLER_17_422 VDD VDD VSS VSS gf180mcu_fd_sc_mcu7t5v0__fillcap_16
X_0980_ _1639_/Q wire600/I _0980_/B1 _0980_/B2 _0984_/A1 VDD VDD VSS VSS gf180mcu_fd_sc_mcu7t5v0__aoi22_1
XFILLER_12_171 VDD VDD VSS VSS gf180mcu_fd_sc_mcu7t5v0__fillcap_4
X_1532_ _1532_/D _1543_/RN clkload9/I _1532_/Q VDD VDD VSS VSS gf180mcu_fd_sc_mcu7t5v0__dffrnq_1
X_1601_ _1601_/D wire785/Z _1670_/CLK _1601_/Q VDD VDD VSS VSS gf180mcu_fd_sc_mcu7t5v0__dffrnq_1
Xoutput439 _1663_/Q cfg_phase90_offset_x[4] VDD VDD VSS VSS gf180mcu_fd_sc_mcu7t5v0__buf_2
Xoutput428 _1672_/Q cfg_phase90_offset_x[13] VDD VDD VSS VSS gf180mcu_fd_sc_mcu7t5v0__buf_2
Xoutput406 _1537_/Q cfg_phase270_offset_y[12] VDD VDD VSS VSS gf180mcu_fd_sc_mcu7t5v0__buf_2
Xoutput417 _1528_/Q cfg_phase270_offset_y[3] VDD VDD VSS VSS gf180mcu_fd_sc_mcu7t5v0__buf_2
XFILLER_67_344 VDD VDD VSS VSS gf180mcu_fd_sc_mcu7t5v0__fillcap_4
X_1463_ wire720/I _1531_/Q _1464_/S _1531_/D VDD VDD VSS VSS gf180mcu_fd_sc_mcu7t5v0__mux2_2
X_1394_ _1476_/Q wire762/Z _1401_/S _1476_/D VDD VDD VSS VSS gf180mcu_fd_sc_mcu7t5v0__mux2_2
XFILLER_4_381 VDD VDD VSS VSS gf180mcu_fd_sc_mcu7t5v0__fillcap_4
XFILLER_55_528 VDD VDD VSS VSS gf180mcu_fd_sc_mcu7t5v0__fill_2
XFILLER_50_233 VDD VDD VSS VSS gf180mcu_fd_sc_mcu7t5v0__fillcap_8
XTAP_TAPCELL_ROW_33_442 VDD VSS gf180mcu_fd_sc_mcu7t5v0__filltie
Xfanout622 _0843_/Z _0893_/A2 VDD VDD VSS VSS gf180mcu_fd_sc_mcu7t5v0__dlyb_1
Xfanout688 _1460_/A1 wire690/I VDD VDD VSS VSS gf180mcu_fd_sc_mcu7t5v0__dlyb_1
XFILLER_53_44 VDD VDD VSS VSS gf180mcu_fd_sc_mcu7t5v0__fillcap_16
XFILLER_41_200 VDD VDD VSS VSS gf180mcu_fd_sc_mcu7t5v0__fillcap_8
XFILLER_49_322 VDD VDD VSS VSS gf180mcu_fd_sc_mcu7t5v0__fillcap_8
XFILLER_49_311 VDD VDD VSS VSS gf180mcu_fd_sc_mcu7t5v0__fill_2
XFILLER_64_303 VDD VDD VSS VSS gf180mcu_fd_sc_mcu7t5v0__fill_2
XFILLER_32_222 VDD VDD VSS VSS gf180mcu_fd_sc_mcu7t5v0__fillcap_4
XFILLER_17_274 VDD VDD VSS VSS gf180mcu_fd_sc_mcu7t5v0__fillcap_4
X_0894_ _0894_/A1 _0910_/A1 wire552/I VDD VDD VSS VSS gf180mcu_fd_sc_mcu7t5v0__nor2_4
X_0963_ _0963_/A1 _0963_/A2 _0963_/A3 _0963_/A4 _0964_/A4 VDD VDD VSS VSS gf180mcu_fd_sc_mcu7t5v0__nand4_1
XFILLER_32_244 VDD VDD VSS VSS gf180mcu_fd_sc_mcu7t5v0__fill_1
XTAP_TAPCELL_ROW_30_412 VDD VSS gf180mcu_fd_sc_mcu7t5v0__filltie
X_1515_ _1515_/D _1515_/RN clkload4/I _1515_/Q VDD VDD VSS VSS gf180mcu_fd_sc_mcu7t5v0__dffrnq_2
X_1377_ _1676_/Q wire754/Z _1381_/S _1676_/D VDD VDD VSS VSS gf180mcu_fd_sc_mcu7t5v0__mux2_2
X_1446_ _1446_/I0 _1517_/Q _1454_/S _1517_/D VDD VDD VSS VSS gf180mcu_fd_sc_mcu7t5v0__mux2_2
XTAP_TAPCELL_ROW_81_835 VDD VSS gf180mcu_fd_sc_mcu7t5v0__filltie
XTAP_TAPCELL_ROW_81_824 VDD VSS gf180mcu_fd_sc_mcu7t5v0__filltie
XFILLER_70_317 VDD VDD VSS VSS gf180mcu_fd_sc_mcu7t5v0__fillcap_8
XFILLER_51_520 VDD VDD VSS VSS gf180mcu_fd_sc_mcu7t5v0__fill_2
XFILLER_11_428 VDD VDD VSS VSS gf180mcu_fd_sc_mcu7t5v0__fill_1
XFILLER_23_36 VDD VDD VSS VSS gf180mcu_fd_sc_mcu7t5v0__fill_1
XFILLER_23_69 VDD VDD VSS VSS gf180mcu_fd_sc_mcu7t5v0__fill_1
XFILLER_58_130 VDD VDD VSS VSS gf180mcu_fd_sc_mcu7t5v0__fillcap_8
XFILLER_48_22 VDD VDD VSS VSS gf180mcu_fd_sc_mcu7t5v0__fillcap_4
XTAP_TAPCELL_ROW_44_526 VDD VSS gf180mcu_fd_sc_mcu7t5v0__filltie
XFILLER_0_18 VDD VDD VSS VSS gf180mcu_fd_sc_mcu7t5v0__fillcap_16
XTAP_TAPCELL_ROW_1_181 VDD VSS gf180mcu_fd_sc_mcu7t5v0__filltie
XTAP_TAPCELL_ROW_52_592 VDD VSS gf180mcu_fd_sc_mcu7t5v0__filltie
Xload_slew814 _1637_/RN _1653_/RN VDD VDD VSS VSS gf180mcu_fd_sc_mcu7t5v0__clkbuf_2
Xload_slew825 wire824/I _1573_/RN VDD VDD VSS VSS gf180mcu_fd_sc_mcu7t5v0__clkbuf_1
X_1231_ input11/Z _1231_/A2 wire511/I input44/Z _1233_/A3 VDD VDD VSS VSS gf180mcu_fd_sc_mcu7t5v0__aoi22_1
X_1162_ _1162_/A1 _1162_/A2 _1162_/A3 _1163_/C VDD VDD VSS VSS gf180mcu_fd_sc_mcu7t5v0__nand3_1
Xload_slew858 _1530_/RN _1543_/RN VDD VDD VSS VSS gf180mcu_fd_sc_mcu7t5v0__buf_2
Xload_slew869 _1593_/RN _1582_/RN VDD VDD VSS VSS gf180mcu_fd_sc_mcu7t5v0__clkbuf_1
X_1300_ _1621_/Q _1424_/I0 _1303_/S _1621_/D VDD VDD VSS VSS gf180mcu_fd_sc_mcu7t5v0__mux2_2
Xload_slew836 _1495_/RN _1493_/RN VDD VDD VSS VSS gf180mcu_fd_sc_mcu7t5v0__clkbuf_1
XFILLER_64_177 VDD VDD VSS VSS gf180mcu_fd_sc_mcu7t5v0__fillcap_8
XFILLER_64_155 VDD VDD VSS VSS gf180mcu_fd_sc_mcu7t5v0__fill_2
X_1093_ _1093_/A1 wire496/Z _1093_/A3 _1093_/A4 _1096_/A1 VDD VDD VSS VSS gf180mcu_fd_sc_mcu7t5v0__nand4_1
XFILLER_52_317 VDD VDD VSS VSS gf180mcu_fd_sc_mcu7t5v0__fillcap_8
XFILLER_33_542 VDD VDD VSS VSS gf180mcu_fd_sc_mcu7t5v0__fill_2
X_0877_ _0893_/A1 _0840_/Z _1105_/A2 VDD VDD VSS VSS gf180mcu_fd_sc_mcu7t5v0__nor2_4
X_0946_ _0946_/A1 _1112_/A2 wire541/Z _0946_/B2 _0948_/A3 VDD VDD VSS VSS gf180mcu_fd_sc_mcu7t5v0__aoi22_4
XTAP_TAPCELL_ROW_15_294 VDD VSS gf180mcu_fd_sc_mcu7t5v0__filltie
XFILLER_20_236 VDD VDD VSS VSS gf180mcu_fd_sc_mcu7t5v0__fillcap_8
XFILLER_20_247 VDD VDD VSS VSS gf180mcu_fd_sc_mcu7t5v0__fill_2
XTAP_TAPCELL_ROW_7_229 VDD VSS gf180mcu_fd_sc_mcu7t5v0__filltie
X_1429_ _1504_/Q wire771/Z _1434_/S _1504_/D VDD VDD VSS VSS gf180mcu_fd_sc_mcu7t5v0__mux2_2
XFILLER_55_166 VDD VDD VSS VSS gf180mcu_fd_sc_mcu7t5v0__fill_1
XTAP_TAPCELL_ROW_41_507 VDD VSS gf180mcu_fd_sc_mcu7t5v0__filltie
Xclkload1 clkload1/I clkload1/Z VDD VDD VSS VSS gf180mcu_fd_sc_mcu7t5v0__clkbuf_2
XFILLER_24_542 VDD VDD VSS VSS gf180mcu_fd_sc_mcu7t5v0__fill_2
XFILLER_59_10 VDD VDD VSS VSS gf180mcu_fd_sc_mcu7t5v0__fill_2
XFILLER_78_247 VDD VDD VSS VSS gf180mcu_fd_sc_mcu7t5v0__fillcap_64
XFILLER_75_64 VDD VDD VSS VSS gf180mcu_fd_sc_mcu7t5v0__fillcap_4
XFILLER_59_483 VDD VDD VSS VSS gf180mcu_fd_sc_mcu7t5v0__fillcap_4
XFILLER_61_136 VDD VDD VSS VSS gf180mcu_fd_sc_mcu7t5v0__fillcap_4
XFILLER_46_177 VDD VDD VSS VSS gf180mcu_fd_sc_mcu7t5v0__fillcap_16
XFILLER_34_339 VDD VDD VSS VSS gf180mcu_fd_sc_mcu7t5v0__fill_1
XFILLER_34_317 VDD VDD VSS VSS gf180mcu_fd_sc_mcu7t5v0__fillcap_4
X_0800_ _1555_/Q _0782_/B _0825_/B2 _0799_/Z _0805_/B _1561_/Q _0801_/I VDD VDD VSS
+ VSS gf180mcu_fd_sc_mcu7t5v0__aoi222_2
XTAP_TAPCELL_ROW_12_275 VDD VSS gf180mcu_fd_sc_mcu7t5v0__filltie
Xload_slew666 wire667/Z _0831_/S VDD VDD VSS VSS gf180mcu_fd_sc_mcu7t5v0__buf_2
Xload_slew655 _0824_/A2 _0864_/A1 VDD VDD VSS VSS gf180mcu_fd_sc_mcu7t5v0__buf_2
Xload_slew633 _0890_/A1 _0896_/A1 VDD VDD VSS VSS gf180mcu_fd_sc_mcu7t5v0__buf_2
Xload_slew611 _0922_/A2 _0857_/A1 VDD VDD VSS VSS gf180mcu_fd_sc_mcu7t5v0__buf_2
XFILLER_80_423 VDD VDD VSS VSS gf180mcu_fd_sc_mcu7t5v0__fillcap_16
X_1214_ wire644/Z _1212_/Z _1214_/A3 _1214_/B _1574_/D VDD VDD VSS VSS gf180mcu_fd_sc_mcu7t5v0__oai31_1
Xload_slew677 _0839_/A2 _0849_/A1 VDD VDD VSS VSS gf180mcu_fd_sc_mcu7t5v0__buf_2
X_1145_ _1145_/A1 wire586/Z _1229_/B1 _1663_/Q _1146_/A4 VDD VDD VSS VSS gf180mcu_fd_sc_mcu7t5v0__aoi22_1
XFILLER_37_177 VDD VDD VSS VSS gf180mcu_fd_sc_mcu7t5v0__fillcap_8
XFILLER_37_166 VDD VDD VSS VSS gf180mcu_fd_sc_mcu7t5v0__fill_2
XFILLER_1_50 VDD VDD VSS VSS gf180mcu_fd_sc_mcu7t5v0__fillcap_16
XFILLER_1_72 VDD VDD VSS VSS gf180mcu_fd_sc_mcu7t5v0__fillcap_64
Xload_slew699 _1615_/Q _1194_/A1 VDD VDD VSS VSS gf180mcu_fd_sc_mcu7t5v0__buf_2
XTAP_TAPCELL_ROW_63_676 VDD VSS gf180mcu_fd_sc_mcu7t5v0__filltie
XFILLER_60_191 VDD VDD VSS VSS gf180mcu_fd_sc_mcu7t5v0__fillcap_16
X_1076_ _1512_/Q _1159_/A2 _1227_/B1 _1076_/B2 wire496/I VDD VDD VSS VSS gf180mcu_fd_sc_mcu7t5v0__aoi22_2
X_0929_ _1504_/Q _0929_/A2 _0929_/B1 _0929_/B2 _0929_/C1 wire552/Z wire502/I VDD VDD
+ VSS VSS gf180mcu_fd_sc_mcu7t5v0__aoi222_4
XFILLER_75_206 VDD VDD VSS VSS gf180mcu_fd_sc_mcu7t5v0__fillcap_4
XFILLER_71_478 VDD VDD VSS VSS gf180mcu_fd_sc_mcu7t5v0__fillcap_8
XTAP_TAPCELL_ROW_54_610 VDD VSS gf180mcu_fd_sc_mcu7t5v0__filltie
XFILLER_28_177 VDD VDD VSS VSS gf180mcu_fd_sc_mcu7t5v0__fill_1
XFILLER_16_317 VDD VDD VSS VSS gf180mcu_fd_sc_mcu7t5v0__fillcap_8
XFILLER_8_527 VDD VDD VSS VSS gf180mcu_fd_sc_mcu7t5v0__fill_1
XFILLER_79_556 VDD VDD VSS VSS gf180mcu_fd_sc_mcu7t5v0__fillcap_4
XFILLER_3_276 VDD VDD VSS VSS gf180mcu_fd_sc_mcu7t5v0__fillcap_4
XFILLER_10_92 VDD VDD VSS VSS gf180mcu_fd_sc_mcu7t5v0__fillcap_8
XFILLER_39_409 VDD VDD VSS VSS gf180mcu_fd_sc_mcu7t5v0__fill_1
XTAP_TAPCELL_ROW_17_312 VDD VSS gf180mcu_fd_sc_mcu7t5v0__filltie
XTAP_TAPCELL_ROW_60_657 VDD VSS gf180mcu_fd_sc_mcu7t5v0__filltie
Xwire480 _1261_/S _1268_/S VDD VDD VSS VSS gf180mcu_fd_sc_mcu7t5v0__buf_1
Xwire491 wire491/I wire491/Z VDD VDD VSS VSS gf180mcu_fd_sc_mcu7t5v0__clkbuf_1
Xload_slew474 _1255_/S _0762_/I VDD VDD VSS VSS gf180mcu_fd_sc_mcu7t5v0__buf_2
Xload_slew485 _1372_/S _1371_/S VDD VDD VSS VSS gf180mcu_fd_sc_mcu7t5v0__buf_2
X_1128_ _1128_/A1 _1199_/B1 wire553/Z _1128_/B2 _1128_/C1 input80/Z _1130_/A2 VDD
+ VDD VSS VSS gf180mcu_fd_sc_mcu7t5v0__aoi222_2
X_1059_ _1059_/A1 _1059_/A2 _1059_/A3 _1059_/A4 _1059_/Z VDD VDD VSS VSS gf180mcu_fd_sc_mcu7t5v0__or4_1
XFILLER_25_125 VDD VDD VSS VSS gf180mcu_fd_sc_mcu7t5v0__fill_2
XFILLER_25_169 VDD VDD VSS VSS gf180mcu_fd_sc_mcu7t5v0__fill_1
XFILLER_40_139 VDD VDD VSS VSS gf180mcu_fd_sc_mcu7t5v0__fill_1
XFILLER_21_320 VDD VDD VSS VSS gf180mcu_fd_sc_mcu7t5v0__fillcap_4
XTAP_TAPCELL_ROW_23_359 VDD VSS gf180mcu_fd_sc_mcu7t5v0__filltie
XFILLER_31_69 VDD VDD VSS VSS gf180mcu_fd_sc_mcu7t5v0__fill_1
XFILLER_76_559 VDD VDD VSS VSS gf180mcu_fd_sc_mcu7t5v0__fill_2
Xinput114 cal_phase90_offset_y[13] _1169_/C1 VDD VDD VSS VSS gf180mcu_fd_sc_mcu7t5v0__buf_2
Xinput125 cal_phase90_offset_y[4] _1123_/A1 VDD VDD VSS VSS gf180mcu_fd_sc_mcu7t5v0__buf_1
Xinput103 cal_phase90_offset_x[3] _1070_/A1 VDD VDD VSS VSS gf180mcu_fd_sc_mcu7t5v0__buf_1
XFILLER_56_55 VDD VDD VSS VSS gf180mcu_fd_sc_mcu7t5v0__fill_1
XFILLER_48_239 VDD VDD VSS VSS gf180mcu_fd_sc_mcu7t5v0__fillcap_4
Xinput169 raw_edge1_x[20] _1115_/B2 VDD VDD VSS VSS gf180mcu_fd_sc_mcu7t5v0__buf_1
Xinput158 raw_edge1_x[10] _1021_/A1 VDD VDD VSS VSS gf180mcu_fd_sc_mcu7t5v0__buf_1
Xinput147 delay_wave_cycle_y[6] _1189_/B2 VDD VDD VSS VSS gf180mcu_fd_sc_mcu7t5v0__buf_1
Xinput136 delay_wave_cycle_x[3] _1097_/C2 VDD VDD VSS VSS gf180mcu_fd_sc_mcu7t5v0__buf_1
XFILLER_4_541 VDD VDD VSS VSS gf180mcu_fd_sc_mcu7t5v0__fill_1
XTAP_TAPCELL_ROW_73_760 VDD VSS gf180mcu_fd_sc_mcu7t5v0__filltie
XFILLER_62_242 VDD VDD VSS VSS gf180mcu_fd_sc_mcu7t5v0__fill_2
XFILLER_54_209 VDD VDD VSS VSS gf180mcu_fd_sc_mcu7t5v0__fillcap_16
XFILLER_30_183 VDD VDD VSS VSS gf180mcu_fd_sc_mcu7t5v0__fill_1
XFILLER_15_191 VDD VDD VSS VSS gf180mcu_fd_sc_mcu7t5v0__fillcap_16
X_1677_ _1677_/D _1677_/RN clkload3/I _1677_/Q VDD VDD VSS VSS gf180mcu_fd_sc_mcu7t5v0__dffrnq_2
Xfanout815 _1476_/RN _1661_/RN VDD VDD VSS VSS gf180mcu_fd_sc_mcu7t5v0__dlyb_1
XFILLER_66_570 VDD VDD VSS VSS gf180mcu_fd_sc_mcu7t5v0__fillcap_4
XFILLER_45_209 VDD VDD VSS VSS gf180mcu_fd_sc_mcu7t5v0__fill_1
Xfanout837 _1593_/RN wire840/I VDD VDD VSS VSS gf180mcu_fd_sc_mcu7t5v0__dlyb_1
Xfanout826 _1486_/RN wire829/I VDD VDD VSS VSS gf180mcu_fd_sc_mcu7t5v0__dlyb_1
XFILLER_81_573 VDD VDD VSS VSS gf180mcu_fd_sc_mcu7t5v0__fill_1
XTAP_TAPCELL_ROW_36_462 VDD VSS gf180mcu_fd_sc_mcu7t5v0__filltie
XFILLER_26_434 VDD VDD VSS VSS gf180mcu_fd_sc_mcu7t5v0__fillcap_4
XFILLER_21_183 VDD VDD VSS VSS gf180mcu_fd_sc_mcu7t5v0__fill_2
XTAP_TAPCELL_ROW_79_808 VDD VSS gf180mcu_fd_sc_mcu7t5v0__filltie
XFILLER_64_518 VDD VDD VSS VSS gf180mcu_fd_sc_mcu7t5v0__fillcap_4
XFILLER_36_209 VDD VDD VSS VSS gf180mcu_fd_sc_mcu7t5v0__fillcap_4
XFILLER_17_489 VDD VDD VSS VSS gf180mcu_fd_sc_mcu7t5v0__fill_1
X_1600_ _1600_/D wire880/Z clkload7/I _1600_/Q VDD VDD VSS VSS gf180mcu_fd_sc_mcu7t5v0__dffrnq_1
X_1531_ _1531_/D _1531_/RN clkload9/I _1531_/Q VDD VDD VSS VSS gf180mcu_fd_sc_mcu7t5v0__dffrnq_2
X_1462_ wire729/I _1530_/Q _1464_/S _1530_/D VDD VDD VSS VSS gf180mcu_fd_sc_mcu7t5v0__mux2_2
Xoutput407 _1538_/Q cfg_phase270_offset_y[13] VDD VDD VSS VSS gf180mcu_fd_sc_mcu7t5v0__buf_2
Xoutput429 _1673_/Q cfg_phase90_offset_x[14] VDD VDD VSS VSS gf180mcu_fd_sc_mcu7t5v0__buf_2
Xoutput418 _1529_/Q cfg_phase270_offset_y[4] VDD VDD VSS VSS gf180mcu_fd_sc_mcu7t5v0__buf_2
XFILLER_67_356 VDD VDD VSS VSS gf180mcu_fd_sc_mcu7t5v0__fill_2
X_1393_ _1475_/Q wire768/Z _1400_/S _1475_/D VDD VDD VSS VSS gf180mcu_fd_sc_mcu7t5v0__mux2_2
XFILLER_50_223 VDD VDD VSS VSS gf180mcu_fd_sc_mcu7t5v0__fill_1
XFILLER_35_275 VDD VDD VSS VSS gf180mcu_fd_sc_mcu7t5v0__fillcap_4
XTAP_TAPCELL_ROW_33_443 VDD VSS gf180mcu_fd_sc_mcu7t5v0__filltie
Xfanout612 _0843_/Z wire621/I VDD VDD VSS VSS gf180mcu_fd_sc_mcu7t5v0__dlyb_1
Xfanout656 _0823_/ZN _0878_/A2 VDD VDD VSS VSS gf180mcu_fd_sc_mcu7t5v0__dlyb_1
XFILLER_46_529 VDD VDD VSS VSS gf180mcu_fd_sc_mcu7t5v0__fill_1
XFILLER_46_507 VDD VDD VSS VSS gf180mcu_fd_sc_mcu7t5v0__fill_2
XFILLER_39_570 VDD VDD VSS VSS gf180mcu_fd_sc_mcu7t5v0__fillcap_4
XFILLER_18_209 VDD VDD VSS VSS gf180mcu_fd_sc_mcu7t5v0__fill_2
XFILLER_81_392 VDD VDD VSS VSS gf180mcu_fd_sc_mcu7t5v0__fill_1
XFILLER_41_212 VDD VDD VSS VSS gf180mcu_fd_sc_mcu7t5v0__fillcap_8
XFILLER_49_334 VDD VDD VSS VSS gf180mcu_fd_sc_mcu7t5v0__fill_2
XFILLER_1_352 VDD VDD VSS VSS gf180mcu_fd_sc_mcu7t5v0__fillcap_64
X_0893_ _0893_/A1 _0893_/A2 wire553/I VDD VDD VSS VSS gf180mcu_fd_sc_mcu7t5v0__nor2_4
X_0962_ _0962_/A1 wire553/Z wire536/Z _1667_/Q _0963_/A4 VDD VDD VSS VSS gf180mcu_fd_sc_mcu7t5v0__aoi22_1
XTAP_TAPCELL_ROW_30_413 VDD VSS gf180mcu_fd_sc_mcu7t5v0__filltie
XFILLER_9_474 VDD VDD VSS VSS gf180mcu_fd_sc_mcu7t5v0__fill_1
XFILLER_9_496 VDD VDD VSS VSS gf180mcu_fd_sc_mcu7t5v0__fill_1
XFILLER_13_492 VDD VDD VSS VSS gf180mcu_fd_sc_mcu7t5v0__fillcap_4
X_1514_ _1514_/D _1515_/RN _1624_/CLK _1514_/Q VDD VDD VSS VSS gf180mcu_fd_sc_mcu7t5v0__dffrnq_1
X_1445_ _0749_/Z _0771_/Z _1445_/A3 _1448_/S VDD VDD VSS VSS gf180mcu_fd_sc_mcu7t5v0__nand3_4
XFILLER_67_142 VDD VDD VSS VSS gf180mcu_fd_sc_mcu7t5v0__fillcap_16
XFILLER_55_348 VDD VDD VSS VSS gf180mcu_fd_sc_mcu7t5v0__fill_2
XFILLER_55_315 VDD VDD VSS VSS gf180mcu_fd_sc_mcu7t5v0__fillcap_4
X_1376_ _1675_/Q wire768/Z _1381_/S _1675_/D VDD VDD VSS VSS gf180mcu_fd_sc_mcu7t5v0__mux2_2
XTAP_TAPCELL_ROW_81_825 VDD VSS gf180mcu_fd_sc_mcu7t5v0__filltie
XFILLER_70_329 VDD VDD VSS VSS gf180mcu_fd_sc_mcu7t5v0__fill_2
XFILLER_51_532 VDD VDD VSS VSS gf180mcu_fd_sc_mcu7t5v0__fill_2
XFILLER_51_510 VDD VDD VSS VSS gf180mcu_fd_sc_mcu7t5v0__fill_1
XFILLER_58_142 VDD VDD VSS VSS gf180mcu_fd_sc_mcu7t5v0__fill_1
XFILLER_48_45 VDD VDD VSS VSS gf180mcu_fd_sc_mcu7t5v0__fillcap_4
Xfanout475 _1266_/S _1265_/S VDD VDD VSS VSS gf180mcu_fd_sc_mcu7t5v0__dlyb_1
XFILLER_61_318 VDD VDD VSS VSS gf180mcu_fd_sc_mcu7t5v0__fillcap_16
XTAP_TAPCELL_ROW_44_527 VDD VSS gf180mcu_fd_sc_mcu7t5v0__filltie
XFILLER_27_562 VDD VDD VSS VSS gf180mcu_fd_sc_mcu7t5v0__fillcap_4
XTAP_TAPCELL_ROW_1_182 VDD VSS gf180mcu_fd_sc_mcu7t5v0__filltie
Xwire876 wire876/I wire876/Z VDD VDD VSS VSS gf180mcu_fd_sc_mcu7t5v0__clkbuf_2
XTAP_TAPCELL_ROW_52_593 VDD VSS gf180mcu_fd_sc_mcu7t5v0__filltie
Xwire843 wire843/I wire843/Z VDD VDD VSS VSS gf180mcu_fd_sc_mcu7t5v0__buf_1
Xwire865 wire867/Z wire865/Z VDD VDD VSS VSS gf180mcu_fd_sc_mcu7t5v0__buf_1
Xwire887 wire887/I wire887/Z VDD VDD VSS VSS gf180mcu_fd_sc_mcu7t5v0__buf_1
Xload_slew804 wire805/Z _1479_/RN VDD VDD VSS VSS gf180mcu_fd_sc_mcu7t5v0__clkbuf_2
Xload_slew848 _1497_/RN _1503_/RN VDD VDD VSS VSS gf180mcu_fd_sc_mcu7t5v0__buf_2
XFILLER_64_101 VDD VDD VSS VSS gf180mcu_fd_sc_mcu7t5v0__fillcap_4
X_1092_ input15/Z _1129_/A2 _1092_/B1 input99/Z _1093_/A4 VDD VDD VSS VSS gf180mcu_fd_sc_mcu7t5v0__aoi22_1
XFILLER_49_142 VDD VDD VSS VSS gf180mcu_fd_sc_mcu7t5v0__fillcap_64
X_1230_ input23/Z _1230_/A2 wire559/Z _1230_/B2 _1233_/A2 VDD VDD VSS VSS gf180mcu_fd_sc_mcu7t5v0__aoi22_1
X_1161_ input72/Z _1219_/A2 wire541/Z _1161_/B2 _1162_/A3 VDD VDD VSS VSS gf180mcu_fd_sc_mcu7t5v0__aoi22_1
Xload_slew859 _1531_/RN _1530_/RN VDD VDD VSS VSS gf180mcu_fd_sc_mcu7t5v0__clkbuf_2
XFILLER_33_532 VDD VDD VSS VSS gf180mcu_fd_sc_mcu7t5v0__fill_1
XTAP_TAPCELL_ROW_15_295 VDD VSS gf180mcu_fd_sc_mcu7t5v0__filltie
X_0945_ _1638_/Q _1199_/A2 _1127_/A2 _0945_/B2 _0948_/A2 VDD VDD VSS VSS gf180mcu_fd_sc_mcu7t5v0__aoi22_1
X_0876_ wire675/I _0913_/A2 _1224_/A2 VDD VDD VSS VSS gf180mcu_fd_sc_mcu7t5v0__nor2_4
XFILLER_9_282 VDD VDD VSS VSS gf180mcu_fd_sc_mcu7t5v0__fillcap_32
X_1428_ _1428_/A1 _0749_/Z _1428_/A3 _1434_/S VDD VDD VSS VSS gf180mcu_fd_sc_mcu7t5v0__and3_2
XFILLER_51_340 VDD VDD VSS VSS gf180mcu_fd_sc_mcu7t5v0__fill_2
XFILLER_36_381 VDD VDD VSS VSS gf180mcu_fd_sc_mcu7t5v0__fillcap_4
X_1359_ _1664_/Q _1399_/I1 _1361_/S _1664_/D VDD VDD VSS VSS gf180mcu_fd_sc_mcu7t5v0__mux2_2
Xclkload2 clkload2/I clkload2/ZN VDD VDD VSS VSS gf180mcu_fd_sc_mcu7t5v0__inv_4
XFILLER_59_88 VDD VDD VSS VSS gf180mcu_fd_sc_mcu7t5v0__fillcap_4
XTAP_TAPCELL_ROW_57_630 VDD VSS gf180mcu_fd_sc_mcu7t5v0__filltie
XFILLER_42_384 VDD VDD VSS VSS gf180mcu_fd_sc_mcu7t5v0__fill_1
XFILLER_40_90 VDD VDD VSS VSS gf180mcu_fd_sc_mcu7t5v0__fillcap_4
XFILLER_6_241 VDD VDD VSS VSS gf180mcu_fd_sc_mcu7t5v0__fillcap_4
XFILLER_10_292 VDD VDD VSS VSS gf180mcu_fd_sc_mcu7t5v0__fillcap_16
X_1213_ _1573_/Q _1245_/A2 _1214_/A3 VDD VDD VSS VSS gf180mcu_fd_sc_mcu7t5v0__nor2_1
Xload_slew634 _0894_/A1 _0890_/A1 VDD VDD VSS VSS gf180mcu_fd_sc_mcu7t5v0__buf_2
Xload_slew601 _1222_/A2 _1198_/A2 VDD VDD VSS VSS gf180mcu_fd_sc_mcu7t5v0__buf_2
Xload_slew678 _0865_/A2 _0839_/A2 VDD VDD VSS VSS gf180mcu_fd_sc_mcu7t5v0__buf_2
Xload_slew623 _0909_/A2 _0895_/A1 VDD VDD VSS VSS gf180mcu_fd_sc_mcu7t5v0__buf_2
Xload_slew689 wire690/Z _1440_/A1 VDD VDD VSS VSS gf180mcu_fd_sc_mcu7t5v0__buf_2
XFILLER_52_115 VDD VDD VSS VSS gf180mcu_fd_sc_mcu7t5v0__fillcap_4
X_1144_ _0967_/Z _1144_/A2 _1144_/A3 _1144_/A4 _1150_/A2 VDD VDD VSS VSS gf180mcu_fd_sc_mcu7t5v0__nand4_1
X_1075_ _1075_/A1 wire598/I _1221_/A2 input82/Z _1095_/A2 VDD VDD VSS VSS gf180mcu_fd_sc_mcu7t5v0__aoi22_1
XTAP_TAPCELL_ROW_63_677 VDD VSS gf180mcu_fd_sc_mcu7t5v0__filltie
X_0859_ _1555_/Q _1248_/A1 _0812_/Z _0911_/A2 VDD VDD VSS VSS gf180mcu_fd_sc_mcu7t5v0__nand3_2
X_0928_ input1/Z _1199_/B1 _1154_/B1 _0928_/B2 _0931_/A2 VDD VDD VSS VSS gf180mcu_fd_sc_mcu7t5v0__aoi22_1
XFILLER_56_465 VDD VDD VSS VSS gf180mcu_fd_sc_mcu7t5v0__fillcap_4
XTAP_TAPCELL_ROW_3_200 VDD VSS gf180mcu_fd_sc_mcu7t5v0__filltie
XFILLER_71_424 VDD VDD VSS VSS gf180mcu_fd_sc_mcu7t5v0__fill_1
XTAP_TAPCELL_ROW_54_611 VDD VSS gf180mcu_fd_sc_mcu7t5v0__filltie
XFILLER_43_148 VDD VDD VSS VSS gf180mcu_fd_sc_mcu7t5v0__fill_1
XFILLER_43_104 VDD VDD VSS VSS gf180mcu_fd_sc_mcu7t5v0__fillcap_16
XFILLER_12_535 VDD VDD VSS VSS gf180mcu_fd_sc_mcu7t5v0__fillcap_4
XFILLER_59_292 VDD VDD VSS VSS gf180mcu_fd_sc_mcu7t5v0__fillcap_4
XFILLER_47_487 VDD VDD VSS VSS gf180mcu_fd_sc_mcu7t5v0__fill_2
XTAP_TAPCELL_ROW_17_313 VDD VSS gf180mcu_fd_sc_mcu7t5v0__filltie
XFILLER_19_123 VDD VDD VSS VSS gf180mcu_fd_sc_mcu7t5v0__fill_1
XTAP_TAPCELL_ROW_60_658 VDD VSS gf180mcu_fd_sc_mcu7t5v0__filltie
XFILLER_30_332 VDD VDD VSS VSS gf180mcu_fd_sc_mcu7t5v0__fill_1
XFILLER_15_362 VDD VDD VSS VSS gf180mcu_fd_sc_mcu7t5v0__fill_1
Xwire470 wire470/I wire470/Z VDD VDD VSS VSS gf180mcu_fd_sc_mcu7t5v0__clkbuf_1
Xwire492 wire492/I wire492/Z VDD VDD VSS VSS gf180mcu_fd_sc_mcu7t5v0__clkbuf_2
Xwire481 _1424_/S _1427_/S VDD VDD VSS VSS gf180mcu_fd_sc_mcu7t5v0__clkbuf_4
XPHY_EDGE_ROW_69_Left_151 VDD VSS gf180mcu_fd_sc_mcu7t5v0__endcap
XTAP_TAPCELL_ROW_76_780 VDD VSS gf180mcu_fd_sc_mcu7t5v0__filltie
XFILLER_65_273 VDD VDD VSS VSS gf180mcu_fd_sc_mcu7t5v0__fill_1
X_1127_ _1127_/A1 _1127_/A2 wire520/Z _1461_/I1 _1679_/Q wire575/Z _1130_/A1 VDD VDD
+ VSS VSS gf180mcu_fd_sc_mcu7t5v0__aoi222_2
X_1058_ _1058_/A1 _1058_/A2 _1058_/A3 _1058_/A4 _1059_/A4 VDD VDD VSS VSS gf180mcu_fd_sc_mcu7t5v0__nand4_2
XFILLER_40_107 VDD VDD VSS VSS gf180mcu_fd_sc_mcu7t5v0__fillcap_32
XPHY_EDGE_ROW_78_Left_160 VDD VSS gf180mcu_fd_sc_mcu7t5v0__endcap
XFILLER_33_192 VDD VDD VSS VSS gf180mcu_fd_sc_mcu7t5v0__fillcap_8
XFILLER_21_398 VDD VDD VSS VSS gf180mcu_fd_sc_mcu7t5v0__fillcap_4
Xinput115 cal_phase90_offset_y[14] _1197_/A1 VDD VDD VSS VSS gf180mcu_fd_sc_mcu7t5v0__buf_1
Xinput126 cal_phase90_offset_y[5] _1165_/A1 VDD VDD VSS VSS gf180mcu_fd_sc_mcu7t5v0__buf_1
Xinput104 cal_phase90_offset_x[4] _1124_/A1 VDD VDD VSS VSS gf180mcu_fd_sc_mcu7t5v0__buf_1
XFILLER_48_207 VDD VDD VSS VSS gf180mcu_fd_sc_mcu7t5v0__fillcap_4
XPHY_EDGE_ROW_1_Right_1 VDD VSS gf180mcu_fd_sc_mcu7t5v0__endcap
XFILLER_76_527 VDD VDD VSS VSS gf180mcu_fd_sc_mcu7t5v0__fillcap_32
XFILLER_56_45 VDD VDD VSS VSS gf180mcu_fd_sc_mcu7t5v0__fillcap_8
Xinput159 raw_edge1_x[11] _1070_/B2 VDD VDD VSS VSS gf180mcu_fd_sc_mcu7t5v0__buf_1
XFILLER_29_498 VDD VDD VSS VSS gf180mcu_fd_sc_mcu7t5v0__fill_2
Xinput148 delay_wave_cycle_y[7] _1241_/B2 VDD VDD VSS VSS gf180mcu_fd_sc_mcu7t5v0__buf_1
Xinput137 delay_wave_cycle_x[4] _1133_/A1 VDD VDD VSS VSS gf180mcu_fd_sc_mcu7t5v0__buf_1
XFILLER_71_276 VDD VDD VSS VSS gf180mcu_fd_sc_mcu7t5v0__fillcap_4
XFILLER_31_129 VDD VDD VSS VSS gf180mcu_fd_sc_mcu7t5v0__fill_1
XFILLER_12_321 VDD VDD VSS VSS gf180mcu_fd_sc_mcu7t5v0__fill_1
XFILLER_12_365 VDD VDD VSS VSS gf180mcu_fd_sc_mcu7t5v0__fillcap_4
XFILLER_12_387 VDD VDD VSS VSS gf180mcu_fd_sc_mcu7t5v0__fillcap_32
XFILLER_24_192 VDD VDD VSS VSS gf180mcu_fd_sc_mcu7t5v0__fill_1
XTAP_TAPCELL_ROW_73_761 VDD VSS gf180mcu_fd_sc_mcu7t5v0__filltie
XFILLER_62_210 VDD VDD VSS VSS gf180mcu_fd_sc_mcu7t5v0__fillcap_32
XFILLER_30_162 VDD VDD VSS VSS gf180mcu_fd_sc_mcu7t5v0__fillcap_4
XFILLER_7_72 VDD VDD VSS VSS gf180mcu_fd_sc_mcu7t5v0__fillcap_64
X_1676_ _1676_/D _1676_/RN clkload2/I _1676_/Q VDD VDD VSS VSS gf180mcu_fd_sc_mcu7t5v0__dffrnq_1
XFILLER_53_232 VDD VDD VSS VSS gf180mcu_fd_sc_mcu7t5v0__fill_1
XFILLER_38_295 VDD VDD VSS VSS gf180mcu_fd_sc_mcu7t5v0__fillcap_4
XFILLER_42_69 VDD VDD VSS VSS gf180mcu_fd_sc_mcu7t5v0__fillcap_8
XTAP_TAPCELL_ROW_36_463 VDD VSS gf180mcu_fd_sc_mcu7t5v0__filltie
XTAP_TAPCELL_ROW_79_809 VDD VSS gf180mcu_fd_sc_mcu7t5v0__filltie
XFILLER_67_66 VDD VDD VSS VSS gf180mcu_fd_sc_mcu7t5v0__fillcap_4
XFILLER_29_284 VDD VDD VSS VSS gf180mcu_fd_sc_mcu7t5v0__fill_1
XFILLER_8_177 VDD VDD VSS VSS gf180mcu_fd_sc_mcu7t5v0__fillcap_64
X_1461_ _1461_/I0 _1461_/I1 _1464_/S _1529_/D VDD VDD VSS VSS gf180mcu_fd_sc_mcu7t5v0__mux2_2
X_1530_ _1530_/D _1530_/RN clkload9/I _1530_/Q VDD VDD VSS VSS gf180mcu_fd_sc_mcu7t5v0__dffrnq_2
Xoutput419 _1530_/Q cfg_phase270_offset_y[5] VDD VDD VSS VSS gf180mcu_fd_sc_mcu7t5v0__buf_2
X_1392_ _1402_/A4 _1374_/I _1401_/S VDD VDD VSS VSS gf180mcu_fd_sc_mcu7t5v0__nor2_4
Xoutput408 _1539_/Q cfg_phase270_offset_y[14] VDD VDD VSS VSS gf180mcu_fd_sc_mcu7t5v0__buf_2
XFILLER_50_279 VDD VDD VSS VSS gf180mcu_fd_sc_mcu7t5v0__fill_1
Xclkbuf_leaf_15_clk clkbuf_leaf_3_clk/I clkload3/I VDD VDD VSS VSS gf180mcu_fd_sc_mcu7t5v0__clkbuf_8
Xfanout646 _0823_/ZN _0824_/A2 VDD VDD VSS VSS gf180mcu_fd_sc_mcu7t5v0__dlyb_1
Xfanout679 _0838_/Z _0907_/A2 VDD VDD VSS VSS gf180mcu_fd_sc_mcu7t5v0__dlyb_1
X_1659_ _1659_/D _1674_/RN _1659_/CLK _1659_/Q VDD VDD VSS VSS gf180mcu_fd_sc_mcu7t5v0__dffrnq_1
XFILLER_37_69 VDD VDD VSS VSS gf180mcu_fd_sc_mcu7t5v0__fill_1
XFILLER_26_243 VDD VDD VSS VSS gf180mcu_fd_sc_mcu7t5v0__fill_2
XFILLER_5_136 VDD VDD VSS VSS gf180mcu_fd_sc_mcu7t5v0__fillcap_4
XFILLER_49_379 VDD VDD VSS VSS gf180mcu_fd_sc_mcu7t5v0__fillcap_4
X_0961_ _1541_/Q _1125_/B1 _1087_/A2 _1659_/Q _0963_/A3 VDD VDD VSS VSS gf180mcu_fd_sc_mcu7t5v0__aoi22_2
X_0892_ _0892_/A1 _0920_/A2 _1229_/B1 VDD VDD VSS VSS gf180mcu_fd_sc_mcu7t5v0__nor2_4
XTAP_TAPCELL_ROW_30_414 VDD VSS gf180mcu_fd_sc_mcu7t5v0__filltie
Xclkbuf_leaf_4_clk clkbuf_leaf_8_clk/I _1597_/CLK VDD VDD VSS VSS gf180mcu_fd_sc_mcu7t5v0__clkbuf_8
X_1375_ _1375_/A1 _1374_/I _1378_/S VDD VDD VSS VSS gf180mcu_fd_sc_mcu7t5v0__nor2_4
X_1513_ _1513_/D wire843/I clkload5/I _1513_/Q VDD VDD VSS VSS gf180mcu_fd_sc_mcu7t5v0__dffrnq_2
X_1444_ _1464_/I0 _1516_/Q _1444_/S _1516_/D VDD VDD VSS VSS gf180mcu_fd_sc_mcu7t5v0__mux2_2
XTAP_TAPCELL_ROW_81_826 VDD VSS gf180mcu_fd_sc_mcu7t5v0__filltie
XFILLER_51_522 VDD VDD VSS VSS gf180mcu_fd_sc_mcu7t5v0__fill_1
XFILLER_31_290 VDD VDD VSS VSS gf180mcu_fd_sc_mcu7t5v0__fill_2
XFILLER_64_34 VDD VDD VSS VSS gf180mcu_fd_sc_mcu7t5v0__fill_1
XTAP_TAPCELL_ROW_44_528 VDD VSS gf180mcu_fd_sc_mcu7t5v0__filltie
XTAP_TAPCELL_ROW_1_183 VDD VSS gf180mcu_fd_sc_mcu7t5v0__filltie
XTAP_TAPCELL_ROW_52_594 VDD VSS gf180mcu_fd_sc_mcu7t5v0__filltie
XFILLER_10_441 VDD VDD VSS VSS gf180mcu_fd_sc_mcu7t5v0__fillcap_8
XPHY_EDGE_ROW_23_Left_105 VDD VSS gf180mcu_fd_sc_mcu7t5v0__endcap
Xload_slew838 _1580_/RN _1486_/RN VDD VDD VSS VSS gf180mcu_fd_sc_mcu7t5v0__buf_1
Xload_slew849 _1624_/RN _1497_/RN VDD VDD VSS VSS gf180mcu_fd_sc_mcu7t5v0__clkbuf_1
XTAP_TAPCELL_ROW_9_250 VDD VSS gf180mcu_fd_sc_mcu7t5v0__filltie
Xload_slew827 wire828/Z _1626_/RN VDD VDD VSS VSS gf180mcu_fd_sc_mcu7t5v0__clkbuf_2
Xload_slew816 _1663_/RN _1674_/RN VDD VDD VSS VSS gf180mcu_fd_sc_mcu7t5v0__clkbuf_2
XFILLER_64_157 VDD VDD VSS VSS gf180mcu_fd_sc_mcu7t5v0__fill_1
X_1091_ input36/Z _1091_/A2 _1091_/B1 _1091_/B2 _1093_/A3 VDD VDD VSS VSS gf180mcu_fd_sc_mcu7t5v0__aoi22_4
XFILLER_37_349 VDD VDD VSS VSS gf180mcu_fd_sc_mcu7t5v0__fill_1
X_1160_ _1622_/Q wire604/I _1237_/B1 _1522_/Q _1162_/A2 VDD VDD VSS VSS gf180mcu_fd_sc_mcu7t5v0__aoi22_1
XPHY_EDGE_ROW_32_Left_114 VDD VSS gf180mcu_fd_sc_mcu7t5v0__endcap
XFILLER_45_393 VDD VDD VSS VSS gf180mcu_fd_sc_mcu7t5v0__fill_1
X_0944_ _1601_/Q _1198_/A2 wire547/Z input47/Z _0948_/A1 VDD VDD VSS VSS gf180mcu_fd_sc_mcu7t5v0__aoi22_1
XTAP_TAPCELL_ROW_15_296 VDD VSS gf180mcu_fd_sc_mcu7t5v0__filltie
XFILLER_20_249 VDD VDD VSS VSS gf180mcu_fd_sc_mcu7t5v0__fill_1
X_0875_ wire617/I _0924_/A2 wire573/I VDD VDD VSS VSS gf180mcu_fd_sc_mcu7t5v0__nor2_4
XPHY_EDGE_ROW_41_Left_123 VDD VSS gf180mcu_fd_sc_mcu7t5v0__endcap
XFILLER_68_452 VDD VDD VSS VSS gf180mcu_fd_sc_mcu7t5v0__fill_2
XFILLER_55_124 VDD VDD VSS VSS gf180mcu_fd_sc_mcu7t5v0__fill_2
XPHY_EDGE_ROW_50_Left_132 VDD VSS gf180mcu_fd_sc_mcu7t5v0__endcap
X_1427_ wire710/Z _1503_/Q _1427_/S _1503_/D VDD VDD VSS VSS gf180mcu_fd_sc_mcu7t5v0__mux2_2
X_1358_ _1663_/Q _1358_/I1 _1358_/S _1663_/D VDD VDD VSS VSS gf180mcu_fd_sc_mcu7t5v0__mux2_2
XFILLER_55_135 VDD VDD VSS VSS gf180mcu_fd_sc_mcu7t5v0__fillcap_4
XFILLER_51_352 VDD VDD VSS VSS gf180mcu_fd_sc_mcu7t5v0__fillcap_4
X_1289_ _1613_/Q wire736/Z _1292_/S _1613_/D VDD VDD VSS VSS gf180mcu_fd_sc_mcu7t5v0__mux2_2
XFILLER_24_544 VDD VDD VSS VSS gf180mcu_fd_sc_mcu7t5v0__fill_1
XFILLER_50_47 VDD VDD VSS VSS gf180mcu_fd_sc_mcu7t5v0__fill_1
Xclkload3 clkload3/I clkload3/Z VDD VDD VSS VSS gf180mcu_fd_sc_mcu7t5v0__clkbuf_2
XFILLER_59_56 VDD VDD VSS VSS gf180mcu_fd_sc_mcu7t5v0__fillcap_8
XFILLER_59_12 VDD VDD VSS VSS gf180mcu_fd_sc_mcu7t5v0__fill_1
XTAP_TAPCELL_ROW_6_220 VDD VSS gf180mcu_fd_sc_mcu7t5v0__filltie
XTAP_TAPCELL_ROW_57_631 VDD VSS gf180mcu_fd_sc_mcu7t5v0__filltie
XFILLER_46_157 VDD VDD VSS VSS gf180mcu_fd_sc_mcu7t5v0__fillcap_16
XFILLER_19_349 VDD VDD VSS VSS gf180mcu_fd_sc_mcu7t5v0__fill_1
Xwire674 wire675/Z wire674/Z VDD VDD VSS VSS gf180mcu_fd_sc_mcu7t5v0__clkbuf_2
XFILLER_10_260 VDD VDD VSS VSS gf180mcu_fd_sc_mcu7t5v0__fillcap_32
Xwire685 wire685/I wire685/Z VDD VDD VSS VSS gf180mcu_fd_sc_mcu7t5v0__buf_1
XFILLER_77_282 VDD VDD VSS VSS gf180mcu_fd_sc_mcu7t5v0__fillcap_64
XFILLER_65_422 VDD VDD VSS VSS gf180mcu_fd_sc_mcu7t5v0__fill_1
Xload_slew613 _0889_/A1 _0920_/A1 VDD VDD VSS VSS gf180mcu_fd_sc_mcu7t5v0__clkbuf_1
X_1212_ _1212_/A1 _1212_/A2 _1212_/A3 _1212_/A4 _1212_/Z VDD VDD VSS VSS gf180mcu_fd_sc_mcu7t5v0__and4_1
Xload_slew635 wire636/Z _0894_/A1 VDD VDD VSS VSS gf180mcu_fd_sc_mcu7t5v0__buf_2
Xload_slew624 _0915_/A1 _0909_/A2 VDD VDD VSS VSS gf180mcu_fd_sc_mcu7t5v0__buf_2
Xload_slew657 _0879_/A1 _0919_/A1 VDD VDD VSS VSS gf180mcu_fd_sc_mcu7t5v0__buf_2
XFILLER_65_488 VDD VDD VSS VSS gf180mcu_fd_sc_mcu7t5v0__fill_2
XTAP_TAPCELL_ROW_63_678 VDD VSS gf180mcu_fd_sc_mcu7t5v0__filltie
X_1074_ input40/Z wire511/Z _1084_/A2 VDD VDD VSS VSS gf180mcu_fd_sc_mcu7t5v0__nand2_1
XFILLER_52_127 VDD VDD VSS VSS gf180mcu_fd_sc_mcu7t5v0__fill_2
XFILLER_33_352 VDD VDD VSS VSS gf180mcu_fd_sc_mcu7t5v0__fill_2
X_1143_ _1508_/Q _1143_/A2 _1143_/B1 _1492_/Q _1144_/A4 VDD VDD VSS VSS gf180mcu_fd_sc_mcu7t5v0__aoi22_1
XFILLER_60_171 VDD VDD VSS VSS gf180mcu_fd_sc_mcu7t5v0__fillcap_4
X_0927_ _1675_/Q wire575/Z _1230_/A2 input5/Z input24/Z _1231_/A2 _0931_/A1 VDD VDD
+ VSS VSS gf180mcu_fd_sc_mcu7t5v0__aoi222_4
XFILLER_21_547 VDD VDD VSS VSS gf180mcu_fd_sc_mcu7t5v0__fillcap_4
X_0789_ _0789_/I _1551_/D VDD VDD VSS VSS gf180mcu_fd_sc_mcu7t5v0__clkinv_1
X_0858_ _0858_/A1 _0880_/A2 wire593/I VDD VDD VSS VSS gf180mcu_fd_sc_mcu7t5v0__nor2_4
XTAP_TAPCELL_ROW_3_201 VDD VSS gf180mcu_fd_sc_mcu7t5v0__filltie
XFILLER_16_308 VDD VDD VSS VSS gf180mcu_fd_sc_mcu7t5v0__fillcap_4
XFILLER_28_124 VDD VDD VSS VSS gf180mcu_fd_sc_mcu7t5v0__fillcap_4
XFILLER_61_68 VDD VDD VSS VSS gf180mcu_fd_sc_mcu7t5v0__fill_2
XFILLER_51_193 VDD VDD VSS VSS gf180mcu_fd_sc_mcu7t5v0__fillcap_16
XFILLER_45_58 VDD VDD VSS VSS gf180mcu_fd_sc_mcu7t5v0__fillcap_8
XPHY_EDGE_ROW_7_Left_89 VDD VSS gf180mcu_fd_sc_mcu7t5v0__endcap
XFILLER_3_212 VDD VDD VSS VSS gf180mcu_fd_sc_mcu7t5v0__fillcap_64
XFILLER_59_282 VDD VDD VSS VSS gf180mcu_fd_sc_mcu7t5v0__fill_2
XFILLER_74_241 VDD VDD VSS VSS gf180mcu_fd_sc_mcu7t5v0__fillcap_4
XTAP_TAPCELL_ROW_17_314 VDD VSS gf180mcu_fd_sc_mcu7t5v0__filltie
XTAP_TAPCELL_ROW_60_659 VDD VSS gf180mcu_fd_sc_mcu7t5v0__filltie
Xwire471 wire471/I wire471/Z VDD VDD VSS VSS gf180mcu_fd_sc_mcu7t5v0__buf_2
Xwire493 wire493/I wire493/Z VDD VDD VSS VSS gf180mcu_fd_sc_mcu7t5v0__buf_2
XFILLER_7_562 VDD VDD VSS VSS gf180mcu_fd_sc_mcu7t5v0__fillcap_4
X_1126_ _1126_/A1 _1126_/A2 _1126_/A3 _1131_/A3 VDD VDD VSS VSS gf180mcu_fd_sc_mcu7t5v0__nand3_1
XFILLER_38_444 VDD VDD VSS VSS gf180mcu_fd_sc_mcu7t5v0__fill_2
XTAP_TAPCELL_ROW_76_781 VDD VSS gf180mcu_fd_sc_mcu7t5v0__filltie
X_1057_ _1057_/A1 _1057_/A2 _1197_/B1 _1057_/B2 _1058_/A4 VDD VDD VSS VSS gf180mcu_fd_sc_mcu7t5v0__aoi22_1
XFILLER_25_127 VDD VDD VSS VSS gf180mcu_fd_sc_mcu7t5v0__fill_1
XFILLER_25_138 VDD VDD VSS VSS gf180mcu_fd_sc_mcu7t5v0__fill_2
XFILLER_76_517 VDD VDD VSS VSS gf180mcu_fd_sc_mcu7t5v0__fillcap_8
Xinput149 jitter_flag_x _0942_/A1 VDD VDD VSS VSS gf180mcu_fd_sc_mcu7t5v0__buf_1
Xinput116 cal_phase90_offset_y[15] _1226_/B2 VDD VDD VSS VSS gf180mcu_fd_sc_mcu7t5v0__buf_1
Xinput105 cal_phase90_offset_x[5] _1176_/B2 VDD VDD VSS VSS gf180mcu_fd_sc_mcu7t5v0__buf_1
Xinput127 cal_phase90_offset_y[6] _1188_/A1 VDD VDD VSS VSS gf180mcu_fd_sc_mcu7t5v0__buf_2
Xinput138 delay_wave_cycle_x[5] _1170_/C1 VDD VDD VSS VSS gf180mcu_fd_sc_mcu7t5v0__buf_1
XFILLER_29_422 VDD VDD VSS VSS gf180mcu_fd_sc_mcu7t5v0__fillcap_4
XFILLER_72_34 VDD VDD VSS VSS gf180mcu_fd_sc_mcu7t5v0__fill_1
XFILLER_44_436 VDD VDD VSS VSS gf180mcu_fd_sc_mcu7t5v0__fill_2
XFILLER_44_403 VDD VDD VSS VSS gf180mcu_fd_sc_mcu7t5v0__fill_1
XFILLER_29_455 VDD VDD VSS VSS gf180mcu_fd_sc_mcu7t5v0__fill_2
XFILLER_12_311 VDD VDD VSS VSS gf180mcu_fd_sc_mcu7t5v0__fillcap_4
XTAP_TAPCELL_ROW_22_350 VDD VSS gf180mcu_fd_sc_mcu7t5v0__filltie
XFILLER_4_521 VDD VDD VSS VSS gf180mcu_fd_sc_mcu7t5v0__fillcap_4
XFILLER_21_82 VDD VDD VSS VSS gf180mcu_fd_sc_mcu7t5v0__fill_2
XFILLER_39_208 VDD VDD VSS VSS gf180mcu_fd_sc_mcu7t5v0__fill_2
XTAP_TAPCELL_ROW_73_762 VDD VSS gf180mcu_fd_sc_mcu7t5v0__filltie
XFILLER_62_244 VDD VDD VSS VSS gf180mcu_fd_sc_mcu7t5v0__fill_1
Xclkbuf_0_clk clk clkbuf_0_clk/Z VDD VDD VSS VSS gf180mcu_fd_sc_mcu7t5v0__clkbuf_16
X_1675_ _1675_/D _1678_/RN clkload2/I _1675_/Q VDD VDD VSS VSS gf180mcu_fd_sc_mcu7t5v0__dffrnq_1
Xfanout806 _1663_/RN _1654_/RN VDD VDD VSS VSS gf180mcu_fd_sc_mcu7t5v0__dlyb_1
XPHY_EDGE_ROW_15_Right_15 VDD VSS gf180mcu_fd_sc_mcu7t5v0__endcap
X_1109_ _1109_/A1 _1109_/A2 _1109_/A3 _1109_/A4 _1109_/Z VDD VDD VSS VSS gf180mcu_fd_sc_mcu7t5v0__and4_1
XFILLER_38_241 VDD VDD VSS VSS gf180mcu_fd_sc_mcu7t5v0__fillcap_4
XPHY_EDGE_ROW_24_Right_24 VDD VSS gf180mcu_fd_sc_mcu7t5v0__endcap
XTAP_TAPCELL_ROW_36_464 VDD VSS gf180mcu_fd_sc_mcu7t5v0__filltie
XPHY_EDGE_ROW_33_Right_33 VDD VSS gf180mcu_fd_sc_mcu7t5v0__endcap
XFILLER_1_524 VDD VDD VSS VSS gf180mcu_fd_sc_mcu7t5v0__fillcap_16
XFILLER_49_517 VDD VDD VSS VSS gf180mcu_fd_sc_mcu7t5v0__fill_1
XTAP_TAPCELL_ROW_70_732 VDD VSS gf180mcu_fd_sc_mcu7t5v0__filltie
XPHY_EDGE_ROW_42_Right_42 VDD VSS gf180mcu_fd_sc_mcu7t5v0__endcap
XFILLER_16_60 VDD VDD VSS VSS gf180mcu_fd_sc_mcu7t5v0__fill_2
XPHY_EDGE_ROW_51_Right_51 VDD VSS gf180mcu_fd_sc_mcu7t5v0__endcap
XFILLER_40_472 VDD VDD VSS VSS gf180mcu_fd_sc_mcu7t5v0__fill_2
XFILLER_8_101 VDD VDD VSS VSS gf180mcu_fd_sc_mcu7t5v0__fillcap_4
Xoutput409 _1540_/Q cfg_phase270_offset_y[15] VDD VDD VSS VSS gf180mcu_fd_sc_mcu7t5v0__buf_2
X_1460_ _1460_/A1 _1464_/S _1460_/B _1528_/D VDD VDD VSS VSS gf180mcu_fd_sc_mcu7t5v0__oai21_1
X_1391_ wire704/Z _1474_/Q _1391_/S _1474_/D VDD VDD VSS VSS gf180mcu_fd_sc_mcu7t5v0__mux2_2
XPHY_EDGE_ROW_60_Right_60 VDD VSS gf180mcu_fd_sc_mcu7t5v0__endcap
XFILLER_50_269 VDD VDD VSS VSS gf180mcu_fd_sc_mcu7t5v0__fill_1
XFILLER_50_247 VDD VDD VSS VSS gf180mcu_fd_sc_mcu7t5v0__fillcap_4
X_1658_ _1658_/D _1663_/RN _1663_/CLK _1658_/Q VDD VDD VSS VSS gf180mcu_fd_sc_mcu7t5v0__dffrnq_2
XFILLER_58_314 VDD VDD VSS VSS gf180mcu_fd_sc_mcu7t5v0__fill_1
X_1589_ _1589_/D _1589_/RN clkload8/I _1589_/Q VDD VDD VSS VSS gf180mcu_fd_sc_mcu7t5v0__dffrnq_1
Xfanout669 _0838_/Z _0865_/A2 VDD VDD VSS VSS gf180mcu_fd_sc_mcu7t5v0__dlyb_1
XFILLER_66_391 VDD VDD VSS VSS gf180mcu_fd_sc_mcu7t5v0__fill_2
XFILLER_22_494 VDD VDD VSS VSS gf180mcu_fd_sc_mcu7t5v0__fill_1
XFILLER_76_177 VDD VDD VSS VSS gf180mcu_fd_sc_mcu7t5v0__fillcap_64
XFILLER_64_317 VDD VDD VSS VSS gf180mcu_fd_sc_mcu7t5v0__fillcap_16
XTAP_TAPCELL_ROW_47_548 VDD VSS gf180mcu_fd_sc_mcu7t5v0__filltie
XFILLER_72_361 VDD VDD VSS VSS gf180mcu_fd_sc_mcu7t5v0__fill_1
XFILLER_72_383 VDD VDD VSS VSS gf180mcu_fd_sc_mcu7t5v0__fill_2
X_0960_ _0960_/A1 _1208_/A2 _1154_/A2 input66/Z _0963_/A2 VDD VDD VSS VSS gf180mcu_fd_sc_mcu7t5v0__aoi22_1
XFILLER_32_247 VDD VDD VSS VSS gf180mcu_fd_sc_mcu7t5v0__fillcap_16
XTAP_TAPCELL_ROW_30_415 VDD VSS gf180mcu_fd_sc_mcu7t5v0__filltie
X_0891_ _0893_/A1 _0891_/A2 _0977_/B1 VDD VDD VSS VSS gf180mcu_fd_sc_mcu7t5v0__nor2_4
XFILLER_9_454 VDD VDD VSS VSS gf180mcu_fd_sc_mcu7t5v0__fillcap_16
X_1512_ _1512_/D _1515_/RN _1624_/CLK _1512_/Q VDD VDD VSS VSS gf180mcu_fd_sc_mcu7t5v0__dffrnq_1
XFILLER_55_306 VDD VDD VSS VSS gf180mcu_fd_sc_mcu7t5v0__fill_1
X_1374_ _1374_/I _1418_/A4 VDD VDD VSS VSS gf180mcu_fd_sc_mcu7t5v0__clkinv_1
X_1443_ wire720/Z _1515_/Q _1444_/S _1515_/D VDD VDD VSS VSS gf180mcu_fd_sc_mcu7t5v0__mux2_2
XTAP_TAPCELL_ROW_81_827 VDD VSS gf180mcu_fd_sc_mcu7t5v0__filltie
XFILLER_2_107 VDD VDD VSS VSS gf180mcu_fd_sc_mcu7t5v0__fillcap_64
XFILLER_73_136 VDD VDD VSS VSS gf180mcu_fd_sc_mcu7t5v0__fillcap_4
Xfanout477 _0761_/ZN _1261_/S VDD VDD VSS VSS gf180mcu_fd_sc_mcu7t5v0__dlyb_1
XFILLER_58_177 VDD VDD VSS VSS gf180mcu_fd_sc_mcu7t5v0__fillcap_32
XFILLER_58_155 VDD VDD VSS VSS gf180mcu_fd_sc_mcu7t5v0__fill_1
XFILLER_81_191 VDD VDD VSS VSS gf180mcu_fd_sc_mcu7t5v0__fillcap_8
XFILLER_81_180 VDD VDD VSS VSS gf180mcu_fd_sc_mcu7t5v0__fill_2
XFILLER_80_34 VDD VDD VSS VSS gf180mcu_fd_sc_mcu7t5v0__fill_1
XTAP_TAPCELL_ROW_52_595 VDD VSS gf180mcu_fd_sc_mcu7t5v0__filltie
XTAP_TAPCELL_ROW_44_529 VDD VSS gf180mcu_fd_sc_mcu7t5v0__filltie
XTAP_TAPCELL_ROW_1_184 VDD VSS gf180mcu_fd_sc_mcu7t5v0__filltie
Xwire867 wire867/I wire867/Z VDD VDD VSS VSS gf180mcu_fd_sc_mcu7t5v0__buf_1
XFILLER_6_457 VDD VDD VSS VSS gf180mcu_fd_sc_mcu7t5v0__fillcap_64
XFILLER_10_453 VDD VDD VSS VSS gf180mcu_fd_sc_mcu7t5v0__fill_2
XFILLER_10_497 VDD VDD VSS VSS gf180mcu_fd_sc_mcu7t5v0__fill_2
XFILLER_13_50 VDD VDD VSS VSS gf180mcu_fd_sc_mcu7t5v0__fill_2
XFILLER_13_94 VDD VDD VSS VSS gf180mcu_fd_sc_mcu7t5v0__fill_2
Xload_slew839 wire840/I _1580_/RN VDD VDD VSS VSS gf180mcu_fd_sc_mcu7t5v0__buf_1
XTAP_TAPCELL_ROW_9_251 VDD VSS gf180mcu_fd_sc_mcu7t5v0__filltie
Xload_slew817 _1661_/RN _1663_/RN VDD VDD VSS VSS gf180mcu_fd_sc_mcu7t5v0__clkbuf_2
X_1090_ _1604_/Q _1222_/A2 _1090_/B1 input91/Z _1090_/C _1109_/A2 VDD VDD VSS VSS
+ gf180mcu_fd_sc_mcu7t5v0__aoi221_1
XFILLER_45_361 VDD VDD VSS VSS gf180mcu_fd_sc_mcu7t5v0__fillcap_32
XFILLER_18_531 VDD VDD VSS VSS gf180mcu_fd_sc_mcu7t5v0__fill_1
XFILLER_60_375 VDD VDD VSS VSS gf180mcu_fd_sc_mcu7t5v0__fill_1
X_0874_ _0874_/A1 _0898_/A2 wire574/I VDD VDD VSS VSS gf180mcu_fd_sc_mcu7t5v0__nor2_4
X_0943_ _0943_/A1 _0943_/A2 _0943_/A3 _0965_/A3 VDD VDD VSS VSS gf180mcu_fd_sc_mcu7t5v0__nand3_1
Xclkload10 _1587_/CLK clkload10/ZN VDD VDD VSS VSS gf180mcu_fd_sc_mcu7t5v0__inv_4
XTAP_TAPCELL_ROW_15_297 VDD VSS gf180mcu_fd_sc_mcu7t5v0__filltie
X_1288_ _1319_/A1 _1292_/S _1288_/B _1612_/D VDD VDD VSS VSS gf180mcu_fd_sc_mcu7t5v0__aoi21_1
X_1426_ wire720/Z _1502_/Q _1427_/S _1502_/D VDD VDD VSS VSS gf180mcu_fd_sc_mcu7t5v0__mux2_2
X_1357_ wire685/Z _1361_/S _1357_/B _1662_/D VDD VDD VSS VSS gf180mcu_fd_sc_mcu7t5v0__aoi21_1
Xclkload4 clkload4/I clkload4/Z VDD VDD VSS VSS gf180mcu_fd_sc_mcu7t5v0__clkbuf_2
XFILLER_3_416 VDD VDD VSS VSS gf180mcu_fd_sc_mcu7t5v0__fillcap_4
XFILLER_59_68 VDD VDD VSS VSS gf180mcu_fd_sc_mcu7t5v0__fill_2
XTAP_TAPCELL_ROW_6_221 VDD VSS gf180mcu_fd_sc_mcu7t5v0__filltie
XFILLER_75_56 VDD VDD VSS VSS gf180mcu_fd_sc_mcu7t5v0__fillcap_8
XTAP_TAPCELL_ROW_57_632 VDD VSS gf180mcu_fd_sc_mcu7t5v0__filltie
XFILLER_46_125 VDD VDD VSS VSS gf180mcu_fd_sc_mcu7t5v0__fillcap_32
Xwire642 _1152_/S wire642/Z VDD VDD VSS VSS gf180mcu_fd_sc_mcu7t5v0__buf_1
XFILLER_69_206 VDD VDD VSS VSS gf180mcu_fd_sc_mcu7t5v0__fillcap_4
Xload_slew614 _0912_/A1 _0889_/A1 VDD VDD VSS VSS gf180mcu_fd_sc_mcu7t5v0__buf_2
Xwire675 wire675/I wire675/Z VDD VDD VSS VSS gf180mcu_fd_sc_mcu7t5v0__buf_1
Xload_slew625 _0905_/A1 _0915_/A1 VDD VDD VSS VSS gf180mcu_fd_sc_mcu7t5v0__buf_2
Xload_slew647 _0900_/A1 _0880_/A1 VDD VDD VSS VSS gf180mcu_fd_sc_mcu7t5v0__clkbuf_1
Xload_slew658 _0906_/A1 _0879_/A1 VDD VDD VSS VSS gf180mcu_fd_sc_mcu7t5v0__buf_2
X_1211_ _1211_/A1 _1211_/A2 _1211_/A3 _1211_/A4 _1212_/A4 VDD VDD VSS VSS gf180mcu_fd_sc_mcu7t5v0__nor4_4
XFILLER_37_125 VDD VDD VSS VSS gf180mcu_fd_sc_mcu7t5v0__fillcap_4
X_1142_ _1142_/A1 wire551/Z wire548/Z _1629_/Q _1144_/A3 VDD VDD VSS VSS gf180mcu_fd_sc_mcu7t5v0__aoi22_1
XTAP_TAPCELL_ROW_63_679 VDD VSS gf180mcu_fd_sc_mcu7t5v0__filltie
X_1073_ input19/Z _1230_/A2 _1073_/B1 _1657_/Q _1084_/A1 VDD VDD VSS VSS gf180mcu_fd_sc_mcu7t5v0__aoi22_1
XFILLER_37_158 VDD VDD VSS VSS gf180mcu_fd_sc_mcu7t5v0__fillcap_8
X_0857_ _0857_/A1 _0891_/A2 wire594/I VDD VDD VSS VSS gf180mcu_fd_sc_mcu7t5v0__nor2_4
X_0926_ _1609_/Q _1220_/A2 wire520/Z _1525_/Q _0939_/A3 VDD VDD VSS VSS gf180mcu_fd_sc_mcu7t5v0__aoi22_1
X_0788_ _1551_/Q _0790_/A2 _0787_/Z wire667/Z _0789_/I VDD VDD VSS VSS gf180mcu_fd_sc_mcu7t5v0__aoi22_1
XTAP_TAPCELL_ROW_3_202 VDD VSS gf180mcu_fd_sc_mcu7t5v0__filltie
X_1409_ _1488_/Q _1409_/I1 _1417_/S _1488_/D VDD VDD VSS VSS gf180mcu_fd_sc_mcu7t5v0__mux2_2
XFILLER_71_448 VDD VDD VSS VSS gf180mcu_fd_sc_mcu7t5v0__fillcap_4
XFILLER_71_404 VDD VDD VSS VSS gf180mcu_fd_sc_mcu7t5v0__fill_1
XFILLER_51_161 VDD VDD VSS VSS gf180mcu_fd_sc_mcu7t5v0__fillcap_32
XFILLER_51_150 VDD VDD VSS VSS gf180mcu_fd_sc_mcu7t5v0__fill_2
XFILLER_8_508 VDD VDD VSS VSS gf180mcu_fd_sc_mcu7t5v0__fill_2
XFILLER_47_489 VDD VDD VSS VSS gf180mcu_fd_sc_mcu7t5v0__fill_1
XFILLER_42_172 VDD VDD VSS VSS gf180mcu_fd_sc_mcu7t5v0__fill_2
XFILLER_42_161 VDD VDD VSS VSS gf180mcu_fd_sc_mcu7t5v0__fill_2
XTAP_TAPCELL_ROW_17_315 VDD VSS gf180mcu_fd_sc_mcu7t5v0__filltie
Xwire494 wire494/I wire494/Z VDD VDD VSS VSS gf180mcu_fd_sc_mcu7t5v0__clkbuf_2
XFILLER_30_323 VDD VDD VSS VSS gf180mcu_fd_sc_mcu7t5v0__fill_1
XFILLER_7_541 VDD VDD VSS VSS gf180mcu_fd_sc_mcu7t5v0__fill_1
XTAP_TAPCELL_ROW_76_782 VDD VSS gf180mcu_fd_sc_mcu7t5v0__filltie
XTAP_TAPCELL_ROW_68_716 VDD VSS gf180mcu_fd_sc_mcu7t5v0__filltie
XFILLER_57_209 VDD VDD VSS VSS gf180mcu_fd_sc_mcu7t5v0__fill_1
X_1125_ _1125_/A1 wire598/I _1125_/B1 _1545_/Q _1126_/A3 VDD VDD VSS VSS gf180mcu_fd_sc_mcu7t5v0__aoi22_1
Xload_slew488 _1320_/S _1316_/S VDD VDD VSS VSS gf180mcu_fd_sc_mcu7t5v0__buf_2
X_1056_ input69/Z _1219_/A2 _1056_/B1 input77/Z _1058_/A3 VDD VDD VSS VSS gf180mcu_fd_sc_mcu7t5v0__aoi22_2
XFILLER_61_492 VDD VDD VSS VSS gf180mcu_fd_sc_mcu7t5v0__fillcap_4
X_0909_ _0918_/A1 _0909_/A2 wire535/I VDD VDD VSS VSS gf180mcu_fd_sc_mcu7t5v0__nor2_4
Xinput117 cal_phase90_offset_y[16] _0929_/C1 VDD VDD VSS VSS gf180mcu_fd_sc_mcu7t5v0__buf_1
Xinput128 cal_phase90_offset_y[7] _1227_/B2 VDD VDD VSS VSS gf180mcu_fd_sc_mcu7t5v0__buf_1
Xinput106 cal_phase90_offset_x[6] _1187_/A1 VDD VDD VSS VSS gf180mcu_fd_sc_mcu7t5v0__buf_1
Xinput139 delay_wave_cycle_x[6] _1186_/A1 VDD VDD VSS VSS gf180mcu_fd_sc_mcu7t5v0__buf_1
XFILLER_71_212 VDD VDD VSS VSS gf180mcu_fd_sc_mcu7t5v0__fillcap_64
XTAP_TAPCELL_ROW_39_484 VDD VSS gf180mcu_fd_sc_mcu7t5v0__filltie
XFILLER_12_345 VDD VDD VSS VSS gf180mcu_fd_sc_mcu7t5v0__fillcap_4
XTAP_TAPCELL_ROW_22_351 VDD VSS gf180mcu_fd_sc_mcu7t5v0__filltie
XFILLER_62_201 VDD VDD VSS VSS gf180mcu_fd_sc_mcu7t5v0__fillcap_4
XTAP_TAPCELL_ROW_73_763 VDD VSS gf180mcu_fd_sc_mcu7t5v0__filltie
XFILLER_15_150 VDD VDD VSS VSS gf180mcu_fd_sc_mcu7t5v0__fillcap_4
X_1674_ _1674_/D _1674_/RN _1674_/CLK _1674_/Q VDD VDD VSS VSS gf180mcu_fd_sc_mcu7t5v0__dffrnq_1
Xfanout818 wire824/Z _1476_/RN VDD VDD VSS VSS gf180mcu_fd_sc_mcu7t5v0__dlyb_1
XFILLER_81_543 VDD VDD VSS VSS gf180mcu_fd_sc_mcu7t5v0__fill_1
XFILLER_81_554 VDD VDD VSS VSS gf180mcu_fd_sc_mcu7t5v0__fillcap_4
X_1039_ _1635_/Q wire585/Z _1039_/B1 _1039_/B2 _1040_/A4 VDD VDD VSS VSS gf180mcu_fd_sc_mcu7t5v0__aoi22_1
XFILLER_53_212 VDD VDD VSS VSS gf180mcu_fd_sc_mcu7t5v0__fillcap_4
X_1108_ _1108_/A1 _1108_/A2 _1108_/A3 wire471/Z _1109_/A4 VDD VDD VSS VSS gf180mcu_fd_sc_mcu7t5v0__nor4_2
XFILLER_41_418 VDD VDD VSS VSS gf180mcu_fd_sc_mcu7t5v0__fill_2
XTAP_TAPCELL_ROW_36_465 VDD VSS gf180mcu_fd_sc_mcu7t5v0__filltie
XFILLER_42_16 VDD VDD VSS VSS gf180mcu_fd_sc_mcu7t5v0__fillcap_4
XFILLER_21_142 VDD VDD VSS VSS gf180mcu_fd_sc_mcu7t5v0__fillcap_4
XPHY_EDGE_ROW_10_Left_92 VDD VSS gf180mcu_fd_sc_mcu7t5v0__endcap
XFILLER_57_562 VDD VDD VSS VSS gf180mcu_fd_sc_mcu7t5v0__fillcap_4
XFILLER_57_540 VDD VDD VSS VSS gf180mcu_fd_sc_mcu7t5v0__fill_2
XFILLER_72_543 VDD VDD VSS VSS gf180mcu_fd_sc_mcu7t5v0__fillcap_4
XTAP_TAPCELL_ROW_70_733 VDD VSS gf180mcu_fd_sc_mcu7t5v0__filltie
XFILLER_25_492 VDD VDD VSS VSS gf180mcu_fd_sc_mcu7t5v0__fill_1
XFILLER_12_197 VDD VDD VSS VSS gf180mcu_fd_sc_mcu7t5v0__fillcap_8
XFILLER_79_142 VDD VDD VSS VSS gf180mcu_fd_sc_mcu7t5v0__fillcap_64
XTAP_TAPCELL_ROW_78_800 VDD VSS gf180mcu_fd_sc_mcu7t5v0__filltie
XFILLER_67_348 VDD VDD VSS VSS gf180mcu_fd_sc_mcu7t5v0__fill_2
X_1390_ _1390_/I0 _1473_/Q _1391_/S _1473_/D VDD VDD VSS VSS gf180mcu_fd_sc_mcu7t5v0__mux2_2
XFILLER_75_392 VDD VDD VSS VSS gf180mcu_fd_sc_mcu7t5v0__fill_1
XFILLER_35_212 VDD VDD VSS VSS gf180mcu_fd_sc_mcu7t5v0__fill_2
XFILLER_23_418 VDD VDD VSS VSS gf180mcu_fd_sc_mcu7t5v0__fill_2
X_1588_ _1588_/D _1589_/RN clkload8/I _1588_/Q VDD VDD VSS VSS gf180mcu_fd_sc_mcu7t5v0__dffrnq_1
X_1657_ _1657_/D _1657_/RN clkload0/I _1657_/Q VDD VDD VSS VSS gf180mcu_fd_sc_mcu7t5v0__dffrnq_1
XFILLER_78_34 VDD VDD VSS VSS gf180mcu_fd_sc_mcu7t5v0__fill_1
XFILLER_76_101 VDD VDD VSS VSS gf180mcu_fd_sc_mcu7t5v0__fillcap_4
XTAP_TAPCELL_ROW_47_549 VDD VSS gf180mcu_fd_sc_mcu7t5v0__filltie
XFILLER_17_278 VDD VDD VSS VSS gf180mcu_fd_sc_mcu7t5v0__fill_2
Xclkbuf_2_0__f_clk clkbuf_0_clk/Z clkbuf_leaf_0_clk/I VDD VDD VSS VSS gf180mcu_fd_sc_mcu7t5v0__clkbuf_16
XFILLER_72_395 VDD VDD VSS VSS gf180mcu_fd_sc_mcu7t5v0__fillcap_4
XFILLER_60_535 VDD VDD VSS VSS gf180mcu_fd_sc_mcu7t5v0__fill_1
XFILLER_60_524 VDD VDD VSS VSS gf180mcu_fd_sc_mcu7t5v0__fill_1
X_0890_ _0890_/A1 _0913_/A2 wire557/I VDD VDD VSS VSS gf180mcu_fd_sc_mcu7t5v0__nor2_4
XFILLER_32_226 VDD VDD VSS VSS gf180mcu_fd_sc_mcu7t5v0__fill_2
XTAP_TAPCELL_ROW_30_416 VDD VSS gf180mcu_fd_sc_mcu7t5v0__filltie
XFILLER_9_422 VDD VDD VSS VSS gf180mcu_fd_sc_mcu7t5v0__fillcap_32
XFILLER_4_171 VDD VDD VSS VSS gf180mcu_fd_sc_mcu7t5v0__fillcap_4
X_1511_ _1511_/D wire843/Z clkload5/I _1511_/Q VDD VDD VSS VSS gf180mcu_fd_sc_mcu7t5v0__dffrnq_2
X_1442_ wire729/Z _1514_/Q _1444_/S _1514_/D VDD VDD VSS VSS gf180mcu_fd_sc_mcu7t5v0__mux2_2
X_1373_ _1579_/Q _1578_/Q _1373_/A3 _1374_/I VDD VDD VSS VSS gf180mcu_fd_sc_mcu7t5v0__nand3_2
XTAP_TAPCELL_ROW_81_828 VDD VSS gf180mcu_fd_sc_mcu7t5v0__filltie
XFILLER_23_259 VDD VDD VSS VSS gf180mcu_fd_sc_mcu7t5v0__fill_2
XFILLER_48_37 VDD VDD VSS VSS gf180mcu_fd_sc_mcu7t5v0__fillcap_8
XFILLER_58_167 VDD VDD VSS VSS gf180mcu_fd_sc_mcu7t5v0__fillcap_8
XFILLER_39_370 VDD VDD VSS VSS gf180mcu_fd_sc_mcu7t5v0__fill_2
XTAP_TAPCELL_ROW_1_185 VDD VSS gf180mcu_fd_sc_mcu7t5v0__filltie
Xwire824 wire824/I wire824/Z VDD VDD VSS VSS gf180mcu_fd_sc_mcu7t5v0__clkbuf_2
XFILLER_14_215 VDD VDD VSS VSS gf180mcu_fd_sc_mcu7t5v0__fillcap_16
XFILLER_77_410 VDD VDD VSS VSS gf180mcu_fd_sc_mcu7t5v0__fill_1
Xload_slew807 _1647_/RN _1639_/RN VDD VDD VSS VSS gf180mcu_fd_sc_mcu7t5v0__clkbuf_2
XFILLER_54_80 VDD VDD VSS VSS gf180mcu_fd_sc_mcu7t5v0__fillcap_4
XFILLER_60_387 VDD VDD VSS VSS gf180mcu_fd_sc_mcu7t5v0__fill_1
X_0873_ _0873_/A1 _0924_/A2 wire575/I VDD VDD VSS VSS gf180mcu_fd_sc_mcu7t5v0__nor2_4
X_0942_ _0942_/A1 _0998_/A2 _1218_/A2 _0942_/B2 _0943_/A3 VDD VDD VSS VSS gf180mcu_fd_sc_mcu7t5v0__aoi22_1
XTAP_TAPCELL_ROW_15_298 VDD VSS gf180mcu_fd_sc_mcu7t5v0__filltie
X_1425_ wire729/Z _1501_/Q _1427_/S _1501_/D VDD VDD VSS VSS gf180mcu_fd_sc_mcu7t5v0__mux2_2
XFILLER_70_107 VDD VDD VSS VSS gf180mcu_fd_sc_mcu7t5v0__fillcap_64
XFILLER_68_465 VDD VDD VSS VSS gf180mcu_fd_sc_mcu7t5v0__fillcap_4
XFILLER_68_454 VDD VDD VSS VSS gf180mcu_fd_sc_mcu7t5v0__fill_1
X_1287_ _1612_/Q _1292_/S _1288_/B VDD VDD VSS VSS gf180mcu_fd_sc_mcu7t5v0__nor2_1
X_1356_ _1662_/Q _1361_/S _1357_/B VDD VDD VSS VSS gf180mcu_fd_sc_mcu7t5v0__nor2_1
XFILLER_36_373 VDD VDD VSS VSS gf180mcu_fd_sc_mcu7t5v0__fillcap_8
Xclkload5 clkload5/I clkload5/Z VDD VDD VSS VSS gf180mcu_fd_sc_mcu7t5v0__clkbuf_2
XFILLER_59_487 VDD VDD VSS VSS gf180mcu_fd_sc_mcu7t5v0__fill_2
XFILLER_46_104 VDD VDD VSS VSS gf180mcu_fd_sc_mcu7t5v0__fill_1
XFILLER_46_115 VDD VDD VSS VSS gf180mcu_fd_sc_mcu7t5v0__fill_2
XTAP_TAPCELL_ROW_6_222 VDD VSS gf180mcu_fd_sc_mcu7t5v0__filltie
XFILLER_75_68 VDD VDD VSS VSS gf180mcu_fd_sc_mcu7t5v0__fill_2
XTAP_TAPCELL_ROW_57_633 VDD VSS gf180mcu_fd_sc_mcu7t5v0__filltie
XFILLER_27_384 VDD VDD VSS VSS gf180mcu_fd_sc_mcu7t5v0__fillcap_4
XFILLER_15_557 VDD VDD VSS VSS gf180mcu_fd_sc_mcu7t5v0__fill_2
Xwire621 wire621/I wire621/Z VDD VDD VSS VSS gf180mcu_fd_sc_mcu7t5v0__clkbuf_2
XFILLER_42_387 VDD VDD VSS VSS gf180mcu_fd_sc_mcu7t5v0__fillcap_4
XFILLER_30_527 VDD VDD VSS VSS gf180mcu_fd_sc_mcu7t5v0__fillcap_4
XFILLER_10_251 VDD VDD VSS VSS gf180mcu_fd_sc_mcu7t5v0__fill_1
XTAP_TAPCELL_ROW_12_268 VDD VSS gf180mcu_fd_sc_mcu7t5v0__filltie
Xload_slew637 _0852_/A1 _0868_/A1 VDD VDD VSS VSS gf180mcu_fd_sc_mcu7t5v0__clkbuf_1
Xload_slew626 _0921_/A1 _0905_/A1 VDD VDD VSS VSS gf180mcu_fd_sc_mcu7t5v0__buf_2
Xload_slew615 _0869_/A2 _0912_/A1 VDD VDD VSS VSS gf180mcu_fd_sc_mcu7t5v0__buf_2
Xwire698 _1617_/Q wire698/Z VDD VDD VSS VSS gf180mcu_fd_sc_mcu7t5v0__buf_2
Xload_slew648 _0902_/A1 _0900_/A1 VDD VDD VSS VSS gf180mcu_fd_sc_mcu7t5v0__buf_2
XFILLER_52_107 VDD VDD VSS VSS gf180mcu_fd_sc_mcu7t5v0__fillcap_8
XFILLER_49_80 VDD VDD VSS VSS gf180mcu_fd_sc_mcu7t5v0__fill_2
X_1141_ _1141_/A1 _1141_/A2 _1141_/A3 _1141_/A4 _1150_/A1 VDD VDD VSS VSS gf180mcu_fd_sc_mcu7t5v0__nand4_1
Xload_slew659 _0901_/A1 _0906_/A1 VDD VDD VSS VSS gf180mcu_fd_sc_mcu7t5v0__buf_2
X_1072_ _1072_/A1 _1072_/A2 _1072_/A3 _1072_/A4 _1108_/A1 VDD VDD VSS VSS gf180mcu_fd_sc_mcu7t5v0__nand4_1
X_1210_ _1210_/A1 _1210_/A2 _1210_/A3 _1210_/A4 _1211_/A4 VDD VDD VSS VSS gf180mcu_fd_sc_mcu7t5v0__nand4_1
XFILLER_33_354 VDD VDD VSS VSS gf180mcu_fd_sc_mcu7t5v0__fill_1
X_0787_ _1550_/Q _1551_/Q _0787_/Z VDD VDD VSS VSS gf180mcu_fd_sc_mcu7t5v0__xor2_1
X_0925_ input89/Z _1176_/B1 _1129_/A2 input12/Z _0939_/A2 VDD VDD VSS VSS gf180mcu_fd_sc_mcu7t5v0__aoi22_2
X_0856_ _0891_/A2 _0898_/A2 _0929_/A2 VDD VDD VSS VSS gf180mcu_fd_sc_mcu7t5v0__nor2_4
XFILLER_68_251 VDD VDD VSS VSS gf180mcu_fd_sc_mcu7t5v0__fill_2
XFILLER_68_240 VDD VDD VSS VSS gf180mcu_fd_sc_mcu7t5v0__fillcap_4
XFILLER_56_413 VDD VDD VSS VSS gf180mcu_fd_sc_mcu7t5v0__fillcap_4
XTAP_TAPCELL_ROW_3_203 VDD VSS gf180mcu_fd_sc_mcu7t5v0__filltie
X_1408_ _1408_/A1 _1374_/I _1416_/S VDD VDD VSS VSS gf180mcu_fd_sc_mcu7t5v0__nor2_4
X_1339_ _1652_/Q wire715/Z _1339_/S _1652_/D VDD VDD VSS VSS gf180mcu_fd_sc_mcu7t5v0__mux2_2
XFILLER_24_387 VDD VDD VSS VSS gf180mcu_fd_sc_mcu7t5v0__fillcap_4
XFILLER_19_115 VDD VDD VSS VSS gf180mcu_fd_sc_mcu7t5v0__fillcap_8
XFILLER_19_72 VDD VDD VSS VSS gf180mcu_fd_sc_mcu7t5v0__fill_1
Xoutput390 _1676_/Q cfg_phase270_offset_x[17] VDD VDD VSS VSS gf180mcu_fd_sc_mcu7t5v0__buf_2
XFILLER_70_493 VDD VDD VSS VSS gf180mcu_fd_sc_mcu7t5v0__fillcap_32
XFILLER_42_151 VDD VDD VSS VSS gf180mcu_fd_sc_mcu7t5v0__fill_2
XFILLER_34_107 VDD VDD VSS VSS gf180mcu_fd_sc_mcu7t5v0__fillcap_4
XFILLER_34_118 VDD VDD VSS VSS gf180mcu_fd_sc_mcu7t5v0__fillcap_16
Xwire495 wire495/I wire495/Z VDD VDD VSS VSS gf180mcu_fd_sc_mcu7t5v0__clkbuf_2
Xwire484 _1378_/S _1381_/S VDD VDD VSS VSS gf180mcu_fd_sc_mcu7t5v0__buf_2
XFILLER_78_571 VDD VDD VSS VSS gf180mcu_fd_sc_mcu7t5v0__fill_2
XTAP_TAPCELL_ROW_68_717 VDD VSS gf180mcu_fd_sc_mcu7t5v0__filltie
Xload_slew478 _1261_/S _1262_/S VDD VDD VSS VSS gf180mcu_fd_sc_mcu7t5v0__clkbuf_1
XPHY_EDGE_ROW_29_Left_111 VDD VSS gf180mcu_fd_sc_mcu7t5v0__endcap
Xload_slew489 _1310_/S _1313_/S VDD VDD VSS VSS gf180mcu_fd_sc_mcu7t5v0__buf_4
XTAP_TAPCELL_ROW_76_783 VDD VSS gf180mcu_fd_sc_mcu7t5v0__filltie
XFILLER_65_298 VDD VDD VSS VSS gf180mcu_fd_sc_mcu7t5v0__fillcap_4
XFILLER_65_232 VDD VDD VSS VSS gf180mcu_fd_sc_mcu7t5v0__fillcap_4
X_1055_ _1055_/A1 wire553/I wire541/Z _1055_/B2 _1058_/A2 VDD VDD VSS VSS gf180mcu_fd_sc_mcu7t5v0__aoi22_1
X_1124_ _1124_/A1 _1176_/B1 _1154_/B1 _1124_/B2 _1642_/Q _1199_/A2 _1126_/A2 VDD VDD
+ VSS VSS gf180mcu_fd_sc_mcu7t5v0__aoi222_4
XFILLER_38_446 VDD VDD VSS VSS gf180mcu_fd_sc_mcu7t5v0__fill_1
XPHY_EDGE_ROW_38_Left_120 VDD VSS gf180mcu_fd_sc_mcu7t5v0__endcap
XFILLER_80_279 VDD VDD VSS VSS gf180mcu_fd_sc_mcu7t5v0__fillcap_16
XFILLER_21_324 VDD VDD VSS VSS gf180mcu_fd_sc_mcu7t5v0__fill_1
X_0908_ wire674/Z _0908_/A2 wire536/I VDD VDD VSS VSS gf180mcu_fd_sc_mcu7t5v0__nor2_4
X_0839_ _0918_/A1 _0839_/A2 wire604/I VDD VDD VSS VSS gf180mcu_fd_sc_mcu7t5v0__nor2_4
XFILLER_0_206 VDD VDD VSS VSS gf180mcu_fd_sc_mcu7t5v0__fillcap_32
Xinput129 cal_phase90_offset_y[8] _0930_/B2 VDD VDD VSS VSS gf180mcu_fd_sc_mcu7t5v0__buf_1
Xinput118 cal_phase90_offset_y[17] _0976_/B2 VDD VDD VSS VSS gf180mcu_fd_sc_mcu7t5v0__buf_1
Xinput107 cal_phase90_offset_x[7] _1234_/A1 VDD VDD VSS VSS gf180mcu_fd_sc_mcu7t5v0__buf_2
XFILLER_29_457 VDD VDD VSS VSS gf180mcu_fd_sc_mcu7t5v0__fill_1
XFILLER_56_276 VDD VDD VSS VSS gf180mcu_fd_sc_mcu7t5v0__fillcap_4
XFILLER_52_482 VDD VDD VSS VSS gf180mcu_fd_sc_mcu7t5v0__fill_1
XFILLER_44_438 VDD VDD VSS VSS gf180mcu_fd_sc_mcu7t5v0__fill_1
XTAP_TAPCELL_ROW_39_485 VDD VSS gf180mcu_fd_sc_mcu7t5v0__filltie
XFILLER_24_140 VDD VDD VSS VSS gf180mcu_fd_sc_mcu7t5v0__fill_1
XFILLER_8_317 VDD VDD VSS VSS gf180mcu_fd_sc_mcu7t5v0__fillcap_64
XTAP_TAPCELL_ROW_22_352 VDD VSS gf180mcu_fd_sc_mcu7t5v0__filltie
XFILLER_79_346 VDD VDD VSS VSS gf180mcu_fd_sc_mcu7t5v0__fillcap_4
XFILLER_47_298 VDD VDD VSS VSS gf180mcu_fd_sc_mcu7t5v0__fillcap_4
XFILLER_47_276 VDD VDD VSS VSS gf180mcu_fd_sc_mcu7t5v0__fillcap_4
XFILLER_7_64 VDD VDD VSS VSS gf180mcu_fd_sc_mcu7t5v0__fillcap_4
X_1673_ _1673_/D _1673_/RN clkload0/I _1673_/Q VDD VDD VSS VSS gf180mcu_fd_sc_mcu7t5v0__dffrnq_1
XFILLER_66_541 VDD VDD VSS VSS gf180mcu_fd_sc_mcu7t5v0__fill_1
XFILLER_58_508 VDD VDD VSS VSS gf180mcu_fd_sc_mcu7t5v0__fill_2
XFILLER_81_500 VDD VDD VSS VSS gf180mcu_fd_sc_mcu7t5v0__fillcap_8
X_1038_ _1038_/A1 _1123_/A2 wire529/Z input56/Z _1040_/A3 VDD VDD VSS VSS gf180mcu_fd_sc_mcu7t5v0__aoi22_1
XFILLER_53_224 VDD VDD VSS VSS gf180mcu_fd_sc_mcu7t5v0__fillcap_8
X_1107_ _1107_/A1 _1107_/A2 _1107_/A3 _1107_/A4 wire471/I VDD VDD VSS VSS gf180mcu_fd_sc_mcu7t5v0__nand4_2
XTAP_TAPCELL_ROW_36_466 VDD VSS gf180mcu_fd_sc_mcu7t5v0__filltie
XPHY_EDGE_ROW_5_Right_5 VDD VSS gf180mcu_fd_sc_mcu7t5v0__endcap
Xclkbuf_leaf_18_clk clkbuf_leaf_3_clk/I _1674_/CLK VDD VDD VSS VSS gf180mcu_fd_sc_mcu7t5v0__clkbuf_8
XFILLER_26_438 VDD VDD VSS VSS gf180mcu_fd_sc_mcu7t5v0__fill_1
Xmax_cap592 _1157_/A2 _1229_/A2 VDD VDD VSS VSS gf180mcu_fd_sc_mcu7t5v0__buf_4
XFILLER_67_58 VDD VDD VSS VSS gf180mcu_fd_sc_mcu7t5v0__fillcap_8
XFILLER_17_438 VDD VDD VSS VSS gf180mcu_fd_sc_mcu7t5v0__fillcap_8
XTAP_TAPCELL_ROW_70_734 VDD VSS gf180mcu_fd_sc_mcu7t5v0__filltie
XFILLER_44_279 VDD VDD VSS VSS gf180mcu_fd_sc_mcu7t5v0__fillcap_16
XFILLER_40_474 VDD VDD VSS VSS gf180mcu_fd_sc_mcu7t5v0__fill_1
XTAP_TAPCELL_ROW_78_801 VDD VSS gf180mcu_fd_sc_mcu7t5v0__filltie
XFILLER_35_279 VDD VDD VSS VSS gf180mcu_fd_sc_mcu7t5v0__fill_1
XTAP_TAPCELL_ROW_33_436 VDD VSS gf180mcu_fd_sc_mcu7t5v0__filltie
XFILLER_58_305 VDD VDD VSS VSS gf180mcu_fd_sc_mcu7t5v0__fill_1
X_1587_ _1587_/D wire863/I _1587_/CLK _1587_/Q VDD VDD VSS VSS gf180mcu_fd_sc_mcu7t5v0__dffrnq_2
Xclkbuf_leaf_7_clk clkbuf_leaf_8_clk/I clkload9/I VDD VDD VSS VSS gf180mcu_fd_sc_mcu7t5v0__clkbuf_8
X_1656_ _1656_/D _1657_/RN clkload1/I _1656_/Q VDD VDD VSS VSS gf180mcu_fd_sc_mcu7t5v0__dffrnq_1
XFILLER_66_382 VDD VDD VSS VSS gf180mcu_fd_sc_mcu7t5v0__fill_2
XFILLER_39_541 VDD VDD VSS VSS gf180mcu_fd_sc_mcu7t5v0__fill_2
XFILLER_22_463 VDD VDD VSS VSS gf180mcu_fd_sc_mcu7t5v0__fill_1
XFILLER_22_485 VDD VDD VSS VSS gf180mcu_fd_sc_mcu7t5v0__fill_1
XFILLER_43_60 VDD VDD VSS VSS gf180mcu_fd_sc_mcu7t5v0__fillcap_8
XTAP_TAPCELL_ROW_30_417 VDD VSS gf180mcu_fd_sc_mcu7t5v0__filltie
XFILLER_13_496 VDD VDD VSS VSS gf180mcu_fd_sc_mcu7t5v0__fill_1
X_1510_ _1510_/D _1510_/RN clkload6/I _1510_/Q VDD VDD VSS VSS gf180mcu_fd_sc_mcu7t5v0__dffrnq_2
X_1441_ _1461_/I0 _1513_/Q _1444_/S _1513_/D VDD VDD VSS VSS gf180mcu_fd_sc_mcu7t5v0__mux2_2
Xinput290 votes_in_phase_x[0] _0933_/A1 VDD VDD VSS VSS gf180mcu_fd_sc_mcu7t5v0__buf_1
XFILLER_55_319 VDD VDD VSS VSS gf180mcu_fd_sc_mcu7t5v0__fill_2
XFILLER_48_382 VDD VDD VSS VSS gf180mcu_fd_sc_mcu7t5v0__fill_2
X_1372_ _1674_/Q wire704/Z _1372_/S _1674_/D VDD VDD VSS VSS gf180mcu_fd_sc_mcu7t5v0__mux2_2
XTAP_TAPCELL_ROW_81_829 VDD VSS gf180mcu_fd_sc_mcu7t5v0__filltie
XFILLER_63_374 VDD VDD VSS VSS gf180mcu_fd_sc_mcu7t5v0__fill_1
XFILLER_63_352 VDD VDD VSS VSS gf180mcu_fd_sc_mcu7t5v0__fillcap_8
XFILLER_31_260 VDD VDD VSS VSS gf180mcu_fd_sc_mcu7t5v0__fillcap_4
XFILLER_16_290 VDD VDD VSS VSS gf180mcu_fd_sc_mcu7t5v0__fill_2
XFILLER_31_282 VDD VDD VSS VSS gf180mcu_fd_sc_mcu7t5v0__fillcap_8
XFILLER_48_49 VDD VDD VSS VSS gf180mcu_fd_sc_mcu7t5v0__fill_2
X_1639_ _1639_/D _1639_/RN _1659_/CLK _1639_/Q VDD VDD VSS VSS gf180mcu_fd_sc_mcu7t5v0__dffrnq_2
XFILLER_81_182 VDD VDD VSS VSS gf180mcu_fd_sc_mcu7t5v0__fill_1
XFILLER_64_37 VDD VDD VSS VSS gf180mcu_fd_sc_mcu7t5v0__fillcap_64
XFILLER_64_26 VDD VDD VSS VSS gf180mcu_fd_sc_mcu7t5v0__fillcap_8
XFILLER_54_374 VDD VDD VSS VSS gf180mcu_fd_sc_mcu7t5v0__fill_2
XFILLER_42_536 VDD VDD VSS VSS gf180mcu_fd_sc_mcu7t5v0__fillcap_4
XTAP_TAPCELL_ROW_1_186 VDD VSS gf180mcu_fd_sc_mcu7t5v0__filltie
Xload_slew819 _1677_/RN _1676_/RN VDD VDD VSS VSS gf180mcu_fd_sc_mcu7t5v0__clkbuf_2
XFILLER_1_142 VDD VDD VSS VSS gf180mcu_fd_sc_mcu7t5v0__fillcap_64
XFILLER_10_499 VDD VDD VSS VSS gf180mcu_fd_sc_mcu7t5v0__fill_1
Xload_slew808 _1647_/RN _1652_/RN VDD VDD VSS VSS gf180mcu_fd_sc_mcu7t5v0__clkbuf_1
XFILLER_77_488 VDD VDD VSS VSS gf180mcu_fd_sc_mcu7t5v0__fill_2
XFILLER_77_422 VDD VDD VSS VSS gf180mcu_fd_sc_mcu7t5v0__fillcap_32
XFILLER_77_400 VDD VDD VSS VSS gf180mcu_fd_sc_mcu7t5v0__fillcap_8
XFILLER_72_171 VDD VDD VSS VSS gf180mcu_fd_sc_mcu7t5v0__fillcap_4
X_0941_ _1633_/Q wire585/Z wire568/I _0941_/B2 _0943_/A2 VDD VDD VSS VSS gf180mcu_fd_sc_mcu7t5v0__aoi22_1
XTAP_TAPCELL_ROW_43_520 VDD VSS gf180mcu_fd_sc_mcu7t5v0__filltie
X_0872_ _1250_/A1 _1554_/Q _0812_/Z _0924_/A2 VDD VDD VSS VSS gf180mcu_fd_sc_mcu7t5v0__nand3_4
XTAP_TAPCELL_ROW_15_299 VDD VSS gf180mcu_fd_sc_mcu7t5v0__filltie
XFILLER_68_444 VDD VDD VSS VSS gf180mcu_fd_sc_mcu7t5v0__fillcap_8
XFILLER_48_2 VDD VDD VSS VSS gf180mcu_fd_sc_mcu7t5v0__fillcap_4
XFILLER_5_492 VDD VDD VSS VSS gf180mcu_fd_sc_mcu7t5v0__fillcap_32
X_1424_ _1424_/I0 _1500_/Q _1424_/S _1500_/D VDD VDD VSS VSS gf180mcu_fd_sc_mcu7t5v0__mux2_2
X_1355_ _1661_/Q _1355_/I1 _1358_/S _1661_/D VDD VDD VSS VSS gf180mcu_fd_sc_mcu7t5v0__mux2_2
XFILLER_68_477 VDD VDD VSS VSS gf180mcu_fd_sc_mcu7t5v0__fillcap_4
XFILLER_55_105 VDD VDD VSS VSS gf180mcu_fd_sc_mcu7t5v0__fill_1
XFILLER_36_341 VDD VDD VSS VSS gf180mcu_fd_sc_mcu7t5v0__fillcap_8
X_1286_ _1611_/Q _1355_/I1 _1292_/S _1611_/D VDD VDD VSS VSS gf180mcu_fd_sc_mcu7t5v0__mux2_2
Xclkload6 clkload6/I clkload6/Z VDD VDD VSS VSS gf180mcu_fd_sc_mcu7t5v0__clkbuf_2
XFILLER_59_400 VDD VDD VSS VSS gf180mcu_fd_sc_mcu7t5v0__fill_2
XTAP_TAPCELL_ROW_57_634 VDD VSS gf180mcu_fd_sc_mcu7t5v0__filltie
XTAP_TAPCELL_ROW_6_223 VDD VSS gf180mcu_fd_sc_mcu7t5v0__filltie
XFILLER_27_352 VDD VDD VSS VSS gf180mcu_fd_sc_mcu7t5v0__fillcap_4
Xwire644 wire644/I wire644/Z VDD VDD VSS VSS gf180mcu_fd_sc_mcu7t5v0__buf_1
Xwire600 wire600/I wire600/Z VDD VDD VSS VSS gf180mcu_fd_sc_mcu7t5v0__buf_2
XTAP_TAPCELL_ROW_12_269 VDD VSS gf180mcu_fd_sc_mcu7t5v0__filltie
Xload_slew627 _0893_/A2 _0921_/A1 VDD VDD VSS VSS gf180mcu_fd_sc_mcu7t5v0__buf_2
Xload_slew638 _0852_/A1 wire636/I VDD VDD VSS VSS gf180mcu_fd_sc_mcu7t5v0__buf_2
Xload_slew649 _0903_/A1 _0902_/A1 VDD VDD VSS VSS gf180mcu_fd_sc_mcu7t5v0__buf_2
Xload_slew616 wire617/Z _0869_/A2 VDD VDD VSS VSS gf180mcu_fd_sc_mcu7t5v0__buf_2
XFILLER_40_94 VDD VDD VSS VSS gf180mcu_fd_sc_mcu7t5v0__fill_2
XFILLER_2_451 VDD VDD VSS VSS gf180mcu_fd_sc_mcu7t5v0__fillcap_4
X_1140_ input71/Z _1140_/A2 _1200_/A2 input20/Z _1141_/A4 VDD VDD VSS VSS gf180mcu_fd_sc_mcu7t5v0__aoi22_1
X_1071_ _1620_/Q wire604/Z wire600/Z _1641_/Q _1072_/A4 VDD VDD VSS VSS gf180mcu_fd_sc_mcu7t5v0__aoi22_1
XFILLER_1_66 VDD VDD VSS VSS gf180mcu_fd_sc_mcu7t5v0__fillcap_4
XFILLER_18_330 VDD VDD VSS VSS gf180mcu_fd_sc_mcu7t5v0__fill_1
XFILLER_60_185 VDD VDD VSS VSS gf180mcu_fd_sc_mcu7t5v0__fill_1
X_0924_ _0924_/A1 _0924_/A2 wire511/I VDD VDD VSS VSS gf180mcu_fd_sc_mcu7t5v0__nor2_4
X_0786_ _1550_/Q _0784_/I _0786_/B _1550_/D VDD VDD VSS VSS gf180mcu_fd_sc_mcu7t5v0__aoi21_1
X_0855_ _0803_/Z _0881_/A2 _0898_/A2 VDD VDD VSS VSS gf180mcu_fd_sc_mcu7t5v0__nand2_4
XFILLER_56_436 VDD VDD VSS VSS gf180mcu_fd_sc_mcu7t5v0__fill_1
X_1338_ _1651_/Q _1338_/I1 _1339_/S _1651_/D VDD VDD VSS VSS gf180mcu_fd_sc_mcu7t5v0__mux2_2
X_1407_ _1487_/Q _1424_/I0 _1407_/S _1487_/D VDD VDD VSS VSS gf180mcu_fd_sc_mcu7t5v0__mux2_2
XTAP_TAPCELL_ROW_54_604 VDD VSS gf180mcu_fd_sc_mcu7t5v0__filltie
X_1269_ _1579_/Q _1578_/Q _1445_/A3 VDD VDD VSS VSS gf180mcu_fd_sc_mcu7t5v0__nor2_4
XTAP_TAPCELL_ROW_62_670 VDD VSS gf180mcu_fd_sc_mcu7t5v0__filltie
XFILLER_12_539 VDD VDD VSS VSS gf180mcu_fd_sc_mcu7t5v0__fill_1
Xoutput380 _1496_/Q cfg_phase0_offset_y[8] VDD VDD VSS VSS gf180mcu_fd_sc_mcu7t5v0__buf_2
XFILLER_10_53 VDD VDD VSS VSS gf180mcu_fd_sc_mcu7t5v0__fillcap_4
Xoutput391 _1677_/Q cfg_phase270_offset_x[18] VDD VDD VSS VSS gf180mcu_fd_sc_mcu7t5v0__buf_2
XFILLER_19_40 VDD VDD VSS VSS gf180mcu_fd_sc_mcu7t5v0__fillcap_4
XFILLER_42_174 VDD VDD VSS VSS gf180mcu_fd_sc_mcu7t5v0__fill_1
XFILLER_35_94 VDD VDD VSS VSS gf180mcu_fd_sc_mcu7t5v0__fillcap_4
XFILLER_35_72 VDD VDD VSS VSS gf180mcu_fd_sc_mcu7t5v0__fillcap_4
XFILLER_30_314 VDD VDD VSS VSS gf180mcu_fd_sc_mcu7t5v0__fill_1
XTAP_TAPCELL_ROW_25_372 VDD VSS gf180mcu_fd_sc_mcu7t5v0__filltie
Xwire496 wire496/I wire496/Z VDD VDD VSS VSS gf180mcu_fd_sc_mcu7t5v0__clkbuf_2
XTAP_TAPCELL_ROW_68_718 VDD VSS gf180mcu_fd_sc_mcu7t5v0__filltie
Xload_slew479 _1268_/S _1266_/S VDD VDD VSS VSS gf180mcu_fd_sc_mcu7t5v0__clkbuf_2
XFILLER_80_247 VDD VDD VSS VSS gf180mcu_fd_sc_mcu7t5v0__fillcap_32
XTAP_TAPCELL_ROW_76_784 VDD VSS gf180mcu_fd_sc_mcu7t5v0__filltie
X_1123_ _1123_/A1 _1123_/A2 _1228_/B1 input50/Z _1241_/B1 _1123_/C2 _1126_/A1 VDD
+ VDD VSS VSS gf180mcu_fd_sc_mcu7t5v0__aoi222_2
X_1054_ _1054_/A1 _1083_/A2 _1112_/A2 _1054_/B2 _1058_/A1 VDD VDD VSS VSS gf180mcu_fd_sc_mcu7t5v0__aoi22_1
X_0907_ _0907_/A1 _0907_/A2 wire539/I VDD VDD VSS VSS gf180mcu_fd_sc_mcu7t5v0__nor2_4
Xinput108 cal_phase90_offset_x[8] _0960_/A1 VDD VDD VSS VSS gf180mcu_fd_sc_mcu7t5v0__buf_1
X_0838_ _1559_/Q _1558_/Q _1560_/Q _0838_/Z VDD VDD VSS VSS gf180mcu_fd_sc_mcu7t5v0__or3_1
X_0769_ _1267_/I1 _1539_/Q _1466_/S _1539_/D VDD VDD VSS VSS gf180mcu_fd_sc_mcu7t5v0__mux2_2
Xinput119 cal_phase90_offset_y[18] _1023_/A1 VDD VDD VSS VSS gf180mcu_fd_sc_mcu7t5v0__buf_1
XTAP_TAPCELL_ROW_39_486 VDD VSS gf180mcu_fd_sc_mcu7t5v0__filltie
XFILLER_29_447 VDD VDD VSS VSS gf180mcu_fd_sc_mcu7t5v0__fill_2
XFILLER_72_37 VDD VDD VSS VSS gf180mcu_fd_sc_mcu7t5v0__fillcap_64
XFILLER_72_26 VDD VDD VSS VSS gf180mcu_fd_sc_mcu7t5v0__fillcap_8
XFILLER_12_303 VDD VDD VSS VSS gf180mcu_fd_sc_mcu7t5v0__fillcap_8
XFILLER_4_535 VDD VDD VSS VSS gf180mcu_fd_sc_mcu7t5v0__fillcap_4
XTAP_TAPCELL_ROW_22_353 VDD VSS gf180mcu_fd_sc_mcu7t5v0__filltie
XFILLER_62_247 VDD VDD VSS VSS gf180mcu_fd_sc_mcu7t5v0__fill_2
XFILLER_46_93 VDD VDD VSS VSS gf180mcu_fd_sc_mcu7t5v0__fill_2
XFILLER_30_177 VDD VDD VSS VSS gf180mcu_fd_sc_mcu7t5v0__fillcap_4
XFILLER_30_166 VDD VDD VSS VSS gf180mcu_fd_sc_mcu7t5v0__fill_1
XFILLER_30_111 VDD VDD VSS VSS gf180mcu_fd_sc_mcu7t5v0__fill_1
X_1672_ _1672_/D _1673_/RN clkload0/I _1672_/Q VDD VDD VSS VSS gf180mcu_fd_sc_mcu7t5v0__dffrnq_1
XFILLER_81_512 VDD VDD VSS VSS gf180mcu_fd_sc_mcu7t5v0__fillcap_4
X_1106_ _1106_/A1 _1194_/A2 wire568/Z _1106_/B2 _1107_/A4 VDD VDD VSS VSS gf180mcu_fd_sc_mcu7t5v0__aoi22_1
XFILLER_61_291 VDD VDD VSS VSS gf180mcu_fd_sc_mcu7t5v0__fillcap_8
X_1037_ _1511_/Q _1037_/A2 _1078_/A2 _1037_/B2 _1040_/A2 VDD VDD VSS VSS gf180mcu_fd_sc_mcu7t5v0__aoi22_1
XTAP_TAPCELL_ROW_36_467 VDD VSS gf180mcu_fd_sc_mcu7t5v0__filltie
Xinput90 cal_phase90_offset_x[10] input90/Z VDD VDD VSS VSS gf180mcu_fd_sc_mcu7t5v0__buf_1
XFILLER_76_317 VDD VDD VSS VSS gf180mcu_fd_sc_mcu7t5v0__fillcap_64
XFILLER_67_26 VDD VDD VSS VSS gf180mcu_fd_sc_mcu7t5v0__fillcap_32
XFILLER_72_523 VDD VDD VSS VSS gf180mcu_fd_sc_mcu7t5v0__fill_2
XFILLER_44_247 VDD VDD VSS VSS gf180mcu_fd_sc_mcu7t5v0__fillcap_32
XTAP_TAPCELL_ROW_70_735 VDD VSS gf180mcu_fd_sc_mcu7t5v0__filltie
XPHY_EDGE_ROW_57_Left_139 VDD VSS gf180mcu_fd_sc_mcu7t5v0__endcap
XFILLER_12_155 VDD VDD VSS VSS gf180mcu_fd_sc_mcu7t5v0__fillcap_16
XFILLER_12_177 VDD VDD VSS VSS gf180mcu_fd_sc_mcu7t5v0__fillcap_4
XPHY_EDGE_ROW_11_Right_11 VDD VSS gf180mcu_fd_sc_mcu7t5v0__endcap
XFILLER_16_96 VDD VDD VSS VSS gf180mcu_fd_sc_mcu7t5v0__fill_1
XFILLER_4_387 VDD VDD VSS VSS gf180mcu_fd_sc_mcu7t5v0__fillcap_64
XPHY_EDGE_ROW_20_Right_20 VDD VSS gf180mcu_fd_sc_mcu7t5v0__endcap
XTAP_TAPCELL_ROW_78_802 VDD VSS gf180mcu_fd_sc_mcu7t5v0__filltie
XPHY_EDGE_ROW_66_Left_148 VDD VSS gf180mcu_fd_sc_mcu7t5v0__endcap
XFILLER_63_534 VDD VDD VSS VSS gf180mcu_fd_sc_mcu7t5v0__fillcap_8
XFILLER_50_217 VDD VDD VSS VSS gf180mcu_fd_sc_mcu7t5v0__fillcap_4
XFILLER_35_214 VDD VDD VSS VSS gf180mcu_fd_sc_mcu7t5v0__fill_1
XTAP_TAPCELL_ROW_33_437 VDD VSS gf180mcu_fd_sc_mcu7t5v0__filltie
XFILLER_16_461 VDD VDD VSS VSS gf180mcu_fd_sc_mcu7t5v0__fill_2
XFILLER_78_2 VDD VDD VSS VSS gf180mcu_fd_sc_mcu7t5v0__fillcap_32
XPHY_EDGE_ROW_75_Left_157 VDD VSS gf180mcu_fd_sc_mcu7t5v0__endcap
XFILLER_58_317 VDD VDD VSS VSS gf180mcu_fd_sc_mcu7t5v0__fill_2
X_1586_ _1586_/D _1593_/RN _1593_/CLK _1586_/Q VDD VDD VSS VSS gf180mcu_fd_sc_mcu7t5v0__dffrnq_1
X_1655_ _1655_/D _1661_/RN _1663_/CLK _1655_/Q VDD VDD VSS VSS gf180mcu_fd_sc_mcu7t5v0__dffrnq_2
XFILLER_81_342 VDD VDD VSS VSS gf180mcu_fd_sc_mcu7t5v0__fillcap_32
XTAP_TAPCELL_ROW_49_570 VDD VSS gf180mcu_fd_sc_mcu7t5v0__filltie
XFILLER_22_431 VDD VDD VSS VSS gf180mcu_fd_sc_mcu7t5v0__fill_2
XFILLER_1_346 VDD VDD VSS VSS gf180mcu_fd_sc_mcu7t5v0__fillcap_4
XFILLER_32_228 VDD VDD VSS VSS gf180mcu_fd_sc_mcu7t5v0__fill_1
XFILLER_43_72 VDD VDD VSS VSS gf180mcu_fd_sc_mcu7t5v0__fillcap_32
XFILLER_40_272 VDD VDD VSS VSS gf180mcu_fd_sc_mcu7t5v0__fill_2
XTAP_TAPCELL_ROW_30_418 VDD VSS gf180mcu_fd_sc_mcu7t5v0__filltie
X_1440_ _1440_/A1 _1444_/S _1440_/B _1512_/D VDD VDD VSS VSS gf180mcu_fd_sc_mcu7t5v0__oai21_1
X_1371_ _1673_/Q _1400_/I1 _1371_/S _1673_/D VDD VDD VSS VSS gf180mcu_fd_sc_mcu7t5v0__mux2_2
Xinput291 votes_in_phase_x[1] _1007_/A1 VDD VDD VSS VSS gf180mcu_fd_sc_mcu7t5v0__buf_1
XFILLER_67_136 VDD VDD VSS VSS gf180mcu_fd_sc_mcu7t5v0__fillcap_4
XFILLER_67_158 VDD VDD VSS VSS gf180mcu_fd_sc_mcu7t5v0__fillcap_4
Xinput280 raw_edge3_y[7] _1232_/B2 VDD VDD VSS VSS gf180mcu_fd_sc_mcu7t5v0__buf_1
XTAP_TAPCELL_ROW_46_540 VDD VSS gf180mcu_fd_sc_mcu7t5v0__filltie
X_1638_ _1638_/D wire785/Z _1670_/CLK _1638_/Q VDD VDD VSS VSS gf180mcu_fd_sc_mcu7t5v0__dffrnq_1
X_1569_ _1569_/D _1569_/RN _1575_/CLK _1569_/Q VDD VDD VSS VSS gf180mcu_fd_sc_mcu7t5v0__dffrnq_1
XFILLER_58_103 VDD VDD VSS VSS gf180mcu_fd_sc_mcu7t5v0__fill_2
XFILLER_46_309 VDD VDD VSS VSS gf180mcu_fd_sc_mcu7t5v0__fillcap_4
XFILLER_81_172 VDD VDD VSS VSS gf180mcu_fd_sc_mcu7t5v0__fillcap_8
XFILLER_39_372 VDD VDD VSS VSS gf180mcu_fd_sc_mcu7t5v0__fill_1
XTAP_TAPCELL_ROW_1_187 VDD VSS gf180mcu_fd_sc_mcu7t5v0__filltie
XFILLER_14_239 VDD VDD VSS VSS gf180mcu_fd_sc_mcu7t5v0__fillcap_4
XFILLER_80_37 VDD VDD VSS VSS gf180mcu_fd_sc_mcu7t5v0__fillcap_64
XFILLER_22_261 VDD VDD VSS VSS gf180mcu_fd_sc_mcu7t5v0__fill_1
XFILLER_49_103 VDD VDD VSS VSS gf180mcu_fd_sc_mcu7t5v0__fillcap_16
Xload_slew809 _1634_/RN _1647_/RN VDD VDD VSS VSS gf180mcu_fd_sc_mcu7t5v0__clkbuf_2
XFILLER_64_139 VDD VDD VSS VSS gf180mcu_fd_sc_mcu7t5v0__fill_1
XFILLER_49_136 VDD VDD VSS VSS gf180mcu_fd_sc_mcu7t5v0__fillcap_4
XFILLER_60_312 VDD VDD VSS VSS gf180mcu_fd_sc_mcu7t5v0__fill_2
X_0940_ input33/Z _1120_/A2 wire604/Z wire698/Z wire603/Z _0940_/C2 _0943_/A1 VDD
+ VDD VSS VSS gf180mcu_fd_sc_mcu7t5v0__aoi222_2
XTAP_TAPCELL_ROW_43_521 VDD VSS gf180mcu_fd_sc_mcu7t5v0__filltie
X_0871_ _0871_/A1 _0913_/A2 wire576/I VDD VDD VSS VSS gf180mcu_fd_sc_mcu7t5v0__nor2_4
XFILLER_9_276 VDD VDD VSS VSS gf180mcu_fd_sc_mcu7t5v0__fillcap_4
XFILLER_68_401 VDD VDD VSS VSS gf180mcu_fd_sc_mcu7t5v0__fillcap_4
X_1285_ _1610_/Q wire754/I _1292_/S _1610_/D VDD VDD VSS VSS gf180mcu_fd_sc_mcu7t5v0__mux2_2
X_1423_ _1440_/A1 _1427_/S _1423_/B _1499_/D VDD VDD VSS VSS gf180mcu_fd_sc_mcu7t5v0__oai21_1
X_1354_ _1660_/Q _1365_/I1 _1361_/S _1660_/D VDD VDD VSS VSS gf180mcu_fd_sc_mcu7t5v0__mux2_2
XFILLER_63_150 VDD VDD VSS VSS gf180mcu_fd_sc_mcu7t5v0__fillcap_8
XFILLER_55_139 VDD VDD VSS VSS gf180mcu_fd_sc_mcu7t5v0__fill_1
XFILLER_51_356 VDD VDD VSS VSS gf180mcu_fd_sc_mcu7t5v0__fill_2
XFILLER_48_191 VDD VDD VSS VSS gf180mcu_fd_sc_mcu7t5v0__fillcap_16
Xclkload7 clkload7/I clkload7/Z VDD VDD VSS VSS gf180mcu_fd_sc_mcu7t5v0__clkbuf_2
XTAP_TAPCELL_ROW_6_224 VDD VSS gf180mcu_fd_sc_mcu7t5v0__filltie
XFILLER_59_489 VDD VDD VSS VSS gf180mcu_fd_sc_mcu7t5v0__fill_1
XTAP_TAPCELL_ROW_57_635 VDD VSS gf180mcu_fd_sc_mcu7t5v0__filltie
XFILLER_54_172 VDD VDD VSS VSS gf180mcu_fd_sc_mcu7t5v0__fill_2
XFILLER_42_367 VDD VDD VSS VSS gf180mcu_fd_sc_mcu7t5v0__fillcap_4
XFILLER_15_559 VDD VDD VSS VSS gf180mcu_fd_sc_mcu7t5v0__fill_1
Xwire667 wire667/I wire667/Z VDD VDD VSS VSS gf180mcu_fd_sc_mcu7t5v0__clkbuf_2
Xwire645 wire645/I wire645/Z VDD VDD VSS VSS gf180mcu_fd_sc_mcu7t5v0__clkbuf_1
Xload_slew639 _0840_/Z _0922_/A1 VDD VDD VSS VSS gf180mcu_fd_sc_mcu7t5v0__buf_2
Xload_slew628 _0854_/A1 _0880_/A2 VDD VDD VSS VSS gf180mcu_fd_sc_mcu7t5v0__clkbuf_4
XFILLER_73_492 VDD VDD VSS VSS gf180mcu_fd_sc_mcu7t5v0__fillcap_32
XFILLER_45_183 VDD VDD VSS VSS gf180mcu_fd_sc_mcu7t5v0__fillcap_16
X_1070_ _1070_/A1 _1176_/B1 _1070_/B1 _1070_/B2 _1072_/A3 VDD VDD VSS VSS gf180mcu_fd_sc_mcu7t5v0__aoi22_1
XFILLER_37_139 VDD VDD VSS VSS gf180mcu_fd_sc_mcu7t5v0__fill_1
X_0854_ _0854_/A1 _0891_/A2 _1086_/A2 VDD VDD VSS VSS gf180mcu_fd_sc_mcu7t5v0__nor2_4
X_0923_ _0923_/A1 _0923_/A2 _1116_/B1 VDD VDD VSS VSS gf180mcu_fd_sc_mcu7t5v0__nor2_4
X_0785_ _1550_/Q wire667/Z _0786_/B VDD VDD VSS VSS gf180mcu_fd_sc_mcu7t5v0__nor2_1
XPHY_EDGE_ROW_49_Right_49 VDD VSS gf180mcu_fd_sc_mcu7t5v0__endcap
XFILLER_68_253 VDD VDD VSS VSS gf180mcu_fd_sc_mcu7t5v0__fill_1
X_1268_ _1567_/Q wire711/I _1268_/S _1590_/D VDD VDD VSS VSS gf180mcu_fd_sc_mcu7t5v0__mux2_2
XPHY_EDGE_ROW_58_Right_58 VDD VSS gf180mcu_fd_sc_mcu7t5v0__endcap
X_1406_ _1486_/Q _1586_/Q _1406_/S _1486_/D VDD VDD VSS VSS gf180mcu_fd_sc_mcu7t5v0__mux2_2
X_1337_ _1650_/Q _1358_/I1 _1340_/S _1650_/D VDD VDD VSS VSS gf180mcu_fd_sc_mcu7t5v0__mux2_2
XFILLER_71_418 VDD VDD VSS VSS gf180mcu_fd_sc_mcu7t5v0__fill_2
XTAP_TAPCELL_ROW_62_671 VDD VSS gf180mcu_fd_sc_mcu7t5v0__filltie
XTAP_TAPCELL_ROW_54_605 VDD VSS gf180mcu_fd_sc_mcu7t5v0__filltie
XFILLER_51_131 VDD VDD VSS VSS gf180mcu_fd_sc_mcu7t5v0__fillcap_8
X_1199_ _1644_/Q _1199_/A2 _1199_/B1 input3/Z _1201_/A3 VDD VDD VSS VSS gf180mcu_fd_sc_mcu7t5v0__aoi22_1
XFILLER_36_150 VDD VDD VSS VSS gf180mcu_fd_sc_mcu7t5v0__fill_1
XPHY_EDGE_ROW_67_Right_67 VDD VSS gf180mcu_fd_sc_mcu7t5v0__endcap
XFILLER_10_10 VDD VDD VSS VSS gf180mcu_fd_sc_mcu7t5v0__fillcap_4
Xoutput392 _1678_/Q cfg_phase270_offset_x[19] VDD VDD VSS VSS gf180mcu_fd_sc_mcu7t5v0__buf_2
Xoutput370 _1485_/Q cfg_phase0_offset_y[18] VDD VDD VSS VSS gf180mcu_fd_sc_mcu7t5v0__buf_2
Xoutput381 _1497_/Q cfg_phase0_offset_y[9] VDD VDD VSS VSS gf180mcu_fd_sc_mcu7t5v0__buf_2
XPHY_EDGE_ROW_76_Right_76 VDD VSS gf180mcu_fd_sc_mcu7t5v0__endcap
XFILLER_55_492 VDD VDD VSS VSS gf180mcu_fd_sc_mcu7t5v0__fill_2
XFILLER_19_139 VDD VDD VSS VSS gf180mcu_fd_sc_mcu7t5v0__fill_1
XFILLER_51_72 VDD VDD VSS VSS gf180mcu_fd_sc_mcu7t5v0__fillcap_16
XFILLER_42_153 VDD VDD VSS VSS gf180mcu_fd_sc_mcu7t5v0__fill_1
XFILLER_11_562 VDD VDD VSS VSS gf180mcu_fd_sc_mcu7t5v0__fillcap_4
XTAP_TAPCELL_ROW_25_373 VDD VSS gf180mcu_fd_sc_mcu7t5v0__filltie
Xwire497 wire497/I wire497/Z VDD VDD VSS VSS gf180mcu_fd_sc_mcu7t5v0__buf_1
Xwire486 _1346_/S _1350_/S VDD VDD VSS VSS gf180mcu_fd_sc_mcu7t5v0__buf_2
XFILLER_78_573 VDD VDD VSS VSS gf180mcu_fd_sc_mcu7t5v0__fill_1
XTAP_TAPCELL_ROW_68_719 VDD VSS gf180mcu_fd_sc_mcu7t5v0__filltie
XFILLER_65_212 VDD VDD VSS VSS gf180mcu_fd_sc_mcu7t5v0__fillcap_4
X_1122_ _1122_/A1 _1122_/A2 _1122_/A3 _1122_/A4 _1131_/A2 VDD VDD VSS VSS gf180mcu_fd_sc_mcu7t5v0__nand4_1
XTAP_TAPCELL_ROW_76_785 VDD VSS gf180mcu_fd_sc_mcu7t5v0__filltie
X_1053_ _1053_/A1 _1053_/A2 _1053_/A3 _1053_/A4 _1059_/A3 VDD VDD VSS VSS gf180mcu_fd_sc_mcu7t5v0__nand4_1
X_0837_ _1556_/Q _1254_/A1 _0883_/A3 _0918_/A1 VDD VDD VSS VSS gf180mcu_fd_sc_mcu7t5v0__nand3_4
X_0906_ _0906_/A1 _0915_/A2 _1228_/B1 VDD VDD VSS VSS gf180mcu_fd_sc_mcu7t5v0__nor2_4
Xinput109 cal_phase90_offset_x[9] _0972_/C2 VDD VDD VSS VSS gf180mcu_fd_sc_mcu7t5v0__buf_2
X_0768_ wire725/I _1538_/Q _1466_/S _1538_/D VDD VDD VSS VSS gf180mcu_fd_sc_mcu7t5v0__mux2_2
XTAP_TAPCELL_ROW_39_487 VDD VSS gf180mcu_fd_sc_mcu7t5v0__filltie
XFILLER_37_492 VDD VDD VSS VSS gf180mcu_fd_sc_mcu7t5v0__fill_2
XFILLER_12_337 VDD VDD VSS VSS gf180mcu_fd_sc_mcu7t5v0__fillcap_8
XTAP_TAPCELL_ROW_22_354 VDD VSS gf180mcu_fd_sc_mcu7t5v0__filltie
XFILLER_47_212 VDD VDD VSS VSS gf180mcu_fd_sc_mcu7t5v0__fillcap_64
XFILLER_15_142 VDD VDD VSS VSS gf180mcu_fd_sc_mcu7t5v0__fillcap_8
XFILLER_7_352 VDD VDD VSS VSS gf180mcu_fd_sc_mcu7t5v0__fillcap_64
X_1671_ _1671_/D _1674_/RN clkload3/I _1671_/Q VDD VDD VSS VSS gf180mcu_fd_sc_mcu7t5v0__dffrnq_2
XFILLER_81_546 VDD VDD VSS VSS gf180mcu_fd_sc_mcu7t5v0__fillcap_8
XFILLER_78_381 VDD VDD VSS VSS gf180mcu_fd_sc_mcu7t5v0__fillcap_4
X_1105_ _1105_/A1 _1105_/A2 wire548/I _1628_/Q _1107_/A3 VDD VDD VSS VSS gf180mcu_fd_sc_mcu7t5v0__aoi22_1
X_1036_ _1036_/A1 _1036_/A2 wire570/I _1036_/B2 _1040_/A1 VDD VDD VSS VSS gf180mcu_fd_sc_mcu7t5v0__aoi22_1
XFILLER_21_101 VDD VDD VSS VSS gf180mcu_fd_sc_mcu7t5v0__fill_1
Xinput80 cal_phase270_offset_y[20] input80/Z VDD VDD VSS VSS gf180mcu_fd_sc_mcu7t5v0__buf_2
Xinput91 cal_phase90_offset_x[11] input91/Z VDD VDD VSS VSS gf180mcu_fd_sc_mcu7t5v0__buf_1
XTAP_TAPCELL_ROW_70_736 VDD VSS gf180mcu_fd_sc_mcu7t5v0__filltie
XFILLER_25_473 VDD VDD VSS VSS gf180mcu_fd_sc_mcu7t5v0__fill_2
XFILLER_52_292 VDD VDD VSS VSS gf180mcu_fd_sc_mcu7t5v0__fillcap_8
XFILLER_40_454 VDD VDD VSS VSS gf180mcu_fd_sc_mcu7t5v0__fill_1
XFILLER_32_41 VDD VDD VSS VSS gf180mcu_fd_sc_mcu7t5v0__fill_1
XTAP_TAPCELL_ROW_78_803 VDD VSS gf180mcu_fd_sc_mcu7t5v0__filltie
XFILLER_4_311 VDD VDD VSS VSS gf180mcu_fd_sc_mcu7t5v0__fillcap_4
XFILLER_75_384 VDD VDD VSS VSS gf180mcu_fd_sc_mcu7t5v0__fillcap_8
XTAP_TAPCELL_ROW_33_438 VDD VSS gf180mcu_fd_sc_mcu7t5v0__filltie
XFILLER_16_451 VDD VDD VSS VSS gf180mcu_fd_sc_mcu7t5v0__fillcap_4
XFILLER_16_495 VDD VDD VSS VSS gf180mcu_fd_sc_mcu7t5v0__fill_1
XFILLER_31_498 VDD VDD VSS VSS gf180mcu_fd_sc_mcu7t5v0__fill_2
X_1654_ _1654_/D _1654_/RN clkload3/I _1654_/Q VDD VDD VSS VSS gf180mcu_fd_sc_mcu7t5v0__dffrnq_2
X_1585_ _1585_/D _1585_/RN _1597_/CLK _1585_/Q VDD VDD VSS VSS gf180mcu_fd_sc_mcu7t5v0__dffrnq_1
Xfanout629 _0840_/Z _0852_/A1 VDD VDD VSS VSS gf180mcu_fd_sc_mcu7t5v0__dlyb_1
XFILLER_39_543 VDD VDD VSS VSS gf180mcu_fd_sc_mcu7t5v0__fill_1
XFILLER_81_376 VDD VDD VSS VSS gf180mcu_fd_sc_mcu7t5v0__fillcap_16
XFILLER_66_384 VDD VDD VSS VSS gf180mcu_fd_sc_mcu7t5v0__fill_1
XFILLER_66_351 VDD VDD VSS VSS gf180mcu_fd_sc_mcu7t5v0__fillcap_8
X_1019_ input48/Z _1154_/A2 _1045_/A1 VDD VDD VSS VSS gf180mcu_fd_sc_mcu7t5v0__nand2_1
XTAP_TAPCELL_ROW_49_571 VDD VSS gf180mcu_fd_sc_mcu7t5v0__filltie
XPHY_EDGE_ROW_14_Left_96 VDD VSS gf180mcu_fd_sc_mcu7t5v0__endcap
XFILLER_78_37 VDD VDD VSS VSS gf180mcu_fd_sc_mcu7t5v0__fillcap_64
XFILLER_49_307 VDD VDD VSS VSS gf180mcu_fd_sc_mcu7t5v0__fillcap_4
XFILLER_72_387 VDD VDD VSS VSS gf180mcu_fd_sc_mcu7t5v0__fillcap_8
XFILLER_40_240 VDD VDD VSS VSS gf180mcu_fd_sc_mcu7t5v0__fillcap_4
XTAP_TAPCELL_ROW_30_419 VDD VSS gf180mcu_fd_sc_mcu7t5v0__filltie
XFILLER_9_414 VDD VDD VSS VSS gf180mcu_fd_sc_mcu7t5v0__fillcap_4
XFILLER_4_34 VDD VDD VSS VSS gf180mcu_fd_sc_mcu7t5v0__fill_1
X_1370_ _1672_/Q _1399_/I1 _1371_/S _1672_/D VDD VDD VSS VSS gf180mcu_fd_sc_mcu7t5v0__mux2_2
Xinput292 votes_in_phase_x[2] _1037_/B2 VDD VDD VSS VSS gf180mcu_fd_sc_mcu7t5v0__buf_1
XFILLER_63_365 VDD VDD VSS VSS gf180mcu_fd_sc_mcu7t5v0__fill_1
Xinput281 raw_edge3_y[8] _0941_/B2 VDD VDD VSS VSS gf180mcu_fd_sc_mcu7t5v0__buf_1
Xinput270 raw_edge3_y[17] _0997_/B2 VDD VDD VSS VSS gf180mcu_fd_sc_mcu7t5v0__buf_1
XFILLER_48_384 VDD VDD VSS VSS gf180mcu_fd_sc_mcu7t5v0__fill_1
XTAP_TAPCELL_ROW_46_541 VDD VSS gf180mcu_fd_sc_mcu7t5v0__filltie
XFILLER_36_524 VDD VDD VSS VSS gf180mcu_fd_sc_mcu7t5v0__fill_1
XFILLER_16_292 VDD VDD VSS VSS gf180mcu_fd_sc_mcu7t5v0__fill_1
X_1637_ _1637_/D _1637_/RN _1663_/CLK _1637_/Q VDD VDD VSS VSS gf180mcu_fd_sc_mcu7t5v0__dffrnq_2
XFILLER_66_170 VDD VDD VSS VSS gf180mcu_fd_sc_mcu7t5v0__fillcap_4
XFILLER_66_181 VDD VDD VSS VSS gf180mcu_fd_sc_mcu7t5v0__fill_2
X_1568_ _1568_/D _1569_/RN _1575_/CLK _1568_/Q VDD VDD VSS VSS gf180mcu_fd_sc_mcu7t5v0__dffrnq_1
XFILLER_58_115 VDD VDD VSS VSS gf180mcu_fd_sc_mcu7t5v0__fillcap_4
XFILLER_54_321 VDD VDD VSS VSS gf180mcu_fd_sc_mcu7t5v0__fill_1
XFILLER_39_362 VDD VDD VSS VSS gf180mcu_fd_sc_mcu7t5v0__fillcap_8
X_1499_ _1499_/D _1624_/RN _1624_/CLK _1499_/Q VDD VDD VSS VSS gf180mcu_fd_sc_mcu7t5v0__dffrnq_1
XFILLER_81_140 VDD VDD VSS VSS gf180mcu_fd_sc_mcu7t5v0__fill_1
XTAP_TAPCELL_ROW_52_588 VDD VSS gf180mcu_fd_sc_mcu7t5v0__filltie
Xwire805 wire805/I wire805/Z VDD VDD VSS VSS gf180mcu_fd_sc_mcu7t5v0__buf_1
XFILLER_13_10 VDD VDD VSS VSS gf180mcu_fd_sc_mcu7t5v0__fillcap_4
XTAP_TAPCELL_ROW_9_244 VDD VSS gf180mcu_fd_sc_mcu7t5v0__filltie
XFILLER_64_107 VDD VDD VSS VSS gf180mcu_fd_sc_mcu7t5v0__fillcap_32
XFILLER_60_302 VDD VDD VSS VSS gf180mcu_fd_sc_mcu7t5v0__fill_2
XFILLER_45_343 VDD VDD VSS VSS gf180mcu_fd_sc_mcu7t5v0__fillcap_4
X_0870_ _0812_/Z _0883_/A3 _0913_/A2 VDD VDD VSS VSS gf180mcu_fd_sc_mcu7t5v0__nand2_2
XFILLER_54_61 VDD VDD VSS VSS gf180mcu_fd_sc_mcu7t5v0__fill_2
XTAP_TAPCELL_ROW_43_522 VDD VSS gf180mcu_fd_sc_mcu7t5v0__filltie
XFILLER_41_571 VDD VDD VSS VSS gf180mcu_fd_sc_mcu7t5v0__fill_2
XFILLER_9_200 VDD VDD VSS VSS gf180mcu_fd_sc_mcu7t5v0__fillcap_8
X_1422_ _1499_/Q _1427_/S _1423_/B VDD VDD VSS VSS gf180mcu_fd_sc_mcu7t5v0__nand2_1
X_1284_ _1609_/Q _1332_/I1 _1292_/S _1609_/D VDD VDD VSS VSS gf180mcu_fd_sc_mcu7t5v0__mux2_2
X_1353_ _1659_/Q wire775/Z _1358_/S _1659_/D VDD VDD VSS VSS gf180mcu_fd_sc_mcu7t5v0__mux2_2
XFILLER_48_181 VDD VDD VSS VSS gf180mcu_fd_sc_mcu7t5v0__fill_2
XFILLER_36_365 VDD VDD VSS VSS gf180mcu_fd_sc_mcu7t5v0__fill_2
Xclkload8 clkload8/I clkload8/ZN VDD VDD VSS VSS gf180mcu_fd_sc_mcu7t5v0__inv_3
X_0999_ _0999_/A1 _1083_/A2 _1117_/B1 _0999_/B2 wire511/I input37/Z _1001_/A3 VDD
+ VDD VSS VSS gf180mcu_fd_sc_mcu7t5v0__aoi222_2
XTAP_TAPCELL_ROW_14_290 VDD VSS gf180mcu_fd_sc_mcu7t5v0__filltie
XTAP_TAPCELL_ROW_6_225 VDD VSS gf180mcu_fd_sc_mcu7t5v0__filltie
XFILLER_54_140 VDD VDD VSS VSS gf180mcu_fd_sc_mcu7t5v0__fillcap_32
XFILLER_46_107 VDD VDD VSS VSS gf180mcu_fd_sc_mcu7t5v0__fillcap_8
Xwire602 wire603/Z wire602/Z VDD VDD VSS VSS gf180mcu_fd_sc_mcu7t5v0__buf_2
XFILLER_42_335 VDD VDD VSS VSS gf180mcu_fd_sc_mcu7t5v0__fillcap_32
XFILLER_10_243 VDD VDD VSS VSS gf180mcu_fd_sc_mcu7t5v0__fill_2
Xwire668 wire668/I _0833_/S VDD VDD VSS VSS gf180mcu_fd_sc_mcu7t5v0__clkbuf_1
XFILLER_6_247 VDD VDD VSS VSS gf180mcu_fd_sc_mcu7t5v0__fillcap_64
XFILLER_77_276 VDD VDD VSS VSS gf180mcu_fd_sc_mcu7t5v0__fillcap_4
XFILLER_65_438 VDD VDD VSS VSS gf180mcu_fd_sc_mcu7t5v0__fill_1
XFILLER_49_72 VDD VDD VSS VSS gf180mcu_fd_sc_mcu7t5v0__fillcap_8
Xload_slew618 _0871_/A1 wire617/I VDD VDD VSS VSS gf180mcu_fd_sc_mcu7t5v0__buf_2
XFILLER_37_129 VDD VDD VSS VSS gf180mcu_fd_sc_mcu7t5v0__fill_1
XFILLER_33_302 VDD VDD VSS VSS gf180mcu_fd_sc_mcu7t5v0__fill_2
XFILLER_81_70 VDD VDD VSS VSS gf180mcu_fd_sc_mcu7t5v0__fillcap_16
X_0922_ _0922_/A1 _0922_/A2 _1056_/B1 VDD VDD VSS VSS gf180mcu_fd_sc_mcu7t5v0__nor2_4
X_0853_ _1257_/A1 _1558_/Q _1259_/A1 _0923_/A1 VDD VDD VSS VSS gf180mcu_fd_sc_mcu7t5v0__nand3_4
XTAP_TAPCELL_ROW_11_260 VDD VSS gf180mcu_fd_sc_mcu7t5v0__filltie
X_0784_ _0784_/I _0790_/A2 VDD VDD VSS VSS gf180mcu_fd_sc_mcu7t5v0__clkinv_1
X_1405_ _1485_/Q wire747/Z _1405_/S _1485_/D VDD VDD VSS VSS gf180mcu_fd_sc_mcu7t5v0__mux2_2
X_1267_ _1566_/Q _1267_/I1 _1268_/S _1589_/D VDD VDD VSS VSS gf180mcu_fd_sc_mcu7t5v0__mux2_2
XTAP_TAPCELL_ROW_54_606 VDD VSS gf180mcu_fd_sc_mcu7t5v0__filltie
Xinput1 cal_dir_x input1/Z VDD VDD VSS VSS gf180mcu_fd_sc_mcu7t5v0__buf_1
X_1198_ _1607_/Q _1198_/A2 _1229_/A2 input31/Z _1201_/A2 VDD VDD VSS VSS gf180mcu_fd_sc_mcu7t5v0__aoi22_1
X_1336_ wire685/Z _1339_/S _1336_/B _1649_/D VDD VDD VSS VSS gf180mcu_fd_sc_mcu7t5v0__aoi21_1
XFILLER_28_107 VDD VDD VSS VSS gf180mcu_fd_sc_mcu7t5v0__fill_2
XTAP_TAPCELL_ROW_62_672 VDD VSS gf180mcu_fd_sc_mcu7t5v0__filltie
XFILLER_51_121 VDD VDD VSS VSS gf180mcu_fd_sc_mcu7t5v0__fill_1
XFILLER_3_206 VDD VDD VSS VSS gf180mcu_fd_sc_mcu7t5v0__fillcap_4
XFILLER_59_232 VDD VDD VSS VSS gf180mcu_fd_sc_mcu7t5v0__fill_2
Xoutput360 _1647_/Q cfg_phase0_offset_x[9] VDD VDD VSS VSS gf180mcu_fd_sc_mcu7t5v0__buf_2
Xoutput371 _1486_/Q cfg_phase0_offset_y[19] VDD VDD VSS VSS gf180mcu_fd_sc_mcu7t5v0__buf_2
Xoutput382 _1680_/Q cfg_phase270_offset_x[0] VDD VDD VSS VSS gf180mcu_fd_sc_mcu7t5v0__buf_2
Xoutput393 _1468_/Q cfg_phase270_offset_x[1] VDD VDD VSS VSS gf180mcu_fd_sc_mcu7t5v0__buf_2
XFILLER_27_173 VDD VDD VSS VSS gf180mcu_fd_sc_mcu7t5v0__fill_2
XFILLER_15_313 VDD VDD VSS VSS gf180mcu_fd_sc_mcu7t5v0__fill_1
XTAP_TAPCELL_ROW_17_308 VDD VSS gf180mcu_fd_sc_mcu7t5v0__filltie
Xwire476 _1265_/S wire476/Z VDD VDD VSS VSS gf180mcu_fd_sc_mcu7t5v0__buf_1
XTAP_TAPCELL_ROW_25_374 VDD VSS gf180mcu_fd_sc_mcu7t5v0__filltie
Xwire498 wire498/I wire498/Z VDD VDD VSS VSS gf180mcu_fd_sc_mcu7t5v0__clkbuf_1
XPHY_EDGE_ROW_2_Left_84 VDD VSS gf180mcu_fd_sc_mcu7t5v0__endcap
Xwire487 _1340_/S _1339_/S VDD VDD VSS VSS gf180mcu_fd_sc_mcu7t5v0__buf_2
XTAP_TAPCELL_ROW_76_786 VDD VSS gf180mcu_fd_sc_mcu7t5v0__filltie
X_1052_ _1052_/A1 _1199_/B1 wire539/Z _1052_/B2 _1053_/A4 VDD VDD VSS VSS gf180mcu_fd_sc_mcu7t5v0__aoi22_1
X_1121_ _1613_/Q _1220_/A2 _1202_/A2 _1479_/Q _1122_/A4 VDD VDD VSS VSS gf180mcu_fd_sc_mcu7t5v0__aoi22_2
XFILLER_61_496 VDD VDD VSS VSS gf180mcu_fd_sc_mcu7t5v0__fill_2
XFILLER_61_485 VDD VDD VSS VSS gf180mcu_fd_sc_mcu7t5v0__fillcap_4
XFILLER_21_349 VDD VDD VSS VSS gf180mcu_fd_sc_mcu7t5v0__fill_1
X_0836_ _1555_/Q _1554_/Q _0883_/A3 VDD VDD VSS VSS gf180mcu_fd_sc_mcu7t5v0__nor2_4
X_0905_ _0905_/A1 _0911_/A2 wire541/I VDD VDD VSS VSS gf180mcu_fd_sc_mcu7t5v0__nor2_4
X_0767_ wire734/Z _1537_/Q _1466_/S _1537_/D VDD VDD VSS VSS gf180mcu_fd_sc_mcu7t5v0__mux2_2
XTAP_TAPCELL_ROW_39_488 VDD VSS gf180mcu_fd_sc_mcu7t5v0__filltie
X_1319_ _1319_/A1 _1316_/S _1319_/B _1636_/D VDD VDD VSS VSS gf180mcu_fd_sc_mcu7t5v0__oai21_1
XFILLER_12_349 VDD VDD VSS VSS gf180mcu_fd_sc_mcu7t5v0__fill_1
XFILLER_20_393 VDD VDD VSS VSS gf180mcu_fd_sc_mcu7t5v0__fillcap_8
XFILLER_21_10 VDD VDD VSS VSS gf180mcu_fd_sc_mcu7t5v0__fill_1
XTAP_TAPCELL_ROW_22_355 VDD VSS gf180mcu_fd_sc_mcu7t5v0__filltie
XFILLER_62_205 VDD VDD VSS VSS gf180mcu_fd_sc_mcu7t5v0__fill_1
XTAP_TAPCELL_ROW_73_756 VDD VSS gf180mcu_fd_sc_mcu7t5v0__filltie
XFILLER_15_154 VDD VDD VSS VSS gf180mcu_fd_sc_mcu7t5v0__fill_2
X_1670_ _1670_/D _1670_/RN _1670_/CLK _1670_/Q VDD VDD VSS VSS gf180mcu_fd_sc_mcu7t5v0__dffrnq_1
XFILLER_81_569 VDD VDD VSS VSS gf180mcu_fd_sc_mcu7t5v0__fillcap_4
XFILLER_81_558 VDD VDD VSS VSS gf180mcu_fd_sc_mcu7t5v0__fill_2
X_1104_ input28/Z _1157_/A2 _1112_/A2 _1104_/B2 _1107_/A2 VDD VDD VSS VSS gf180mcu_fd_sc_mcu7t5v0__aoi22_1
X_1035_ _1035_/A1 _1035_/A2 _1035_/A3 _1035_/A4 _1035_/Z VDD VDD VSS VSS gf180mcu_fd_sc_mcu7t5v0__and4_1
XFILLER_38_279 VDD VDD VSS VSS gf180mcu_fd_sc_mcu7t5v0__fillcap_16
XFILLER_34_463 VDD VDD VSS VSS gf180mcu_fd_sc_mcu7t5v0__fill_1
XFILLER_21_146 VDD VDD VSS VSS gf180mcu_fd_sc_mcu7t5v0__fill_2
Xinput70 cal_phase270_offset_y[11] input70/Z VDD VDD VSS VSS gf180mcu_fd_sc_mcu7t5v0__buf_2
Xinput81 cal_phase270_offset_y[2] input81/Z VDD VDD VSS VSS gf180mcu_fd_sc_mcu7t5v0__buf_1
X_0819_ _1549_/Q _1559_/Q _1558_/Q _0819_/A4 _0820_/C VDD VDD VSS VSS gf180mcu_fd_sc_mcu7t5v0__nand4_1
Xinput92 cal_phase90_offset_x[12] input92/Z VDD VDD VSS VSS gf180mcu_fd_sc_mcu7t5v0__buf_1
XFILLER_69_360 VDD VDD VSS VSS gf180mcu_fd_sc_mcu7t5v0__fill_1
Xload_slew790 _1657_/RN _1669_/RN VDD VDD VSS VSS gf180mcu_fd_sc_mcu7t5v0__buf_1
XFILLER_72_547 VDD VDD VSS VSS gf180mcu_fd_sc_mcu7t5v0__fill_2
XTAP_TAPCELL_ROW_70_737 VDD VSS gf180mcu_fd_sc_mcu7t5v0__filltie
XFILLER_40_422 VDD VDD VSS VSS gf180mcu_fd_sc_mcu7t5v0__fill_1
XFILLER_37_290 VDD VDD VSS VSS gf180mcu_fd_sc_mcu7t5v0__fillcap_4
XFILLER_16_10 VDD VDD VSS VSS gf180mcu_fd_sc_mcu7t5v0__fill_2
XFILLER_75_352 VDD VDD VSS VSS gf180mcu_fd_sc_mcu7t5v0__fillcap_32
XFILLER_57_72 VDD VDD VSS VSS gf180mcu_fd_sc_mcu7t5v0__fillcap_32
XTAP_TAPCELL_ROW_33_439 VDD VSS gf180mcu_fd_sc_mcu7t5v0__filltie
XFILLER_31_488 VDD VDD VSS VSS gf180mcu_fd_sc_mcu7t5v0__fill_2
XFILLER_16_463 VDD VDD VSS VSS gf180mcu_fd_sc_mcu7t5v0__fill_1
X_1584_ _1584_/D _1584_/RN clkload8/I _1584_/Q VDD VDD VSS VSS gf180mcu_fd_sc_mcu7t5v0__dffrnq_1
XPHY_EDGE_ROW_9_Right_9 VDD VSS gf180mcu_fd_sc_mcu7t5v0__endcap
X_1653_ _1653_/D _1653_/RN _1663_/CLK _1653_/Q VDD VDD VSS VSS gf180mcu_fd_sc_mcu7t5v0__dffrnq_1
XFILLER_66_363 VDD VDD VSS VSS gf180mcu_fd_sc_mcu7t5v0__fill_2
XFILLER_81_399 VDD VDD VSS VSS gf180mcu_fd_sc_mcu7t5v0__fillcap_8
XFILLER_41_208 VDD VDD VSS VSS gf180mcu_fd_sc_mcu7t5v0__fill_2
X_1018_ _1506_/Q _1143_/A2 _1030_/A1 VDD VDD VSS VSS gf180mcu_fd_sc_mcu7t5v0__nand2_1
XFILLER_72_311 VDD VDD VSS VSS gf180mcu_fd_sc_mcu7t5v0__fillcap_4
XFILLER_57_352 VDD VDD VSS VSS gf180mcu_fd_sc_mcu7t5v0__fillcap_4
XFILLER_45_503 VDD VDD VSS VSS gf180mcu_fd_sc_mcu7t5v0__fill_1
XFILLER_72_399 VDD VDD VSS VSS gf180mcu_fd_sc_mcu7t5v0__fill_2
XFILLER_60_506 VDD VDD VSS VSS gf180mcu_fd_sc_mcu7t5v0__fill_2
XFILLER_40_296 VDD VDD VSS VSS gf180mcu_fd_sc_mcu7t5v0__fillcap_16
XFILLER_40_274 VDD VDD VSS VSS gf180mcu_fd_sc_mcu7t5v0__fill_1
XFILLER_13_422 VDD VDD VSS VSS gf180mcu_fd_sc_mcu7t5v0__fillcap_4
XFILLER_25_282 VDD VDD VSS VSS gf180mcu_fd_sc_mcu7t5v0__fillcap_4
Xinput271 raw_edge3_y[18] _1046_/A1 VDD VDD VSS VSS gf180mcu_fd_sc_mcu7t5v0__buf_1
Xinput260 raw_edge3_x[8] _0933_/C2 VDD VDD VSS VSS gf180mcu_fd_sc_mcu7t5v0__buf_1
Xinput293 votes_in_phase_x[3] _1078_/A1 VDD VDD VSS VSS gf180mcu_fd_sc_mcu7t5v0__buf_1
Xinput282 raw_edge3_y[9] _0983_/A1 VDD VDD VSS VSS gf180mcu_fd_sc_mcu7t5v0__buf_1
XTAP_TAPCELL_ROW_46_542 VDD VSS gf180mcu_fd_sc_mcu7t5v0__filltie
XFILLER_16_282 VDD VDD VSS VSS gf180mcu_fd_sc_mcu7t5v0__fillcap_8
X_1567_ _1567_/D _1590_/RN clkload8/I _1567_/Q VDD VDD VSS VSS gf180mcu_fd_sc_mcu7t5v0__dffrnq_1
X_1636_ _1636_/D _1637_/RN _1663_/CLK _1636_/Q VDD VDD VSS VSS gf180mcu_fd_sc_mcu7t5v0__dffrnq_1
XFILLER_58_138 VDD VDD VSS VSS gf180mcu_fd_sc_mcu7t5v0__fillcap_4
XFILLER_39_352 VDD VDD VSS VSS gf180mcu_fd_sc_mcu7t5v0__fill_1
X_1498_ _1498_/D wire843/I clkload5/I _1498_/Q VDD VDD VSS VSS gf180mcu_fd_sc_mcu7t5v0__dffrnq_2
XFILLER_81_163 VDD VDD VSS VSS gf180mcu_fd_sc_mcu7t5v0__fillcap_4
XTAP_TAPCELL_ROW_52_589 VDD VSS gf180mcu_fd_sc_mcu7t5v0__filltie
XFILLER_10_403 VDD VDD VSS VSS gf180mcu_fd_sc_mcu7t5v0__fill_2
XFILLER_22_285 VDD VDD VSS VSS gf180mcu_fd_sc_mcu7t5v0__fill_2
Xwire828 wire829/I wire828/Z VDD VDD VSS VSS gf180mcu_fd_sc_mcu7t5v0__buf_1
XTAP_TAPCELL_ROW_9_245 VDD VSS gf180mcu_fd_sc_mcu7t5v0__filltie
XFILLER_60_325 VDD VDD VSS VSS gf180mcu_fd_sc_mcu7t5v0__fillcap_4
XFILLER_60_314 VDD VDD VSS VSS gf180mcu_fd_sc_mcu7t5v0__fill_1
XFILLER_54_84 VDD VDD VSS VSS gf180mcu_fd_sc_mcu7t5v0__fill_1
XTAP_TAPCELL_ROW_43_523 VDD VSS gf180mcu_fd_sc_mcu7t5v0__filltie
XFILLER_9_212 VDD VDD VSS VSS gf180mcu_fd_sc_mcu7t5v0__fillcap_64
XFILLER_13_241 VDD VDD VSS VSS gf180mcu_fd_sc_mcu7t5v0__fill_2
X_1421_ _1438_/I0 _1498_/Q _1424_/S _1498_/D VDD VDD VSS VSS gf180mcu_fd_sc_mcu7t5v0__mux2_2
XFILLER_68_469 VDD VDD VSS VSS gf180mcu_fd_sc_mcu7t5v0__fill_2
X_1283_ _1435_/A2 _1445_/A3 _1331_/A3 _1292_/S VDD VDD VSS VSS gf180mcu_fd_sc_mcu7t5v0__and3_4
X_1352_ _1343_/I _1402_/A4 _1358_/S VDD VDD VSS VSS gf180mcu_fd_sc_mcu7t5v0__nor2_4
XFILLER_51_336 VDD VDD VSS VSS gf180mcu_fd_sc_mcu7t5v0__fillcap_4
X_0998_ _0998_/A1 _0998_/A2 wire557/Z input2/Z _1001_/A2 VDD VDD VSS VSS gf180mcu_fd_sc_mcu7t5v0__aoi22_1
Xclkload9 clkload9/I clkload9/Z VDD VDD VSS VSS gf180mcu_fd_sc_mcu7t5v0__clkbuf_2
XTAP_TAPCELL_ROW_14_291 VDD VSS gf180mcu_fd_sc_mcu7t5v0__filltie
XTAP_TAPCELL_ROW_6_226 VDD VSS gf180mcu_fd_sc_mcu7t5v0__filltie
X_1619_ _1619_/D _1626_/RN clkload6/I _1619_/Q VDD VDD VSS VSS gf180mcu_fd_sc_mcu7t5v0__dffrnq_2
XTAP_TAPCELL_ROW_65_692 VDD VSS gf180mcu_fd_sc_mcu7t5v0__filltie
XFILLER_54_174 VDD VDD VSS VSS gf180mcu_fd_sc_mcu7t5v0__fill_1
XFILLER_42_314 VDD VDD VSS VSS gf180mcu_fd_sc_mcu7t5v0__fill_1
XFILLER_27_388 VDD VDD VSS VSS gf180mcu_fd_sc_mcu7t5v0__fill_1
XFILLER_27_311 VDD VDD VSS VSS gf180mcu_fd_sc_mcu7t5v0__fill_1
XFILLER_27_300 VDD VDD VSS VSS gf180mcu_fd_sc_mcu7t5v0__fill_1
Xwire636 wire636/I wire636/Z VDD VDD VSS VSS gf180mcu_fd_sc_mcu7t5v0__buf_1
Xwire603 wire603/I wire603/Z VDD VDD VSS VSS gf180mcu_fd_sc_mcu7t5v0__buf_2
Xload_slew608 _1235_/B _1177_/B VDD VDD VSS VSS gf180mcu_fd_sc_mcu7t5v0__buf_4
Xload_slew619 _0845_/A1 _0871_/A1 VDD VDD VSS VSS gf180mcu_fd_sc_mcu7t5v0__buf_2
XFILLER_58_491 VDD VDD VSS VSS gf180mcu_fd_sc_mcu7t5v0__fill_2
XFILLER_49_40 VDD VDD VSS VSS gf180mcu_fd_sc_mcu7t5v0__fillcap_8
Xfanout791 wire805/Z wire794/I VDD VDD VSS VSS gf180mcu_fd_sc_mcu7t5v0__dlyb_1
XFILLER_65_72 VDD VDD VSS VSS gf180mcu_fd_sc_mcu7t5v0__fillcap_64
XFILLER_60_177 VDD VDD VSS VSS gf180mcu_fd_sc_mcu7t5v0__fillcap_8
X_0921_ _0921_/A1 _0921_/A2 wire515/I VDD VDD VSS VSS gf180mcu_fd_sc_mcu7t5v0__nor2_4
XFILLER_45_130 VDD VDD VSS VSS gf180mcu_fd_sc_mcu7t5v0__fill_1
XFILLER_18_377 VDD VDD VSS VSS gf180mcu_fd_sc_mcu7t5v0__fillcap_8
X_0783_ _0834_/A1 _1594_/Q _1592_/D _0784_/I VDD VDD VSS VSS gf180mcu_fd_sc_mcu7t5v0__oai21_1
X_0852_ _0852_/A1 _0915_/A2 _1083_/A2 VDD VDD VSS VSS gf180mcu_fd_sc_mcu7t5v0__nor2_4
XTAP_TAPCELL_ROW_11_261 VDD VSS gf180mcu_fd_sc_mcu7t5v0__filltie
XFILLER_68_244 VDD VDD VSS VSS gf180mcu_fd_sc_mcu7t5v0__fill_1
XFILLER_46_2 VDD VDD VSS VSS gf180mcu_fd_sc_mcu7t5v0__fill_2
X_1335_ _1649_/Q _1339_/S _1336_/B VDD VDD VSS VSS gf180mcu_fd_sc_mcu7t5v0__nor2_1
X_1404_ _1484_/Q _1437_/I0 _1407_/S _1484_/D VDD VDD VSS VSS gf180mcu_fd_sc_mcu7t5v0__mux2_2
X_1266_ _1565_/Q _1266_/I1 _1266_/S _1588_/D VDD VDD VSS VSS gf180mcu_fd_sc_mcu7t5v0__mux2_2
Xinput2 cal_dir_y input2/Z VDD VDD VSS VSS gf180mcu_fd_sc_mcu7t5v0__buf_1
XFILLER_56_417 VDD VDD VSS VSS gf180mcu_fd_sc_mcu7t5v0__fill_1
X_1197_ _1197_/A1 _1197_/A2 _1197_/B1 _1197_/B2 _1197_/C _1212_/A3 VDD VDD VSS VSS
+ gf180mcu_fd_sc_mcu7t5v0__aoi221_4
XTAP_TAPCELL_ROW_54_607 VDD VSS gf180mcu_fd_sc_mcu7t5v0__filltie
XFILLER_24_314 VDD VDD VSS VSS gf180mcu_fd_sc_mcu7t5v0__fill_1
XTAP_TAPCELL_ROW_62_673 VDD VSS gf180mcu_fd_sc_mcu7t5v0__filltie
Xoutput361 _1488_/Q cfg_phase0_offset_y[0] VDD VDD VSS VSS gf180mcu_fd_sc_mcu7t5v0__buf_2
Xoutput350 _1636_/Q cfg_phase0_offset_x[19] VDD VDD VSS VSS gf180mcu_fd_sc_mcu7t5v0__buf_2
XFILLER_74_247 VDD VDD VSS VSS gf180mcu_fd_sc_mcu7t5v0__fillcap_64
Xoutput394 _1679_/Q cfg_phase270_offset_x[20] VDD VDD VSS VSS gf180mcu_fd_sc_mcu7t5v0__buf_2
Xoutput372 _1489_/Q cfg_phase0_offset_y[1] VDD VDD VSS VSS gf180mcu_fd_sc_mcu7t5v0__buf_2
Xoutput383 _1477_/Q cfg_phase270_offset_x[10] VDD VDD VSS VSS gf180mcu_fd_sc_mcu7t5v0__buf_2
XFILLER_42_177 VDD VDD VSS VSS gf180mcu_fd_sc_mcu7t5v0__fillcap_32
XTAP_TAPCELL_ROW_17_309 VDD VSS gf180mcu_fd_sc_mcu7t5v0__filltie
XTAP_TAPCELL_ROW_25_375 VDD VSS gf180mcu_fd_sc_mcu7t5v0__filltie
Xwire499 wire499/I wire499/Z VDD VDD VSS VSS gf180mcu_fd_sc_mcu7t5v0__buf_2
XTAP_TAPCELL_ROW_76_787 VDD VSS gf180mcu_fd_sc_mcu7t5v0__filltie
XFILLER_65_236 VDD VDD VSS VSS gf180mcu_fd_sc_mcu7t5v0__fill_1
X_1120_ input38/Z _1120_/A2 wire529/Z input59/Z _1122_/A3 VDD VDD VSS VSS gf180mcu_fd_sc_mcu7t5v0__aoi22_1
X_1051_ input18/Z _1230_/A2 wire535/Z _1051_/B2 _1053_/A3 VDD VDD VSS VSS gf180mcu_fd_sc_mcu7t5v0__aoi22_1
X_0904_ _0904_/A1 _0916_/A2 _1039_/B1 VDD VDD VSS VSS gf180mcu_fd_sc_mcu7t5v0__nor2_4
X_0835_ _1568_/Q _1014_/A1 _0969_/B VDD VDD VSS VSS gf180mcu_fd_sc_mcu7t5v0__nand2_1
X_0766_ wire690/Z _1466_/S _0766_/B _1536_/D VDD VDD VSS VSS gf180mcu_fd_sc_mcu7t5v0__oai21_1
XTAP_TAPCELL_ROW_67_710 VDD VSS gf180mcu_fd_sc_mcu7t5v0__filltie
XFILLER_56_236 VDD VDD VSS VSS gf180mcu_fd_sc_mcu7t5v0__fill_1
XFILLER_56_247 VDD VDD VSS VSS gf180mcu_fd_sc_mcu7t5v0__fill_2
X_1318_ _1636_/Q _1316_/S _1319_/B VDD VDD VSS VSS gf180mcu_fd_sc_mcu7t5v0__nand2_1
XFILLER_71_206 VDD VDD VSS VSS gf180mcu_fd_sc_mcu7t5v0__fillcap_4
XTAP_TAPCELL_ROW_39_489 VDD VSS gf180mcu_fd_sc_mcu7t5v0__filltie
X_1249_ _1577_/Q _1254_/A2 _1250_/B VDD VDD VSS VSS gf180mcu_fd_sc_mcu7t5v0__nand2_1
XFILLER_12_317 VDD VDD VSS VSS gf180mcu_fd_sc_mcu7t5v0__fillcap_4
XFILLER_24_100 VDD VDD VSS VSS gf180mcu_fd_sc_mcu7t5v0__fillcap_4
XFILLER_4_527 VDD VDD VSS VSS gf180mcu_fd_sc_mcu7t5v0__fillcap_8
XFILLER_21_99 VDD VDD VSS VSS gf180mcu_fd_sc_mcu7t5v0__fill_2
XFILLER_75_556 VDD VDD VSS VSS gf180mcu_fd_sc_mcu7t5v0__fillcap_4
XFILLER_46_85 VDD VDD VSS VSS gf180mcu_fd_sc_mcu7t5v0__fillcap_8
XFILLER_28_472 VDD VDD VSS VSS gf180mcu_fd_sc_mcu7t5v0__fill_1
XFILLER_28_450 VDD VDD VSS VSS gf180mcu_fd_sc_mcu7t5v0__fillcap_4
XTAP_TAPCELL_ROW_73_757 VDD VSS gf180mcu_fd_sc_mcu7t5v0__filltie
XFILLER_30_103 VDD VDD VSS VSS gf180mcu_fd_sc_mcu7t5v0__fill_2
XFILLER_7_68 VDD VDD VSS VSS gf180mcu_fd_sc_mcu7t5v0__fill_2
X_1103_ _1536_/Q _1217_/A2 _1103_/B1 _1103_/B2 _1107_/A1 VDD VDD VSS VSS gf180mcu_fd_sc_mcu7t5v0__aoi22_1
X_1034_ input35/Z _1091_/A2 wire548/I _1627_/Q _1035_/A4 VDD VDD VSS VSS gf180mcu_fd_sc_mcu7t5v0__aoi22_2
XFILLER_38_247 VDD VDD VSS VSS gf180mcu_fd_sc_mcu7t5v0__fillcap_32
XFILLER_21_136 VDD VDD VSS VSS gf180mcu_fd_sc_mcu7t5v0__fillcap_4
Xinput82 cal_phase270_offset_y[3] input82/Z VDD VDD VSS VSS gf180mcu_fd_sc_mcu7t5v0__buf_1
Xinput71 cal_phase270_offset_y[12] input71/Z VDD VDD VSS VSS gf180mcu_fd_sc_mcu7t5v0__buf_1
X_0818_ _0820_/B1 _0818_/A2 _0818_/B _1558_/D VDD VDD VSS VSS gf180mcu_fd_sc_mcu7t5v0__oai21_1
Xinput60 cal_phase270_offset_x[2] input60/Z VDD VDD VSS VSS gf180mcu_fd_sc_mcu7t5v0__buf_1
Xinput93 cal_phase90_offset_x[13] input93/Z VDD VDD VSS VSS gf180mcu_fd_sc_mcu7t5v0__buf_1
X_0749_ _1580_/Q _1593_/Q _0749_/A3 _0749_/Z VDD VDD VSS VSS gf180mcu_fd_sc_mcu7t5v0__and3_4
XFILLER_72_515 VDD VDD VSS VSS gf180mcu_fd_sc_mcu7t5v0__fillcap_8
XFILLER_29_236 VDD VDD VSS VSS gf180mcu_fd_sc_mcu7t5v0__fill_1
Xload_slew780 _1498_/Q _1052_/B2 VDD VDD VSS VSS gf180mcu_fd_sc_mcu7t5v0__buf_2
XTAP_TAPCELL_ROW_70_738 VDD VSS gf180mcu_fd_sc_mcu7t5v0__filltie
XFILLER_8_107 VDD VDD VSS VSS gf180mcu_fd_sc_mcu7t5v0__fillcap_64
XFILLER_25_464 VDD VDD VSS VSS gf180mcu_fd_sc_mcu7t5v0__fill_1
XPHY_EDGE_ROW_26_Left_108 VDD VSS gf180mcu_fd_sc_mcu7t5v0__endcap
XFILLER_79_136 VDD VDD VSS VSS gf180mcu_fd_sc_mcu7t5v0__fillcap_4
XFILLER_73_72 VDD VDD VSS VSS gf180mcu_fd_sc_mcu7t5v0__fillcap_64
XFILLER_50_209 VDD VDD VSS VSS gf180mcu_fd_sc_mcu7t5v0__fillcap_8
XPHY_EDGE_ROW_35_Left_117 VDD VSS gf180mcu_fd_sc_mcu7t5v0__endcap
X_1583_ _1583_/D _1584_/RN clkload8/I _1583_/Q VDD VDD VSS VSS gf180mcu_fd_sc_mcu7t5v0__dffrnq_1
XPHY_EDGE_ROW_44_Left_126 VDD VSS gf180mcu_fd_sc_mcu7t5v0__endcap
X_1652_ _1652_/D _1652_/RN _1659_/CLK _1652_/Q VDD VDD VSS VSS gf180mcu_fd_sc_mcu7t5v0__dffrnq_1
XFILLER_81_312 VDD VDD VSS VSS gf180mcu_fd_sc_mcu7t5v0__fill_1
XPHY_EDGE_ROW_53_Left_135 VDD VSS gf180mcu_fd_sc_mcu7t5v0__endcap
X_1017_ _1017_/A1 _1133_/A2 _1026_/A1 VDD VDD VSS VSS gf180mcu_fd_sc_mcu7t5v0__nand2_1
XFILLER_26_239 VDD VDD VSS VSS gf180mcu_fd_sc_mcu7t5v0__fillcap_4
XPHY_EDGE_ROW_62_Left_144 VDD VSS gf180mcu_fd_sc_mcu7t5v0__endcap
XPHY_EDGE_ROW_71_Left_153 VDD VSS gf180mcu_fd_sc_mcu7t5v0__endcap
XPHY_EDGE_ROW_80_Left_162 VDD VSS gf180mcu_fd_sc_mcu7t5v0__endcap
XFILLER_40_286 VDD VDD VSS VSS gf180mcu_fd_sc_mcu7t5v0__fill_2
XFILLER_13_489 VDD VDD VSS VSS gf180mcu_fd_sc_mcu7t5v0__fill_1
Xinput283 rst_n wire887/I VDD VDD VSS VSS gf180mcu_fd_sc_mcu7t5v0__buf_1
Xinput294 votes_in_phase_y[0] _0959_/B2 VDD VDD VSS VSS gf180mcu_fd_sc_mcu7t5v0__buf_1
Xinput272 raw_edge3_y[19] _1088_/B2 VDD VDD VSS VSS gf180mcu_fd_sc_mcu7t5v0__buf_1
Xinput250 raw_edge3_x[18] _1023_/B2 VDD VDD VSS VSS gf180mcu_fd_sc_mcu7t5v0__buf_1
Xinput261 raw_edge3_x[9] _1004_/B2 VDD VDD VSS VSS gf180mcu_fd_sc_mcu7t5v0__buf_1
XTAP_TAPCELL_ROW_46_543 VDD VSS gf180mcu_fd_sc_mcu7t5v0__filltie
XFILLER_76_2 VDD VDD VSS VSS gf180mcu_fd_sc_mcu7t5v0__fillcap_32
X_1566_ _1566_/D _1590_/RN clkload8/I _1566_/Q VDD VDD VSS VSS gf180mcu_fd_sc_mcu7t5v0__dffrnq_1
X_1497_ _1497_/D _1497_/RN _1624_/CLK _1497_/Q VDD VDD VSS VSS gf180mcu_fd_sc_mcu7t5v0__dffrnq_1
X_1635_ _1635_/D _1653_/RN _1663_/CLK _1635_/Q VDD VDD VSS VSS gf180mcu_fd_sc_mcu7t5v0__dffrnq_2
XFILLER_66_183 VDD VDD VSS VSS gf180mcu_fd_sc_mcu7t5v0__fill_1
Xwire829 wire829/I wire829/Z VDD VDD VSS VSS gf180mcu_fd_sc_mcu7t5v0__buf_1
XFILLER_22_220 VDD VDD VSS VSS gf180mcu_fd_sc_mcu7t5v0__fill_1
XTAP_TAPCELL_ROW_9_246 VDD VSS gf180mcu_fd_sc_mcu7t5v0__filltie
XFILLER_13_67 VDD VDD VSS VSS gf180mcu_fd_sc_mcu7t5v0__fill_2
XFILLER_13_78 VDD VDD VSS VSS gf180mcu_fd_sc_mcu7t5v0__fillcap_16
XFILLER_54_63 VDD VDD VSS VSS gf180mcu_fd_sc_mcu7t5v0__fill_1
XFILLER_41_573 VDD VDD VSS VSS gf180mcu_fd_sc_mcu7t5v0__fill_1
XFILLER_48_6 VDD VDD VSS VSS gf180mcu_fd_sc_mcu7t5v0__fill_1
X_1420_ _1466_/I0 _1497_/Q _1427_/S _1497_/D VDD VDD VSS VSS gf180mcu_fd_sc_mcu7t5v0__mux2_2
X_1351_ _1593_/Q _1455_/A3 _1402_/A4 VDD VDD VSS VSS gf180mcu_fd_sc_mcu7t5v0__nand2_2
XFILLER_63_142 VDD VDD VSS VSS gf180mcu_fd_sc_mcu7t5v0__fill_2
XFILLER_48_183 VDD VDD VSS VSS gf180mcu_fd_sc_mcu7t5v0__fill_1
XFILLER_48_161 VDD VDD VSS VSS gf180mcu_fd_sc_mcu7t5v0__fillcap_8
X_1282_ _1608_/Q _1417_/I1 _1282_/S _1608_/D VDD VDD VSS VSS gf180mcu_fd_sc_mcu7t5v0__mux2_2
XFILLER_17_570 VDD VDD VSS VSS gf180mcu_fd_sc_mcu7t5v0__fillcap_4
X_0997_ input79/Z wire579/I wire574/Z _0997_/B2 _1156_/B1 input25/Z _1001_/A1 VDD
+ VDD VSS VSS gf180mcu_fd_sc_mcu7t5v0__aoi222_2
X_1618_ _1618_/D _1621_/RN clkload5/I _1618_/Q VDD VDD VSS VSS gf180mcu_fd_sc_mcu7t5v0__dffrnq_2
X_1549_ _1549_/D wire871/Z clkload7/I _1549_/Q VDD VDD VSS VSS gf180mcu_fd_sc_mcu7t5v0__dffrnq_2
XFILLER_59_448 VDD VDD VSS VSS gf180mcu_fd_sc_mcu7t5v0__fill_1
XTAP_TAPCELL_ROW_6_227 VDD VSS gf180mcu_fd_sc_mcu7t5v0__filltie
XTAP_TAPCELL_ROW_65_693 VDD VSS gf180mcu_fd_sc_mcu7t5v0__filltie
XFILLER_27_356 VDD VDD VSS VSS gf180mcu_fd_sc_mcu7t5v0__fill_2
XFILLER_23_540 VDD VDD VSS VSS gf180mcu_fd_sc_mcu7t5v0__fillcap_4
XFILLER_24_33 VDD VDD VSS VSS gf180mcu_fd_sc_mcu7t5v0__fill_2
XFILLER_50_381 VDD VDD VSS VSS gf180mcu_fd_sc_mcu7t5v0__fillcap_4
Xwire604 wire604/I wire604/Z VDD VDD VSS VSS gf180mcu_fd_sc_mcu7t5v0__buf_2
XFILLER_40_21 VDD VDD VSS VSS gf180mcu_fd_sc_mcu7t5v0__fillcap_4
XFILLER_23_562 VDD VDD VSS VSS gf180mcu_fd_sc_mcu7t5v0__fillcap_4
XFILLER_77_212 VDD VDD VSS VSS gf180mcu_fd_sc_mcu7t5v0__fillcap_64
Xload_slew609 _0967_/Z _1245_/A2 VDD VDD VSS VSS gf180mcu_fd_sc_mcu7t5v0__buf_2
XFILLER_45_142 VDD VDD VSS VSS gf180mcu_fd_sc_mcu7t5v0__fillcap_32
XFILLER_45_120 VDD VDD VSS VSS gf180mcu_fd_sc_mcu7t5v0__fillcap_8
XFILLER_18_367 VDD VDD VSS VSS gf180mcu_fd_sc_mcu7t5v0__fillcap_4
XFILLER_81_94 VDD VDD VSS VSS gf180mcu_fd_sc_mcu7t5v0__fill_2
XFILLER_73_473 VDD VDD VSS VSS gf180mcu_fd_sc_mcu7t5v0__fillcap_16
X_0920_ _0920_/A1 _0920_/A2 _1220_/B1 VDD VDD VSS VSS gf180mcu_fd_sc_mcu7t5v0__nor2_4
XFILLER_41_370 VDD VDD VSS VSS gf180mcu_fd_sc_mcu7t5v0__fill_1
XFILLER_33_348 VDD VDD VSS VSS gf180mcu_fd_sc_mcu7t5v0__fill_2
X_0782_ _1596_/Q _0795_/A1 _0782_/B _1549_/D VDD VDD VSS VSS gf180mcu_fd_sc_mcu7t5v0__oai21_1
X_0851_ _1252_/A1 _1557_/Q _0803_/Z _0915_/A2 VDD VDD VSS VSS gf180mcu_fd_sc_mcu7t5v0__nand3_4
XFILLER_5_282 VDD VDD VSS VSS gf180mcu_fd_sc_mcu7t5v0__fillcap_64
XTAP_TAPCELL_ROW_11_262 VDD VSS gf180mcu_fd_sc_mcu7t5v0__filltie
X_1265_ _1564_/Q wire734/I _1265_/S _1587_/D VDD VDD VSS VSS gf180mcu_fd_sc_mcu7t5v0__mux2_2
X_1334_ _1648_/Q wire742/I _1340_/S _1648_/D VDD VDD VSS VSS gf180mcu_fd_sc_mcu7t5v0__mux2_2
XPHY_EDGE_ROW_18_Right_18 VDD VSS gf180mcu_fd_sc_mcu7t5v0__endcap
X_1403_ _1483_/Q _1409_/I1 _1405_/S _1483_/D VDD VDD VSS VSS gf180mcu_fd_sc_mcu7t5v0__mux2_2
XFILLER_28_109 VDD VDD VSS VSS gf180mcu_fd_sc_mcu7t5v0__fill_1
Xinput3 cal_done_x input3/Z VDD VDD VSS VSS gf180mcu_fd_sc_mcu7t5v0__buf_1
XFILLER_64_473 VDD VDD VSS VSS gf180mcu_fd_sc_mcu7t5v0__fill_2
XTAP_TAPCELL_ROW_54_608 VDD VSS gf180mcu_fd_sc_mcu7t5v0__filltie
X_1196_ _1196_/A1 _1196_/A2 _1196_/A3 _1197_/C VDD VDD VSS VSS gf180mcu_fd_sc_mcu7t5v0__nand3_1
XPHY_EDGE_ROW_27_Right_27 VDD VSS gf180mcu_fd_sc_mcu7t5v0__endcap
XTAP_TAPCELL_ROW_62_674 VDD VSS gf180mcu_fd_sc_mcu7t5v0__filltie
XFILLER_59_212 VDD VDD VSS VSS gf180mcu_fd_sc_mcu7t5v0__fillcap_16
XPHY_EDGE_ROW_36_Right_36 VDD VSS gf180mcu_fd_sc_mcu7t5v0__endcap
Xoutput362 _1498_/Q cfg_phase0_offset_y[10] VDD VDD VSS VSS gf180mcu_fd_sc_mcu7t5v0__buf_2
Xoutput373 _1487_/Q cfg_phase0_offset_y[20] VDD VDD VSS VSS gf180mcu_fd_sc_mcu7t5v0__buf_2
Xoutput340 _1638_/Q cfg_phase0_offset_x[0] VDD VDD VSS VSS gf180mcu_fd_sc_mcu7t5v0__buf_2
Xoutput351 _1639_/Q cfg_phase0_offset_x[1] VDD VDD VSS VSS gf180mcu_fd_sc_mcu7t5v0__buf_2
XFILLER_10_57 VDD VDD VSS VSS gf180mcu_fd_sc_mcu7t5v0__fill_1
Xoutput395 _1469_/Q cfg_phase270_offset_x[2] VDD VDD VSS VSS gf180mcu_fd_sc_mcu7t5v0__buf_2
Xoutput384 _1478_/Q cfg_phase270_offset_x[11] VDD VDD VSS VSS gf180mcu_fd_sc_mcu7t5v0__buf_2
XFILLER_59_234 VDD VDD VSS VSS gf180mcu_fd_sc_mcu7t5v0__fill_1
XFILLER_55_440 VDD VDD VSS VSS gf180mcu_fd_sc_mcu7t5v0__fill_2
XFILLER_19_44 VDD VDD VSS VSS gf180mcu_fd_sc_mcu7t5v0__fill_1
XFILLER_70_443 VDD VDD VSS VSS gf180mcu_fd_sc_mcu7t5v0__fillcap_4
XPHY_EDGE_ROW_45_Right_45 VDD VSS gf180mcu_fd_sc_mcu7t5v0__endcap
XFILLER_42_123 VDD VDD VSS VSS gf180mcu_fd_sc_mcu7t5v0__fill_2
XFILLER_35_98 VDD VDD VSS VSS gf180mcu_fd_sc_mcu7t5v0__fill_2
XFILLER_35_65 VDD VDD VSS VSS gf180mcu_fd_sc_mcu7t5v0__fillcap_4
XFILLER_27_175 VDD VDD VSS VSS gf180mcu_fd_sc_mcu7t5v0__fill_1
XTAP_TAPCELL_ROW_25_376 VDD VSS gf180mcu_fd_sc_mcu7t5v0__filltie
XPHY_EDGE_ROW_54_Right_54 VDD VSS gf180mcu_fd_sc_mcu7t5v0__endcap
XFILLER_51_97 VDD VDD VSS VSS gf180mcu_fd_sc_mcu7t5v0__fillcap_16
XFILLER_7_558 VDD VDD VSS VSS gf180mcu_fd_sc_mcu7t5v0__fill_2
XFILLER_2_241 VDD VDD VSS VSS gf180mcu_fd_sc_mcu7t5v0__fillcap_4
XPHY_EDGE_ROW_63_Right_63 VDD VSS gf180mcu_fd_sc_mcu7t5v0__endcap
X_1050_ _1050_/A1 wire558/Z _1050_/B1 _1448_/I1 _1053_/A2 VDD VDD VSS VSS gf180mcu_fd_sc_mcu7t5v0__aoi22_1
XFILLER_46_473 VDD VDD VSS VSS gf180mcu_fd_sc_mcu7t5v0__fillcap_16
XFILLER_33_134 VDD VDD VSS VSS gf180mcu_fd_sc_mcu7t5v0__fillcap_4
X_0834_ _0834_/A1 _1594_/Q _1592_/D wire645/I VDD VDD VSS VSS gf180mcu_fd_sc_mcu7t5v0__nand3_1
X_0903_ _0903_/A1 _0908_/A2 _1137_/B1 VDD VDD VSS VSS gf180mcu_fd_sc_mcu7t5v0__nor2_4
XPHY_EDGE_ROW_72_Right_72 VDD VSS gf180mcu_fd_sc_mcu7t5v0__endcap
X_0765_ _1536_/Q _1466_/S _0766_/B VDD VDD VSS VSS gf180mcu_fd_sc_mcu7t5v0__nand2_1
XPHY_EDGE_ROW_81_Right_81 VDD VSS gf180mcu_fd_sc_mcu7t5v0__endcap
XFILLER_69_543 VDD VDD VSS VSS gf180mcu_fd_sc_mcu7t5v0__fillcap_4
XTAP_TAPCELL_ROW_67_711 VDD VSS gf180mcu_fd_sc_mcu7t5v0__filltie
X_1248_ _1248_/A1 _0762_/I _1248_/B _1576_/D VDD VDD VSS VSS gf180mcu_fd_sc_mcu7t5v0__oai21_1
X_1317_ _1355_/I1 _1635_/Q _1320_/S _1635_/D VDD VDD VSS VSS gf180mcu_fd_sc_mcu7t5v0__mux2_2
XFILLER_52_432 VDD VDD VSS VSS gf180mcu_fd_sc_mcu7t5v0__fillcap_4
X_1179_ _1179_/A1 _1179_/A2 _1179_/A3 _1179_/A4 _1180_/A4 VDD VDD VSS VSS gf180mcu_fd_sc_mcu7t5v0__nor4_1
XFILLER_24_123 VDD VDD VSS VSS gf180mcu_fd_sc_mcu7t5v0__fill_1
XFILLER_4_539 VDD VDD VSS VSS gf180mcu_fd_sc_mcu7t5v0__fill_2
XFILLER_21_78 VDD VDD VSS VSS gf180mcu_fd_sc_mcu7t5v0__fillcap_4
XTAP_TAPCELL_ROW_73_758 VDD VSS gf180mcu_fd_sc_mcu7t5v0__filltie
XFILLER_15_156 VDD VDD VSS VSS gf180mcu_fd_sc_mcu7t5v0__fill_1
XFILLER_3_550 VDD VDD VSS VSS gf180mcu_fd_sc_mcu7t5v0__fill_2
XFILLER_66_535 VDD VDD VSS VSS gf180mcu_fd_sc_mcu7t5v0__fillcap_4
XFILLER_66_524 VDD VDD VSS VSS gf180mcu_fd_sc_mcu7t5v0__fill_1
X_1102_ _1102_/A1 _1102_/A2 _1108_/A3 VDD VDD VSS VSS gf180mcu_fd_sc_mcu7t5v0__nand2_1
XFILLER_81_527 VDD VDD VSS VSS gf180mcu_fd_sc_mcu7t5v0__fillcap_16
XFILLER_81_516 VDD VDD VSS VSS gf180mcu_fd_sc_mcu7t5v0__fill_2
XFILLER_53_207 VDD VDD VSS VSS gf180mcu_fd_sc_mcu7t5v0__fill_2
X_1033_ _1033_/A1 _1033_/A2 _1137_/B1 input98/Z _1035_/A3 VDD VDD VSS VSS gf180mcu_fd_sc_mcu7t5v0__aoi22_1
XFILLER_34_498 VDD VDD VSS VSS gf180mcu_fd_sc_mcu7t5v0__fillcap_4
Xinput72 cal_phase270_offset_y[13] input72/Z VDD VDD VSS VSS gf180mcu_fd_sc_mcu7t5v0__buf_1
Xinput50 cal_phase270_offset_x[12] input50/Z VDD VDD VSS VSS gf180mcu_fd_sc_mcu7t5v0__buf_1
Xinput61 cal_phase270_offset_x[3] input61/Z VDD VDD VSS VSS gf180mcu_fd_sc_mcu7t5v0__buf_1
X_0817_ _1558_/Q _0819_/A4 _0818_/A2 VDD VDD VSS VSS gf180mcu_fd_sc_mcu7t5v0__nor2_1
XFILLER_21_148 VDD VDD VSS VSS gf180mcu_fd_sc_mcu7t5v0__fill_1
Xinput83 cal_phase270_offset_y[4] input83/Z VDD VDD VSS VSS gf180mcu_fd_sc_mcu7t5v0__buf_1
Xinput94 cal_phase90_offset_x[14] input94/Z VDD VDD VSS VSS gf180mcu_fd_sc_mcu7t5v0__buf_1
X_0748_ _1580_/Q _0749_/A3 _1402_/A3 VDD VDD VSS VSS gf180mcu_fd_sc_mcu7t5v0__nand2_1
XFILLER_72_549 VDD VDD VSS VSS gf180mcu_fd_sc_mcu7t5v0__fill_1
XFILLER_72_527 VDD VDD VSS VSS gf180mcu_fd_sc_mcu7t5v0__fillcap_16
Xload_slew792 wire794/Z _1616_/RN VDD VDD VSS VSS gf180mcu_fd_sc_mcu7t5v0__clkbuf_2
Xload_slew781 _1495_/Q _1417_/I0 VDD VDD VSS VSS gf180mcu_fd_sc_mcu7t5v0__buf_2
Xload_slew770 wire771/Z _1409_/I1 VDD VDD VSS VSS gf180mcu_fd_sc_mcu7t5v0__buf_1
XFILLER_80_571 VDD VDD VSS VSS gf180mcu_fd_sc_mcu7t5v0__fill_2
XTAP_TAPCELL_ROW_70_739 VDD VSS gf180mcu_fd_sc_mcu7t5v0__filltie
XPHY_EDGE_ROW_0_Right_0 VDD VSS gf180mcu_fd_sc_mcu7t5v0__endcap
XFILLER_32_99 VDD VDD VSS VSS gf180mcu_fd_sc_mcu7t5v0__fillcap_4
XFILLER_57_63 VDD VDD VSS VSS gf180mcu_fd_sc_mcu7t5v0__fillcap_4
XFILLER_48_524 VDD VDD VSS VSS gf180mcu_fd_sc_mcu7t5v0__fill_1
XFILLER_16_443 VDD VDD VSS VSS gf180mcu_fd_sc_mcu7t5v0__fillcap_8
XFILLER_11_170 VDD VDD VSS VSS gf180mcu_fd_sc_mcu7t5v0__fillcap_4
X_1651_ _1651_/D _1662_/RN _1674_/CLK _1651_/Q VDD VDD VSS VSS gf180mcu_fd_sc_mcu7t5v0__dffrnq_1
X_1582_ _1582_/D _1582_/RN clkload9/I _1582_/Q VDD VDD VSS VSS gf180mcu_fd_sc_mcu7t5v0__dffrnq_1
XFILLER_81_335 VDD VDD VSS VSS gf180mcu_fd_sc_mcu7t5v0__fillcap_4
XFILLER_66_387 VDD VDD VSS VSS gf180mcu_fd_sc_mcu7t5v0__fillcap_4
XFILLER_66_365 VDD VDD VSS VSS gf180mcu_fd_sc_mcu7t5v0__fill_1
XFILLER_54_527 VDD VDD VSS VSS gf180mcu_fd_sc_mcu7t5v0__fill_2
XFILLER_39_513 VDD VDD VSS VSS gf180mcu_fd_sc_mcu7t5v0__fill_2
X_1016_ _1640_/Q _1199_/A2 _1208_/A2 input90/Z _1053_/A1 VDD VDD VSS VSS gf180mcu_fd_sc_mcu7t5v0__aoi22_1
XTAP_TAPCELL_ROW_32_430 VDD VSS gf180mcu_fd_sc_mcu7t5v0__filltie
XFILLER_22_402 VDD VDD VSS VSS gf180mcu_fd_sc_mcu7t5v0__fill_2
XFILLER_76_107 VDD VDD VSS VSS gf180mcu_fd_sc_mcu7t5v0__fillcap_64
XFILLER_72_357 VDD VDD VSS VSS gf180mcu_fd_sc_mcu7t5v0__fillcap_4
XFILLER_4_177 VDD VDD VSS VSS gf180mcu_fd_sc_mcu7t5v0__fillcap_64
XFILLER_4_37 VDD VDD VSS VSS gf180mcu_fd_sc_mcu7t5v0__fillcap_64
Xinput284 spi_cs_n _1595_/D VDD VDD VSS VSS gf180mcu_fd_sc_mcu7t5v0__buf_1
Xinput295 votes_in_phase_y[1] _0989_/A1 VDD VDD VSS VSS gf180mcu_fd_sc_mcu7t5v0__buf_1
XFILLER_63_346 VDD VDD VSS VSS gf180mcu_fd_sc_mcu7t5v0__fillcap_4
Xinput251 raw_edge3_x[19] _1068_/A1 VDD VDD VSS VSS gf180mcu_fd_sc_mcu7t5v0__buf_1
Xinput262 raw_edge3_y[0] _0938_/A1 VDD VDD VSS VSS gf180mcu_fd_sc_mcu7t5v0__buf_1
Xinput240 raw_edge2_y[9] _1007_/B2 VDD VDD VSS VSS gf180mcu_fd_sc_mcu7t5v0__buf_1
Xinput273 raw_edge3_y[1] _0973_/C2 VDD VDD VSS VSS gf180mcu_fd_sc_mcu7t5v0__buf_1
XFILLER_51_508 VDD VDD VSS VSS gf180mcu_fd_sc_mcu7t5v0__fill_2
XTAP_TAPCELL_ROW_46_544 VDD VSS gf180mcu_fd_sc_mcu7t5v0__filltie
Xclkbuf_leaf_11_clk clkbuf_leaf_9_clk/I clkload5/I VDD VDD VSS VSS gf180mcu_fd_sc_mcu7t5v0__clkbuf_8
X_1634_ _1634_/D _1634_/RN clkload3/I _1634_/Q VDD VDD VSS VSS gf180mcu_fd_sc_mcu7t5v0__dffrnq_2
X_1565_ _1565_/D wire876/Z clkload7/I _1565_/Q VDD VDD VSS VSS gf180mcu_fd_sc_mcu7t5v0__dffrnq_1
XFILLER_58_107 VDD VDD VSS VSS gf180mcu_fd_sc_mcu7t5v0__fillcap_8
X_1496_ _1496_/D _1497_/RN _1624_/CLK _1496_/Q VDD VDD VSS VSS gf180mcu_fd_sc_mcu7t5v0__dffrnq_1
XTAP_TAPCELL_ROW_80_812 VDD VSS gf180mcu_fd_sc_mcu7t5v0__filltie
XFILLER_10_449 VDD VDD VSS VSS gf180mcu_fd_sc_mcu7t5v0__fillcap_4
XTAP_TAPCELL_ROW_9_247 VDD VSS gf180mcu_fd_sc_mcu7t5v0__filltie
XFILLER_1_136 VDD VDD VSS VSS gf180mcu_fd_sc_mcu7t5v0__fillcap_4
XFILLER_77_416 VDD VDD VSS VSS gf180mcu_fd_sc_mcu7t5v0__fillcap_4
XFILLER_38_32 VDD VDD VSS VSS gf180mcu_fd_sc_mcu7t5v0__fill_2
XFILLER_18_527 VDD VDD VSS VSS gf180mcu_fd_sc_mcu7t5v0__fillcap_4
XTAP_TAPCELL_ROW_51_580 VDD VSS gf180mcu_fd_sc_mcu7t5v0__filltie
XFILLER_79_72 VDD VDD VSS VSS gf180mcu_fd_sc_mcu7t5v0__fillcap_64
XFILLER_68_405 VDD VDD VSS VSS gf180mcu_fd_sc_mcu7t5v0__fill_2
XFILLER_5_486 VDD VDD VSS VSS gf180mcu_fd_sc_mcu7t5v0__fillcap_4
X_1281_ _1607_/Q wire715/Z _1282_/S _1607_/D VDD VDD VSS VSS gf180mcu_fd_sc_mcu7t5v0__mux2_2
X_1350_ _1658_/Q wire737/I _1350_/S _1658_/D VDD VDD VSS VSS gf180mcu_fd_sc_mcu7t5v0__mux2_2
XFILLER_76_482 VDD VDD VSS VSS gf180mcu_fd_sc_mcu7t5v0__fill_1
XFILLER_63_176 VDD VDD VSS VSS gf180mcu_fd_sc_mcu7t5v0__fillcap_32
XFILLER_48_173 VDD VDD VSS VSS gf180mcu_fd_sc_mcu7t5v0__fill_2
XFILLER_36_313 VDD VDD VSS VSS gf180mcu_fd_sc_mcu7t5v0__fill_2
Xclkbuf_leaf_0_clk clkbuf_leaf_0_clk/I clkload0/I VDD VDD VSS VSS gf180mcu_fd_sc_mcu7t5v0__clkbuf_8
X_0996_ _0996_/A1 _0996_/A2 _1012_/A2 VDD VDD VSS VSS gf180mcu_fd_sc_mcu7t5v0__nor2_1
X_1617_ _1617_/D _1621_/RN clkload5/I _1617_/Q VDD VDD VSS VSS gf180mcu_fd_sc_mcu7t5v0__dffrnq_2
X_1548_ _1548_/D _1569_/RN _1575_/CLK _1548_/Q VDD VDD VSS VSS gf180mcu_fd_sc_mcu7t5v0__dffrnq_1
XTAP_TAPCELL_ROW_57_628 VDD VSS gf180mcu_fd_sc_mcu7t5v0__filltie
XFILLER_54_121 VDD VDD VSS VSS gf180mcu_fd_sc_mcu7t5v0__fill_1
XFILLER_39_151 VDD VDD VSS VSS gf180mcu_fd_sc_mcu7t5v0__fillcap_16
X_1479_ _1479_/D _1479_/RN clkload1/I _1479_/Q VDD VDD VSS VSS gf180mcu_fd_sc_mcu7t5v0__dffrnq_1
XTAP_TAPCELL_ROW_65_694 VDD VSS gf180mcu_fd_sc_mcu7t5v0__filltie
XFILLER_73_430 VDD VDD VSS VSS gf180mcu_fd_sc_mcu7t5v0__fill_1
X_0850_ wire617/Z _0910_/A1 wire598/I VDD VDD VSS VSS gf180mcu_fd_sc_mcu7t5v0__nor2_4
XTAP_TAPCELL_ROW_28_396 VDD VSS gf180mcu_fd_sc_mcu7t5v0__filltie
X_0781_ _0781_/I0 _1548_/Q _0781_/S _1548_/D VDD VDD VSS VSS gf180mcu_fd_sc_mcu7t5v0__mux2_2
X_1402_ _1579_/Q _1578_/Q _1402_/A3 _1402_/A4 _1406_/S VDD VDD VSS VSS gf180mcu_fd_sc_mcu7t5v0__nor4_4
XTAP_TAPCELL_ROW_11_263 VDD VSS gf180mcu_fd_sc_mcu7t5v0__filltie
Xinput4 cal_done_y input4/Z VDD VDD VSS VSS gf180mcu_fd_sc_mcu7t5v0__buf_1
XFILLER_68_224 VDD VDD VSS VSS gf180mcu_fd_sc_mcu7t5v0__fillcap_16
X_1264_ wire690/I _1593_/D _1264_/B _1586_/D VDD VDD VSS VSS gf180mcu_fd_sc_mcu7t5v0__oai21_1
X_1333_ _1647_/Q wire754/I _1339_/S _1647_/D VDD VDD VSS VSS gf180mcu_fd_sc_mcu7t5v0__mux2_2
XTAP_TAPCELL_ROW_62_675 VDD VSS gf180mcu_fd_sc_mcu7t5v0__filltie
XTAP_TAPCELL_ROW_54_609 VDD VSS gf180mcu_fd_sc_mcu7t5v0__filltie
X_1195_ _1539_/Q _1217_/A2 wire579/Z input85/Z _1196_/A3 VDD VDD VSS VSS gf180mcu_fd_sc_mcu7t5v0__aoi22_1
XFILLER_51_113 VDD VDD VSS VSS gf180mcu_fd_sc_mcu7t5v0__fillcap_8
Xclkbuf_2_1__f_clk clkbuf_0_clk/Z clkbuf_leaf_3_clk/I VDD VDD VSS VSS gf180mcu_fd_sc_mcu7t5v0__clkbuf_16
XTAP_TAPCELL_ROW_19_330 VDD VSS gf180mcu_fd_sc_mcu7t5v0__filltie
X_0979_ _0979_/A1 _0979_/A2 _0979_/A3 _0979_/A4 _0985_/A2 VDD VDD VSS VSS gf180mcu_fd_sc_mcu7t5v0__nand4_1
Xoutput363 _1499_/Q cfg_phase0_offset_y[11] VDD VDD VSS VSS gf180mcu_fd_sc_mcu7t5v0__buf_2
Xoutput330 _1624_/Q cfg_f_MEMS_fcw_y[15] VDD VDD VSS VSS gf180mcu_fd_sc_mcu7t5v0__buf_2
Xoutput374 _1490_/Q cfg_phase0_offset_y[2] VDD VDD VSS VSS gf180mcu_fd_sc_mcu7t5v0__buf_2
Xoutput341 _1648_/Q cfg_phase0_offset_x[10] VDD VDD VSS VSS gf180mcu_fd_sc_mcu7t5v0__buf_2
Xoutput396 _1470_/Q cfg_phase270_offset_x[3] VDD VDD VSS VSS gf180mcu_fd_sc_mcu7t5v0__buf_2
Xoutput352 _1320_/I1 cfg_phase0_offset_x[20] VDD VDD VSS VSS gf180mcu_fd_sc_mcu7t5v0__buf_2
Xoutput385 _1479_/Q cfg_phase270_offset_x[12] VDD VDD VSS VSS gf180mcu_fd_sc_mcu7t5v0__buf_2
XFILLER_59_279 VDD VDD VSS VSS gf180mcu_fd_sc_mcu7t5v0__fill_1
XFILLER_15_305 VDD VDD VSS VSS gf180mcu_fd_sc_mcu7t5v0__fillcap_8
XFILLER_51_54 VDD VDD VSS VSS gf180mcu_fd_sc_mcu7t5v0__fillcap_16
XFILLER_11_555 VDD VDD VSS VSS gf180mcu_fd_sc_mcu7t5v0__fillcap_4
XTAP_TAPCELL_ROW_25_377 VDD VSS gf180mcu_fd_sc_mcu7t5v0__filltie
XFILLER_73_282 VDD VDD VSS VSS gf180mcu_fd_sc_mcu7t5v0__fillcap_64
XTAP_TAPCELL_ROW_16_300 VDD VSS gf180mcu_fd_sc_mcu7t5v0__filltie
X_0833_ _1567_/Q _1566_/Q _0833_/S _1567_/D VDD VDD VSS VSS gf180mcu_fd_sc_mcu7t5v0__mux2_2
X_0902_ _0902_/A1 _0920_/A2 _1090_/B1 VDD VDD VSS VSS gf180mcu_fd_sc_mcu7t5v0__nor2_4
XFILLER_69_511 VDD VDD VSS VSS gf180mcu_fd_sc_mcu7t5v0__fillcap_32
XFILLER_69_500 VDD VDD VSS VSS gf180mcu_fd_sc_mcu7t5v0__fill_2
XFILLER_51_2 VDD VDD VSS VSS gf180mcu_fd_sc_mcu7t5v0__fillcap_4
X_0764_ _0749_/Z _1455_/A2 _1435_/A2 _1467_/S VDD VDD VSS VSS gf180mcu_fd_sc_mcu7t5v0__nand3_4
XTAP_TAPCELL_ROW_67_712 VDD VSS gf180mcu_fd_sc_mcu7t5v0__filltie
XFILLER_56_249 VDD VDD VSS VSS gf180mcu_fd_sc_mcu7t5v0__fill_1
X_1247_ _1576_/Q _0762_/I _1248_/B VDD VDD VSS VSS gf180mcu_fd_sc_mcu7t5v0__nand2_1
X_1178_ _1178_/A1 wire492/Z _1178_/A3 _1178_/A4 _1179_/A4 VDD VDD VSS VSS gf180mcu_fd_sc_mcu7t5v0__nand4_1
X_1316_ _1346_/I1 _1634_/Q _1316_/S _1634_/D VDD VDD VSS VSS gf180mcu_fd_sc_mcu7t5v0__mux2_2
XTAP_TAPCELL_ROW_73_759 VDD VSS gf180mcu_fd_sc_mcu7t5v0__filltie
XFILLER_70_241 VDD VDD VSS VSS gf180mcu_fd_sc_mcu7t5v0__fillcap_4
XFILLER_55_282 VDD VDD VSS VSS gf180mcu_fd_sc_mcu7t5v0__fill_2
XFILLER_43_422 VDD VDD VSS VSS gf180mcu_fd_sc_mcu7t5v0__fill_1
XTAP_TAPCELL_ROW_38_480 VDD VSS gf180mcu_fd_sc_mcu7t5v0__filltie
XPHY_EDGE_ROW_6_Left_88 VDD VSS gf180mcu_fd_sc_mcu7t5v0__endcap
XFILLER_43_488 VDD VDD VSS VSS gf180mcu_fd_sc_mcu7t5v0__fill_2
XFILLER_7_48 VDD VDD VSS VSS gf180mcu_fd_sc_mcu7t5v0__fillcap_16
XFILLER_3_562 VDD VDD VSS VSS gf180mcu_fd_sc_mcu7t5v0__fillcap_4
XFILLER_3_540 VDD VDD VSS VSS gf180mcu_fd_sc_mcu7t5v0__fill_2
X_1101_ input49/Z _1154_/A2 wire535/Z _1101_/B2 _1102_/A2 VDD VDD VSS VSS gf180mcu_fd_sc_mcu7t5v0__aoi22_1
X_1032_ _1661_/Q _1087_/A2 _1240_/B1 _1490_/Q _1035_/A2 VDD VDD VSS VSS gf180mcu_fd_sc_mcu7t5v0__aoi22_1
XFILLER_61_241 VDD VDD VSS VSS gf180mcu_fd_sc_mcu7t5v0__fill_2
Xinput84 cal_phase270_offset_y[5] input84/Z VDD VDD VSS VSS gf180mcu_fd_sc_mcu7t5v0__buf_1
Xinput51 cal_phase270_offset_x[13] input51/Z VDD VDD VSS VSS gf180mcu_fd_sc_mcu7t5v0__buf_1
Xinput73 cal_phase270_offset_y[14] input73/Z VDD VDD VSS VSS gf180mcu_fd_sc_mcu7t5v0__buf_1
X_0816_ _0822_/B _0822_/A2 _0820_/B1 VDD VDD VSS VSS gf180mcu_fd_sc_mcu7t5v0__nand2_1
Xinput95 cal_phase90_offset_x[15] input95/Z VDD VDD VSS VSS gf180mcu_fd_sc_mcu7t5v0__buf_1
Xinput62 cal_phase270_offset_x[4] input62/Z VDD VDD VSS VSS gf180mcu_fd_sc_mcu7t5v0__buf_1
Xinput40 cal_phase0_offset_y[3] input40/Z VDD VDD VSS VSS gf180mcu_fd_sc_mcu7t5v0__buf_1
X_0747_ _1581_/Q _1582_/Q _0749_/A3 VDD VDD VSS VSS gf180mcu_fd_sc_mcu7t5v0__nor2_1
XFILLER_69_352 VDD VDD VSS VSS gf180mcu_fd_sc_mcu7t5v0__fillcap_8
Xload_slew782 _1489_/Q _1410_/I0 VDD VDD VSS VSS gf180mcu_fd_sc_mcu7t5v0__buf_2
Xload_slew793 wire794/Z _1646_/RN VDD VDD VSS VSS gf180mcu_fd_sc_mcu7t5v0__buf_2
Xload_slew760 _0774_/I0 _1466_/I0 VDD VDD VSS VSS gf180mcu_fd_sc_mcu7t5v0__clkbuf_1
XFILLER_37_282 VDD VDD VSS VSS gf180mcu_fd_sc_mcu7t5v0__fillcap_8
XFILLER_32_56 VDD VDD VSS VSS gf180mcu_fd_sc_mcu7t5v0__fill_2
X_1581_ _1581_/D wire863/I clkload9/I _1581_/Q VDD VDD VSS VSS gf180mcu_fd_sc_mcu7t5v0__dffrnq_1
XFILLER_7_142 VDD VDD VSS VSS gf180mcu_fd_sc_mcu7t5v0__fillcap_64
X_1650_ _1650_/D _1650_/RN _1663_/CLK _1650_/Q VDD VDD VSS VSS gf180mcu_fd_sc_mcu7t5v0__dffrnq_1
XFILLER_78_171 VDD VDD VSS VSS gf180mcu_fd_sc_mcu7t5v0__fillcap_4
X_1015_ _1570_/Q wire642/Z _1062_/B VDD VDD VSS VSS gf180mcu_fd_sc_mcu7t5v0__nand2_1
XTAP_TAPCELL_ROW_49_564 VDD VSS gf180mcu_fd_sc_mcu7t5v0__filltie
XFILLER_19_282 VDD VDD VSS VSS gf180mcu_fd_sc_mcu7t5v0__fillcap_4
XTAP_TAPCELL_ROW_32_431 VDD VSS gf180mcu_fd_sc_mcu7t5v0__filltie
Xload_slew590 _1037_/A2 _1119_/A2 VDD VDD VSS VSS gf180mcu_fd_sc_mcu7t5v0__buf_2
XFILLER_17_208 VDD VDD VSS VSS gf180mcu_fd_sc_mcu7t5v0__fill_2
XFILLER_43_44 VDD VDD VSS VSS gf180mcu_fd_sc_mcu7t5v0__fillcap_16
XFILLER_40_233 VDD VDD VSS VSS gf180mcu_fd_sc_mcu7t5v0__fill_1
XFILLER_40_244 VDD VDD VSS VSS gf180mcu_fd_sc_mcu7t5v0__fill_1
XFILLER_4_101 VDD VDD VSS VSS gf180mcu_fd_sc_mcu7t5v0__fillcap_4
XFILLER_9_418 VDD VDD VSS VSS gf180mcu_fd_sc_mcu7t5v0__fill_2
XFILLER_68_30 VDD VDD VSS VSS gf180mcu_fd_sc_mcu7t5v0__fillcap_4
Xinput285 spi_mosi _1599_/D VDD VDD VSS VSS gf180mcu_fd_sc_mcu7t5v0__buf_1
Xinput296 votes_in_phase_y[2] _1039_/B2 VDD VDD VSS VSS gf180mcu_fd_sc_mcu7t5v0__buf_1
Xinput274 raw_edge3_y[20] _1113_/A1 VDD VDD VSS VSS gf180mcu_fd_sc_mcu7t5v0__buf_1
Xinput252 raw_edge3_x[1] _0988_/B2 VDD VDD VSS VSS gf180mcu_fd_sc_mcu7t5v0__buf_1
Xinput230 raw_edge2_y[19] _1104_/B2 VDD VDD VSS VSS gf180mcu_fd_sc_mcu7t5v0__buf_1
Xinput263 raw_edge3_y[10] _1043_/B2 VDD VDD VSS VSS gf180mcu_fd_sc_mcu7t5v0__buf_1
XTAP_TAPCELL_ROW_46_545 VDD VSS gf180mcu_fd_sc_mcu7t5v0__filltie
Xinput241 raw_edge3_x[0] _0928_/B2 VDD VDD VSS VSS gf180mcu_fd_sc_mcu7t5v0__buf_1
XPHY_EDGE_ROW_9_Left_91 VDD VSS gf180mcu_fd_sc_mcu7t5v0__endcap
X_1564_ _1564_/D _1564_/RN clkload7/I _1564_/Q VDD VDD VSS VSS gf180mcu_fd_sc_mcu7t5v0__dffrnq_1
XFILLER_8_473 VDD VDD VSS VSS gf180mcu_fd_sc_mcu7t5v0__fill_1
XFILLER_8_451 VDD VDD VSS VSS gf180mcu_fd_sc_mcu7t5v0__fillcap_4
X_1633_ _1633_/D _1647_/RN clkload3/I _1633_/Q VDD VDD VSS VSS gf180mcu_fd_sc_mcu7t5v0__dffrnq_1
XFILLER_58_119 VDD VDD VSS VSS gf180mcu_fd_sc_mcu7t5v0__fill_2
X_1495_ _1495_/D _1495_/RN _1629_/CLK _1495_/Q VDD VDD VSS VSS gf180mcu_fd_sc_mcu7t5v0__dffrnq_2
XFILLER_81_199 VDD VDD VSS VSS gf180mcu_fd_sc_mcu7t5v0__fillcap_4
XTAP_TAPCELL_ROW_80_813 VDD VSS gf180mcu_fd_sc_mcu7t5v0__filltie
XFILLER_66_174 VDD VDD VSS VSS gf180mcu_fd_sc_mcu7t5v0__fill_1
XFILLER_54_314 VDD VDD VSS VSS gf180mcu_fd_sc_mcu7t5v0__fill_1
XFILLER_13_14 VDD VDD VSS VSS gf180mcu_fd_sc_mcu7t5v0__fill_2
XFILLER_13_69 VDD VDD VSS VSS gf180mcu_fd_sc_mcu7t5v0__fill_1
XFILLER_22_255 VDD VDD VSS VSS gf180mcu_fd_sc_mcu7t5v0__fillcap_4
XFILLER_49_119 VDD VDD VSS VSS gf180mcu_fd_sc_mcu7t5v0__fillcap_8
XTAP_TAPCELL_ROW_9_248 VDD VSS gf180mcu_fd_sc_mcu7t5v0__filltie
XFILLER_57_130 VDD VDD VSS VSS gf180mcu_fd_sc_mcu7t5v0__fill_1
XFILLER_45_347 VDD VDD VSS VSS gf180mcu_fd_sc_mcu7t5v0__fill_2
XFILLER_38_55 VDD VDD VSS VSS gf180mcu_fd_sc_mcu7t5v0__fill_2
XFILLER_72_177 VDD VDD VSS VSS gf180mcu_fd_sc_mcu7t5v0__fillcap_64
XFILLER_60_317 VDD VDD VSS VSS gf180mcu_fd_sc_mcu7t5v0__fillcap_8
XTAP_TAPCELL_ROW_51_581 VDD VSS gf180mcu_fd_sc_mcu7t5v0__filltie
XTAP_TAPCELL_ROW_0_170 VDD VSS gf180mcu_fd_sc_mcu7t5v0__filltie
XFILLER_68_428 VDD VDD VSS VSS gf180mcu_fd_sc_mcu7t5v0__fillcap_16
X_1280_ _1606_/Q _1338_/I1 _1282_/S _1606_/D VDD VDD VSS VSS gf180mcu_fd_sc_mcu7t5v0__mux2_2
XFILLER_63_144 VDD VDD VSS VSS gf180mcu_fd_sc_mcu7t5v0__fill_1
XFILLER_51_328 VDD VDD VSS VSS gf180mcu_fd_sc_mcu7t5v0__fillcap_8
XFILLER_32_531 VDD VDD VSS VSS gf180mcu_fd_sc_mcu7t5v0__fill_1
XFILLER_81_2 VDD VDD VSS VSS gf180mcu_fd_sc_mcu7t5v0__fillcap_8
X_0995_ _0995_/A1 _0995_/A2 _0995_/A3 _0995_/A4 _0996_/A2 VDD VDD VSS VSS gf180mcu_fd_sc_mcu7t5v0__nand4_1
X_1547_ _1547_/D _1585_/RN _1597_/CLK _1547_/Q VDD VDD VSS VSS gf180mcu_fd_sc_mcu7t5v0__dffrnq_1
X_1616_ _1616_/D _1616_/RN _1674_/CLK _1616_/Q VDD VDD VSS VSS gf180mcu_fd_sc_mcu7t5v0__dffrnq_1
XFILLER_67_483 VDD VDD VSS VSS gf180mcu_fd_sc_mcu7t5v0__fill_1
XTAP_TAPCELL_ROW_57_629 VDD VSS gf180mcu_fd_sc_mcu7t5v0__filltie
X_1478_ _1478_/D _1478_/RN clkload2/I _1478_/Q VDD VDD VSS VSS gf180mcu_fd_sc_mcu7t5v0__dffrnq_1
XTAP_TAPCELL_ROW_65_695 VDD VSS gf180mcu_fd_sc_mcu7t5v0__filltie
XPHY_EDGE_ROW_59_Left_141 VDD VSS gf180mcu_fd_sc_mcu7t5v0__endcap
XFILLER_54_177 VDD VDD VSS VSS gf180mcu_fd_sc_mcu7t5v0__fillcap_32
Xwire606 _1467_/S _1466_/S VDD VDD VSS VSS gf180mcu_fd_sc_mcu7t5v0__buf_4
XFILLER_10_214 VDD VDD VSS VSS gf180mcu_fd_sc_mcu7t5v0__fillcap_4
XFILLER_23_531 VDD VDD VSS VSS gf180mcu_fd_sc_mcu7t5v0__fill_1
XPHY_EDGE_ROW_68_Left_150 VDD VSS gf180mcu_fd_sc_mcu7t5v0__endcap
Xwire617 wire617/I wire617/Z VDD VDD VSS VSS gf180mcu_fd_sc_mcu7t5v0__buf_1
XFILLER_10_247 VDD VDD VSS VSS gf180mcu_fd_sc_mcu7t5v0__fillcap_4
Xfanout761 _1584_/Q wire763/I VDD VDD VSS VSS gf180mcu_fd_sc_mcu7t5v0__dlyb_1
XFILLER_2_457 VDD VDD VSS VSS gf180mcu_fd_sc_mcu7t5v0__fillcap_64
Xfanout783 _1479_/RN wire786/I VDD VDD VSS VSS gf180mcu_fd_sc_mcu7t5v0__dlyb_1
XFILLER_60_103 VDD VDD VSS VSS gf180mcu_fd_sc_mcu7t5v0__fill_2
XFILLER_45_199 VDD VDD VSS VSS gf180mcu_fd_sc_mcu7t5v0__fillcap_8
XFILLER_14_531 VDD VDD VSS VSS gf180mcu_fd_sc_mcu7t5v0__fill_1
XTAP_TAPCELL_ROW_28_397 VDD VSS gf180mcu_fd_sc_mcu7t5v0__filltie
XFILLER_81_63 VDD VDD VSS VSS gf180mcu_fd_sc_mcu7t5v0__fillcap_4
XFILLER_81_52 VDD VDD VSS VSS gf180mcu_fd_sc_mcu7t5v0__fillcap_4
X_0780_ _1261_/I1 _1547_/Q _0781_/S _1547_/D VDD VDD VSS VSS gf180mcu_fd_sc_mcu7t5v0__mux2_2
XTAP_TAPCELL_ROW_11_264 VDD VSS gf180mcu_fd_sc_mcu7t5v0__filltie
X_1401_ _1482_/Q wire706/Z _1401_/S _1482_/D VDD VDD VSS VSS gf180mcu_fd_sc_mcu7t5v0__mux2_2
XFILLER_68_247 VDD VDD VSS VSS gf180mcu_fd_sc_mcu7t5v0__fillcap_4
Xinput5 cal_phase0_offset_x[0] input5/Z VDD VDD VSS VSS gf180mcu_fd_sc_mcu7t5v0__buf_1
X_1194_ _1194_/A1 _1194_/A2 wire511/Z input43/Z _1196_/A2 VDD VDD VSS VSS gf180mcu_fd_sc_mcu7t5v0__aoi22_1
X_1263_ _1563_/Q _1593_/D _1264_/B VDD VDD VSS VSS gf180mcu_fd_sc_mcu7t5v0__nand2_1
X_1332_ _1646_/Q _1332_/I1 _1339_/S _1646_/D VDD VDD VSS VSS gf180mcu_fd_sc_mcu7t5v0__mux2_2
XTAP_TAPCELL_ROW_19_331 VDD VSS gf180mcu_fd_sc_mcu7t5v0__filltie
XFILLER_36_177 VDD VDD VSS VSS gf180mcu_fd_sc_mcu7t5v0__fillcap_32
XFILLER_24_317 VDD VDD VSS VSS gf180mcu_fd_sc_mcu7t5v0__fill_1
X_0978_ input58/Z wire547/I wire529/Z input55/Z _0979_/A4 VDD VDD VSS VSS gf180mcu_fd_sc_mcu7t5v0__aoi22_4
Xoutput320 _1615_/Q cfg_f_MEMS_fcw_x[6] VDD VDD VSS VSS gf180mcu_fd_sc_mcu7t5v0__buf_2
Xoutput331 _1626_/Q cfg_f_MEMS_fcw_y[1] VDD VDD VSS VSS gf180mcu_fd_sc_mcu7t5v0__buf_2
Xoutput342 _1649_/Q cfg_phase0_offset_x[11] VDD VDD VSS VSS gf180mcu_fd_sc_mcu7t5v0__buf_2
Xoutput353 _1640_/Q cfg_phase0_offset_x[2] VDD VDD VSS VSS gf180mcu_fd_sc_mcu7t5v0__buf_2
Xoutput375 _1491_/Q cfg_phase0_offset_y[3] VDD VDD VSS VSS gf180mcu_fd_sc_mcu7t5v0__buf_2
Xoutput364 _1500_/Q cfg_phase0_offset_y[12] VDD VDD VSS VSS gf180mcu_fd_sc_mcu7t5v0__buf_2
Xoutput397 _1471_/Q cfg_phase270_offset_x[4] VDD VDD VSS VSS gf180mcu_fd_sc_mcu7t5v0__buf_2
Xoutput386 _1480_/Q cfg_phase270_offset_x[13] VDD VDD VSS VSS gf180mcu_fd_sc_mcu7t5v0__buf_2
XFILLER_70_401 VDD VDD VSS VSS gf180mcu_fd_sc_mcu7t5v0__fillcap_4
XFILLER_55_486 VDD VDD VSS VSS gf180mcu_fd_sc_mcu7t5v0__fillcap_4
XFILLER_42_125 VDD VDD VSS VSS gf180mcu_fd_sc_mcu7t5v0__fill_1
XFILLER_19_68 VDD VDD VSS VSS gf180mcu_fd_sc_mcu7t5v0__fill_2
XFILLER_51_88 VDD VDD VSS VSS gf180mcu_fd_sc_mcu7t5v0__fill_1
XFILLER_7_516 VDD VDD VSS VSS gf180mcu_fd_sc_mcu7t5v0__fill_1
XFILLER_23_361 VDD VDD VSS VSS gf180mcu_fd_sc_mcu7t5v0__fillcap_4
XTAP_TAPCELL_ROW_25_378 VDD VSS gf180mcu_fd_sc_mcu7t5v0__filltie
XFILLER_78_567 VDD VDD VSS VSS gf180mcu_fd_sc_mcu7t5v0__fillcap_4
XFILLER_61_489 VDD VDD VSS VSS gf180mcu_fd_sc_mcu7t5v0__fill_1
XTAP_TAPCELL_ROW_16_301 VDD VSS gf180mcu_fd_sc_mcu7t5v0__filltie
XFILLER_18_177 VDD VDD VSS VSS gf180mcu_fd_sc_mcu7t5v0__fillcap_16
X_0832_ _1566_/Q _1565_/Q _0832_/S _1566_/D VDD VDD VSS VSS gf180mcu_fd_sc_mcu7t5v0__mux2_2
X_0901_ _0901_/A1 _0923_/A2 _0980_/B1 VDD VDD VSS VSS gf180mcu_fd_sc_mcu7t5v0__nor2_4
X_0763_ _0771_/A1 _1577_/Q _1435_/A2 VDD VDD VSS VSS gf180mcu_fd_sc_mcu7t5v0__nor2_4
XFILLER_44_2 VDD VDD VSS VSS gf180mcu_fd_sc_mcu7t5v0__fillcap_4
X_1315_ _1332_/I1 _1633_/Q _1316_/S _1633_/D VDD VDD VSS VSS gf180mcu_fd_sc_mcu7t5v0__mux2_2
XTAP_TAPCELL_ROW_67_713 VDD VSS gf180mcu_fd_sc_mcu7t5v0__filltie
X_1246_ wire644/Z _1244_/Z _1246_/A3 _1246_/B _1575_/D VDD VDD VSS VSS gf180mcu_fd_sc_mcu7t5v0__oai31_1
XFILLER_64_283 VDD VDD VSS VSS gf180mcu_fd_sc_mcu7t5v0__fill_1
XFILLER_49_291 VDD VDD VSS VSS gf180mcu_fd_sc_mcu7t5v0__fillcap_16
X_1177_ _1493_/Q _1240_/B1 _1177_/B _1178_/A4 VDD VDD VSS VSS gf180mcu_fd_sc_mcu7t5v0__aoi21_1
XTAP_TAPCELL_ROW_22_348 VDD VSS gf180mcu_fd_sc_mcu7t5v0__filltie
XFILLER_21_69 VDD VDD VSS VSS gf180mcu_fd_sc_mcu7t5v0__fill_1
XFILLER_62_32 VDD VDD VSS VSS gf180mcu_fd_sc_mcu7t5v0__fill_2
XFILLER_55_294 VDD VDD VSS VSS gf180mcu_fd_sc_mcu7t5v0__fillcap_8
XTAP_TAPCELL_ROW_38_481 VDD VSS gf180mcu_fd_sc_mcu7t5v0__filltie
XFILLER_7_346 VDD VDD VSS VSS gf180mcu_fd_sc_mcu7t5v0__fillcap_4
XFILLER_11_80 VDD VDD VSS VSS gf180mcu_fd_sc_mcu7t5v0__fillcap_4
XFILLER_81_518 VDD VDD VSS VSS gf180mcu_fd_sc_mcu7t5v0__fill_1
XFILLER_53_209 VDD VDD VSS VSS gf180mcu_fd_sc_mcu7t5v0__fill_1
X_1031_ _1031_/A1 wire598/I wire511/I input39/Z _1035_/A1 VDD VDD VSS VSS gf180mcu_fd_sc_mcu7t5v0__aoi22_1
X_1100_ _1100_/A1 wire493/Z _1100_/A3 _1108_/A2 VDD VDD VSS VSS gf180mcu_fd_sc_mcu7t5v0__nand3_1
Xinput74 cal_phase270_offset_y[15] input74/Z VDD VDD VSS VSS gf180mcu_fd_sc_mcu7t5v0__buf_1
Xinput52 cal_phase270_offset_x[14] input52/Z VDD VDD VSS VSS gf180mcu_fd_sc_mcu7t5v0__buf_1
Xinput85 cal_phase270_offset_y[6] input85/Z VDD VDD VSS VSS gf180mcu_fd_sc_mcu7t5v0__buf_1
Xinput63 cal_phase270_offset_x[5] input63/Z VDD VDD VSS VSS gf180mcu_fd_sc_mcu7t5v0__buf_1
X_0815_ _1558_/Q _0819_/A4 _0822_/A2 VDD VDD VSS VSS gf180mcu_fd_sc_mcu7t5v0__nand2_1
Xinput30 cal_phase0_offset_y[13] input30/Z VDD VDD VSS VSS gf180mcu_fd_sc_mcu7t5v0__buf_1
X_0746_ _1571_/Q _1151_/A1 VDD VDD VSS VSS gf180mcu_fd_sc_mcu7t5v0__clkinv_1
Xinput96 cal_phase90_offset_x[16] input96/Z VDD VDD VSS VSS gf180mcu_fd_sc_mcu7t5v0__buf_1
Xinput41 cal_phase0_offset_y[4] input41/Z VDD VDD VSS VSS gf180mcu_fd_sc_mcu7t5v0__buf_1
XFILLER_69_331 VDD VDD VSS VSS gf180mcu_fd_sc_mcu7t5v0__fill_2
XFILLER_57_515 VDD VDD VSS VSS gf180mcu_fd_sc_mcu7t5v0__fill_1
Xload_slew772 wire771/I _1446_/I0 VDD VDD VSS VSS gf180mcu_fd_sc_mcu7t5v0__buf_2
XFILLER_80_573 VDD VDD VSS VSS gf180mcu_fd_sc_mcu7t5v0__fill_1
X_1229_ input32/Z _1229_/A2 _1229_/B1 _1666_/Q _1242_/A2 VDD VDD VSS VSS gf180mcu_fd_sc_mcu7t5v0__aoi22_1
XFILLER_32_24 VDD VDD VSS VSS gf180mcu_fd_sc_mcu7t5v0__fillcap_4
XFILLER_63_518 VDD VDD VSS VSS gf180mcu_fd_sc_mcu7t5v0__fillcap_16
XFILLER_48_504 VDD VDD VSS VSS gf180mcu_fd_sc_mcu7t5v0__fillcap_4
XFILLER_73_64 VDD VDD VSS VSS gf180mcu_fd_sc_mcu7t5v0__fillcap_4
XFILLER_71_540 VDD VDD VSS VSS gf180mcu_fd_sc_mcu7t5v0__fillcap_8
XFILLER_11_150 VDD VDD VSS VSS gf180mcu_fd_sc_mcu7t5v0__fillcap_4
X_1580_ _1580_/D _1580_/RN clkload9/I _1580_/Q VDD VDD VSS VSS gf180mcu_fd_sc_mcu7t5v0__dffrnq_1
XFILLER_66_378 VDD VDD VSS VSS gf180mcu_fd_sc_mcu7t5v0__fillcap_4
X_1014_ _1014_/A1 _1012_/Z _1014_/A3 _1014_/B _1569_/D VDD VDD VSS VSS gf180mcu_fd_sc_mcu7t5v0__oai31_1
XFILLER_54_529 VDD VDD VSS VSS gf180mcu_fd_sc_mcu7t5v0__fill_1
XTAP_TAPCELL_ROW_49_565 VDD VSS gf180mcu_fd_sc_mcu7t5v0__filltie
XFILLER_34_242 VDD VDD VSS VSS gf180mcu_fd_sc_mcu7t5v0__fill_2
XPHY_EDGE_ROW_22_Left_104 VDD VSS gf180mcu_fd_sc_mcu7t5v0__endcap
XFILLER_22_404 VDD VDD VSS VSS gf180mcu_fd_sc_mcu7t5v0__fill_1
XTAP_TAPCELL_ROW_32_432 VDD VSS gf180mcu_fd_sc_mcu7t5v0__filltie
XPHY_EDGE_ROW_31_Left_113 VDD VSS gf180mcu_fd_sc_mcu7t5v0__endcap
Xload_slew580 wire579/I _1221_/A2 VDD VDD VSS VSS gf180mcu_fd_sc_mcu7t5v0__buf_2
XFILLER_57_356 VDD VDD VSS VSS gf180mcu_fd_sc_mcu7t5v0__fill_1
XFILLER_57_345 VDD VDD VSS VSS gf180mcu_fd_sc_mcu7t5v0__fillcap_4
Xload_slew591 _1037_/A2 _1159_/A2 VDD VDD VSS VSS gf180mcu_fd_sc_mcu7t5v0__buf_2
XFILLER_80_381 VDD VDD VSS VSS gf180mcu_fd_sc_mcu7t5v0__fillcap_4
XFILLER_53_562 VDD VDD VSS VSS gf180mcu_fd_sc_mcu7t5v0__fillcap_4
XFILLER_43_34 VDD VDD VSS VSS gf180mcu_fd_sc_mcu7t5v0__fill_1
XFILLER_40_201 VDD VDD VSS VSS gf180mcu_fd_sc_mcu7t5v0__fillcap_4
XPHY_EDGE_ROW_40_Left_122 VDD VSS gf180mcu_fd_sc_mcu7t5v0__endcap
XFILLER_13_426 VDD VDD VSS VSS gf180mcu_fd_sc_mcu7t5v0__fill_2
XFILLER_25_253 VDD VDD VSS VSS gf180mcu_fd_sc_mcu7t5v0__fill_1
Xinput253 raw_edge3_x[20] _1127_/A1 VDD VDD VSS VSS gf180mcu_fd_sc_mcu7t5v0__buf_1
Xinput242 raw_edge3_x[10] _1050_/A1 VDD VDD VSS VSS gf180mcu_fd_sc_mcu7t5v0__buf_1
XFILLER_48_334 VDD VDD VSS VSS gf180mcu_fd_sc_mcu7t5v0__fillcap_4
Xinput220 raw_edge2_y[0] _0946_/B2 VDD VDD VSS VSS gf180mcu_fd_sc_mcu7t5v0__buf_1
Xinput231 raw_edge2_y[1] _0971_/B2 VDD VDD VSS VSS gf180mcu_fd_sc_mcu7t5v0__buf_1
Xinput286 spi_sclk _1597_/D VDD VDD VSS VSS gf180mcu_fd_sc_mcu7t5v0__buf_1
Xinput297 votes_in_phase_y[3] _1103_/B2 VDD VDD VSS VSS gf180mcu_fd_sc_mcu7t5v0__buf_1
XFILLER_75_142 VDD VDD VSS VSS gf180mcu_fd_sc_mcu7t5v0__fillcap_64
Xinput264 raw_edge3_y[11] _1106_/B2 VDD VDD VSS VSS gf180mcu_fd_sc_mcu7t5v0__buf_1
Xinput275 raw_edge3_y[2] _1044_/A1 VDD VDD VSS VSS gf180mcu_fd_sc_mcu7t5v0__buf_1
XTAP_TAPCELL_ROW_46_546 VDD VSS gf180mcu_fd_sc_mcu7t5v0__filltie
XFILLER_29_570 VDD VDD VSS VSS gf180mcu_fd_sc_mcu7t5v0__fillcap_4
X_1563_ _1563_/D _1563_/RN _1597_/CLK _1563_/Q VDD VDD VSS VSS gf180mcu_fd_sc_mcu7t5v0__dffrnq_1
X_1632_ _1632_/D _1632_/RN clkload5/I _1632_/Q VDD VDD VSS VSS gf180mcu_fd_sc_mcu7t5v0__dffrnq_1
X_1494_ _1494_/D _1494_/RN _1663_/CLK _1494_/Q VDD VDD VSS VSS gf180mcu_fd_sc_mcu7t5v0__dffrnq_2
XFILLER_79_492 VDD VDD VSS VSS gf180mcu_fd_sc_mcu7t5v0__fillcap_64
XFILLER_39_389 VDD VDD VSS VSS gf180mcu_fd_sc_mcu7t5v0__fillcap_16
XFILLER_39_345 VDD VDD VSS VSS gf180mcu_fd_sc_mcu7t5v0__fillcap_4
XFILLER_81_167 VDD VDD VSS VSS gf180mcu_fd_sc_mcu7t5v0__fill_2
XTAP_TAPCELL_ROW_80_814 VDD VSS gf180mcu_fd_sc_mcu7t5v0__filltie
XFILLER_35_562 VDD VDD VSS VSS gf180mcu_fd_sc_mcu7t5v0__fillcap_4
XFILLER_57_120 VDD VDD VSS VSS gf180mcu_fd_sc_mcu7t5v0__fillcap_8
XFILLER_38_34 VDD VDD VSS VSS gf180mcu_fd_sc_mcu7t5v0__fill_1
XTAP_TAPCELL_ROW_9_249 VDD VSS gf180mcu_fd_sc_mcu7t5v0__filltie
XFILLER_72_101 VDD VDD VSS VSS gf180mcu_fd_sc_mcu7t5v0__fillcap_4
XFILLER_60_329 VDD VDD VSS VSS gf180mcu_fd_sc_mcu7t5v0__fill_2
XFILLER_57_153 VDD VDD VSS VSS gf180mcu_fd_sc_mcu7t5v0__fillcap_8
XTAP_TAPCELL_ROW_43_516 VDD VSS gf180mcu_fd_sc_mcu7t5v0__filltie
XTAP_TAPCELL_ROW_0_171 VDD VSS gf180mcu_fd_sc_mcu7t5v0__filltie
XTAP_TAPCELL_ROW_51_582 VDD VSS gf180mcu_fd_sc_mcu7t5v0__filltie
XFILLER_13_212 VDD VDD VSS VSS gf180mcu_fd_sc_mcu7t5v0__fill_2
XFILLER_5_422 VDD VDD VSS VSS gf180mcu_fd_sc_mcu7t5v0__fillcap_64
XFILLER_76_462 VDD VDD VSS VSS gf180mcu_fd_sc_mcu7t5v0__fillcap_16
XFILLER_68_407 VDD VDD VSS VSS gf180mcu_fd_sc_mcu7t5v0__fill_1
X_0994_ input34/Z _1120_/A2 _1092_/B1 input97/Z _1127_/A2 _0994_/C2 _0995_/A4 VDD
+ VDD VSS VSS gf180mcu_fd_sc_mcu7t5v0__aoi222_2
XTAP_TAPCELL_ROW_14_284 VDD VSS gf180mcu_fd_sc_mcu7t5v0__filltie
X_1546_ _1546_/D wire824/I _1575_/CLK _1546_/Q VDD VDD VSS VSS gf180mcu_fd_sc_mcu7t5v0__dffrnq_1
X_1477_ _1477_/D _1676_/RN clkload2/I _1477_/Q VDD VDD VSS VSS gf180mcu_fd_sc_mcu7t5v0__dffrnq_1
X_1615_ _1615_/D _1650_/RN _1663_/CLK _1615_/Q VDD VDD VSS VSS gf180mcu_fd_sc_mcu7t5v0__dffrnq_2
XFILLER_39_131 VDD VDD VSS VSS gf180mcu_fd_sc_mcu7t5v0__fillcap_8
XFILLER_27_348 VDD VDD VSS VSS gf180mcu_fd_sc_mcu7t5v0__fill_2
Xwire607 wire607/I _0782_/B VDD VDD VSS VSS gf180mcu_fd_sc_mcu7t5v0__clkbuf_4
XTAP_TAPCELL_ROW_65_696 VDD VSS gf180mcu_fd_sc_mcu7t5v0__filltie
Xfanout773 _1583_/Q wire774/I VDD VDD VSS VSS gf180mcu_fd_sc_mcu7t5v0__dlyb_1
XFILLER_58_473 VDD VDD VSS VSS gf180mcu_fd_sc_mcu7t5v0__fill_2
Xfanout740 wire750/Z wire742/I VDD VDD VSS VSS gf180mcu_fd_sc_mcu7t5v0__dlyb_1
XFILLER_1_18 VDD VDD VSS VSS gf180mcu_fd_sc_mcu7t5v0__fillcap_32
XFILLER_18_326 VDD VDD VSS VSS gf180mcu_fd_sc_mcu7t5v0__fillcap_4
Xfanout795 wire805/Z _1666_/RN VDD VDD VSS VSS gf180mcu_fd_sc_mcu7t5v0__dlyb_1
XFILLER_81_31 VDD VDD VSS VSS gf180mcu_fd_sc_mcu7t5v0__fill_2
XTAP_TAPCELL_ROW_28_398 VDD VSS gf180mcu_fd_sc_mcu7t5v0__filltie
XFILLER_14_521 VDD VDD VSS VSS gf180mcu_fd_sc_mcu7t5v0__fillcap_4
XFILLER_81_86 VDD VDD VSS VSS gf180mcu_fd_sc_mcu7t5v0__fillcap_8
XTAP_TAPCELL_ROW_11_265 VDD VSS gf180mcu_fd_sc_mcu7t5v0__filltie
X_1400_ _1481_/Q _1400_/I1 _1400_/S _1481_/D VDD VDD VSS VSS gf180mcu_fd_sc_mcu7t5v0__mux2_2
X_1331_ _1455_/A2 _0771_/Z _1331_/A3 _1340_/S VDD VDD VSS VSS gf180mcu_fd_sc_mcu7t5v0__and3_2
X_1262_ _1562_/Q wire750/I _1262_/S _1585_/D VDD VDD VSS VSS gf180mcu_fd_sc_mcu7t5v0__mux2_2
XFILLER_64_465 VDD VDD VSS VSS gf180mcu_fd_sc_mcu7t5v0__fillcap_8
Xinput6 cal_phase0_offset_x[10] input6/Z VDD VDD VSS VSS gf180mcu_fd_sc_mcu7t5v0__buf_1
XFILLER_49_440 VDD VDD VSS VSS gf180mcu_fd_sc_mcu7t5v0__fill_2
X_1193_ _1652_/Q wire593/Z _1193_/B1 _1193_/B2 _1212_/A2 VDD VDD VSS VSS gf180mcu_fd_sc_mcu7t5v0__aoi22_1
XFILLER_36_167 VDD VDD VSS VSS gf180mcu_fd_sc_mcu7t5v0__fillcap_8
XFILLER_36_134 VDD VDD VSS VSS gf180mcu_fd_sc_mcu7t5v0__fillcap_16
XFILLER_36_123 VDD VDD VSS VSS gf180mcu_fd_sc_mcu7t5v0__fill_2
XFILLER_64_498 VDD VDD VSS VSS gf180mcu_fd_sc_mcu7t5v0__fillcap_4
X_0977_ input88/Z _1140_/A2 _0977_/B1 _1547_/Q _0979_/A3 VDD VDD VSS VSS gf180mcu_fd_sc_mcu7t5v0__aoi22_1
Xoutput310 _1604_/Q cfg_f_MEMS_fcw_x[11] VDD VDD VSS VSS gf180mcu_fd_sc_mcu7t5v0__buf_2
Xoutput332 _1627_/Q cfg_f_MEMS_fcw_y[2] VDD VDD VSS VSS gf180mcu_fd_sc_mcu7t5v0__buf_2
Xoutput321 _1616_/Q cfg_f_MEMS_fcw_x[7] VDD VDD VSS VSS gf180mcu_fd_sc_mcu7t5v0__buf_2
Xoutput343 _1650_/Q cfg_phase0_offset_x[12] VDD VDD VSS VSS gf180mcu_fd_sc_mcu7t5v0__buf_2
X_1529_ _1529_/D _1531_/RN _1587_/CLK _1529_/Q VDD VDD VSS VSS gf180mcu_fd_sc_mcu7t5v0__dffrnq_2
Xoutput365 _1501_/Q cfg_phase0_offset_y[13] VDD VDD VSS VSS gf180mcu_fd_sc_mcu7t5v0__buf_2
Xoutput354 _1641_/Q cfg_phase0_offset_x[3] VDD VDD VSS VSS gf180mcu_fd_sc_mcu7t5v0__buf_2
Xoutput376 _1492_/Q cfg_phase0_offset_y[4] VDD VDD VSS VSS gf180mcu_fd_sc_mcu7t5v0__buf_2
Xoutput398 _1472_/Q cfg_phase270_offset_x[5] VDD VDD VSS VSS gf180mcu_fd_sc_mcu7t5v0__buf_2
Xoutput387 _1481_/Q cfg_phase270_offset_x[14] VDD VDD VSS VSS gf180mcu_fd_sc_mcu7t5v0__buf_2
XFILLER_70_457 VDD VDD VSS VSS gf180mcu_fd_sc_mcu7t5v0__fill_2
XTAP_TAPCELL_ROW_53_600 VDD VSS gf180mcu_fd_sc_mcu7t5v0__filltie
XFILLER_42_104 VDD VDD VSS VSS gf180mcu_fd_sc_mcu7t5v0__fill_1
XPHY_EDGE_ROW_14_Right_14 VDD VSS gf180mcu_fd_sc_mcu7t5v0__endcap
XTAP_TAPCELL_ROW_25_379 VDD VSS gf180mcu_fd_sc_mcu7t5v0__filltie
XFILLER_78_524 VDD VDD VSS VSS gf180mcu_fd_sc_mcu7t5v0__fill_1
XPHY_EDGE_ROW_23_Right_23 VDD VSS gf180mcu_fd_sc_mcu7t5v0__endcap
XFILLER_18_123 VDD VDD VSS VSS gf180mcu_fd_sc_mcu7t5v0__fill_2
XFILLER_61_413 VDD VDD VSS VSS gf180mcu_fd_sc_mcu7t5v0__fill_1
X_0900_ _0900_/A1 _0916_/A2 wire547/I VDD VDD VSS VSS gf180mcu_fd_sc_mcu7t5v0__nor2_4
XPHY_EDGE_ROW_32_Right_32 VDD VSS gf180mcu_fd_sc_mcu7t5v0__endcap
XFILLER_14_395 VDD VDD VSS VSS gf180mcu_fd_sc_mcu7t5v0__fillcap_4
XTAP_TAPCELL_ROW_16_302 VDD VSS gf180mcu_fd_sc_mcu7t5v0__filltie
X_0831_ _1565_/Q _1564_/Q _0831_/S _1565_/D VDD VDD VSS VSS gf180mcu_fd_sc_mcu7t5v0__mux2_2
X_0762_ _0762_/I _1593_/D VDD VDD VSS VSS gf180mcu_fd_sc_mcu7t5v0__clkinv_1
XFILLER_69_502 VDD VDD VSS VSS gf180mcu_fd_sc_mcu7t5v0__fill_1
XTAP_TAPCELL_ROW_67_714 VDD VSS gf180mcu_fd_sc_mcu7t5v0__filltie
XPHY_EDGE_ROW_41_Right_41 VDD VSS gf180mcu_fd_sc_mcu7t5v0__endcap
X_1314_ _1578_/Q _1428_/A3 _1331_/A3 _1320_/S VDD VDD VSS VSS gf180mcu_fd_sc_mcu7t5v0__nand3_2
X_1245_ _1574_/Q _1245_/A2 _1246_/A3 VDD VDD VSS VSS gf180mcu_fd_sc_mcu7t5v0__nor2_1
XFILLER_64_295 VDD VDD VSS VSS gf180mcu_fd_sc_mcu7t5v0__fillcap_8
XFILLER_52_413 VDD VDD VSS VSS gf180mcu_fd_sc_mcu7t5v0__fill_1
XPHY_EDGE_ROW_50_Right_50 VDD VSS gf180mcu_fd_sc_mcu7t5v0__endcap
X_1176_ _1480_/Q _1202_/A2 _1176_/B1 _1176_/B2 _1178_/A3 VDD VDD VSS VSS gf180mcu_fd_sc_mcu7t5v0__aoi22_1
XFILLER_24_104 VDD VDD VSS VSS gf180mcu_fd_sc_mcu7t5v0__fill_1
XFILLER_32_181 VDD VDD VSS VSS gf180mcu_fd_sc_mcu7t5v0__fill_1
XFILLER_20_321 VDD VDD VSS VSS gf180mcu_fd_sc_mcu7t5v0__fill_2
XFILLER_21_26 VDD VDD VSS VSS gf180mcu_fd_sc_mcu7t5v0__fill_1
XTAP_TAPCELL_ROW_22_349 VDD VSS gf180mcu_fd_sc_mcu7t5v0__filltie
XFILLER_47_207 VDD VDD VSS VSS gf180mcu_fd_sc_mcu7t5v0__fill_2
XFILLER_28_454 VDD VDD VSS VSS gf180mcu_fd_sc_mcu7t5v0__fill_1
XFILLER_55_284 VDD VDD VSS VSS gf180mcu_fd_sc_mcu7t5v0__fill_1
XFILLER_55_273 VDD VDD VSS VSS gf180mcu_fd_sc_mcu7t5v0__fillcap_4
XFILLER_43_413 VDD VDD VSS VSS gf180mcu_fd_sc_mcu7t5v0__fillcap_4
XTAP_TAPCELL_ROW_38_482 VDD VSS gf180mcu_fd_sc_mcu7t5v0__filltie
XFILLER_30_107 VDD VDD VSS VSS gf180mcu_fd_sc_mcu7t5v0__fillcap_4
XFILLER_78_387 VDD VDD VSS VSS gf180mcu_fd_sc_mcu7t5v0__fillcap_16
XFILLER_66_527 VDD VDD VSS VSS gf180mcu_fd_sc_mcu7t5v0__fillcap_8
XFILLER_81_508 VDD VDD VSS VSS gf180mcu_fd_sc_mcu7t5v0__fill_2
XTAP_TAPCELL_ROW_72_750 VDD VSS gf180mcu_fd_sc_mcu7t5v0__filltie
XFILLER_61_221 VDD VDD VSS VSS gf180mcu_fd_sc_mcu7t5v0__fillcap_16
X_1030_ _1030_/A1 _1030_/A2 _1030_/A3 _1030_/Z VDD VDD VSS VSS gf180mcu_fd_sc_mcu7t5v0__and3_1
X_0814_ _0782_/B _0907_/A1 _0819_/A4 VDD VDD VSS VSS gf180mcu_fd_sc_mcu7t5v0__nor2_1
Xinput31 cal_phase0_offset_y[14] input31/Z VDD VDD VSS VSS gf180mcu_fd_sc_mcu7t5v0__buf_2
Xinput20 cal_phase0_offset_x[4] input20/Z VDD VDD VSS VSS gf180mcu_fd_sc_mcu7t5v0__buf_1
Xinput86 cal_phase270_offset_y[7] input86/Z VDD VDD VSS VSS gf180mcu_fd_sc_mcu7t5v0__buf_1
Xinput75 cal_phase270_offset_y[16] input75/Z VDD VDD VSS VSS gf180mcu_fd_sc_mcu7t5v0__buf_1
Xinput53 cal_phase270_offset_x[15] input53/Z VDD VDD VSS VSS gf180mcu_fd_sc_mcu7t5v0__buf_2
Xinput64 cal_phase270_offset_x[6] input64/Z VDD VDD VSS VSS gf180mcu_fd_sc_mcu7t5v0__buf_1
Xinput97 cal_phase90_offset_x[17] input97/Z VDD VDD VSS VSS gf180mcu_fd_sc_mcu7t5v0__buf_1
X_0745_ _1560_/Q _1259_/A1 VDD VDD VSS VSS gf180mcu_fd_sc_mcu7t5v0__clkinv_1
Xinput42 cal_phase0_offset_y[5] input42/Z VDD VDD VSS VSS gf180mcu_fd_sc_mcu7t5v0__buf_1
Xload_slew751 _0781_/I0 wire750/I VDD VDD VSS VSS gf180mcu_fd_sc_mcu7t5v0__buf_2
X_1228_ _1228_/A1 wire541/Z _1228_/B1 input53/Z _1239_/A2 VDD VDD VSS VSS gf180mcu_fd_sc_mcu7t5v0__aoi22_1
Xload_slew784 wire785/Z _1644_/RN VDD VDD VSS VSS gf180mcu_fd_sc_mcu7t5v0__clkbuf_1
XFILLER_52_276 VDD VDD VSS VSS gf180mcu_fd_sc_mcu7t5v0__fillcap_16
XFILLER_52_243 VDD VDD VSS VSS gf180mcu_fd_sc_mcu7t5v0__fill_2
XTAP_TAPCELL_ROW_35_452 VDD VSS gf180mcu_fd_sc_mcu7t5v0__filltie
X_1159_ _1514_/Q _1159_/A2 _1217_/B1 _1159_/B2 _1162_/A1 VDD VDD VSS VSS gf180mcu_fd_sc_mcu7t5v0__aoi22_1
XFILLER_12_107 VDD VDD VSS VSS gf180mcu_fd_sc_mcu7t5v0__fillcap_4
XFILLER_32_58 VDD VDD VSS VSS gf180mcu_fd_sc_mcu7t5v0__fill_1
XFILLER_4_317 VDD VDD VSS VSS gf180mcu_fd_sc_mcu7t5v0__fillcap_64
XFILLER_20_173 VDD VDD VSS VSS gf180mcu_fd_sc_mcu7t5v0__fill_2
XFILLER_0_512 VDD VDD VSS VSS gf180mcu_fd_sc_mcu7t5v0__fillcap_32
XFILLER_75_346 VDD VDD VSS VSS gf180mcu_fd_sc_mcu7t5v0__fillcap_4
XFILLER_71_552 VDD VDD VSS VSS gf180mcu_fd_sc_mcu7t5v0__fill_2
XFILLER_28_240 VDD VDD VSS VSS gf180mcu_fd_sc_mcu7t5v0__fillcap_4
XFILLER_16_457 VDD VDD VSS VSS gf180mcu_fd_sc_mcu7t5v0__fillcap_4
XFILLER_43_276 VDD VDD VSS VSS gf180mcu_fd_sc_mcu7t5v0__fillcap_4
XTAP_TAPCELL_ROW_49_566 VDD VSS gf180mcu_fd_sc_mcu7t5v0__filltie
X_1013_ _1568_/Q _1245_/A2 _1014_/A3 VDD VDD VSS VSS gf180mcu_fd_sc_mcu7t5v0__nor2_1
XFILLER_62_541 VDD VDD VSS VSS gf180mcu_fd_sc_mcu7t5v0__fill_1
XFILLER_22_427 VDD VDD VSS VSS gf180mcu_fd_sc_mcu7t5v0__fillcap_4
XTAP_TAPCELL_ROW_32_433 VDD VSS gf180mcu_fd_sc_mcu7t5v0__filltie
Xclkbuf_leaf_14_clk clkbuf_leaf_0_clk/I _1593_/CLK VDD VDD VSS VSS gf180mcu_fd_sc_mcu7t5v0__clkbuf_8
XPHY_EDGE_ROW_4_Right_4 VDD VSS gf180mcu_fd_sc_mcu7t5v0__endcap
XFILLER_72_349 VDD VDD VSS VSS gf180mcu_fd_sc_mcu7t5v0__fillcap_8
Xload_slew581 _0951_/A2 _1219_/A2 VDD VDD VSS VSS gf180mcu_fd_sc_mcu7t5v0__buf_2
XFILLER_43_68 VDD VDD VSS VSS gf180mcu_fd_sc_mcu7t5v0__fill_2
XFILLER_40_257 VDD VDD VSS VSS gf180mcu_fd_sc_mcu7t5v0__fillcap_8
Xinput287 state_o[0] _0957_/A1 VDD VDD VSS VSS gf180mcu_fd_sc_mcu7t5v0__buf_1
Xinput243 raw_edge3_x[11] _1067_/B2 VDD VDD VSS VSS gf180mcu_fd_sc_mcu7t5v0__buf_1
Xinput265 raw_edge3_y[12] _1138_/B2 VDD VDD VSS VSS gf180mcu_fd_sc_mcu7t5v0__buf_1
Xinput276 raw_edge3_y[3] _1091_/B2 VDD VDD VSS VSS gf180mcu_fd_sc_mcu7t5v0__buf_1
Xinput254 raw_edge3_x[2] _1057_/B2 VDD VDD VSS VSS gf180mcu_fd_sc_mcu7t5v0__buf_1
Xinput232 raw_edge2_y[20] _1112_/A1 VDD VDD VSS VSS gf180mcu_fd_sc_mcu7t5v0__buf_1
Xinput221 raw_edge2_y[10] _1033_/A1 VDD VDD VSS VSS gf180mcu_fd_sc_mcu7t5v0__buf_1
Xinput210 raw_edge2_x[1] _0993_/A1 VDD VDD VSS VSS gf180mcu_fd_sc_mcu7t5v0__buf_1
XFILLER_0_342 VDD VDD VSS VSS gf180mcu_fd_sc_mcu7t5v0__fillcap_32
Xinput298 votes_out_phase_x[0] _0935_/C2 VDD VDD VSS VSS gf180mcu_fd_sc_mcu7t5v0__buf_2
XTAP_TAPCELL_ROW_46_547 VDD VSS gf180mcu_fd_sc_mcu7t5v0__filltie
XFILLER_44_541 VDD VDD VSS VSS gf180mcu_fd_sc_mcu7t5v0__fill_1
X_1631_ _1631_/D wire843/Z clkload5/I _1631_/Q VDD VDD VSS VSS gf180mcu_fd_sc_mcu7t5v0__dffrnq_2
X_1562_ _1562_/D _1575_/RN _1597_/CLK _1562_/Q VDD VDD VSS VSS gf180mcu_fd_sc_mcu7t5v0__dffrnq_1
Xclkbuf_leaf_3_clk clkbuf_leaf_3_clk/I _1575_/CLK VDD VDD VSS VSS gf180mcu_fd_sc_mcu7t5v0__clkbuf_8
X_1493_ _1493_/D _1493_/RN _1629_/CLK _1493_/Q VDD VDD VSS VSS gf180mcu_fd_sc_mcu7t5v0__dffrnq_2
XTAP_TAPCELL_ROW_80_815 VDD VSS gf180mcu_fd_sc_mcu7t5v0__filltie
XFILLER_77_408 VDD VDD VSS VSS gf180mcu_fd_sc_mcu7t5v0__fill_2
XFILLER_38_57 VDD VDD VSS VSS gf180mcu_fd_sc_mcu7t5v0__fill_1
XPHY_EDGE_ROW_79_Right_79 VDD VSS gf180mcu_fd_sc_mcu7t5v0__endcap
XFILLER_54_34 VDD VDD VSS VSS gf180mcu_fd_sc_mcu7t5v0__fill_1
XFILLER_45_349 VDD VDD VSS VSS gf180mcu_fd_sc_mcu7t5v0__fill_1
XTAP_TAPCELL_ROW_43_517 VDD VSS gf180mcu_fd_sc_mcu7t5v0__filltie
XTAP_TAPCELL_ROW_0_172 VDD VSS gf180mcu_fd_sc_mcu7t5v0__filltie
XTAP_TAPCELL_ROW_51_583 VDD VSS gf180mcu_fd_sc_mcu7t5v0__filltie
XFILLER_13_279 VDD VDD VSS VSS gf180mcu_fd_sc_mcu7t5v0__fill_1
XTAP_TAPCELL_ROW_59_650 VDD VSS gf180mcu_fd_sc_mcu7t5v0__filltie
XFILLER_36_305 VDD VDD VSS VSS gf180mcu_fd_sc_mcu7t5v0__fillcap_8
XFILLER_0_172 VDD VDD VSS VSS gf180mcu_fd_sc_mcu7t5v0__fillcap_32
X_0993_ _0993_/A1 wire602/Z wire598/Z _0993_/B2 _1216_/A2 _0993_/C2 _0995_/A3 VDD
+ VDD VSS VSS gf180mcu_fd_sc_mcu7t5v0__aoi222_4
X_1614_ _1614_/D _1639_/RN _1659_/CLK _1614_/Q VDD VDD VSS VSS gf180mcu_fd_sc_mcu7t5v0__dffrnq_2
XTAP_TAPCELL_ROW_14_285 VDD VSS gf180mcu_fd_sc_mcu7t5v0__filltie
X_1545_ _1545_/D _1545_/RN clkload9/I _1545_/Q VDD VDD VSS VSS gf180mcu_fd_sc_mcu7t5v0__dffrnq_1
X_1476_ _1476_/D _1476_/RN clkload3/I _1476_/Q VDD VDD VSS VSS gf180mcu_fd_sc_mcu7t5v0__dffrnq_1
XFILLER_5_72 VDD VDD VSS VSS gf180mcu_fd_sc_mcu7t5v0__fillcap_64
XTAP_TAPCELL_ROW_65_697 VDD VSS gf180mcu_fd_sc_mcu7t5v0__filltie
XFILLER_40_25 VDD VDD VSS VSS gf180mcu_fd_sc_mcu7t5v0__fill_1
XFILLER_10_227 VDD VDD VSS VSS gf180mcu_fd_sc_mcu7t5v0__fillcap_16
XFILLER_65_66 VDD VDD VSS VSS gf180mcu_fd_sc_mcu7t5v0__fillcap_4
XTAP_TAPCELL_ROW_56_620 VDD VSS gf180mcu_fd_sc_mcu7t5v0__filltie
XFILLER_49_67 VDD VDD VSS VSS gf180mcu_fd_sc_mcu7t5v0__fill_2
Xfanout730 _1587_/Q wire734/I VDD VDD VSS VSS gf180mcu_fd_sc_mcu7t5v0__dlyb_1
Xfanout752 wire762/Z _1346_/I1 VDD VDD VSS VSS gf180mcu_fd_sc_mcu7t5v0__dlyb_1
XFILLER_81_10 VDD VDD VSS VSS gf180mcu_fd_sc_mcu7t5v0__fillcap_4
XFILLER_41_352 VDD VDD VSS VSS gf180mcu_fd_sc_mcu7t5v0__fillcap_16
XTAP_TAPCELL_ROW_28_399 VDD VSS gf180mcu_fd_sc_mcu7t5v0__filltie
XFILLER_26_382 VDD VDD VSS VSS gf180mcu_fd_sc_mcu7t5v0__fill_2
XFILLER_26_393 VDD VDD VSS VSS gf180mcu_fd_sc_mcu7t5v0__fill_1
XTAP_TAPCELL_ROW_11_266 VDD VSS gf180mcu_fd_sc_mcu7t5v0__filltie
X_1261_ _1561_/Q _1261_/I1 _1261_/S _1584_/D VDD VDD VSS VSS gf180mcu_fd_sc_mcu7t5v0__mux2_2
XFILLER_30_91 VDD VDD VSS VSS gf180mcu_fd_sc_mcu7t5v0__fillcap_8
XFILLER_1_492 VDD VDD VSS VSS gf180mcu_fd_sc_mcu7t5v0__fillcap_32
X_1330_ _1645_/Q _1330_/I1 _1330_/S _1645_/D VDD VDD VSS VSS gf180mcu_fd_sc_mcu7t5v0__mux2_2
Xinput7 cal_phase0_offset_x[11] input7/Z VDD VDD VSS VSS gf180mcu_fd_sc_mcu7t5v0__buf_1
X_1192_ _1192_/A1 wire541/I _1228_/B1 input52/Z _1212_/A1 VDD VDD VSS VSS gf180mcu_fd_sc_mcu7t5v0__aoi22_1
XFILLER_17_382 VDD VDD VSS VSS gf180mcu_fd_sc_mcu7t5v0__fillcap_4
X_0976_ _1534_/Q _1217_/A2 wire552/Z _0976_/B2 _0979_/A2 VDD VDD VSS VSS gf180mcu_fd_sc_mcu7t5v0__aoi22_2
Xoutput322 _1601_/Q cfg_f_MEMS_fcw_x[8] VDD VDD VSS VSS gf180mcu_fd_sc_mcu7t5v0__buf_2
Xoutput333 _1628_/Q cfg_f_MEMS_fcw_y[3] VDD VDD VSS VSS gf180mcu_fd_sc_mcu7t5v0__buf_2
Xoutput355 _1642_/Q cfg_phase0_offset_x[4] VDD VDD VSS VSS gf180mcu_fd_sc_mcu7t5v0__buf_2
Xoutput311 _1605_/Q cfg_f_MEMS_fcw_x[12] VDD VDD VSS VSS gf180mcu_fd_sc_mcu7t5v0__buf_2
Xoutput366 _1502_/Q cfg_phase0_offset_y[14] VDD VDD VSS VSS gf180mcu_fd_sc_mcu7t5v0__buf_2
Xoutput377 _1493_/Q cfg_phase0_offset_y[5] VDD VDD VSS VSS gf180mcu_fd_sc_mcu7t5v0__buf_2
Xoutput344 _1651_/Q cfg_phase0_offset_x[13] VDD VDD VSS VSS gf180mcu_fd_sc_mcu7t5v0__buf_2
X_1528_ _1528_/D _1543_/RN clkload9/I _1528_/Q VDD VDD VSS VSS gf180mcu_fd_sc_mcu7t5v0__dffrnq_2
X_1459_ _1528_/Q _1464_/S _1460_/B VDD VDD VSS VSS gf180mcu_fd_sc_mcu7t5v0__nand2_1
Xoutput388 _1482_/Q cfg_phase270_offset_x[15] VDD VDD VSS VSS gf180mcu_fd_sc_mcu7t5v0__buf_2
Xoutput399 _1473_/Q cfg_phase270_offset_x[6] VDD VDD VSS VSS gf180mcu_fd_sc_mcu7t5v0__buf_2
XTAP_TAPCELL_ROW_53_601 VDD VSS gf180mcu_fd_sc_mcu7t5v0__filltie
XFILLER_50_160 VDD VDD VSS VSS gf180mcu_fd_sc_mcu7t5v0__fillcap_8
XFILLER_35_69 VDD VDD VSS VSS gf180mcu_fd_sc_mcu7t5v0__fill_1
XFILLER_46_499 VDD VDD VSS VSS gf180mcu_fd_sc_mcu7t5v0__fillcap_8
XTAP_TAPCELL_ROW_16_303 VDD VSS gf180mcu_fd_sc_mcu7t5v0__filltie
X_0830_ _1564_/Q _1563_/Q _0831_/S _1564_/D VDD VDD VSS VSS gf180mcu_fd_sc_mcu7t5v0__mux2_2
XFILLER_33_138 VDD VDD VSS VSS gf180mcu_fd_sc_mcu7t5v0__fill_2
X_0761_ _1553_/Q _0825_/B2 _0761_/ZN VDD VDD VSS VSS gf180mcu_fd_sc_mcu7t5v0__nand2_1
XFILLER_69_547 VDD VDD VSS VSS gf180mcu_fd_sc_mcu7t5v0__fill_1
XTAP_TAPCELL_ROW_67_715 VDD VSS gf180mcu_fd_sc_mcu7t5v0__filltie
X_1244_ _1244_/A1 _1244_/A2 _1244_/A3 _1244_/A4 _1244_/Z VDD VDD VSS VSS gf180mcu_fd_sc_mcu7t5v0__and4_1
XFILLER_37_422 VDD VDD VSS VSS gf180mcu_fd_sc_mcu7t5v0__fill_1
X_1313_ wire710/Z _1632_/Q _1313_/S _1632_/D VDD VDD VSS VSS gf180mcu_fd_sc_mcu7t5v0__mux2_2
XFILLER_52_436 VDD VDD VSS VSS gf180mcu_fd_sc_mcu7t5v0__fill_1
X_1175_ _1175_/A1 _1175_/A2 _1175_/A3 _1175_/A4 _1179_/A3 VDD VDD VSS VSS gf180mcu_fd_sc_mcu7t5v0__nand4_1
XFILLER_24_138 VDD VDD VSS VSS gf180mcu_fd_sc_mcu7t5v0__fill_2
X_0959_ _1546_/Q _0977_/B1 _1039_/B1 _0959_/B2 _0963_/A1 VDD VDD VSS VSS gf180mcu_fd_sc_mcu7t5v0__aoi22_2
XFILLER_55_263 VDD VDD VSS VSS gf180mcu_fd_sc_mcu7t5v0__fill_1
XFILLER_62_34 VDD VDD VSS VSS gf180mcu_fd_sc_mcu7t5v0__fill_1
XTAP_TAPCELL_ROW_38_483 VDD VSS gf180mcu_fd_sc_mcu7t5v0__filltie
XFILLER_78_311 VDD VDD VSS VSS gf180mcu_fd_sc_mcu7t5v0__fillcap_4
XFILLER_66_539 VDD VDD VSS VSS gf180mcu_fd_sc_mcu7t5v0__fill_2
XTAP_TAPCELL_ROW_72_751 VDD VSS gf180mcu_fd_sc_mcu7t5v0__filltie
XFILLER_61_277 VDD VDD VSS VSS gf180mcu_fd_sc_mcu7t5v0__fill_2
XFILLER_46_230 VDD VDD VSS VSS gf180mcu_fd_sc_mcu7t5v0__fillcap_8
Xinput54 cal_phase270_offset_x[16] input54/Z VDD VDD VSS VSS gf180mcu_fd_sc_mcu7t5v0__buf_1
Xinput43 cal_phase0_offset_y[6] input43/Z VDD VDD VSS VSS gf180mcu_fd_sc_mcu7t5v0__buf_1
XFILLER_61_299 VDD VDD VSS VSS gf180mcu_fd_sc_mcu7t5v0__fill_1
Xinput10 cal_phase0_offset_x[14] input10/Z VDD VDD VSS VSS gf180mcu_fd_sc_mcu7t5v0__buf_1
Xinput32 cal_phase0_offset_y[15] input32/Z VDD VDD VSS VSS gf180mcu_fd_sc_mcu7t5v0__buf_2
X_0813_ _0803_/Z _0812_/Z _0907_/A1 VDD VDD VSS VSS gf180mcu_fd_sc_mcu7t5v0__nand2_2
Xinput21 cal_phase0_offset_x[5] input21/Z VDD VDD VSS VSS gf180mcu_fd_sc_mcu7t5v0__buf_1
Xinput76 cal_phase270_offset_y[17] input76/Z VDD VDD VSS VSS gf180mcu_fd_sc_mcu7t5v0__buf_1
XFILLER_69_333 VDD VDD VSS VSS gf180mcu_fd_sc_mcu7t5v0__fill_1
Xinput87 cal_phase270_offset_y[8] input87/Z VDD VDD VSS VSS gf180mcu_fd_sc_mcu7t5v0__buf_1
Xinput65 cal_phase270_offset_x[7] input65/Z VDD VDD VSS VSS gf180mcu_fd_sc_mcu7t5v0__buf_1
Xinput98 cal_phase90_offset_x[18] input98/Z VDD VDD VSS VSS gf180mcu_fd_sc_mcu7t5v0__buf_1
X_0744_ _1559_/Q _1257_/A1 VDD VDD VSS VSS gf180mcu_fd_sc_mcu7t5v0__clkinv_1
XFILLER_6_381 VDD VDD VSS VSS gf180mcu_fd_sc_mcu7t5v0__fillcap_4
X_1227_ _1624_/Q wire604/I _1227_/B1 _1227_/B2 _1236_/A2 VDD VDD VSS VSS gf180mcu_fd_sc_mcu7t5v0__aoi22_1
X_1158_ _1158_/A1 wire603/Z wire594/Z _1538_/Q _1180_/A2 VDD VDD VSS VSS gf180mcu_fd_sc_mcu7t5v0__aoi22_1
XFILLER_37_241 VDD VDD VSS VSS gf180mcu_fd_sc_mcu7t5v0__fill_1
Xload_slew796 _1662_/RN _1665_/RN VDD VDD VSS VSS gf180mcu_fd_sc_mcu7t5v0__clkbuf_2
XTAP_TAPCELL_ROW_35_453 VDD VSS gf180mcu_fd_sc_mcu7t5v0__filltie
X_1089_ wire495/Z _1089_/A2 _1089_/A3 _1090_/C VDD VDD VSS VSS gf180mcu_fd_sc_mcu7t5v0__nand3_1
XFILLER_32_37 VDD VDD VSS VSS gf180mcu_fd_sc_mcu7t5v0__fillcap_4
XFILLER_20_152 VDD VDD VSS VSS gf180mcu_fd_sc_mcu7t5v0__fill_2
XFILLER_57_67 VDD VDD VSS VSS gf180mcu_fd_sc_mcu7t5v0__fill_2
XFILLER_0_546 VDD VDD VSS VSS gf180mcu_fd_sc_mcu7t5v0__fillcap_4
XFILLER_16_403 VDD VDD VSS VSS gf180mcu_fd_sc_mcu7t5v0__fillcap_4
X_1012_ wire470/Z _1012_/A2 _1012_/A3 _1012_/Z VDD VDD VSS VSS gf180mcu_fd_sc_mcu7t5v0__and3_1
XTAP_TAPCELL_ROW_49_567 VDD VSS gf180mcu_fd_sc_mcu7t5v0__filltie
XFILLER_47_550 VDD VDD VSS VSS gf180mcu_fd_sc_mcu7t5v0__fill_1
XFILLER_81_339 VDD VDD VSS VSS gf180mcu_fd_sc_mcu7t5v0__fill_1
XFILLER_34_244 VDD VDD VSS VSS gf180mcu_fd_sc_mcu7t5v0__fill_1
XFILLER_34_255 VDD VDD VSS VSS gf180mcu_fd_sc_mcu7t5v0__fillcap_4
XTAP_TAPCELL_ROW_32_434 VDD VSS gf180mcu_fd_sc_mcu7t5v0__filltie
Xload_slew582 _0951_/A2 _1140_/A2 VDD VDD VSS VSS gf180mcu_fd_sc_mcu7t5v0__buf_2
Xload_slew571 _1105_/A2 _1036_/A2 VDD VDD VSS VSS gf180mcu_fd_sc_mcu7t5v0__buf_2
Xload_slew560 _1033_/A2 _1193_/B1 VDD VDD VSS VSS gf180mcu_fd_sc_mcu7t5v0__buf_2
XFILLER_72_317 VDD VDD VSS VSS gf180mcu_fd_sc_mcu7t5v0__fillcap_32
XFILLER_40_247 VDD VDD VSS VSS gf180mcu_fd_sc_mcu7t5v0__fill_1
XFILLER_13_428 VDD VDD VSS VSS gf180mcu_fd_sc_mcu7t5v0__fill_1
XFILLER_68_22 VDD VDD VSS VSS gf180mcu_fd_sc_mcu7t5v0__fillcap_8
Xinput288 state_o[1] _1000_/B2 VDD VDD VSS VSS gf180mcu_fd_sc_mcu7t5v0__buf_1
Xinput299 votes_out_phase_x[1] _0982_/A1 VDD VDD VSS VSS gf180mcu_fd_sc_mcu7t5v0__buf_1
Xinput266 raw_edge3_y[13] _1173_/A1 VDD VDD VSS VSS gf180mcu_fd_sc_mcu7t5v0__buf_1
Xinput244 raw_edge3_x[12] _1129_/B2 VDD VDD VSS VSS gf180mcu_fd_sc_mcu7t5v0__buf_1
Xinput277 raw_edge3_y[4] _1145_/A1 VDD VDD VSS VSS gf180mcu_fd_sc_mcu7t5v0__buf_1
XFILLER_48_303 VDD VDD VSS VSS gf180mcu_fd_sc_mcu7t5v0__fill_2
Xinput255 raw_edge3_x[3] _1080_/B2 VDD VDD VSS VSS gf180mcu_fd_sc_mcu7t5v0__buf_1
Xinput222 raw_edge2_y[11] _1094_/A1 VDD VDD VSS VSS gf180mcu_fd_sc_mcu7t5v0__buf_1
Xinput211 raw_edge2_x[20] _1128_/B2 VDD VDD VSS VSS gf180mcu_fd_sc_mcu7t5v0__buf_1
Xinput200 raw_edge2_x[10] _1042_/A1 VDD VDD VSS VSS gf180mcu_fd_sc_mcu7t5v0__buf_1
Xinput233 raw_edge2_y[2] _1055_/B2 VDD VDD VSS VSS gf180mcu_fd_sc_mcu7t5v0__buf_1
XFILLER_0_376 VDD VDD VSS VSS gf180mcu_fd_sc_mcu7t5v0__fillcap_32
XFILLER_17_81 VDD VDD VSS VSS gf180mcu_fd_sc_mcu7t5v0__fillcap_8
X_1630_ _1630_/D wire829/Z clkload6/I _1630_/Q VDD VDD VSS VSS gf180mcu_fd_sc_mcu7t5v0__dffrnq_2
XFILLER_12_472 VDD VDD VSS VSS gf180mcu_fd_sc_mcu7t5v0__fillcap_4
X_1561_ _1561_/D wire876/Z clkload7/I _1561_/Q VDD VDD VSS VSS gf180mcu_fd_sc_mcu7t5v0__dffrnq_1
XFILLER_39_314 VDD VDD VSS VSS gf180mcu_fd_sc_mcu7t5v0__fill_1
X_1492_ _1492_/D wire828/Z _1629_/CLK _1492_/Q VDD VDD VSS VSS gf180mcu_fd_sc_mcu7t5v0__dffrnq_1
XFILLER_81_169 VDD VDD VSS VSS gf180mcu_fd_sc_mcu7t5v0__fill_1
XFILLER_81_147 VDD VDD VSS VSS gf180mcu_fd_sc_mcu7t5v0__fillcap_16
XTAP_TAPCELL_ROW_80_816 VDD VSS gf180mcu_fd_sc_mcu7t5v0__filltie
XFILLER_66_177 VDD VDD VSS VSS gf180mcu_fd_sc_mcu7t5v0__fillcap_4
XFILLER_54_317 VDD VDD VSS VSS gf180mcu_fd_sc_mcu7t5v0__fillcap_4
XFILLER_54_306 VDD VDD VSS VSS gf180mcu_fd_sc_mcu7t5v0__fillcap_8
XFILLER_50_501 VDD VDD VSS VSS gf180mcu_fd_sc_mcu7t5v0__fill_1
XFILLER_12_2 VDD VDD VSS VSS gf180mcu_fd_sc_mcu7t5v0__fillcap_4
XFILLER_50_523 VDD VDD VSS VSS gf180mcu_fd_sc_mcu7t5v0__fill_2
XFILLER_22_247 VDD VDD VSS VSS gf180mcu_fd_sc_mcu7t5v0__fillcap_8
XFILLER_57_199 VDD VDD VSS VSS gf180mcu_fd_sc_mcu7t5v0__fill_2
XFILLER_54_57 VDD VDD VSS VSS gf180mcu_fd_sc_mcu7t5v0__fillcap_4
XTAP_TAPCELL_ROW_43_518 VDD VSS gf180mcu_fd_sc_mcu7t5v0__filltie
XFILLER_38_380 VDD VDD VSS VSS gf180mcu_fd_sc_mcu7t5v0__fillcap_4
XTAP_TAPCELL_ROW_0_173 VDD VSS gf180mcu_fd_sc_mcu7t5v0__filltie
XFILLER_70_34 VDD VDD VSS VSS gf180mcu_fd_sc_mcu7t5v0__fill_1
XTAP_TAPCELL_ROW_51_584 VDD VSS gf180mcu_fd_sc_mcu7t5v0__filltie
XFILLER_48_100 VDD VDD VSS VSS gf180mcu_fd_sc_mcu7t5v0__fillcap_4
XTAP_TAPCELL_ROW_8_240 VDD VSS gf180mcu_fd_sc_mcu7t5v0__filltie
XFILLER_63_136 VDD VDD VSS VSS gf180mcu_fd_sc_mcu7t5v0__fillcap_4
XTAP_TAPCELL_ROW_59_651 VDD VSS gf180mcu_fd_sc_mcu7t5v0__filltie
XFILLER_48_177 VDD VDD VSS VSS gf180mcu_fd_sc_mcu7t5v0__fillcap_4
XFILLER_36_328 VDD VDD VSS VSS gf180mcu_fd_sc_mcu7t5v0__fillcap_8
XFILLER_36_317 VDD VDD VSS VSS gf180mcu_fd_sc_mcu7t5v0__fill_2
X_0992_ input13/Z _1129_/A2 wire536/Z _1668_/Q _1177_/B _0995_/A2 VDD VDD VSS VSS
+ gf180mcu_fd_sc_mcu7t5v0__aoi221_1
XFILLER_44_383 VDD VDD VSS VSS gf180mcu_fd_sc_mcu7t5v0__fill_2
XTAP_TAPCELL_ROW_14_286 VDD VSS gf180mcu_fd_sc_mcu7t5v0__filltie
X_1544_ _1544_/D wire865/Z clkload4/I _1544_/Q VDD VDD VSS VSS gf180mcu_fd_sc_mcu7t5v0__dffrnq_1
X_1613_ _1613_/D _1616_/RN _1674_/CLK _1613_/Q VDD VDD VSS VSS gf180mcu_fd_sc_mcu7t5v0__dffrnq_1
X_1475_ _1475_/D _1481_/RN clkload1/I _1475_/Q VDD VDD VSS VSS gf180mcu_fd_sc_mcu7t5v0__dffrnq_1
XPHY_EDGE_ROW_19_Left_101 VDD VSS gf180mcu_fd_sc_mcu7t5v0__endcap
XTAP_TAPCELL_ROW_65_698 VDD VSS gf180mcu_fd_sc_mcu7t5v0__filltie
XFILLER_54_103 VDD VDD VSS VSS gf180mcu_fd_sc_mcu7t5v0__fill_2
XFILLER_39_188 VDD VDD VSS VSS gf180mcu_fd_sc_mcu7t5v0__fillcap_16
XFILLER_40_37 VDD VDD VSS VSS gf180mcu_fd_sc_mcu7t5v0__fillcap_4
XPHY_EDGE_ROW_28_Left_110 VDD VSS gf180mcu_fd_sc_mcu7t5v0__endcap
XFILLER_77_206 VDD VDD VSS VSS gf180mcu_fd_sc_mcu7t5v0__fillcap_4
XTAP_TAPCELL_ROW_56_621 VDD VSS gf180mcu_fd_sc_mcu7t5v0__filltie
XFILLER_18_317 VDD VDD VSS VSS gf180mcu_fd_sc_mcu7t5v0__fill_1
XFILLER_81_33 VDD VDD VSS VSS gf180mcu_fd_sc_mcu7t5v0__fill_1
XFILLER_73_489 VDD VDD VSS VSS gf180mcu_fd_sc_mcu7t5v0__fill_1
XFILLER_53_191 VDD VDD VSS VSS gf180mcu_fd_sc_mcu7t5v0__fillcap_16
XFILLER_5_276 VDD VDD VSS VSS gf180mcu_fd_sc_mcu7t5v0__fillcap_4
XTAP_TAPCELL_ROW_11_267 VDD VSS gf180mcu_fd_sc_mcu7t5v0__filltie
XFILLER_14_82 VDD VDD VSS VSS gf180mcu_fd_sc_mcu7t5v0__fillcap_16
X_1260_ _1600_/Q wire774/Z _1261_/S _1583_/D VDD VDD VSS VSS gf180mcu_fd_sc_mcu7t5v0__mux2_2
XFILLER_64_401 VDD VDD VSS VSS gf180mcu_fd_sc_mcu7t5v0__fill_1
Xinput8 cal_phase0_offset_x[12] input8/Z VDD VDD VSS VSS gf180mcu_fd_sc_mcu7t5v0__buf_1
X_1191_ _1191_/A1 wire576/Z wire568/Z _1191_/B2 _1196_/A1 VDD VDD VSS VSS gf180mcu_fd_sc_mcu7t5v0__aoi22_1
XFILLER_51_139 VDD VDD VSS VSS gf180mcu_fd_sc_mcu7t5v0__fill_1
XTAP_TAPCELL_ROW_62_668 VDD VSS gf180mcu_fd_sc_mcu7t5v0__filltie
X_0975_ _1626_/Q wire548/Z wire535/Z _0975_/B2 _0979_/A1 VDD VDD VSS VSS gf180mcu_fd_sc_mcu7t5v0__aoi22_1
XFILLER_59_228 VDD VDD VSS VSS gf180mcu_fd_sc_mcu7t5v0__fillcap_4
X_1527_ _1527_/D _1530_/RN clkload9/I _1527_/Q VDD VDD VSS VSS gf180mcu_fd_sc_mcu7t5v0__dffrnq_1
Xoutput389 _1675_/Q cfg_phase270_offset_x[16] VDD VDD VSS VSS gf180mcu_fd_sc_mcu7t5v0__buf_2
Xoutput378 _1494_/Q cfg_phase0_offset_y[6] VDD VDD VSS VSS gf180mcu_fd_sc_mcu7t5v0__buf_2
Xoutput312 _1606_/Q cfg_f_MEMS_fcw_x[13] VDD VDD VSS VSS gf180mcu_fd_sc_mcu7t5v0__buf_2
Xoutput356 _1643_/Q cfg_phase0_offset_x[5] VDD VDD VSS VSS gf180mcu_fd_sc_mcu7t5v0__buf_2
Xoutput345 _1652_/Q cfg_phase0_offset_x[14] VDD VDD VSS VSS gf180mcu_fd_sc_mcu7t5v0__buf_2
Xoutput334 _1629_/Q cfg_f_MEMS_fcw_y[4] VDD VDD VSS VSS gf180mcu_fd_sc_mcu7t5v0__buf_2
Xoutput323 _1602_/Q cfg_f_MEMS_fcw_x[9] VDD VDD VSS VSS gf180mcu_fd_sc_mcu7t5v0__buf_2
Xoutput367 _1503_/Q cfg_phase0_offset_y[15] VDD VDD VSS VSS gf180mcu_fd_sc_mcu7t5v0__buf_2
X_1458_ _1467_/I0 _1527_/Q _1464_/S _1527_/D VDD VDD VSS VSS gf180mcu_fd_sc_mcu7t5v0__mux2_2
X_1389_ wire725/Z _1472_/Q _1389_/S _1472_/D VDD VDD VSS VSS gf180mcu_fd_sc_mcu7t5v0__mux2_2
XTAP_TAPCELL_ROW_53_602 VDD VSS gf180mcu_fd_sc_mcu7t5v0__filltie
XFILLER_50_172 VDD VDD VSS VSS gf180mcu_fd_sc_mcu7t5v0__fill_2
XFILLER_7_508 VDD VDD VSS VSS gf180mcu_fd_sc_mcu7t5v0__fillcap_8
XFILLER_11_559 VDD VDD VSS VSS gf180mcu_fd_sc_mcu7t5v0__fill_1
XFILLER_78_559 VDD VDD VSS VSS gf180mcu_fd_sc_mcu7t5v0__fillcap_8
XFILLER_46_489 VDD VDD VSS VSS gf180mcu_fd_sc_mcu7t5v0__fill_1
XTAP_TAPCELL_ROW_16_304 VDD VSS gf180mcu_fd_sc_mcu7t5v0__filltie
XFILLER_18_125 VDD VDD VSS VSS gf180mcu_fd_sc_mcu7t5v0__fill_1
X_0760_ _1549_/Q _0795_/A2 _0810_/A1 VDD VDD VSS VSS gf180mcu_fd_sc_mcu7t5v0__nand2_1
XFILLER_41_150 VDD VDD VSS VSS gf180mcu_fd_sc_mcu7t5v0__fillcap_16
XTAP_TAPCELL_ROW_24_370 VDD VSS gf180mcu_fd_sc_mcu7t5v0__filltie
XFILLER_51_6 VDD VDD VSS VSS gf180mcu_fd_sc_mcu7t5v0__fill_1
XFILLER_6_552 VDD VDD VSS VSS gf180mcu_fd_sc_mcu7t5v0__fillcap_4
XFILLER_77_570 VDD VDD VSS VSS gf180mcu_fd_sc_mcu7t5v0__fillcap_4
X_1243_ _1243_/A1 _1243_/A2 _1243_/A3 _1243_/A4 _1244_/A4 VDD VDD VSS VSS gf180mcu_fd_sc_mcu7t5v0__nor4_1
X_1174_ _1174_/A1 _1174_/A2 wire551/Z _1174_/B2 _1175_/A4 VDD VDD VSS VSS gf180mcu_fd_sc_mcu7t5v0__aoi22_1
X_1312_ wire720/Z _1631_/Q _1313_/S _1631_/D VDD VDD VSS VSS gf180mcu_fd_sc_mcu7t5v0__mux2_2
XFILLER_60_470 VDD VDD VSS VSS gf180mcu_fd_sc_mcu7t5v0__fill_2
XFILLER_37_489 VDD VDD VSS VSS gf180mcu_fd_sc_mcu7t5v0__fill_1
XFILLER_20_323 VDD VDD VSS VSS gf180mcu_fd_sc_mcu7t5v0__fill_1
X_0889_ _0889_/A1 _0908_/A2 wire559/I VDD VDD VSS VSS gf180mcu_fd_sc_mcu7t5v0__nor2_4
X_0958_ _0958_/A1 _0958_/A2 _0958_/A3 _0958_/A4 _0964_/A3 VDD VDD VSS VSS gf180mcu_fd_sc_mcu7t5v0__nand4_1
XFILLER_47_209 VDD VDD VSS VSS gf180mcu_fd_sc_mcu7t5v0__fill_1
XFILLER_46_69 VDD VDD VSS VSS gf180mcu_fd_sc_mcu7t5v0__fillcap_16
XTAP_TAPCELL_ROW_21_340 VDD VSS gf180mcu_fd_sc_mcu7t5v0__filltie
XFILLER_11_72 VDD VDD VSS VSS gf180mcu_fd_sc_mcu7t5v0__fillcap_8
XFILLER_74_551 VDD VDD VSS VSS gf180mcu_fd_sc_mcu7t5v0__fillcap_4
XFILLER_46_242 VDD VDD VSS VSS gf180mcu_fd_sc_mcu7t5v0__fill_2
XTAP_TAPCELL_ROW_72_752 VDD VSS gf180mcu_fd_sc_mcu7t5v0__filltie
Xinput88 cal_phase270_offset_y[9] input88/Z VDD VDD VSS VSS gf180mcu_fd_sc_mcu7t5v0__buf_1
Xinput55 cal_phase270_offset_x[17] input55/Z VDD VDD VSS VSS gf180mcu_fd_sc_mcu7t5v0__buf_1
Xinput77 cal_phase270_offset_y[18] input77/Z VDD VDD VSS VSS gf180mcu_fd_sc_mcu7t5v0__buf_1
Xinput66 cal_phase270_offset_x[8] input66/Z VDD VDD VSS VSS gf180mcu_fd_sc_mcu7t5v0__buf_1
Xinput33 cal_phase0_offset_y[16] input33/Z VDD VDD VSS VSS gf180mcu_fd_sc_mcu7t5v0__buf_1
Xinput11 cal_phase0_offset_x[15] input11/Z VDD VDD VSS VSS gf180mcu_fd_sc_mcu7t5v0__buf_1
X_0812_ _1556_/Q _1557_/Q _0812_/Z VDD VDD VSS VSS gf180mcu_fd_sc_mcu7t5v0__and2_2
X_0743_ _1557_/Q _1254_/A1 VDD VDD VSS VSS gf180mcu_fd_sc_mcu7t5v0__inv_2
Xinput44 cal_phase0_offset_y[7] input44/Z VDD VDD VSS VSS gf180mcu_fd_sc_mcu7t5v0__buf_1
Xinput22 cal_phase0_offset_x[6] input22/Z VDD VDD VSS VSS gf180mcu_fd_sc_mcu7t5v0__buf_2
Xload_slew764 wire763/I _1261_/I1 VDD VDD VSS VSS gf180mcu_fd_sc_mcu7t5v0__buf_2
Xinput99 cal_phase90_offset_x[19] input99/Z VDD VDD VSS VSS gf180mcu_fd_sc_mcu7t5v0__buf_1
XFILLER_42_2 VDD VDD VSS VSS gf180mcu_fd_sc_mcu7t5v0__fillcap_4
Xload_slew731 _1424_/I0 _1414_/I1 VDD VDD VSS VSS gf180mcu_fd_sc_mcu7t5v0__clkbuf_1
Xload_slew753 wire754/Z _1365_/I1 VDD VDD VSS VSS gf180mcu_fd_sc_mcu7t5v0__buf_1
XFILLER_80_521 VDD VDD VSS VSS gf180mcu_fd_sc_mcu7t5v0__fillcap_4
XFILLER_65_540 VDD VDD VSS VSS gf180mcu_fd_sc_mcu7t5v0__fill_2
X_1157_ input30/Z _1157_/A2 wire511/Z input42/Z _1180_/A1 VDD VDD VSS VSS gf180mcu_fd_sc_mcu7t5v0__aoi22_4
X_1226_ _1226_/A1 wire551/Z _1226_/B1 _1226_/B2 _1226_/C _1244_/A3 VDD VDD VSS VSS
+ gf180mcu_fd_sc_mcu7t5v0__aoi221_1
XFILLER_37_231 VDD VDD VSS VSS gf180mcu_fd_sc_mcu7t5v0__fillcap_8
Xload_slew797 _1666_/RN _1662_/RN VDD VDD VSS VSS gf180mcu_fd_sc_mcu7t5v0__clkbuf_1
X_1088_ _1088_/A1 wire576/Z wire574/Z _1088_/B2 _1089_/A3 VDD VDD VSS VSS gf180mcu_fd_sc_mcu7t5v0__aoi22_4
XFILLER_40_418 VDD VDD VSS VSS gf180mcu_fd_sc_mcu7t5v0__fillcap_4
XTAP_TAPCELL_ROW_35_454 VDD VSS gf180mcu_fd_sc_mcu7t5v0__filltie
XFILLER_33_492 VDD VDD VSS VSS gf180mcu_fd_sc_mcu7t5v0__fillcap_4
XFILLER_43_212 VDD VDD VSS VSS gf180mcu_fd_sc_mcu7t5v0__fillcap_64
XFILLER_11_142 VDD VDD VSS VSS gf180mcu_fd_sc_mcu7t5v0__fillcap_8
XFILLER_3_352 VDD VDD VSS VSS gf180mcu_fd_sc_mcu7t5v0__fillcap_64
XFILLER_74_381 VDD VDD VSS VSS gf180mcu_fd_sc_mcu7t5v0__fillcap_4
XFILLER_66_359 VDD VDD VSS VSS gf180mcu_fd_sc_mcu7t5v0__fillcap_4
XFILLER_62_510 VDD VDD VSS VSS gf180mcu_fd_sc_mcu7t5v0__fillcap_8
X_1011_ _1011_/A1 _1011_/A2 _1011_/A3 _1012_/A3 VDD VDD VSS VSS gf180mcu_fd_sc_mcu7t5v0__nor3_1
XTAP_TAPCELL_ROW_49_568 VDD VSS gf180mcu_fd_sc_mcu7t5v0__filltie
XTAP_TAPCELL_ROW_32_435 VDD VSS gf180mcu_fd_sc_mcu7t5v0__filltie
XFILLER_15_492 VDD VDD VSS VSS gf180mcu_fd_sc_mcu7t5v0__fill_1
XFILLER_69_142 VDD VDD VSS VSS gf180mcu_fd_sc_mcu7t5v0__fillcap_64
Xload_slew561 _1033_/A2 _1234_/B1 VDD VDD VSS VSS gf180mcu_fd_sc_mcu7t5v0__buf_2
Xload_slew550 wire551/Z _1070_/B1 VDD VDD VSS VSS gf180mcu_fd_sc_mcu7t5v0__buf_2
Xload_slew583 _1020_/B1 _1220_/A2 VDD VDD VSS VSS gf180mcu_fd_sc_mcu7t5v0__buf_2
Xload_slew572 _1224_/A2 _1202_/A2 VDD VDD VSS VSS gf180mcu_fd_sc_mcu7t5v0__buf_2
X_1209_ _1209_/A1 wire602/Z wire536/Z _1673_/Q _1210_/A4 VDD VDD VSS VSS gf180mcu_fd_sc_mcu7t5v0__aoi22_1
XFILLER_25_212 VDD VDD VSS VSS gf180mcu_fd_sc_mcu7t5v0__fillcap_4
XFILLER_68_34 VDD VDD VSS VSS gf180mcu_fd_sc_mcu7t5v0__fill_1
Xinput201 raw_edge2_x[11] _1097_/A1 VDD VDD VSS VSS gf180mcu_fd_sc_mcu7t5v0__buf_1
Xinput289 state_o[2] _1025_/B2 VDD VDD VSS VSS gf180mcu_fd_sc_mcu7t5v0__buf_1
Xinput267 raw_edge3_y[14] _1191_/B2 VDD VDD VSS VSS gf180mcu_fd_sc_mcu7t5v0__buf_1
Xinput245 raw_edge3_x[13] _1169_/B2 VDD VDD VSS VSS gf180mcu_fd_sc_mcu7t5v0__buf_1
Xinput256 raw_edge3_x[4] _1124_/B2 VDD VDD VSS VSS gf180mcu_fd_sc_mcu7t5v0__buf_1
Xinput278 raw_edge3_y[5] _1167_/A1 VDD VDD VSS VSS gf180mcu_fd_sc_mcu7t5v0__buf_1
Xinput223 raw_edge2_y[12] _1148_/B2 VDD VDD VSS VSS gf180mcu_fd_sc_mcu7t5v0__buf_1
Xinput212 raw_edge2_x[2] _1047_/A1 VDD VDD VSS VSS gf180mcu_fd_sc_mcu7t5v0__buf_1
Xinput234 raw_edge2_y[3] _1082_/C1 VDD VDD VSS VSS gf180mcu_fd_sc_mcu7t5v0__buf_1
X_1560_ _1560_/D _1560_/RN clkload8/I _1560_/Q VDD VDD VSS VSS gf180mcu_fd_sc_mcu7t5v0__dffrnq_1
XFILLER_33_92 VDD VDD VSS VSS gf180mcu_fd_sc_mcu7t5v0__fill_1
XFILLER_66_101 VDD VDD VSS VSS gf180mcu_fd_sc_mcu7t5v0__fillcap_4
XFILLER_66_123 VDD VDD VSS VSS gf180mcu_fd_sc_mcu7t5v0__fillcap_4
X_1491_ _1491_/D wire828/Z clkload6/I _1491_/Q VDD VDD VSS VSS gf180mcu_fd_sc_mcu7t5v0__dffrnq_1
XFILLER_81_104 VDD VDD VSS VSS gf180mcu_fd_sc_mcu7t5v0__fillcap_32
XTAP_TAPCELL_ROW_80_817 VDD VSS gf180mcu_fd_sc_mcu7t5v0__filltie
XFILLER_47_370 VDD VDD VSS VSS gf180mcu_fd_sc_mcu7t5v0__fillcap_8
XFILLER_22_259 VDD VDD VSS VSS gf180mcu_fd_sc_mcu7t5v0__fill_2
XFILLER_57_167 VDD VDD VSS VSS gf180mcu_fd_sc_mcu7t5v0__fillcap_32
XPHY_EDGE_ROW_13_Left_95 VDD VSS gf180mcu_fd_sc_mcu7t5v0__endcap
XTAP_TAPCELL_ROW_43_519 VDD VSS gf180mcu_fd_sc_mcu7t5v0__filltie
XFILLER_9_208 VDD VDD VSS VSS gf180mcu_fd_sc_mcu7t5v0__fill_2
XTAP_TAPCELL_ROW_0_174 VDD VSS gf180mcu_fd_sc_mcu7t5v0__filltie
XFILLER_13_237 VDD VDD VSS VSS gf180mcu_fd_sc_mcu7t5v0__fillcap_4
XTAP_TAPCELL_ROW_51_585 VDD VSS gf180mcu_fd_sc_mcu7t5v0__filltie
XFILLER_79_66 VDD VDD VSS VSS gf180mcu_fd_sc_mcu7t5v0__fillcap_4
XTAP_TAPCELL_ROW_8_241 VDD VSS gf180mcu_fd_sc_mcu7t5v0__filltie
XFILLER_48_145 VDD VDD VSS VSS gf180mcu_fd_sc_mcu7t5v0__fillcap_16
X_0991_ _0991_/A1 _1036_/A2 _1240_/B1 _1410_/I0 _1602_/Q _1198_/A2 _0995_/A1 VDD VDD
+ VSS VSS gf180mcu_fd_sc_mcu7t5v0__aoi222_2
XFILLER_8_241 VDD VDD VSS VSS gf180mcu_fd_sc_mcu7t5v0__fillcap_4
XTAP_TAPCELL_ROW_14_287 VDD VSS gf180mcu_fd_sc_mcu7t5v0__filltie
X_1543_ _1543_/D _1543_/RN clkload9/I _1543_/Q VDD VDD VSS VSS gf180mcu_fd_sc_mcu7t5v0__dffrnq_1
X_1474_ _1474_/D _1679_/RN clkload1/I _1474_/Q VDD VDD VSS VSS gf180mcu_fd_sc_mcu7t5v0__dffrnq_1
X_1612_ _1612_/D _1648_/RN _1659_/CLK _1612_/Q VDD VDD VSS VSS gf180mcu_fd_sc_mcu7t5v0__dffrnq_2
XFILLER_54_115 VDD VDD VSS VSS gf180mcu_fd_sc_mcu7t5v0__fillcap_4
XFILLER_39_167 VDD VDD VSS VSS gf180mcu_fd_sc_mcu7t5v0__fill_2
XTAP_TAPCELL_ROW_65_699 VDD VSS gf180mcu_fd_sc_mcu7t5v0__filltie
XFILLER_50_354 VDD VDD VSS VSS gf180mcu_fd_sc_mcu7t5v0__fill_1
XFILLER_50_387 VDD VDD VSS VSS gf180mcu_fd_sc_mcu7t5v0__fill_2
XFILLER_10_218 VDD VDD VSS VSS gf180mcu_fd_sc_mcu7t5v0__fill_1
Xfanout721 _1588_/Q _1266_/I1 VDD VDD VSS VSS gf180mcu_fd_sc_mcu7t5v0__dlyb_1
XFILLER_49_69 VDD VDD VSS VSS gf180mcu_fd_sc_mcu7t5v0__fill_1
Xfanout765 wire775/Z wire768/I VDD VDD VSS VSS gf180mcu_fd_sc_mcu7t5v0__dlyb_1
XFILLER_60_107 VDD VDD VSS VSS gf180mcu_fd_sc_mcu7t5v0__fillcap_64
XTAP_TAPCELL_ROW_56_622 VDD VSS gf180mcu_fd_sc_mcu7t5v0__filltie
XFILLER_45_104 VDD VDD VSS VSS gf180mcu_fd_sc_mcu7t5v0__fillcap_16
Xfanout798 wire805/Z _1478_/RN VDD VDD VSS VSS gf180mcu_fd_sc_mcu7t5v0__dlyb_1
Xfanout787 _1479_/RN _1657_/RN VDD VDD VSS VSS gf180mcu_fd_sc_mcu7t5v0__dlyb_1
XFILLER_81_67 VDD VDD VSS VSS gf180mcu_fd_sc_mcu7t5v0__fill_1
XFILLER_81_56 VDD VDD VSS VSS gf180mcu_fd_sc_mcu7t5v0__fill_1
XFILLER_81_23 VDD VDD VSS VSS gf180mcu_fd_sc_mcu7t5v0__fillcap_8
XFILLER_26_384 VDD VDD VSS VSS gf180mcu_fd_sc_mcu7t5v0__fill_1
Xinput9 cal_phase0_offset_x[13] input9/Z VDD VDD VSS VSS gf180mcu_fd_sc_mcu7t5v0__buf_1
XFILLER_36_104 VDD VDD VSS VSS gf180mcu_fd_sc_mcu7t5v0__fill_1
X_1190_ _1190_/A1 _1190_/A2 _1190_/A3 _1190_/A4 _1211_/A1 VDD VDD VSS VSS gf180mcu_fd_sc_mcu7t5v0__nand4_1
XTAP_TAPCELL_ROW_62_669 VDD VSS gf180mcu_fd_sc_mcu7t5v0__filltie
XFILLER_32_310 VDD VDD VSS VSS gf180mcu_fd_sc_mcu7t5v0__fillcap_4
XTAP_TAPCELL_ROW_27_390 VDD VSS gf180mcu_fd_sc_mcu7t5v0__filltie
XTAP_TAPCELL_ROW_19_324 VDD VSS gf180mcu_fd_sc_mcu7t5v0__filltie
X_0974_ _0974_/A1 _0974_/A2 _0985_/A1 VDD VDD VSS VSS gf180mcu_fd_sc_mcu7t5v0__nand2_1
XFILLER_59_207 VDD VDD VSS VSS gf180mcu_fd_sc_mcu7t5v0__fill_2
X_1526_ _1526_/D _1526_/RN clkload9/I _1526_/Q VDD VDD VSS VSS gf180mcu_fd_sc_mcu7t5v0__dffrnq_1
Xoutput368 _1483_/Q cfg_phase0_offset_y[16] VDD VDD VSS VSS gf180mcu_fd_sc_mcu7t5v0__buf_2
Xoutput335 _1630_/Q cfg_f_MEMS_fcw_y[5] VDD VDD VSS VSS gf180mcu_fd_sc_mcu7t5v0__buf_2
Xoutput379 _1495_/Q cfg_phase0_offset_y[7] VDD VDD VSS VSS gf180mcu_fd_sc_mcu7t5v0__buf_2
Xoutput313 _1607_/Q cfg_f_MEMS_fcw_x[14] VDD VDD VSS VSS gf180mcu_fd_sc_mcu7t5v0__buf_2
Xoutput324 _1625_/Q cfg_f_MEMS_fcw_y[0] VDD VDD VSS VSS gf180mcu_fd_sc_mcu7t5v0__buf_2
Xoutput357 _1644_/Q cfg_phase0_offset_x[6] VDD VDD VSS VSS gf180mcu_fd_sc_mcu7t5v0__buf_2
Xoutput346 _1653_/Q cfg_phase0_offset_x[15] VDD VDD VSS VSS gf180mcu_fd_sc_mcu7t5v0__buf_2
X_1457_ _1457_/I0 _1526_/Q _1457_/S _1526_/D VDD VDD VSS VSS gf180mcu_fd_sc_mcu7t5v0__mux2_2
XFILLER_70_405 VDD VDD VSS VSS gf180mcu_fd_sc_mcu7t5v0__fill_2
XTAP_TAPCELL_ROW_53_603 VDD VSS gf180mcu_fd_sc_mcu7t5v0__filltie
XFILLER_42_107 VDD VDD VSS VSS gf180mcu_fd_sc_mcu7t5v0__fillcap_16
X_1388_ wire737/I _1471_/Q _1389_/S _1471_/D VDD VDD VSS VSS gf180mcu_fd_sc_mcu7t5v0__mux2_2
XFILLER_50_151 VDD VDD VSS VSS gf180mcu_fd_sc_mcu7t5v0__fill_2
XFILLER_23_365 VDD VDD VSS VSS gf180mcu_fd_sc_mcu7t5v0__fill_2
XFILLER_2_247 VDD VDD VSS VSS gf180mcu_fd_sc_mcu7t5v0__fillcap_64
XFILLER_78_527 VDD VDD VSS VSS gf180mcu_fd_sc_mcu7t5v0__fillcap_32
XFILLER_78_516 VDD VDD VSS VSS gf180mcu_fd_sc_mcu7t5v0__fillcap_8
XFILLER_76_34 VDD VDD VSS VSS gf180mcu_fd_sc_mcu7t5v0__fill_1
XFILLER_73_276 VDD VDD VSS VSS gf180mcu_fd_sc_mcu7t5v0__fillcap_4
XFILLER_61_438 VDD VDD VSS VSS gf180mcu_fd_sc_mcu7t5v0__fill_1
XTAP_TAPCELL_ROW_16_305 VDD VSS gf180mcu_fd_sc_mcu7t5v0__filltie
XFILLER_26_170 VDD VDD VSS VSS gf180mcu_fd_sc_mcu7t5v0__fillcap_4
XFILLER_14_387 VDD VDD VSS VSS gf180mcu_fd_sc_mcu7t5v0__fillcap_8
XTAP_TAPCELL_ROW_24_371 VDD VSS gf180mcu_fd_sc_mcu7t5v0__filltie
XPHY_EDGE_ROW_47_Left_129 VDD VSS gf180mcu_fd_sc_mcu7t5v0__endcap
XFILLER_44_6 VDD VDD VSS VSS gf180mcu_fd_sc_mcu7t5v0__fill_1
X_1311_ _1415_/I1 _1630_/Q _1313_/S _1630_/D VDD VDD VSS VSS gf180mcu_fd_sc_mcu7t5v0__mux2_2
XTAP_TAPCELL_ROW_75_772 VDD VSS gf180mcu_fd_sc_mcu7t5v0__filltie
XPHY_EDGE_ROW_56_Left_138 VDD VSS gf180mcu_fd_sc_mcu7t5v0__endcap
X_1173_ _1173_/A1 wire568/I _1200_/A2 input21/Z _1175_/A3 VDD VDD VSS VSS gf180mcu_fd_sc_mcu7t5v0__aoi22_1
X_1242_ _1242_/A1 _1242_/A2 _1242_/A3 _1242_/A4 _1243_/A4 VDD VDD VSS VSS gf180mcu_fd_sc_mcu7t5v0__nand4_1
XPHY_EDGE_ROW_10_Right_10 VDD VSS gf180mcu_fd_sc_mcu7t5v0__endcap
XFILLER_24_107 VDD VDD VSS VSS gf180mcu_fd_sc_mcu7t5v0__fillcap_16
XPHY_EDGE_ROW_65_Left_147 VDD VSS gf180mcu_fd_sc_mcu7t5v0__endcap
X_0888_ _1250_/A1 _1554_/Q _1252_/A1 _1557_/Q _0908_/A2 VDD VDD VSS VSS gf180mcu_fd_sc_mcu7t5v0__nand4_4
X_0957_ _0957_/A1 _1025_/B1 _1218_/B1 _1680_/Q _0958_/A4 VDD VDD VSS VSS gf180mcu_fd_sc_mcu7t5v0__aoi22_1
X_1509_ _1509_/D _1509_/RN clkload6/I _1509_/Q VDD VDD VSS VSS gf180mcu_fd_sc_mcu7t5v0__dffrnq_1
XPHY_EDGE_ROW_74_Left_156 VDD VSS gf180mcu_fd_sc_mcu7t5v0__endcap
XFILLER_46_37 VDD VDD VSS VSS gf180mcu_fd_sc_mcu7t5v0__fillcap_32
XFILLER_51_460 VDD VDD VSS VSS gf180mcu_fd_sc_mcu7t5v0__fillcap_4
XTAP_TAPCELL_ROW_21_341 VDD VSS gf180mcu_fd_sc_mcu7t5v0__filltie
XFILLER_23_173 VDD VDD VSS VSS gf180mcu_fd_sc_mcu7t5v0__fill_1
XFILLER_11_84 VDD VDD VSS VSS gf180mcu_fd_sc_mcu7t5v0__fill_1
XFILLER_61_202 VDD VDD VSS VSS gf180mcu_fd_sc_mcu7t5v0__fillcap_8
XFILLER_46_210 VDD VDD VSS VSS gf180mcu_fd_sc_mcu7t5v0__fill_2
XTAP_TAPCELL_ROW_72_753 VDD VSS gf180mcu_fd_sc_mcu7t5v0__filltie
XFILLER_61_279 VDD VDD VSS VSS gf180mcu_fd_sc_mcu7t5v0__fill_1
XFILLER_34_438 VDD VDD VSS VSS gf180mcu_fd_sc_mcu7t5v0__fill_2
XPHY_EDGE_ROW_1_Left_83 VDD VSS gf180mcu_fd_sc_mcu7t5v0__endcap
Xinput78 cal_phase270_offset_y[19] input78/Z VDD VDD VSS VSS gf180mcu_fd_sc_mcu7t5v0__buf_1
Xinput56 cal_phase270_offset_x[18] input56/Z VDD VDD VSS VSS gf180mcu_fd_sc_mcu7t5v0__buf_1
Xinput67 cal_phase270_offset_x[9] input67/Z VDD VDD VSS VSS gf180mcu_fd_sc_mcu7t5v0__buf_1
X_0811_ _1564_/Q _0796_/S _0818_/B VDD VDD VSS VSS gf180mcu_fd_sc_mcu7t5v0__nand2_1
Xinput34 cal_phase0_offset_y[17] input34/Z VDD VDD VSS VSS gf180mcu_fd_sc_mcu7t5v0__buf_1
Xinput45 cal_phase0_offset_y[8] input45/Z VDD VDD VSS VSS gf180mcu_fd_sc_mcu7t5v0__buf_1
Xinput89 cal_phase90_offset_x[0] input89/Z VDD VDD VSS VSS gf180mcu_fd_sc_mcu7t5v0__buf_1
Xinput12 cal_phase0_offset_x[16] input12/Z VDD VDD VSS VSS gf180mcu_fd_sc_mcu7t5v0__buf_1
X_0742_ _1556_/Q _1252_/A1 VDD VDD VSS VSS gf180mcu_fd_sc_mcu7t5v0__inv_2
Xinput23 cal_phase0_offset_x[7] input23/Z VDD VDD VSS VSS gf180mcu_fd_sc_mcu7t5v0__buf_1
Xwire771 wire771/I wire771/Z VDD VDD VSS VSS gf180mcu_fd_sc_mcu7t5v0__clkbuf_2
Xload_slew776 wire774/I wire775/I VDD VDD VSS VSS gf180mcu_fd_sc_mcu7t5v0__buf_1
Xload_slew732 wire733/Z _1424_/I0 VDD VDD VSS VSS gf180mcu_fd_sc_mcu7t5v0__buf_2
Xload_slew743 wire742/I _1355_/I1 VDD VDD VSS VSS gf180mcu_fd_sc_mcu7t5v0__clkbuf_2
X_1156_ _1630_/Q wire548/I _1156_/B1 input9/Z _1175_/A1 VDD VDD VSS VSS gf180mcu_fd_sc_mcu7t5v0__aoi22_1
XFILLER_40_408 VDD VDD VSS VSS gf180mcu_fd_sc_mcu7t5v0__fillcap_4
X_1225_ _1225_/A1 _1225_/A2 _1225_/A3 _1226_/C VDD VDD VSS VSS gf180mcu_fd_sc_mcu7t5v0__nand3_1
XTAP_TAPCELL_ROW_35_455 VDD VSS gf180mcu_fd_sc_mcu7t5v0__filltie
X_1087_ _1662_/Q _1087_/A2 _1218_/B1 _1470_/Q _1089_/A2 VDD VDD VSS VSS gf180mcu_fd_sc_mcu7t5v0__aoi22_1
Xclkbuf_leaf_17_clk clkbuf_leaf_0_clk/I _1659_/CLK VDD VDD VSS VSS gf180mcu_fd_sc_mcu7t5v0__clkbuf_8
XFILLER_32_28 VDD VDD VSS VSS gf180mcu_fd_sc_mcu7t5v0__fill_1
XFILLER_57_69 VDD VDD VSS VSS gf180mcu_fd_sc_mcu7t5v0__fill_1
XFILLER_57_47 VDD VDD VSS VSS gf180mcu_fd_sc_mcu7t5v0__fillcap_16
XFILLER_48_508 VDD VDD VSS VSS gf180mcu_fd_sc_mcu7t5v0__fill_1
XFILLER_73_68 VDD VDD VSS VSS gf180mcu_fd_sc_mcu7t5v0__fill_2
XFILLER_7_136 VDD VDD VSS VSS gf180mcu_fd_sc_mcu7t5v0__fillcap_4
XFILLER_11_154 VDD VDD VSS VSS gf180mcu_fd_sc_mcu7t5v0__fill_1
XFILLER_81_319 VDD VDD VSS VSS gf180mcu_fd_sc_mcu7t5v0__fillcap_16
XFILLER_81_308 VDD VDD VSS VSS gf180mcu_fd_sc_mcu7t5v0__fillcap_4
XFILLER_62_522 VDD VDD VSS VSS gf180mcu_fd_sc_mcu7t5v0__fill_2
X_1010_ _1010_/A1 _1010_/A2 _1010_/A3 _1010_/A4 _1011_/A3 VDD VDD VSS VSS gf180mcu_fd_sc_mcu7t5v0__nand4_1
XTAP_TAPCELL_ROW_49_569 VDD VSS gf180mcu_fd_sc_mcu7t5v0__filltie
XFILLER_8_85 VDD VDD VSS VSS gf180mcu_fd_sc_mcu7t5v0__fillcap_16
XFILLER_15_482 VDD VDD VSS VSS gf180mcu_fd_sc_mcu7t5v0__fill_2
Xclkbuf_leaf_6_clk clkbuf_leaf_8_clk/I clkload8/I VDD VDD VSS VSS gf180mcu_fd_sc_mcu7t5v0__clkbuf_8
XFILLER_57_349 VDD VDD VSS VSS gf180mcu_fd_sc_mcu7t5v0__fill_1
Xload_slew540 _1228_/B1 _1154_/A2 VDD VDD VSS VSS gf180mcu_fd_sc_mcu7t5v0__buf_2
Xload_slew584 _1194_/A2 _1020_/B1 VDD VDD VSS VSS gf180mcu_fd_sc_mcu7t5v0__buf_2
Xload_slew595 wire594/I _1217_/A2 VDD VDD VSS VSS gf180mcu_fd_sc_mcu7t5v0__buf_2
Xload_slew562 _1133_/A2 _1238_/B1 VDD VDD VSS VSS gf180mcu_fd_sc_mcu7t5v0__buf_2
X_1208_ input94/Z _1208_/A2 wire520/Z _1531_/Q _1210_/A3 VDD VDD VSS VSS gf180mcu_fd_sc_mcu7t5v0__aoi22_1
XFILLER_40_205 VDD VDD VSS VSS gf180mcu_fd_sc_mcu7t5v0__fill_2
X_1139_ _1500_/Q wire539/Z _1165_/B1 _1471_/Q _1141_/A3 VDD VDD VSS VSS gf180mcu_fd_sc_mcu7t5v0__aoi22_1
XFILLER_48_305 VDD VDD VSS VSS gf180mcu_fd_sc_mcu7t5v0__fill_1
Xinput224 raw_edge2_y[13] _1164_/B2 VDD VDD VSS VSS gf180mcu_fd_sc_mcu7t5v0__buf_1
Xinput235 raw_edge2_y[4] _1117_/A1 VDD VDD VSS VSS gf180mcu_fd_sc_mcu7t5v0__buf_1
Xinput202 raw_edge2_x[12] _1134_/A1 VDD VDD VSS VSS gf180mcu_fd_sc_mcu7t5v0__buf_1
Xinput213 raw_edge2_x[3] _1069_/A1 VDD VDD VSS VSS gf180mcu_fd_sc_mcu7t5v0__buf_1
XFILLER_71_352 VDD VDD VSS VSS gf180mcu_fd_sc_mcu7t5v0__fillcap_4
Xinput268 raw_edge3_y[15] _1222_/B2 VDD VDD VSS VSS gf180mcu_fd_sc_mcu7t5v0__buf_1
Xinput246 raw_edge3_x[14] _1202_/B2 VDD VDD VSS VSS gf180mcu_fd_sc_mcu7t5v0__buf_1
Xinput279 raw_edge3_y[6] _1204_/A1 VDD VDD VSS VSS gf180mcu_fd_sc_mcu7t5v0__buf_1
Xinput257 raw_edge3_x[5] _1154_/B2 VDD VDD VSS VSS gf180mcu_fd_sc_mcu7t5v0__buf_1
XFILLER_44_522 VDD VDD VSS VSS gf180mcu_fd_sc_mcu7t5v0__fill_2
XFILLER_17_72 VDD VDD VSS VSS gf180mcu_fd_sc_mcu7t5v0__fill_2
X_1490_ _1490_/D _1494_/RN _1659_/CLK _1490_/Q VDD VDD VSS VSS gf180mcu_fd_sc_mcu7t5v0__dffrnq_1
XFILLER_39_349 VDD VDD VSS VSS gf180mcu_fd_sc_mcu7t5v0__fill_1
XFILLER_81_138 VDD VDD VSS VSS gf180mcu_fd_sc_mcu7t5v0__fill_2
XTAP_TAPCELL_ROW_80_818 VDD VSS gf180mcu_fd_sc_mcu7t5v0__filltie
XFILLER_62_396 VDD VDD VSS VSS gf180mcu_fd_sc_mcu7t5v0__fill_2
XFILLER_35_522 VDD VDD VSS VSS gf180mcu_fd_sc_mcu7t5v0__fillcap_4
XPHY_EDGE_ROW_8_Right_8 VDD VSS gf180mcu_fd_sc_mcu7t5v0__endcap
XFILLER_30_271 VDD VDD VSS VSS gf180mcu_fd_sc_mcu7t5v0__fillcap_4
XPHY_EDGE_ROW_39_Right_39 VDD VSS gf180mcu_fd_sc_mcu7t5v0__endcap
XFILLER_54_48 VDD VDD VSS VSS gf180mcu_fd_sc_mcu7t5v0__fill_2
XFILLER_80_171 VDD VDD VSS VSS gf180mcu_fd_sc_mcu7t5v0__fillcap_4
XTAP_TAPCELL_ROW_51_586 VDD VSS gf180mcu_fd_sc_mcu7t5v0__filltie
XPHY_EDGE_ROW_48_Right_48 VDD VSS gf180mcu_fd_sc_mcu7t5v0__endcap
XTAP_TAPCELL_ROW_0_164 VDD VSS gf180mcu_fd_sc_mcu7t5v0__filltie
XTAP_TAPCELL_ROW_0_175 VDD VSS gf180mcu_fd_sc_mcu7t5v0__filltie
XFILLER_21_282 VDD VDD VSS VSS gf180mcu_fd_sc_mcu7t5v0__fill_2
XPHY_EDGE_ROW_57_Right_57 VDD VSS gf180mcu_fd_sc_mcu7t5v0__endcap
XTAP_TAPCELL_ROW_8_242 VDD VSS gf180mcu_fd_sc_mcu7t5v0__filltie
XPHY_EDGE_ROW_66_Right_66 VDD VSS gf180mcu_fd_sc_mcu7t5v0__endcap
XFILLER_56_190 VDD VDD VSS VSS gf180mcu_fd_sc_mcu7t5v0__fill_1
XFILLER_44_363 VDD VDD VSS VSS gf180mcu_fd_sc_mcu7t5v0__fillcap_16
XFILLER_44_341 VDD VDD VSS VSS gf180mcu_fd_sc_mcu7t5v0__fillcap_8
XFILLER_36_319 VDD VDD VSS VSS gf180mcu_fd_sc_mcu7t5v0__fill_1
X_0990_ _0990_/A1 _0990_/A2 _0990_/A3 _0990_/A4 _0996_/A1 VDD VDD VSS VSS gf180mcu_fd_sc_mcu7t5v0__nand4_1
XFILLER_44_92 VDD VDD VSS VSS gf180mcu_fd_sc_mcu7t5v0__fill_2
X_1611_ _1611_/D _1650_/RN _1663_/CLK _1611_/Q VDD VDD VSS VSS gf180mcu_fd_sc_mcu7t5v0__dffrnq_2
XTAP_TAPCELL_ROW_14_288 VDD VSS gf180mcu_fd_sc_mcu7t5v0__filltie
XPHY_EDGE_ROW_75_Right_75 VDD VSS gf180mcu_fd_sc_mcu7t5v0__endcap
XFILLER_67_400 VDD VDD VSS VSS gf180mcu_fd_sc_mcu7t5v0__fill_1
X_1542_ _1542_/D wire865/Z clkload4/I _1542_/Q VDD VDD VSS VSS gf180mcu_fd_sc_mcu7t5v0__dffrnq_1
X_1473_ _1473_/D _1680_/RN clkload1/I _1473_/Q VDD VDD VSS VSS gf180mcu_fd_sc_mcu7t5v0__dffrnq_1
XFILLER_79_282 VDD VDD VSS VSS gf180mcu_fd_sc_mcu7t5v0__fillcap_64
XFILLER_62_193 VDD VDD VSS VSS gf180mcu_fd_sc_mcu7t5v0__fillcap_8
XFILLER_49_59 VDD VDD VSS VSS gf180mcu_fd_sc_mcu7t5v0__fillcap_8
XFILLER_49_48 VDD VDD VSS VSS gf180mcu_fd_sc_mcu7t5v0__fill_2
Xfanout744 wire750/Z wire747/I VDD VDD VSS VSS gf180mcu_fd_sc_mcu7t5v0__dlyb_1
XTAP_TAPCELL_ROW_5_212 VDD VSS gf180mcu_fd_sc_mcu7t5v0__filltie
XFILLER_65_58 VDD VDD VSS VSS gf180mcu_fd_sc_mcu7t5v0__fillcap_8
XTAP_TAPCELL_ROW_56_623 VDD VSS gf180mcu_fd_sc_mcu7t5v0__filltie
XFILLER_53_182 VDD VDD VSS VSS gf180mcu_fd_sc_mcu7t5v0__fill_2
XFILLER_5_212 VDD VDD VSS VSS gf180mcu_fd_sc_mcu7t5v0__fillcap_64
XFILLER_76_241 VDD VDD VSS VSS gf180mcu_fd_sc_mcu7t5v0__fillcap_4
XTAP_TAPCELL_ROW_19_325 VDD VSS gf180mcu_fd_sc_mcu7t5v0__filltie
XFILLER_44_171 VDD VDD VSS VSS gf180mcu_fd_sc_mcu7t5v0__fillcap_4
XTAP_TAPCELL_ROW_27_391 VDD VSS gf180mcu_fd_sc_mcu7t5v0__filltie
X_0973_ _1542_/Q _1086_/A2 _1207_/A2 _1518_/Q _1091_/B1 _0973_/C2 _0974_/A2 VDD VDD
+ VSS VSS gf180mcu_fd_sc_mcu7t5v0__aoi222_2
Xoutput314 _1608_/Q cfg_f_MEMS_fcw_x[15] VDD VDD VSS VSS gf180mcu_fd_sc_mcu7t5v0__buf_2
Xoutput325 _1619_/Q cfg_f_MEMS_fcw_y[10] VDD VDD VSS VSS gf180mcu_fd_sc_mcu7t5v0__buf_2
XFILLER_9_562 VDD VDD VSS VSS gf180mcu_fd_sc_mcu7t5v0__fillcap_4
X_1456_ wire771/I _1525_/Q _1457_/S _1525_/D VDD VDD VSS VSS gf180mcu_fd_sc_mcu7t5v0__mux2_2
Xoutput369 _1484_/Q cfg_phase0_offset_y[17] VDD VDD VSS VSS gf180mcu_fd_sc_mcu7t5v0__buf_2
Xoutput336 _1631_/Q cfg_f_MEMS_fcw_y[6] VDD VDD VSS VSS gf180mcu_fd_sc_mcu7t5v0__buf_2
Xoutput358 _1645_/Q cfg_phase0_offset_x[7] VDD VDD VSS VSS gf180mcu_fd_sc_mcu7t5v0__buf_2
Xoutput347 _1633_/Q cfg_phase0_offset_x[16] VDD VDD VSS VSS gf180mcu_fd_sc_mcu7t5v0__buf_2
X_1525_ _1525_/D _1525_/RN clkload4/I _1525_/Q VDD VDD VSS VSS gf180mcu_fd_sc_mcu7t5v0__dffrnq_2
X_1387_ _1397_/A1 _1391_/S _1387_/B _1470_/D VDD VDD VSS VSS gf180mcu_fd_sc_mcu7t5v0__oai21_1
XFILLER_67_274 VDD VDD VSS VSS gf180mcu_fd_sc_mcu7t5v0__fillcap_4
XFILLER_50_174 VDD VDD VSS VSS gf180mcu_fd_sc_mcu7t5v0__fill_1
XFILLER_11_506 VDD VDD VSS VSS gf180mcu_fd_sc_mcu7t5v0__fill_1
XFILLER_78_506 VDD VDD VSS VSS gf180mcu_fd_sc_mcu7t5v0__fillcap_4
XFILLER_41_174 VDD VDD VSS VSS gf180mcu_fd_sc_mcu7t5v0__fill_1
XFILLER_14_366 VDD VDD VSS VSS gf180mcu_fd_sc_mcu7t5v0__fill_2
XFILLER_14_377 VDD VDD VSS VSS gf180mcu_fd_sc_mcu7t5v0__fillcap_8
XTAP_TAPCELL_ROW_16_306 VDD VSS gf180mcu_fd_sc_mcu7t5v0__filltie
XFILLER_6_521 VDD VDD VSS VSS gf180mcu_fd_sc_mcu7t5v0__fillcap_4
X_1241_ _1241_/A1 wire598/Z _1241_/B1 _1241_/B2 _1242_/A4 VDD VDD VSS VSS gf180mcu_fd_sc_mcu7t5v0__aoi22_1
X_1310_ _1414_/I1 _1629_/Q _1310_/S _1629_/D VDD VDD VSS VSS gf180mcu_fd_sc_mcu7t5v0__mux2_2
XTAP_TAPCELL_ROW_75_773 VDD VSS gf180mcu_fd_sc_mcu7t5v0__filltie
XFILLER_64_244 VDD VDD VSS VSS gf180mcu_fd_sc_mcu7t5v0__fill_1
XFILLER_49_263 VDD VDD VSS VSS gf180mcu_fd_sc_mcu7t5v0__fillcap_4
X_1172_ input63/Z wire547/Z wire536/Z _1672_/Q _1175_/A2 VDD VDD VSS VSS gf180mcu_fd_sc_mcu7t5v0__aoi22_2
XFILLER_37_436 VDD VDD VSS VSS gf180mcu_fd_sc_mcu7t5v0__fillcap_4
X_0956_ _0956_/A1 _1070_/B1 _1128_/C1 input75/Z _0958_/A3 VDD VDD VSS VSS gf180mcu_fd_sc_mcu7t5v0__aoi22_1
XFILLER_20_358 VDD VDD VSS VSS gf180mcu_fd_sc_mcu7t5v0__fillcap_4
X_0887_ _0907_/A1 wire621/I _1033_/A2 VDD VDD VSS VSS gf180mcu_fd_sc_mcu7t5v0__nor2_4
X_1439_ _1512_/Q _1444_/S _1440_/B VDD VDD VSS VSS gf180mcu_fd_sc_mcu7t5v0__nand2_1
X_1508_ _1508_/D _1508_/RN _1593_/CLK _1508_/Q VDD VDD VSS VSS gf180mcu_fd_sc_mcu7t5v0__dffrnq_1
XFILLER_70_247 VDD VDD VSS VSS gf180mcu_fd_sc_mcu7t5v0__fillcap_64
XFILLER_62_37 VDD VDD VSS VSS gf180mcu_fd_sc_mcu7t5v0__fillcap_64
XFILLER_55_277 VDD VDD VSS VSS gf180mcu_fd_sc_mcu7t5v0__fill_2
XFILLER_43_417 VDD VDD VSS VSS gf180mcu_fd_sc_mcu7t5v0__fill_2
XTAP_TAPCELL_ROW_21_342 VDD VSS gf180mcu_fd_sc_mcu7t5v0__filltie
XFILLER_3_524 VDD VDD VSS VSS gf180mcu_fd_sc_mcu7t5v0__fillcap_16
XFILLER_46_244 VDD VDD VSS VSS gf180mcu_fd_sc_mcu7t5v0__fill_1
XTAP_TAPCELL_ROW_72_754 VDD VSS gf180mcu_fd_sc_mcu7t5v0__filltie
X_0810_ _0810_/A1 _0893_/A1 _0810_/B _1557_/D VDD VDD VSS VSS gf180mcu_fd_sc_mcu7t5v0__oai21_1
Xinput13 cal_phase0_offset_x[17] input13/Z VDD VDD VSS VSS gf180mcu_fd_sc_mcu7t5v0__buf_1
Xinput68 cal_phase270_offset_y[0] input68/Z VDD VDD VSS VSS gf180mcu_fd_sc_mcu7t5v0__buf_1
Xinput57 cal_phase270_offset_x[19] input57/Z VDD VDD VSS VSS gf180mcu_fd_sc_mcu7t5v0__buf_1
Xinput79 cal_phase270_offset_y[1] input79/Z VDD VDD VSS VSS gf180mcu_fd_sc_mcu7t5v0__buf_1
X_0741_ _1554_/Q _1248_/A1 VDD VDD VSS VSS gf180mcu_fd_sc_mcu7t5v0__inv_2
Xinput46 cal_phase0_offset_y[9] input46/Z VDD VDD VSS VSS gf180mcu_fd_sc_mcu7t5v0__buf_1
Xinput35 cal_phase0_offset_y[18] input35/Z VDD VDD VSS VSS gf180mcu_fd_sc_mcu7t5v0__buf_1
Xinput24 cal_phase0_offset_x[8] input24/Z VDD VDD VSS VSS gf180mcu_fd_sc_mcu7t5v0__buf_1
Xmax_cap538 wire539/Z _1219_/B1 VDD VDD VSS VSS gf180mcu_fd_sc_mcu7t5v0__buf_4
Xwire750 wire750/I wire750/Z VDD VDD VSS VSS gf180mcu_fd_sc_mcu7t5v0__buf_2
Xwire794 wire794/I wire794/Z VDD VDD VSS VSS gf180mcu_fd_sc_mcu7t5v0__buf_1
Xload_slew777 _1529_/Q _1461_/I1 VDD VDD VSS VSS gf180mcu_fd_sc_mcu7t5v0__buf_2
XFILLER_37_222 VDD VDD VSS VSS gf180mcu_fd_sc_mcu7t5v0__fill_1
Xload_slew799 _1481_/RN _1678_/RN VDD VDD VSS VSS gf180mcu_fd_sc_mcu7t5v0__clkbuf_1
X_1224_ _1482_/Q _1224_/A2 wire520/I _1532_/Q _1225_/A3 VDD VDD VSS VSS gf180mcu_fd_sc_mcu7t5v0__aoi22_1
Xload_slew755 _1346_/I1 wire754/I VDD VDD VSS VSS gf180mcu_fd_sc_mcu7t5v0__buf_1
Xload_slew722 _1338_/I1 _1399_/I1 VDD VDD VSS VSS gf180mcu_fd_sc_mcu7t5v0__clkbuf_2
Xload_slew766 wire768/I _1332_/I1 VDD VDD VSS VSS gf180mcu_fd_sc_mcu7t5v0__clkbuf_2
Xload_slew788 _1673_/RN _1670_/RN VDD VDD VSS VSS gf180mcu_fd_sc_mcu7t5v0__clkbuf_1
XFILLER_80_567 VDD VDD VSS VSS gf180mcu_fd_sc_mcu7t5v0__fillcap_4
XFILLER_52_247 VDD VDD VSS VSS gf180mcu_fd_sc_mcu7t5v0__fill_2
XFILLER_52_203 VDD VDD VSS VSS gf180mcu_fd_sc_mcu7t5v0__fillcap_4
X_1155_ _1155_/A1 wire557/Z _1219_/B1 _1501_/Q wire492/I VDD VDD VSS VSS gf180mcu_fd_sc_mcu7t5v0__aoi22_2
XTAP_TAPCELL_ROW_35_456 VDD VSS gf180mcu_fd_sc_mcu7t5v0__filltie
X_1086_ _1544_/Q _1086_/A2 _1237_/B1 _1520_/Q wire495/I VDD VDD VSS VSS gf180mcu_fd_sc_mcu7t5v0__aoi22_2
X_0939_ _0939_/A1 _0939_/A2 _0939_/A3 _0939_/A4 _0965_/A2 VDD VDD VSS VSS gf180mcu_fd_sc_mcu7t5v0__nand4_1
XFILLER_33_483 VDD VDD VSS VSS gf180mcu_fd_sc_mcu7t5v0__fill_1
XFILLER_20_177 VDD VDD VSS VSS gf180mcu_fd_sc_mcu7t5v0__fillcap_4
XFILLER_68_391 VDD VDD VSS VSS gf180mcu_fd_sc_mcu7t5v0__fill_2
Xclkbuf_2_2__f_clk clkbuf_0_clk/Z clkbuf_leaf_9_clk/I VDD VDD VSS VSS gf180mcu_fd_sc_mcu7t5v0__clkbuf_16
XFILLER_28_255 VDD VDD VSS VSS gf180mcu_fd_sc_mcu7t5v0__fillcap_4
XFILLER_28_244 VDD VDD VSS VSS gf180mcu_fd_sc_mcu7t5v0__fill_1
XFILLER_24_450 VDD VDD VSS VSS gf180mcu_fd_sc_mcu7t5v0__fillcap_4
XFILLER_78_177 VDD VDD VSS VSS gf180mcu_fd_sc_mcu7t5v0__fillcap_64
XFILLER_34_247 VDD VDD VSS VSS gf180mcu_fd_sc_mcu7t5v0__fillcap_8
XFILLER_19_277 VDD VDD VSS VSS gf180mcu_fd_sc_mcu7t5v0__fill_2
XTAP_TAPCELL_ROW_40_492 VDD VSS gf180mcu_fd_sc_mcu7t5v0__filltie
XFILLER_8_53 VDD VDD VSS VSS gf180mcu_fd_sc_mcu7t5v0__fillcap_32
XFILLER_8_31 VDD VDD VSS VSS gf180mcu_fd_sc_mcu7t5v0__fillcap_4
Xload_slew530 _1023_/B1 _1127_/A2 VDD VDD VSS VSS gf180mcu_fd_sc_mcu7t5v0__buf_2
XFILLER_65_372 VDD VDD VSS VSS gf180mcu_fd_sc_mcu7t5v0__fill_2
XFILLER_65_361 VDD VDD VSS VSS gf180mcu_fd_sc_mcu7t5v0__fill_2
XFILLER_57_317 VDD VDD VSS VSS gf180mcu_fd_sc_mcu7t5v0__fill_1
Xload_slew563 _1000_/A2 _1133_/A2 VDD VDD VSS VSS gf180mcu_fd_sc_mcu7t5v0__buf_2
Xload_slew596 _0929_/A2 _1143_/A2 VDD VDD VSS VSS gf180mcu_fd_sc_mcu7t5v0__buf_2
X_1207_ _1523_/Q _1207_/A2 _1235_/B _1210_/A2 VDD VDD VSS VSS gf180mcu_fd_sc_mcu7t5v0__aoi21_4
X_1138_ input29/Z _1157_/A2 wire568/Z _1138_/B2 _1141_/A2 VDD VDD VSS VSS gf180mcu_fd_sc_mcu7t5v0__aoi22_2
X_1069_ _1069_/A1 wire602/Z _1069_/B1 _1591_/Q _1072_/A2 VDD VDD VSS VSS gf180mcu_fd_sc_mcu7t5v0__aoi22_1
XFILLER_40_217 VDD VDD VSS VSS gf180mcu_fd_sc_mcu7t5v0__fillcap_16
XFILLER_4_107 VDD VDD VSS VSS gf180mcu_fd_sc_mcu7t5v0__fillcap_64
XFILLER_75_136 VDD VDD VSS VSS gf180mcu_fd_sc_mcu7t5v0__fillcap_4
Xinput269 raw_edge3_y[16] _0938_/B2 VDD VDD VSS VSS gf180mcu_fd_sc_mcu7t5v0__buf_1
Xinput247 raw_edge3_x[15] _1230_/B2 VDD VDD VSS VSS gf180mcu_fd_sc_mcu7t5v0__buf_1
XFILLER_48_317 VDD VDD VSS VSS gf180mcu_fd_sc_mcu7t5v0__fill_1
Xinput225 raw_edge2_y[14] _1193_/B2 VDD VDD VSS VSS gf180mcu_fd_sc_mcu7t5v0__buf_1
Xinput236 raw_edge2_y[5] _1161_/B2 VDD VDD VSS VSS gf180mcu_fd_sc_mcu7t5v0__buf_1
Xinput258 raw_edge3_x[6] _1197_/B2 VDD VDD VSS VSS gf180mcu_fd_sc_mcu7t5v0__buf_2
Xinput214 raw_edge2_x[4] _1136_/A1 VDD VDD VSS VSS gf180mcu_fd_sc_mcu7t5v0__buf_1
Xinput203 raw_edge2_x[13] _1167_/B2 VDD VDD VSS VSS gf180mcu_fd_sc_mcu7t5v0__buf_1
XFILLER_16_247 VDD VDD VSS VSS gf180mcu_fd_sc_mcu7t5v0__fill_1
XFILLER_8_457 VDD VDD VSS VSS gf180mcu_fd_sc_mcu7t5v0__fillcap_16
XFILLER_12_431 VDD VDD VSS VSS gf180mcu_fd_sc_mcu7t5v0__fill_1
XFILLER_58_91 VDD VDD VSS VSS gf180mcu_fd_sc_mcu7t5v0__fillcap_8
XTAP_TAPCELL_ROW_80_819 VDD VSS gf180mcu_fd_sc_mcu7t5v0__filltie
XFILLER_53_320 VDD VDD VSS VSS gf180mcu_fd_sc_mcu7t5v0__fill_1
XTAP_TAPCELL_ROW_0_165 VDD VSS gf180mcu_fd_sc_mcu7t5v0__filltie
XTAP_TAPCELL_ROW_0_176 VDD VSS gf180mcu_fd_sc_mcu7t5v0__filltie
XFILLER_70_37 VDD VDD VSS VSS gf180mcu_fd_sc_mcu7t5v0__fillcap_64
XFILLER_70_26 VDD VDD VSS VSS gf180mcu_fd_sc_mcu7t5v0__fillcap_8
XTAP_TAPCELL_ROW_51_587 VDD VSS gf180mcu_fd_sc_mcu7t5v0__filltie
XTAP_TAPCELL_ROW_8_243 VDD VSS gf180mcu_fd_sc_mcu7t5v0__filltie
XFILLER_5_416 VDD VDD VSS VSS gf180mcu_fd_sc_mcu7t5v0__fillcap_4
XFILLER_76_478 VDD VDD VSS VSS gf180mcu_fd_sc_mcu7t5v0__fillcap_4
XFILLER_76_445 VDD VDD VSS VSS gf180mcu_fd_sc_mcu7t5v0__fill_2
XFILLER_48_169 VDD VDD VSS VSS gf180mcu_fd_sc_mcu7t5v0__fillcap_4
XFILLER_17_512 VDD VDD VSS VSS gf180mcu_fd_sc_mcu7t5v0__fillcap_4
XTAP_TAPCELL_ROW_42_510 VDD VSS gf180mcu_fd_sc_mcu7t5v0__filltie
XFILLER_17_556 VDD VDD VSS VSS gf180mcu_fd_sc_mcu7t5v0__fillcap_4
X_1610_ _1610_/D _1639_/RN _1659_/CLK _1610_/Q VDD VDD VSS VSS gf180mcu_fd_sc_mcu7t5v0__dffrnq_1
XTAP_TAPCELL_ROW_14_289 VDD VSS gf180mcu_fd_sc_mcu7t5v0__filltie
X_1541_ _1541_/D _1545_/RN clkload4/I _1541_/Q VDD VDD VSS VSS gf180mcu_fd_sc_mcu7t5v0__dffrnq_1
X_1472_ _1472_/D _1676_/RN clkload3/I _1472_/Q VDD VDD VSS VSS gf180mcu_fd_sc_mcu7t5v0__dffrnq_1
XFILLER_39_169 VDD VDD VSS VSS gf180mcu_fd_sc_mcu7t5v0__fill_1
XFILLER_27_309 VDD VDD VSS VSS gf180mcu_fd_sc_mcu7t5v0__fill_2
XFILLER_62_161 VDD VDD VSS VSS gf180mcu_fd_sc_mcu7t5v0__fill_2
XFILLER_23_559 VDD VDD VSS VSS gf180mcu_fd_sc_mcu7t5v0__fill_1
XFILLER_65_26 VDD VDD VSS VSS gf180mcu_fd_sc_mcu7t5v0__fillcap_32
Xfanout712 _1589_/Q _1267_/I1 VDD VDD VSS VSS gf180mcu_fd_sc_mcu7t5v0__dlyb_1
Xfanout756 wire763/Z _0774_/I0 VDD VDD VSS VSS gf180mcu_fd_sc_mcu7t5v0__dlyb_1
XTAP_TAPCELL_ROW_5_213 VDD VSS gf180mcu_fd_sc_mcu7t5v0__filltie
XFILLER_81_36 VDD VDD VSS VSS gf180mcu_fd_sc_mcu7t5v0__fillcap_16
XFILLER_81_14 VDD VDD VSS VSS gf180mcu_fd_sc_mcu7t5v0__fill_1
XTAP_TAPCELL_ROW_64_690 VDD VSS gf180mcu_fd_sc_mcu7t5v0__filltie
XTAP_TAPCELL_ROW_56_624 VDD VSS gf180mcu_fd_sc_mcu7t5v0__filltie
XFILLER_53_150 VDD VDD VSS VSS gf180mcu_fd_sc_mcu7t5v0__fillcap_4
XFILLER_45_139 VDD VDD VSS VSS gf180mcu_fd_sc_mcu7t5v0__fill_1
XFILLER_45_128 VDD VDD VSS VSS gf180mcu_fd_sc_mcu7t5v0__fill_2
XFILLER_49_489 VDD VDD VSS VSS gf180mcu_fd_sc_mcu7t5v0__fill_1
XTAP_TAPCELL_ROW_19_326 VDD VSS gf180mcu_fd_sc_mcu7t5v0__filltie
X_0972_ _0972_/A1 wire573/I _1057_/A2 _0972_/B2 _1221_/B1 _0972_/C2 _0974_/A1 VDD
+ VDD VSS VSS gf180mcu_fd_sc_mcu7t5v0__aoi222_2
XFILLER_32_356 VDD VDD VSS VSS gf180mcu_fd_sc_mcu7t5v0__fillcap_4
XTAP_TAPCELL_ROW_27_392 VDD VSS gf180mcu_fd_sc_mcu7t5v0__filltie
XFILLER_17_386 VDD VDD VSS VSS gf180mcu_fd_sc_mcu7t5v0__fill_2
XFILLER_58_2 VDD VDD VSS VSS gf180mcu_fd_sc_mcu7t5v0__fill_1
X_1524_ _1524_/D wire861/Z clkload4/I _1524_/Q VDD VDD VSS VSS gf180mcu_fd_sc_mcu7t5v0__dffrnq_1
Xoutput315 _1610_/Q cfg_f_MEMS_fcw_x[1] VDD VDD VSS VSS gf180mcu_fd_sc_mcu7t5v0__buf_2
Xoutput359 _1646_/Q cfg_phase0_offset_x[8] VDD VDD VSS VSS gf180mcu_fd_sc_mcu7t5v0__buf_2
Xoutput337 _1632_/Q cfg_f_MEMS_fcw_y[7] VDD VDD VSS VSS gf180mcu_fd_sc_mcu7t5v0__buf_2
Xoutput326 _1620_/Q cfg_f_MEMS_fcw_y[11] VDD VDD VSS VSS gf180mcu_fd_sc_mcu7t5v0__buf_2
Xoutput348 _1634_/Q cfg_phase0_offset_x[17] VDD VDD VSS VSS gf180mcu_fd_sc_mcu7t5v0__buf_2
XFILLER_67_242 VDD VDD VSS VSS gf180mcu_fd_sc_mcu7t5v0__fillcap_16
XFILLER_67_231 VDD VDD VSS VSS gf180mcu_fd_sc_mcu7t5v0__fillcap_4
XFILLER_59_209 VDD VDD VSS VSS gf180mcu_fd_sc_mcu7t5v0__fill_1
X_1455_ _0749_/Z _1455_/A2 _1455_/A3 _1457_/S VDD VDD VSS VSS gf180mcu_fd_sc_mcu7t5v0__nand3_4
XFILLER_27_106 VDD VDD VSS VSS gf180mcu_fd_sc_mcu7t5v0__fillcap_4
X_1386_ _1470_/Q _1391_/S _1387_/B VDD VDD VSS VSS gf180mcu_fd_sc_mcu7t5v0__nand2_1
XFILLER_35_194 VDD VDD VSS VSS gf180mcu_fd_sc_mcu7t5v0__fillcap_16
XFILLER_35_29 VDD VDD VSS VSS gf180mcu_fd_sc_mcu7t5v0__fill_2
XFILLER_23_323 VDD VDD VSS VSS gf180mcu_fd_sc_mcu7t5v0__fill_1
XTAP_TAPCELL_ROW_61_660 VDD VSS gf180mcu_fd_sc_mcu7t5v0__filltie
XFILLER_73_212 VDD VDD VSS VSS gf180mcu_fd_sc_mcu7t5v0__fillcap_64
XFILLER_58_286 VDD VDD VSS VSS gf180mcu_fd_sc_mcu7t5v0__fill_1
XTAP_TAPCELL_ROW_16_307 VDD VSS gf180mcu_fd_sc_mcu7t5v0__filltie
XFILLER_41_72 VDD VDD VSS VSS gf180mcu_fd_sc_mcu7t5v0__fillcap_4
XFILLER_77_562 VDD VDD VSS VSS gf180mcu_fd_sc_mcu7t5v0__fillcap_8
XTAP_TAPCELL_ROW_67_708 VDD VSS gf180mcu_fd_sc_mcu7t5v0__filltie
X_1240_ input65/Z wire547/Z _1240_/B1 _1417_/I0 _1242_/A3 VDD VDD VSS VSS gf180mcu_fd_sc_mcu7t5v0__aoi22_1
X_1171_ _1171_/A1 _1171_/A2 _1171_/A3 _1171_/A4 _1179_/A2 VDD VDD VSS VSS gf180mcu_fd_sc_mcu7t5v0__nand4_1
XFILLER_1_282 VDD VDD VSS VSS gf180mcu_fd_sc_mcu7t5v0__fillcap_64
XTAP_TAPCELL_ROW_75_774 VDD VSS gf180mcu_fd_sc_mcu7t5v0__filltie
XFILLER_45_492 VDD VDD VSS VSS gf180mcu_fd_sc_mcu7t5v0__fillcap_4
XFILLER_17_150 VDD VDD VSS VSS gf180mcu_fd_sc_mcu7t5v0__fill_1
X_0955_ _0955_/A1 wire515/Z wire511/Z input26/Z _0958_/A2 VDD VDD VSS VSS gf180mcu_fd_sc_mcu7t5v0__aoi22_4
X_0886_ wire621/Z _0923_/A2 _0929_/B1 VDD VDD VSS VSS gf180mcu_fd_sc_mcu7t5v0__nor2_4
X_1507_ _1507_/D _1510_/RN _1593_/CLK _1507_/Q VDD VDD VSS VSS gf180mcu_fd_sc_mcu7t5v0__dffrnq_1
XFILLER_55_212 VDD VDD VSS VSS gf180mcu_fd_sc_mcu7t5v0__fillcap_4
XFILLER_28_415 VDD VDD VSS VSS gf180mcu_fd_sc_mcu7t5v0__fillcap_4
X_1438_ _1438_/I0 _1511_/Q _1444_/S _1511_/D VDD VDD VSS VSS gf180mcu_fd_sc_mcu7t5v0__mux2_2
X_1369_ _1671_/Q wire737/I _1372_/S _1671_/D VDD VDD VSS VSS gf180mcu_fd_sc_mcu7t5v0__mux2_2
XFILLER_51_440 VDD VDD VSS VSS gf180mcu_fd_sc_mcu7t5v0__fill_2
XTAP_TAPCELL_ROW_38_476 VDD VSS gf180mcu_fd_sc_mcu7t5v0__filltie
XFILLER_23_131 VDD VDD VSS VSS gf180mcu_fd_sc_mcu7t5v0__fill_1
XFILLER_23_142 VDD VDD VSS VSS gf180mcu_fd_sc_mcu7t5v0__fillcap_4
XTAP_TAPCELL_ROW_21_343 VDD VSS gf180mcu_fd_sc_mcu7t5v0__filltie
XFILLER_74_543 VDD VDD VSS VSS gf180mcu_fd_sc_mcu7t5v0__fillcap_8
XFILLER_74_521 VDD VDD VSS VSS gf180mcu_fd_sc_mcu7t5v0__fillcap_4
XTAP_TAPCELL_ROW_72_755 VDD VSS gf180mcu_fd_sc_mcu7t5v0__filltie
XFILLER_61_237 VDD VDD VSS VSS gf180mcu_fd_sc_mcu7t5v0__fillcap_4
XFILLER_46_256 VDD VDD VSS VSS gf180mcu_fd_sc_mcu7t5v0__fillcap_4
XFILLER_46_201 VDD VDD VSS VSS gf180mcu_fd_sc_mcu7t5v0__fill_2
XTAP_TAPCELL_ROW_29_410 VDD VSS gf180mcu_fd_sc_mcu7t5v0__filltie
XFILLER_27_492 VDD VDD VSS VSS gf180mcu_fd_sc_mcu7t5v0__fill_2
XFILLER_14_131 VDD VDD VSS VSS gf180mcu_fd_sc_mcu7t5v0__fill_2
XFILLER_19_415 VDD VDD VSS VSS gf180mcu_fd_sc_mcu7t5v0__fillcap_4
XFILLER_19_437 VDD VDD VSS VSS gf180mcu_fd_sc_mcu7t5v0__fill_2
X_0740_ _1555_/Q _1250_/A1 VDD VDD VSS VSS gf180mcu_fd_sc_mcu7t5v0__inv_3
Xinput36 cal_phase0_offset_y[19] input36/Z VDD VDD VSS VSS gf180mcu_fd_sc_mcu7t5v0__buf_1
Xinput14 cal_phase0_offset_x[18] input14/Z VDD VDD VSS VSS gf180mcu_fd_sc_mcu7t5v0__buf_1
Xinput25 cal_phase0_offset_x[9] input25/Z VDD VDD VSS VSS gf180mcu_fd_sc_mcu7t5v0__buf_1
XFILLER_52_93 VDD VDD VSS VSS gf180mcu_fd_sc_mcu7t5v0__fill_2
Xinput69 cal_phase270_offset_y[10] input69/Z VDD VDD VSS VSS gf180mcu_fd_sc_mcu7t5v0__buf_1
Xinput58 cal_phase270_offset_x[1] input58/Z VDD VDD VSS VSS gf180mcu_fd_sc_mcu7t5v0__buf_1
Xinput47 cal_phase270_offset_x[0] input47/Z VDD VDD VSS VSS gf180mcu_fd_sc_mcu7t5v0__buf_1
Xwire762 wire763/Z wire762/Z VDD VDD VSS VSS gf180mcu_fd_sc_mcu7t5v0__buf_2
Xload_slew701 _1612_/Q _1106_/A1 VDD VDD VSS VSS gf180mcu_fd_sc_mcu7t5v0__buf_2
Xload_slew723 _1328_/I1 _1338_/I1 VDD VDD VSS VSS gf180mcu_fd_sc_mcu7t5v0__clkbuf_1
XFILLER_65_532 VDD VDD VSS VSS gf180mcu_fd_sc_mcu7t5v0__fillcap_8
X_1154_ input51/Z _1154_/A2 _1154_/B1 _1154_/B2 _1178_/A1 VDD VDD VSS VSS gf180mcu_fd_sc_mcu7t5v0__aoi22_2
X_1223_ _1653_/Q wire593/Z wire557/I input4/Z _1225_/A2 VDD VDD VSS VSS gf180mcu_fd_sc_mcu7t5v0__aoi22_1
Xload_slew767 wire768/Z _1364_/I1 VDD VDD VSS VSS gf180mcu_fd_sc_mcu7t5v0__clkbuf_2
Xload_slew745 wire746/Z _1438_/I0 VDD VDD VSS VSS gf180mcu_fd_sc_mcu7t5v0__clkbuf_2
Xload_slew778 _1519_/Q _1448_/I1 VDD VDD VSS VSS gf180mcu_fd_sc_mcu7t5v0__buf_2
Xload_slew789 _1669_/RN _1673_/RN VDD VDD VSS VSS gf180mcu_fd_sc_mcu7t5v0__buf_2
XFILLER_80_513 VDD VDD VSS VSS gf180mcu_fd_sc_mcu7t5v0__fillcap_8
X_1085_ _1085_/A1 _1085_/A2 _1109_/A1 VDD VDD VSS VSS gf180mcu_fd_sc_mcu7t5v0__nor2_1
XTAP_TAPCELL_ROW_35_457 VDD VSS gf180mcu_fd_sc_mcu7t5v0__filltie
XFILLER_33_440 VDD VDD VSS VSS gf180mcu_fd_sc_mcu7t5v0__fill_2
X_0938_ _0938_/A1 _1204_/A2 wire574/Z _0938_/B2 _0939_/A4 VDD VDD VSS VSS gf180mcu_fd_sc_mcu7t5v0__aoi22_4
X_0869_ _0880_/A2 _0869_/A2 _1185_/B1 VDD VDD VSS VSS gf180mcu_fd_sc_mcu7t5v0__nor2_4
XFILLER_73_48 VDD VDD VSS VSS gf180mcu_fd_sc_mcu7t5v0__fillcap_16
XFILLER_71_524 VDD VDD VSS VSS gf180mcu_fd_sc_mcu7t5v0__fillcap_16
XFILLER_16_407 VDD VDD VSS VSS gf180mcu_fd_sc_mcu7t5v0__fill_2
XFILLER_11_123 VDD VDD VSS VSS gf180mcu_fd_sc_mcu7t5v0__fill_2
XFILLER_78_101 VDD VDD VSS VSS gf180mcu_fd_sc_mcu7t5v0__fillcap_4
XFILLER_74_395 VDD VDD VSS VSS gf180mcu_fd_sc_mcu7t5v0__fill_1
XFILLER_62_535 VDD VDD VSS VSS gf180mcu_fd_sc_mcu7t5v0__fillcap_4
XFILLER_62_524 VDD VDD VSS VSS gf180mcu_fd_sc_mcu7t5v0__fill_1
Xwire570 wire570/I wire570/Z VDD VDD VSS VSS gf180mcu_fd_sc_mcu7t5v0__buf_2
XTAP_TAPCELL_ROW_40_493 VDD VSS gf180mcu_fd_sc_mcu7t5v0__filltie
XFILLER_8_10 VDD VDD VSS VSS gf180mcu_fd_sc_mcu7t5v0__fillcap_4
XFILLER_6_171 VDD VDD VSS VSS gf180mcu_fd_sc_mcu7t5v0__fillcap_4
Xload_slew542 _1039_/B1 _1103_/B1 VDD VDD VSS VSS gf180mcu_fd_sc_mcu7t5v0__buf_2
Xload_slew564 _0929_/B1 _1000_/A2 VDD VDD VSS VSS gf180mcu_fd_sc_mcu7t5v0__buf_2
Xload_slew531 _1200_/C1 _1240_/B1 VDD VDD VSS VSS gf180mcu_fd_sc_mcu7t5v0__buf_2
X_1137_ _1137_/A1 wire573/I _1137_/B1 _1137_/B2 _1141_/A1 VDD VDD VSS VSS gf180mcu_fd_sc_mcu7t5v0__aoi22_1
XTAP_TAPCELL_ROW_48_560 VDD VSS gf180mcu_fd_sc_mcu7t5v0__filltie
Xload_slew597 _1086_/A2 _1125_/B1 VDD VDD VSS VSS gf180mcu_fd_sc_mcu7t5v0__buf_2
X_1206_ _1206_/A1 _1206_/A2 _1206_/A3 _1206_/A4 _1211_/A3 VDD VDD VSS VSS gf180mcu_fd_sc_mcu7t5v0__nand4_1
X_1068_ _1068_/A1 _1127_/A2 wire520/Z _1528_/Q _1072_/A1 VDD VDD VSS VSS gf180mcu_fd_sc_mcu7t5v0__aoi22_1
XFILLER_40_207 VDD VDD VSS VSS gf180mcu_fd_sc_mcu7t5v0__fill_1
XFILLER_33_270 VDD VDD VSS VSS gf180mcu_fd_sc_mcu7t5v0__fill_1
XFILLER_68_37 VDD VDD VSS VSS gf180mcu_fd_sc_mcu7t5v0__fillcap_64
Xinput248 raw_edge3_x[16] _0945_/B2 VDD VDD VSS VSS gf180mcu_fd_sc_mcu7t5v0__buf_1
Xinput259 raw_edge3_x[7] _1220_/B2 VDD VDD VSS VSS gf180mcu_fd_sc_mcu7t5v0__buf_1
Xinput226 raw_edge2_y[15] _1234_/B2 VDD VDD VSS VSS gf180mcu_fd_sc_mcu7t5v0__buf_1
Xinput204 raw_edge2_x[14] _1185_/B2 VDD VDD VSS VSS gf180mcu_fd_sc_mcu7t5v0__buf_1
Xinput237 raw_edge2_y[6] _1192_/A1 VDD VDD VSS VSS gf180mcu_fd_sc_mcu7t5v0__buf_1
Xinput215 raw_edge2_x[5] _1158_/A1 VDD VDD VSS VSS gf180mcu_fd_sc_mcu7t5v0__buf_1
XFILLER_44_524 VDD VDD VSS VSS gf180mcu_fd_sc_mcu7t5v0__fill_1
XTAP_TAPCELL_ROW_3_196 VDD VSS gf180mcu_fd_sc_mcu7t5v0__filltie
XFILLER_17_74 VDD VDD VSS VSS gf180mcu_fd_sc_mcu7t5v0__fill_1
XFILLER_17_96 VDD VDD VSS VSS gf180mcu_fd_sc_mcu7t5v0__fill_1
XFILLER_33_84 VDD VDD VSS VSS gf180mcu_fd_sc_mcu7t5v0__fill_2
XFILLER_12_476 VDD VDD VSS VSS gf180mcu_fd_sc_mcu7t5v0__fill_1
XFILLER_39_329 VDD VDD VSS VSS gf180mcu_fd_sc_mcu7t5v0__fillcap_16
XFILLER_35_557 VDD VDD VSS VSS gf180mcu_fd_sc_mcu7t5v0__fill_2
XFILLER_12_6 VDD VDD VSS VSS gf180mcu_fd_sc_mcu7t5v0__fill_2
XFILLER_50_527 VDD VDD VSS VSS gf180mcu_fd_sc_mcu7t5v0__fill_2
XFILLER_15_270 VDD VDD VSS VSS gf180mcu_fd_sc_mcu7t5v0__fill_2
XFILLER_22_229 VDD VDD VSS VSS gf180mcu_fd_sc_mcu7t5v0__fill_1
XFILLER_22_218 VDD VDD VSS VSS gf180mcu_fd_sc_mcu7t5v0__fill_2
XFILLER_57_104 VDD VDD VSS VSS gf180mcu_fd_sc_mcu7t5v0__fillcap_16
XFILLER_72_107 VDD VDD VSS VSS gf180mcu_fd_sc_mcu7t5v0__fillcap_64
XFILLER_38_384 VDD VDD VSS VSS gf180mcu_fd_sc_mcu7t5v0__fill_1
XTAP_TAPCELL_ROW_0_166 VDD VSS gf180mcu_fd_sc_mcu7t5v0__filltie
XTAP_TAPCELL_ROW_0_177 VDD VSS gf180mcu_fd_sc_mcu7t5v0__filltie
XFILLER_13_229 VDD VDD VSS VSS gf180mcu_fd_sc_mcu7t5v0__fillcap_8
XFILLER_76_457 VDD VDD VSS VSS gf180mcu_fd_sc_mcu7t5v0__fill_1
XTAP_TAPCELL_ROW_59_644 VDD VSS gf180mcu_fd_sc_mcu7t5v0__filltie
XFILLER_48_115 VDD VDD VSS VSS gf180mcu_fd_sc_mcu7t5v0__fillcap_4
XFILLER_48_104 VDD VDD VSS VSS gf180mcu_fd_sc_mcu7t5v0__fill_1
XFILLER_29_384 VDD VDD VSS VSS gf180mcu_fd_sc_mcu7t5v0__fill_2
XFILLER_44_387 VDD VDD VSS VSS gf180mcu_fd_sc_mcu7t5v0__fillcap_16
XFILLER_44_72 VDD VDD VSS VSS gf180mcu_fd_sc_mcu7t5v0__fill_2
XFILLER_44_94 VDD VDD VSS VSS gf180mcu_fd_sc_mcu7t5v0__fill_1
XTAP_TAPCELL_ROW_42_511 VDD VSS gf180mcu_fd_sc_mcu7t5v0__filltie
XFILLER_32_527 VDD VDD VSS VSS gf180mcu_fd_sc_mcu7t5v0__fillcap_4
XFILLER_12_251 VDD VDD VSS VSS gf180mcu_fd_sc_mcu7t5v0__fill_1
XFILLER_60_71 VDD VDD VSS VSS gf180mcu_fd_sc_mcu7t5v0__fillcap_32
X_1540_ _1540_/D wire865/Z _1587_/CLK _1540_/Q VDD VDD VSS VSS gf180mcu_fd_sc_mcu7t5v0__dffrnq_1
XFILLER_39_115 VDD VDD VSS VSS gf180mcu_fd_sc_mcu7t5v0__fillcap_16
X_1471_ _1471_/D _1634_/RN clkload3/I _1471_/Q VDD VDD VSS VSS gf180mcu_fd_sc_mcu7t5v0__dffrnq_1
XFILLER_5_66 VDD VDD VSS VSS gf180mcu_fd_sc_mcu7t5v0__fillcap_4
XFILLER_67_479 VDD VDD VSS VSS gf180mcu_fd_sc_mcu7t5v0__fillcap_4
XPHY_EDGE_ROW_17_Left_99 VDD VSS gf180mcu_fd_sc_mcu7t5v0__endcap
Xfanout702 _1590_/Q _0770_/I0 VDD VDD VSS VSS gf180mcu_fd_sc_mcu7t5v0__dlyb_1
X_1669_ _1669_/D _1669_/RN clkload0/I _1669_/Q VDD VDD VSS VSS gf180mcu_fd_sc_mcu7t5v0__dffrnq_1
XTAP_TAPCELL_ROW_56_625 VDD VSS gf180mcu_fd_sc_mcu7t5v0__filltie
XTAP_TAPCELL_ROW_5_214 VDD VSS gf180mcu_fd_sc_mcu7t5v0__filltie
Xfanout735 _1461_/I0 _1358_/I1 VDD VDD VSS VSS gf180mcu_fd_sc_mcu7t5v0__dlyb_1
XTAP_TAPCELL_ROW_64_691 VDD VSS gf180mcu_fd_sc_mcu7t5v0__filltie
XFILLER_53_184 VDD VDD VSS VSS gf180mcu_fd_sc_mcu7t5v0__fill_1
XFILLER_41_368 VDD VDD VSS VSS gf180mcu_fd_sc_mcu7t5v0__fill_2
XFILLER_14_527 VDD VDD VSS VSS gf180mcu_fd_sc_mcu7t5v0__fillcap_4
XFILLER_30_52 VDD VDD VSS VSS gf180mcu_fd_sc_mcu7t5v0__fillcap_4
XFILLER_49_402 VDD VDD VSS VSS gf180mcu_fd_sc_mcu7t5v0__fillcap_4
XFILLER_39_72 VDD VDD VSS VSS gf180mcu_fd_sc_mcu7t5v0__fillcap_4
XFILLER_1_486 VDD VDD VSS VSS gf180mcu_fd_sc_mcu7t5v0__fillcap_4
XFILLER_36_107 VDD VDD VSS VSS gf180mcu_fd_sc_mcu7t5v0__fillcap_16
XFILLER_32_302 VDD VDD VSS VSS gf180mcu_fd_sc_mcu7t5v0__fillcap_8
XTAP_TAPCELL_ROW_19_327 VDD VSS gf180mcu_fd_sc_mcu7t5v0__filltie
X_0971_ _1676_/Q wire575/I wire541/I _0971_/B2 _1005_/A1 VDD VDD VSS VSS gf180mcu_fd_sc_mcu7t5v0__aoi22_1
XTAP_TAPCELL_ROW_27_393 VDD VSS gf180mcu_fd_sc_mcu7t5v0__filltie
Xoutput338 _1617_/Q cfg_f_MEMS_fcw_y[8] VDD VDD VSS VSS gf180mcu_fd_sc_mcu7t5v0__buf_2
Xoutput349 _1635_/Q cfg_phase0_offset_x[18] VDD VDD VSS VSS gf180mcu_fd_sc_mcu7t5v0__buf_2
Xoutput327 _1621_/Q cfg_f_MEMS_fcw_y[12] VDD VDD VSS VSS gf180mcu_fd_sc_mcu7t5v0__buf_2
Xoutput316 _1611_/Q cfg_f_MEMS_fcw_x[2] VDD VDD VSS VSS gf180mcu_fd_sc_mcu7t5v0__buf_2
X_1523_ _1523_/D _1525_/RN clkload4/I _1523_/Q VDD VDD VSS VSS gf180mcu_fd_sc_mcu7t5v0__dffrnq_1
X_1454_ wire711/Z _1524_/Q _1454_/S _1524_/D VDD VDD VSS VSS gf180mcu_fd_sc_mcu7t5v0__mux2_2
XFILLER_67_298 VDD VDD VSS VSS gf180mcu_fd_sc_mcu7t5v0__fillcap_4
X_1385_ wire747/I _1469_/Q _1389_/S _1469_/D VDD VDD VSS VSS gf180mcu_fd_sc_mcu7t5v0__mux2_2
XTAP_TAPCELL_ROW_61_661 VDD VSS gf180mcu_fd_sc_mcu7t5v0__filltie
XFILLER_35_162 VDD VDD VSS VSS gf180mcu_fd_sc_mcu7t5v0__fillcap_32
XFILLER_76_37 VDD VDD VSS VSS gf180mcu_fd_sc_mcu7t5v0__fillcap_64
XFILLER_18_107 VDD VDD VSS VSS gf180mcu_fd_sc_mcu7t5v0__fillcap_16
XFILLER_26_162 VDD VDD VSS VSS gf180mcu_fd_sc_mcu7t5v0__fillcap_8
XFILLER_41_110 VDD VDD VSS VSS gf180mcu_fd_sc_mcu7t5v0__fillcap_4
XFILLER_14_368 VDD VDD VSS VSS gf180mcu_fd_sc_mcu7t5v0__fill_1
XFILLER_6_556 VDD VDD VSS VSS gf180mcu_fd_sc_mcu7t5v0__fill_2
XTAP_TAPCELL_ROW_67_709 VDD VSS gf180mcu_fd_sc_mcu7t5v0__filltie
XFILLER_49_221 VDD VDD VSS VSS gf180mcu_fd_sc_mcu7t5v0__fillcap_16
XFILLER_37_416 VDD VDD VSS VSS gf180mcu_fd_sc_mcu7t5v0__fillcap_4
X_1170_ input93/Z _1208_/A2 _1241_/B1 _1170_/B2 _1170_/C1 _1238_/B1 _1171_/A4 VDD
+ VDD VSS VSS gf180mcu_fd_sc_mcu7t5v0__aoi222_2
XFILLER_2_34 VDD VDD VSS VSS gf180mcu_fd_sc_mcu7t5v0__fill_1
XTAP_TAPCELL_ROW_75_775 VDD VSS gf180mcu_fd_sc_mcu7t5v0__filltie
XFILLER_64_279 VDD VDD VSS VSS gf180mcu_fd_sc_mcu7t5v0__fillcap_4
XPHY_EDGE_ROW_25_Left_107 VDD VSS gf180mcu_fd_sc_mcu7t5v0__endcap
X_0954_ _0954_/A1 _1036_/A2 _1123_/A2 _0954_/B2 _0958_/A1 VDD VDD VSS VSS gf180mcu_fd_sc_mcu7t5v0__aoi22_1
X_0885_ _0885_/A1 _0918_/A1 _1200_/A2 VDD VDD VSS VSS gf180mcu_fd_sc_mcu7t5v0__nor2_4
XPHY_EDGE_ROW_34_Left_116 VDD VSS gf180mcu_fd_sc_mcu7t5v0__endcap
X_1437_ _1437_/I0 _1510_/Q _1437_/S _1510_/D VDD VDD VSS VSS gf180mcu_fd_sc_mcu7t5v0__mux2_2
X_1506_ _1506_/D _1508_/RN _1593_/CLK _1506_/Q VDD VDD VSS VSS gf180mcu_fd_sc_mcu7t5v0__dffrnq_1
XFILLER_55_279 VDD VDD VSS VSS gf180mcu_fd_sc_mcu7t5v0__fill_1
XFILLER_55_235 VDD VDD VSS VSS gf180mcu_fd_sc_mcu7t5v0__fillcap_4
XFILLER_43_419 VDD VDD VSS VSS gf180mcu_fd_sc_mcu7t5v0__fill_1
XTAP_TAPCELL_ROW_38_477 VDD VSS gf180mcu_fd_sc_mcu7t5v0__filltie
X_1299_ _1413_/A1 _1303_/S _1299_/B _1620_/D VDD VDD VSS VSS gf180mcu_fd_sc_mcu7t5v0__aoi21_1
X_1368_ wire685/I _1371_/S _1368_/B _1670_/D VDD VDD VSS VSS gf180mcu_fd_sc_mcu7t5v0__aoi21_1
XPHY_EDGE_ROW_43_Left_125 VDD VSS gf180mcu_fd_sc_mcu7t5v0__endcap
XTAP_TAPCELL_ROW_21_344 VDD VSS gf180mcu_fd_sc_mcu7t5v0__filltie
XPHY_EDGE_ROW_52_Left_134 VDD VSS gf180mcu_fd_sc_mcu7t5v0__endcap
XTAP_TAPCELL_ROW_29_411 VDD VSS gf180mcu_fd_sc_mcu7t5v0__filltie
XFILLER_74_555 VDD VDD VSS VSS gf180mcu_fd_sc_mcu7t5v0__fill_1
XPHY_EDGE_ROW_61_Left_143 VDD VSS gf180mcu_fd_sc_mcu7t5v0__endcap
Xinput59 cal_phase270_offset_x[20] input59/Z VDD VDD VSS VSS gf180mcu_fd_sc_mcu7t5v0__buf_1
XPHY_EDGE_ROW_70_Left_152 VDD VSS gf180mcu_fd_sc_mcu7t5v0__endcap
Xinput48 cal_phase270_offset_x[10] input48/Z VDD VDD VSS VSS gf180mcu_fd_sc_mcu7t5v0__buf_1
Xwire774 wire774/I wire774/Z VDD VDD VSS VSS gf180mcu_fd_sc_mcu7t5v0__buf_1
Xinput15 cal_phase0_offset_x[19] input15/Z VDD VDD VSS VSS gf180mcu_fd_sc_mcu7t5v0__buf_1
Xinput37 cal_phase0_offset_y[1] input37/Z VDD VDD VSS VSS gf180mcu_fd_sc_mcu7t5v0__buf_1
Xinput26 cal_phase0_offset_y[0] input26/Z VDD VDD VSS VSS gf180mcu_fd_sc_mcu7t5v0__buf_1
Xwire763 wire763/I wire763/Z VDD VDD VSS VSS gf180mcu_fd_sc_mcu7t5v0__buf_2
Xwire785 wire786/Z wire785/Z VDD VDD VSS VSS gf180mcu_fd_sc_mcu7t5v0__buf_1
Xmax_cap507 _1407_/S _1405_/S VDD VDD VSS VSS gf180mcu_fd_sc_mcu7t5v0__clkbuf_1
Xwire741 wire742/Z wire741/Z VDD VDD VSS VSS gf180mcu_fd_sc_mcu7t5v0__buf_2
XFILLER_42_6 VDD VDD VSS VSS gf180mcu_fd_sc_mcu7t5v0__fill_1
Xload_slew724 wire725/Z _1328_/I1 VDD VDD VSS VSS gf180mcu_fd_sc_mcu7t5v0__clkbuf_2
Xload_slew713 wire715/Z _1400_/I1 VDD VDD VSS VSS gf180mcu_fd_sc_mcu7t5v0__clkbuf_2
Xload_slew757 _1457_/I0 _1437_/I0 VDD VDD VSS VSS gf180mcu_fd_sc_mcu7t5v0__buf_1
X_1153_ _1573_/Q wire644/Z _1182_/B VDD VDD VSS VSS gf180mcu_fd_sc_mcu7t5v0__nand2_1
X_1084_ _1084_/A1 _1084_/A2 _1084_/A3 _1084_/A4 _1085_/A2 VDD VDD VSS VSS gf180mcu_fd_sc_mcu7t5v0__nand4_1
X_1222_ _1608_/Q _1222_/A2 wire568/I _1222_/B2 _1225_/A1 VDD VDD VSS VSS gf180mcu_fd_sc_mcu7t5v0__aoi22_1
XFILLER_37_279 VDD VDD VSS VSS gf180mcu_fd_sc_mcu7t5v0__fill_1
Xload_slew779 _1510_/Q _0993_/C2 VDD VDD VSS VSS gf180mcu_fd_sc_mcu7t5v0__buf_2
XFILLER_60_282 VDD VDD VSS VSS gf180mcu_fd_sc_mcu7t5v0__fillcap_4
XFILLER_52_249 VDD VDD VSS VSS gf180mcu_fd_sc_mcu7t5v0__fill_1
XFILLER_52_227 VDD VDD VSS VSS gf180mcu_fd_sc_mcu7t5v0__fillcap_16
XTAP_TAPCELL_ROW_35_458 VDD VSS gf180mcu_fd_sc_mcu7t5v0__filltie
X_0799_ _1555_/Q _1554_/Q _0799_/Z VDD VDD VSS VSS gf180mcu_fd_sc_mcu7t5v0__xor2_1
X_0868_ _0868_/A1 _0898_/A2 wire579/I VDD VDD VSS VSS gf180mcu_fd_sc_mcu7t5v0__nor2_4
X_0937_ _0937_/A1 _0937_/A2 _0937_/Z VDD VDD VSS VSS gf180mcu_fd_sc_mcu7t5v0__or2_1
Xclkbuf_leaf_9_clk clkbuf_leaf_9_clk/I clkload4/I VDD VDD VSS VSS gf180mcu_fd_sc_mcu7t5v0__clkbuf_8
XFILLER_57_28 VDD VDD VSS VSS gf180mcu_fd_sc_mcu7t5v0__fillcap_4
XFILLER_73_16 VDD VDD VSS VSS gf180mcu_fd_sc_mcu7t5v0__fillcap_32
XFILLER_43_205 VDD VDD VSS VSS gf180mcu_fd_sc_mcu7t5v0__fillcap_4
XFILLER_28_279 VDD VDD VSS VSS gf180mcu_fd_sc_mcu7t5v0__fill_2
XFILLER_51_282 VDD VDD VSS VSS gf180mcu_fd_sc_mcu7t5v0__fillcap_4
XPHY_EDGE_ROW_5_Left_87 VDD VSS gf180mcu_fd_sc_mcu7t5v0__endcap
XFILLER_22_97 VDD VDD VSS VSS gf180mcu_fd_sc_mcu7t5v0__fillcap_8
XFILLER_47_533 VDD VDD VSS VSS gf180mcu_fd_sc_mcu7t5v0__fill_2
XFILLER_47_72 VDD VDD VSS VSS gf180mcu_fd_sc_mcu7t5v0__fillcap_32
XFILLER_19_279 VDD VDD VSS VSS gf180mcu_fd_sc_mcu7t5v0__fill_1
XFILLER_42_282 VDD VDD VSS VSS gf180mcu_fd_sc_mcu7t5v0__fillcap_32
XFILLER_42_271 VDD VDD VSS VSS gf180mcu_fd_sc_mcu7t5v0__fill_2
XFILLER_34_238 VDD VDD VSS VSS gf180mcu_fd_sc_mcu7t5v0__fillcap_4
XTAP_TAPCELL_ROW_32_428 VDD VSS gf180mcu_fd_sc_mcu7t5v0__filltie
XFILLER_30_411 VDD VDD VSS VSS gf180mcu_fd_sc_mcu7t5v0__fill_2
Xwire593 wire593/I wire593/Z VDD VDD VSS VSS gf180mcu_fd_sc_mcu7t5v0__buf_2
XTAP_TAPCELL_ROW_40_494 VDD VSS gf180mcu_fd_sc_mcu7t5v0__filltie
Xload_slew543 _1137_/B1 _1092_/B1 VDD VDD VSS VSS gf180mcu_fd_sc_mcu7t5v0__buf_2
Xload_slew521 _1226_/B1 _1169_/C2 VDD VDD VSS VSS gf180mcu_fd_sc_mcu7t5v0__buf_2
Xload_slew587 _1091_/B1 _1204_/A2 VDD VDD VSS VSS gf180mcu_fd_sc_mcu7t5v0__buf_2
Xload_slew565 _1200_/A2 _1230_/A2 VDD VDD VSS VSS gf180mcu_fd_sc_mcu7t5v0__buf_2
Xload_slew554 _1229_/B1 _1087_/A2 VDD VDD VSS VSS gf180mcu_fd_sc_mcu7t5v0__buf_2
Xload_slew532 _1143_/B1 _1200_/C1 VDD VDD VSS VSS gf180mcu_fd_sc_mcu7t5v0__buf_2
XFILLER_65_374 VDD VDD VSS VSS gf180mcu_fd_sc_mcu7t5v0__fill_1
XFILLER_53_525 VDD VDD VSS VSS gf180mcu_fd_sc_mcu7t5v0__fill_2
XTAP_TAPCELL_ROW_48_561 VDD VSS gf180mcu_fd_sc_mcu7t5v0__filltie
X_1136_ _1136_/A1 wire602/Z _1198_/A2 _1605_/Q _1149_/A2 VDD VDD VSS VSS gf180mcu_fd_sc_mcu7t5v0__aoi22_4
X_1067_ _1649_/Q wire593/Z wire558/Z _1067_/B2 _1095_/A1 VDD VDD VSS VSS gf180mcu_fd_sc_mcu7t5v0__aoi22_2
X_1205_ _1502_/Q _1205_/A2 _1217_/B1 _1205_/B2 _1206_/A4 VDD VDD VSS VSS gf180mcu_fd_sc_mcu7t5v0__aoi22_4
XFILLER_25_216 VDD VDD VSS VSS gf180mcu_fd_sc_mcu7t5v0__fill_1
XFILLER_33_282 VDD VDD VSS VSS gf180mcu_fd_sc_mcu7t5v0__fillcap_16
XFILLER_33_260 VDD VDD VSS VSS gf180mcu_fd_sc_mcu7t5v0__fillcap_8
XFILLER_21_422 VDD VDD VSS VSS gf180mcu_fd_sc_mcu7t5v0__fillcap_16
Xinput249 raw_edge3_x[17] _0994_/C2 VDD VDD VSS VSS gf180mcu_fd_sc_mcu7t5v0__buf_1
Xinput227 raw_edge2_y[16] _0946_/A1 VDD VDD VSS VSS gf180mcu_fd_sc_mcu7t5v0__buf_1
Xinput238 raw_edge2_y[7] _1228_/A1 VDD VDD VSS VSS gf180mcu_fd_sc_mcu7t5v0__buf_1
Xinput205 raw_edge2_x[15] _1218_/A1 VDD VDD VSS VSS gf180mcu_fd_sc_mcu7t5v0__buf_1
Xinput216 raw_edge2_x[6] _1209_/A1 VDD VDD VSS VSS gf180mcu_fd_sc_mcu7t5v0__buf_1
XFILLER_29_555 VDD VDD VSS VSS gf180mcu_fd_sc_mcu7t5v0__fillcap_4
XFILLER_29_500 VDD VDD VSS VSS gf180mcu_fd_sc_mcu7t5v0__fill_1
XTAP_TAPCELL_ROW_3_197 VDD VSS gf180mcu_fd_sc_mcu7t5v0__filltie
XFILLER_16_227 VDD VDD VSS VSS gf180mcu_fd_sc_mcu7t5v0__fill_2
XFILLER_66_127 VDD VDD VSS VSS gf180mcu_fd_sc_mcu7t5v0__fill_2
XFILLER_3_142 VDD VDD VSS VSS gf180mcu_fd_sc_mcu7t5v0__fillcap_64
XFILLER_74_171 VDD VDD VSS VSS gf180mcu_fd_sc_mcu7t5v0__fillcap_4
XFILLER_15_282 VDD VDD VSS VSS gf180mcu_fd_sc_mcu7t5v0__fillcap_8
XFILLER_7_492 VDD VDD VSS VSS gf180mcu_fd_sc_mcu7t5v0__fillcap_16
XFILLER_38_363 VDD VDD VSS VSS gf180mcu_fd_sc_mcu7t5v0__fillcap_4
XFILLER_38_330 VDD VDD VSS VSS gf180mcu_fd_sc_mcu7t5v0__fillcap_8
X_1119_ _1513_/Q _1119_/A2 wire536/I _1671_/Q _1119_/C1 _1119_/C2 _1122_/A2 VDD VDD
+ VSS VSS gf180mcu_fd_sc_mcu7t5v0__aoi222_4
XTAP_TAPCELL_ROW_0_167 VDD VSS gf180mcu_fd_sc_mcu7t5v0__filltie
XTAP_TAPCELL_ROW_0_178 VDD VSS gf180mcu_fd_sc_mcu7t5v0__filltie
XPHY_EDGE_ROW_17_Right_17 VDD VSS gf180mcu_fd_sc_mcu7t5v0__endcap
XPHY_EDGE_ROW_26_Right_26 VDD VSS gf180mcu_fd_sc_mcu7t5v0__endcap
XFILLER_76_447 VDD VDD VSS VSS gf180mcu_fd_sc_mcu7t5v0__fill_1
XTAP_TAPCELL_ROW_59_645 VDD VSS gf180mcu_fd_sc_mcu7t5v0__filltie
XFILLER_29_352 VDD VDD VSS VSS gf180mcu_fd_sc_mcu7t5v0__fillcap_4
XFILLER_17_525 VDD VDD VSS VSS gf180mcu_fd_sc_mcu7t5v0__fillcap_4
XFILLER_44_84 VDD VDD VSS VSS gf180mcu_fd_sc_mcu7t5v0__fillcap_8
XTAP_TAPCELL_ROW_42_512 VDD VSS gf180mcu_fd_sc_mcu7t5v0__filltie
XPHY_EDGE_ROW_35_Right_35 VDD VSS gf180mcu_fd_sc_mcu7t5v0__endcap
XFILLER_5_34 VDD VDD VSS VSS gf180mcu_fd_sc_mcu7t5v0__fillcap_32
XFILLER_4_451 VDD VDD VSS VSS gf180mcu_fd_sc_mcu7t5v0__fillcap_4
X_1470_ _1470_/D wire794/I clkload0/I _1470_/Q VDD VDD VSS VSS gf180mcu_fd_sc_mcu7t5v0__dffrnq_1
XPHY_EDGE_ROW_44_Right_44 VDD VSS gf180mcu_fd_sc_mcu7t5v0__endcap
XPHY_EDGE_ROW_8_Left_90 VDD VSS gf180mcu_fd_sc_mcu7t5v0__endcap
XFILLER_62_163 VDD VDD VSS VSS gf180mcu_fd_sc_mcu7t5v0__fill_1
XFILLER_54_119 VDD VDD VSS VSS gf180mcu_fd_sc_mcu7t5v0__fill_2
XPHY_EDGE_ROW_53_Right_53 VDD VSS gf180mcu_fd_sc_mcu7t5v0__endcap
XFILLER_50_325 VDD VDD VSS VSS gf180mcu_fd_sc_mcu7t5v0__fillcap_4
XTAP_TAPCELL_ROW_13_280 VDD VSS gf180mcu_fd_sc_mcu7t5v0__filltie
X_1599_ _1599_/D wire880/Z clkload7/I _1600_/D VDD VDD VSS VSS gf180mcu_fd_sc_mcu7t5v0__dffrnq_1
XPHY_EDGE_ROW_62_Right_62 VDD VSS gf180mcu_fd_sc_mcu7t5v0__endcap
XTAP_TAPCELL_ROW_5_215 VDD VSS gf180mcu_fd_sc_mcu7t5v0__filltie
X_1668_ _1668_/D _1669_/RN clkload0/I _1668_/Q VDD VDD VSS VSS gf180mcu_fd_sc_mcu7t5v0__dffrnq_1
XTAP_TAPCELL_ROW_56_626 VDD VSS gf180mcu_fd_sc_mcu7t5v0__filltie
Xfanout769 wire775/I wire771/I VDD VDD VSS VSS gf180mcu_fd_sc_mcu7t5v0__dlyb_1
XPHY_EDGE_ROW_71_Right_71 VDD VSS gf180mcu_fd_sc_mcu7t5v0__endcap
XFILLER_41_347 VDD VDD VSS VSS gf180mcu_fd_sc_mcu7t5v0__fill_2
XFILLER_41_303 VDD VDD VSS VSS gf180mcu_fd_sc_mcu7t5v0__fillcap_16
XPHY_EDGE_ROW_80_Right_80 VDD VSS gf180mcu_fd_sc_mcu7t5v0__endcap
XFILLER_14_98 VDD VDD VSS VSS gf180mcu_fd_sc_mcu7t5v0__fillcap_4
XFILLER_72_483 VDD VDD VSS VSS gf180mcu_fd_sc_mcu7t5v0__fillcap_32
XFILLER_55_72 VDD VDD VSS VSS gf180mcu_fd_sc_mcu7t5v0__fillcap_8
XFILLER_44_163 VDD VDD VSS VSS gf180mcu_fd_sc_mcu7t5v0__fillcap_8
XFILLER_32_314 VDD VDD VSS VSS gf180mcu_fd_sc_mcu7t5v0__fill_1
XTAP_TAPCELL_ROW_27_394 VDD VSS gf180mcu_fd_sc_mcu7t5v0__filltie
XTAP_TAPCELL_ROW_19_328 VDD VSS gf180mcu_fd_sc_mcu7t5v0__filltie
X_0970_ _1569_/Q _1014_/A1 _1014_/B VDD VDD VSS VSS gf180mcu_fd_sc_mcu7t5v0__nand2_1
Xoutput306 _1546_/Q boot_complete VDD VDD VSS VSS gf180mcu_fd_sc_mcu7t5v0__buf_2
Xoutput339 _1618_/Q cfg_f_MEMS_fcw_y[9] VDD VDD VSS VSS gf180mcu_fd_sc_mcu7t5v0__buf_2
Xoutput317 _1612_/Q cfg_f_MEMS_fcw_x[3] VDD VDD VSS VSS gf180mcu_fd_sc_mcu7t5v0__buf_2
Xoutput328 _1622_/Q cfg_f_MEMS_fcw_y[13] VDD VDD VSS VSS gf180mcu_fd_sc_mcu7t5v0__buf_2
X_1453_ wire720/I _1523_/Q _1454_/S _1523_/D VDD VDD VSS VSS gf180mcu_fd_sc_mcu7t5v0__mux2_2
X_1522_ _1522_/D _1522_/RN clkload4/I _1522_/Q VDD VDD VSS VSS gf180mcu_fd_sc_mcu7t5v0__dffrnq_1
XFILLER_67_266 VDD VDD VSS VSS gf180mcu_fd_sc_mcu7t5v0__fill_2
X_1384_ wire754/Z _1468_/Q _1391_/S _1468_/D VDD VDD VSS VSS gf180mcu_fd_sc_mcu7t5v0__mux2_2
XTAP_TAPCELL_ROW_61_662 VDD VSS gf180mcu_fd_sc_mcu7t5v0__filltie
XFILLER_50_177 VDD VDD VSS VSS gf180mcu_fd_sc_mcu7t5v0__fillcap_32
XFILLER_58_266 VDD VDD VSS VSS gf180mcu_fd_sc_mcu7t5v0__fill_2
XFILLER_26_152 VDD VDD VSS VSS gf180mcu_fd_sc_mcu7t5v0__fill_1
XFILLER_26_174 VDD VDD VSS VSS gf180mcu_fd_sc_mcu7t5v0__fill_1
XFILLER_41_166 VDD VDD VSS VSS gf180mcu_fd_sc_mcu7t5v0__fillcap_8
XFILLER_41_133 VDD VDD VSS VSS gf180mcu_fd_sc_mcu7t5v0__fillcap_4
XFILLER_41_63 VDD VDD VSS VSS gf180mcu_fd_sc_mcu7t5v0__fillcap_4
XFILLER_10_542 VDD VDD VSS VSS gf180mcu_fd_sc_mcu7t5v0__fill_2
XTAP_TAPCELL_ROW_24_364 VDD VSS gf180mcu_fd_sc_mcu7t5v0__filltie
XFILLER_64_247 VDD VDD VSS VSS gf180mcu_fd_sc_mcu7t5v0__fillcap_32
XTAP_TAPCELL_ROW_75_776 VDD VSS gf180mcu_fd_sc_mcu7t5v0__filltie
XFILLER_32_177 VDD VDD VSS VSS gf180mcu_fd_sc_mcu7t5v0__fillcap_4
XFILLER_20_317 VDD VDD VSS VSS gf180mcu_fd_sc_mcu7t5v0__fillcap_4
X_0884_ _0884_/A1 _0920_/A2 _1078_/A2 VDD VDD VSS VSS gf180mcu_fd_sc_mcu7t5v0__nor2_4
X_0953_ wire499/Z _0953_/A2 _0953_/A3 _0953_/A4 _0964_/A2 VDD VDD VSS VSS gf180mcu_fd_sc_mcu7t5v0__nand4_2
X_1436_ wire771/Z _1509_/Q _1444_/S _1509_/D VDD VDD VSS VSS gf180mcu_fd_sc_mcu7t5v0__mux2_2
X_1367_ _1670_/Q _1371_/S _1368_/B VDD VDD VSS VSS gf180mcu_fd_sc_mcu7t5v0__nor2_1
X_1505_ _1505_/D _1510_/RN _1593_/CLK _1505_/Q VDD VDD VSS VSS gf180mcu_fd_sc_mcu7t5v0__dffrnq_2
XTAP_TAPCELL_ROW_38_478 VDD VSS gf180mcu_fd_sc_mcu7t5v0__filltie
X_1298_ _1620_/Q _1303_/S _1299_/B VDD VDD VSS VSS gf180mcu_fd_sc_mcu7t5v0__nor2_1
XFILLER_51_464 VDD VDD VSS VSS gf180mcu_fd_sc_mcu7t5v0__fill_1
XTAP_TAPCELL_ROW_21_345 VDD VSS gf180mcu_fd_sc_mcu7t5v0__filltie
XFILLER_78_317 VDD VDD VSS VSS gf180mcu_fd_sc_mcu7t5v0__fillcap_64
XFILLER_19_439 VDD VDD VSS VSS gf180mcu_fd_sc_mcu7t5v0__fill_1
XFILLER_54_291 VDD VDD VSS VSS gf180mcu_fd_sc_mcu7t5v0__fillcap_4
XFILLER_46_269 VDD VDD VSS VSS gf180mcu_fd_sc_mcu7t5v0__fillcap_32
XFILLER_36_96 VDD VDD VSS VSS gf180mcu_fd_sc_mcu7t5v0__fillcap_8
XFILLER_27_494 VDD VDD VSS VSS gf180mcu_fd_sc_mcu7t5v0__fill_1
XFILLER_14_133 VDD VDD VSS VSS gf180mcu_fd_sc_mcu7t5v0__fill_1
XFILLER_14_177 VDD VDD VSS VSS gf180mcu_fd_sc_mcu7t5v0__fill_2
Xinput49 cal_phase270_offset_x[11] input49/Z VDD VDD VSS VSS gf180mcu_fd_sc_mcu7t5v0__buf_1
Xinput38 cal_phase0_offset_y[20] input38/Z VDD VDD VSS VSS gf180mcu_fd_sc_mcu7t5v0__buf_1
Xinput27 cal_phase0_offset_y[10] input27/Z VDD VDD VSS VSS gf180mcu_fd_sc_mcu7t5v0__buf_1
Xinput16 cal_phase0_offset_x[1] input16/Z VDD VDD VSS VSS gf180mcu_fd_sc_mcu7t5v0__buf_1
Xwire742 wire742/I wire742/Z VDD VDD VSS VSS gf180mcu_fd_sc_mcu7t5v0__buf_1
Xwire775 wire775/I wire775/Z VDD VDD VSS VSS gf180mcu_fd_sc_mcu7t5v0__buf_2
XFILLER_6_387 VDD VDD VSS VSS gf180mcu_fd_sc_mcu7t5v0__fillcap_64
Xwire786 wire786/I wire786/Z VDD VDD VSS VSS gf180mcu_fd_sc_mcu7t5v0__buf_1
Xwire720 wire720/I wire720/Z VDD VDD VSS VSS gf180mcu_fd_sc_mcu7t5v0__buf_1
XFILLER_69_306 VDD VDD VSS VSS gf180mcu_fd_sc_mcu7t5v0__fill_1
X_1221_ input86/Z _1221_/A2 _1221_/B1 input95/Z _1244_/A2 VDD VDD VSS VSS gf180mcu_fd_sc_mcu7t5v0__aoi22_1
Xload_slew714 wire715/Z _1390_/I0 VDD VDD VSS VSS gf180mcu_fd_sc_mcu7t5v0__clkbuf_1
Xload_slew703 wire704/Z _1330_/I1 VDD VDD VSS VSS gf180mcu_fd_sc_mcu7t5v0__clkbuf_1
Xload_slew758 _1457_/I0 _1306_/I0 VDD VDD VSS VSS gf180mcu_fd_sc_mcu7t5v0__clkbuf_1
XFILLER_80_559 VDD VDD VSS VSS gf180mcu_fd_sc_mcu7t5v0__fillcap_8
X_1152_ _1152_/I0 _1572_/Q _1152_/S _1572_/D VDD VDD VSS VSS gf180mcu_fd_sc_mcu7t5v0__mux2_2
X_1083_ _1083_/A1 _1083_/A2 wire557/Z _1083_/B2 _1084_/A4 VDD VDD VSS VSS gf180mcu_fd_sc_mcu7t5v0__aoi22_4
XFILLER_37_247 VDD VDD VSS VSS gf180mcu_fd_sc_mcu7t5v0__fillcap_32
X_0936_ wire501/Z wire500/Z _0936_/A3 _0936_/A4 _0937_/A2 VDD VDD VSS VSS gf180mcu_fd_sc_mcu7t5v0__nand4_1
XTAP_TAPCELL_ROW_35_459 VDD VSS gf180mcu_fd_sc_mcu7t5v0__filltie
XFILLER_33_442 VDD VDD VSS VSS gf180mcu_fd_sc_mcu7t5v0__fill_1
XFILLER_20_169 VDD VDD VSS VSS gf180mcu_fd_sc_mcu7t5v0__fillcap_4
X_0798_ _1554_/Q _0810_/A1 _0798_/B _1554_/D VDD VDD VSS VSS gf180mcu_fd_sc_mcu7t5v0__oai21_1
X_0867_ _0918_/A1 wire636/I _0951_/A2 VDD VDD VSS VSS gf180mcu_fd_sc_mcu7t5v0__nor2_4
XFILLER_56_523 VDD VDD VSS VSS gf180mcu_fd_sc_mcu7t5v0__fill_2
XFILLER_28_247 VDD VDD VSS VSS gf180mcu_fd_sc_mcu7t5v0__fillcap_8
X_1419_ _1446_/I0 _1496_/Q _1427_/S _1496_/D VDD VDD VSS VSS gf180mcu_fd_sc_mcu7t5v0__mux2_2
XFILLER_71_548 VDD VDD VSS VSS gf180mcu_fd_sc_mcu7t5v0__fillcap_4
XFILLER_3_346 VDD VDD VSS VSS gf180mcu_fd_sc_mcu7t5v0__fillcap_4
XFILLER_34_206 VDD VDD VSS VSS gf180mcu_fd_sc_mcu7t5v0__fillcap_32
XFILLER_63_72 VDD VDD VSS VSS gf180mcu_fd_sc_mcu7t5v0__fillcap_64
XTAP_TAPCELL_ROW_32_429 VDD VSS gf180mcu_fd_sc_mcu7t5v0__filltie
Xwire594 wire594/I wire594/Z VDD VDD VSS VSS gf180mcu_fd_sc_mcu7t5v0__buf_2
XTAP_TAPCELL_ROW_40_495 VDD VSS gf180mcu_fd_sc_mcu7t5v0__filltie
XFILLER_69_136 VDD VDD VSS VSS gf180mcu_fd_sc_mcu7t5v0__fillcap_4
XFILLER_65_320 VDD VDD VSS VSS gf180mcu_fd_sc_mcu7t5v0__fillcap_4
Xload_slew522 _1147_/B1 _1197_/A2 VDD VDD VSS VSS gf180mcu_fd_sc_mcu7t5v0__buf_2
Xload_slew544 _1090_/B1 _1208_/A2 VDD VDD VSS VSS gf180mcu_fd_sc_mcu7t5v0__buf_2
XFILLER_57_309 VDD VDD VSS VSS gf180mcu_fd_sc_mcu7t5v0__fillcap_8
Xload_slew566 _1123_/A2 _1188_/A2 VDD VDD VSS VSS gf180mcu_fd_sc_mcu7t5v0__buf_2
Xload_slew555 _0977_/B1 _1069_/B1 VDD VDD VSS VSS gf180mcu_fd_sc_mcu7t5v0__buf_2
Xload_slew588 wire586/I _1091_/B1 VDD VDD VSS VSS gf180mcu_fd_sc_mcu7t5v0__buf_2
Xload_slew533 _1207_/A2 _1237_/B1 VDD VDD VSS VSS gf180mcu_fd_sc_mcu7t5v0__buf_2
X_1204_ _1204_/A1 _1204_/A2 _1219_/A2 input73/Z _1206_/A3 VDD VDD VSS VSS gf180mcu_fd_sc_mcu7t5v0__aoi22_4
Xload_slew577 wire576/I _1174_/A2 VDD VDD VSS VSS gf180mcu_fd_sc_mcu7t5v0__buf_2
Xload_slew599 wire600/Z _1199_/A2 VDD VDD VSS VSS gf180mcu_fd_sc_mcu7t5v0__buf_2
XFILLER_65_342 VDD VDD VSS VSS gf180mcu_fd_sc_mcu7t5v0__fillcap_8
X_1066_ input61/Z wire547/I wire536/Z _1670_/Q _1093_/A1 VDD VDD VSS VSS gf180mcu_fd_sc_mcu7t5v0__aoi22_1
X_1135_ _1521_/Q _1237_/B1 wire511/Z input41/Z _1149_/A1 VDD VDD VSS VSS gf180mcu_fd_sc_mcu7t5v0__aoi22_1
XTAP_TAPCELL_ROW_48_562 VDD VSS gf180mcu_fd_sc_mcu7t5v0__filltie
X_0919_ _0919_/A1 _0922_/A2 _1156_/B1 VDD VDD VSS VSS gf180mcu_fd_sc_mcu7t5v0__nor2_4
XFILLER_21_489 VDD VDD VSS VSS gf180mcu_fd_sc_mcu7t5v0__fill_1
Xinput206 raw_edge2_x[16] _0962_/A1 VDD VDD VSS VSS gf180mcu_fd_sc_mcu7t5v0__buf_1
Xinput217 raw_edge2_x[7] _1232_/A1 VDD VDD VSS VSS gf180mcu_fd_sc_mcu7t5v0__buf_1
XFILLER_44_537 VDD VDD VSS VSS gf180mcu_fd_sc_mcu7t5v0__fillcap_4
Xinput239 raw_edge2_y[8] _0933_/B2 VDD VDD VSS VSS gf180mcu_fd_sc_mcu7t5v0__buf_2
Xinput228 raw_edge2_y[17] _0980_/B2 VDD VDD VSS VSS gf180mcu_fd_sc_mcu7t5v0__buf_1
XTAP_TAPCELL_ROW_3_198 VDD VSS gf180mcu_fd_sc_mcu7t5v0__filltie
XFILLER_71_356 VDD VDD VSS VSS gf180mcu_fd_sc_mcu7t5v0__fill_2
XFILLER_12_8 VDD VDD VSS VSS gf180mcu_fd_sc_mcu7t5v0__fill_1
XFILLER_50_529 VDD VDD VSS VSS gf180mcu_fd_sc_mcu7t5v0__fill_1
XFILLER_47_397 VDD VDD VSS VSS gf180mcu_fd_sc_mcu7t5v0__fill_1
XFILLER_47_342 VDD VDD VSS VSS gf180mcu_fd_sc_mcu7t5v0__fillcap_8
XTAP_TAPCELL_ROW_45_532 VDD VSS gf180mcu_fd_sc_mcu7t5v0__filltie
XFILLER_35_559 VDD VDD VSS VSS gf180mcu_fd_sc_mcu7t5v0__fill_1
XFILLER_30_275 VDD VDD VSS VSS gf180mcu_fd_sc_mcu7t5v0__fill_2
XFILLER_30_242 VDD VDD VSS VSS gf180mcu_fd_sc_mcu7t5v0__fill_2
XFILLER_57_128 VDD VDD VSS VSS gf180mcu_fd_sc_mcu7t5v0__fill_2
XFILLER_65_194 VDD VDD VSS VSS gf180mcu_fd_sc_mcu7t5v0__fill_1
X_1049_ wire497/Z _1049_/A2 _1049_/A3 _1059_/A2 VDD VDD VSS VSS gf180mcu_fd_sc_mcu7t5v0__nand3_1
X_1118_ _1118_/A1 _1118_/A2 _1118_/A3 _1118_/A4 _1131_/A1 VDD VDD VSS VSS gf180mcu_fd_sc_mcu7t5v0__nand4_1
XTAP_TAPCELL_ROW_0_168 VDD VSS gf180mcu_fd_sc_mcu7t5v0__filltie
XTAP_TAPCELL_ROW_0_179 VDD VSS gf180mcu_fd_sc_mcu7t5v0__filltie
XFILLER_76_437 VDD VDD VSS VSS gf180mcu_fd_sc_mcu7t5v0__fillcap_8
XTAP_TAPCELL_ROW_59_646 VDD VSS gf180mcu_fd_sc_mcu7t5v0__filltie
XFILLER_71_142 VDD VDD VSS VSS gf180mcu_fd_sc_mcu7t5v0__fillcap_64
XFILLER_44_74 VDD VDD VSS VSS gf180mcu_fd_sc_mcu7t5v0__fill_1
XTAP_TAPCELL_ROW_42_513 VDD VSS gf180mcu_fd_sc_mcu7t5v0__filltie
XFILLER_40_551 VDD VDD VSS VSS gf180mcu_fd_sc_mcu7t5v0__fill_1
XFILLER_67_437 VDD VDD VSS VSS gf180mcu_fd_sc_mcu7t5v0__fillcap_8
XFILLER_39_139 VDD VDD VSS VSS gf180mcu_fd_sc_mcu7t5v0__fill_1
XFILLER_35_323 VDD VDD VSS VSS gf180mcu_fd_sc_mcu7t5v0__fillcap_4
XFILLER_75_492 VDD VDD VSS VSS gf180mcu_fd_sc_mcu7t5v0__fillcap_64
XFILLER_47_183 VDD VDD VSS VSS gf180mcu_fd_sc_mcu7t5v0__fillcap_16
XFILLER_31_562 VDD VDD VSS VSS gf180mcu_fd_sc_mcu7t5v0__fillcap_4
XFILLER_23_529 VDD VDD VSS VSS gf180mcu_fd_sc_mcu7t5v0__fill_2
XTAP_TAPCELL_ROW_13_281 VDD VSS gf180mcu_fd_sc_mcu7t5v0__filltie
X_1598_ _1598_/D wire880/Z clkload7/I _1598_/Q VDD VDD VSS VSS gf180mcu_fd_sc_mcu7t5v0__dffrnq_1
Xfanout748 _1585_/Q _0781_/I0 VDD VDD VSS VSS gf180mcu_fd_sc_mcu7t5v0__dlyb_1
XTAP_TAPCELL_ROW_5_216 VDD VSS gf180mcu_fd_sc_mcu7t5v0__filltie
X_1667_ _1667_/D _1670_/RN clkload0/I _1667_/Q VDD VDD VSS VSS gf180mcu_fd_sc_mcu7t5v0__dffrnq_1
XFILLER_81_484 VDD VDD VSS VSS gf180mcu_fd_sc_mcu7t5v0__fillcap_16
XTAP_TAPCELL_ROW_56_627 VDD VSS gf180mcu_fd_sc_mcu7t5v0__filltie
XFILLER_53_142 VDD VDD VSS VSS gf180mcu_fd_sc_mcu7t5v0__fillcap_8
XFILLER_26_312 VDD VDD VSS VSS gf180mcu_fd_sc_mcu7t5v0__fill_2
XFILLER_30_10 VDD VDD VSS VSS gf180mcu_fd_sc_mcu7t5v0__fill_2
XFILLER_1_422 VDD VDD VSS VSS gf180mcu_fd_sc_mcu7t5v0__fillcap_64
XTAP_TAPCELL_ROW_19_329 VDD VSS gf180mcu_fd_sc_mcu7t5v0__filltie
XFILLER_44_131 VDD VDD VSS VSS gf180mcu_fd_sc_mcu7t5v0__fillcap_32
XFILLER_29_194 VDD VDD VSS VSS gf180mcu_fd_sc_mcu7t5v0__fill_1
XTAP_TAPCELL_ROW_27_395 VDD VSS gf180mcu_fd_sc_mcu7t5v0__filltie
XFILLER_13_562 VDD VDD VSS VSS gf180mcu_fd_sc_mcu7t5v0__fillcap_4
Xoutput307 _1547_/Q cfg_done VDD VDD VSS VSS gf180mcu_fd_sc_mcu7t5v0__buf_2
XFILLER_71_72 VDD VDD VSS VSS gf180mcu_fd_sc_mcu7t5v0__fillcap_64
XFILLER_67_212 VDD VDD VSS VSS gf180mcu_fd_sc_mcu7t5v0__fillcap_4
X_1383_ wire768/Z _1680_/Q _1391_/S _1680_/D VDD VDD VSS VSS gf180mcu_fd_sc_mcu7t5v0__mux2_2
X_1452_ wire729/I _1522_/Q _1454_/S _1522_/D VDD VDD VSS VSS gf180mcu_fd_sc_mcu7t5v0__mux2_2
Xoutput329 _1623_/Q cfg_f_MEMS_fcw_y[14] VDD VDD VSS VSS gf180mcu_fd_sc_mcu7t5v0__buf_2
Xoutput318 _1613_/Q cfg_f_MEMS_fcw_x[4] VDD VDD VSS VSS gf180mcu_fd_sc_mcu7t5v0__buf_2
X_1521_ _1521_/D _1521_/RN _1624_/CLK _1521_/Q VDD VDD VSS VSS gf180mcu_fd_sc_mcu7t5v0__dffrnq_1
XTAP_TAPCELL_ROW_78_796 VDD VSS gf180mcu_fd_sc_mcu7t5v0__filltie
XFILLER_67_278 VDD VDD VSS VSS gf180mcu_fd_sc_mcu7t5v0__fill_2
XFILLER_55_418 VDD VDD VSS VSS gf180mcu_fd_sc_mcu7t5v0__fill_2
XFILLER_35_142 VDD VDD VSS VSS gf180mcu_fd_sc_mcu7t5v0__fill_2
XTAP_TAPCELL_ROW_61_663 VDD VSS gf180mcu_fd_sc_mcu7t5v0__filltie
XTAP_TAPCELL_ROW_69_730 VDD VSS gf180mcu_fd_sc_mcu7t5v0__filltie
XFILLER_54_451 VDD VDD VSS VSS gf180mcu_fd_sc_mcu7t5v0__fillcap_4
XFILLER_41_86 VDD VDD VSS VSS gf180mcu_fd_sc_mcu7t5v0__fillcap_16
XFILLER_10_521 VDD VDD VSS VSS gf180mcu_fd_sc_mcu7t5v0__fillcap_4
XTAP_TAPCELL_ROW_24_365 VDD VSS gf180mcu_fd_sc_mcu7t5v0__filltie
XTAP_TAPCELL_ROW_75_777 VDD VSS gf180mcu_fd_sc_mcu7t5v0__filltie
XFILLER_49_267 VDD VDD VSS VSS gf180mcu_fd_sc_mcu7t5v0__fill_2
XFILLER_49_278 VDD VDD VSS VSS gf180mcu_fd_sc_mcu7t5v0__fill_2
X_0952_ _0952_/A1 _1083_/A2 _1237_/B1 _1517_/Q _0953_/A4 VDD VDD VSS VSS gf180mcu_fd_sc_mcu7t5v0__aoi22_1
XFILLER_9_352 VDD VDD VSS VSS gf180mcu_fd_sc_mcu7t5v0__fillcap_16
X_0883_ _1252_/A1 _1557_/Q _0883_/A3 _0920_/A2 VDD VDD VSS VSS gf180mcu_fd_sc_mcu7t5v0__nand3_4
XFILLER_56_2 VDD VDD VSS VSS gf180mcu_fd_sc_mcu7t5v0__fillcap_4
X_1504_ _1504_/D wire829/I _1629_/CLK _1504_/Q VDD VDD VSS VSS gf180mcu_fd_sc_mcu7t5v0__dffrnq_2
XFILLER_68_543 VDD VDD VSS VSS gf180mcu_fd_sc_mcu7t5v0__fill_1
XTAP_TAPCELL_ROW_66_700 VDD VSS gf180mcu_fd_sc_mcu7t5v0__filltie
XFILLER_28_407 VDD VDD VSS VSS gf180mcu_fd_sc_mcu7t5v0__fillcap_8
X_1435_ _0749_/Z _1435_/A2 _1445_/A3 _1437_/S VDD VDD VSS VSS gf180mcu_fd_sc_mcu7t5v0__nand3_4
X_1366_ _1669_/Q wire741/Z _1372_/S _1669_/D VDD VDD VSS VSS gf180mcu_fd_sc_mcu7t5v0__mux2_2
XFILLER_55_259 VDD VDD VSS VSS gf180mcu_fd_sc_mcu7t5v0__fillcap_4
XTAP_TAPCELL_ROW_38_479 VDD VSS gf180mcu_fd_sc_mcu7t5v0__filltie
XFILLER_36_451 VDD VDD VSS VSS gf180mcu_fd_sc_mcu7t5v0__fillcap_4
X_1297_ _1619_/Q wire747/Z _1303_/S _1619_/D VDD VDD VSS VSS gf180mcu_fd_sc_mcu7t5v0__mux2_2
XTAP_TAPCELL_ROW_21_346 VDD VSS gf180mcu_fd_sc_mcu7t5v0__filltie
XFILLER_54_281 VDD VDD VSS VSS gf180mcu_fd_sc_mcu7t5v0__fill_1
XFILLER_14_123 VDD VDD VSS VSS gf180mcu_fd_sc_mcu7t5v0__fillcap_8
Xinput17 cal_phase0_offset_x[20] input17/Z VDD VDD VSS VSS gf180mcu_fd_sc_mcu7t5v0__buf_1
Xinput28 cal_phase0_offset_y[11] input28/Z VDD VDD VSS VSS gf180mcu_fd_sc_mcu7t5v0__buf_1
Xinput39 cal_phase0_offset_y[2] input39/Z VDD VDD VSS VSS gf180mcu_fd_sc_mcu7t5v0__buf_1
XFILLER_6_311 VDD VDD VSS VSS gf180mcu_fd_sc_mcu7t5v0__fillcap_4
Xwire754 wire754/I wire754/Z VDD VDD VSS VSS gf180mcu_fd_sc_mcu7t5v0__buf_1
Xwire710 wire711/Z wire710/Z VDD VDD VSS VSS gf180mcu_fd_sc_mcu7t5v0__buf_1
XFILLER_77_384 VDD VDD VSS VSS gf180mcu_fd_sc_mcu7t5v0__fillcap_16
Xload_slew726 _1266_/I1 wire725/I VDD VDD VSS VSS gf180mcu_fd_sc_mcu7t5v0__clkbuf_2
X_1151_ _1151_/A1 _1177_/B _1151_/B1 _1151_/B2 _1152_/I0 VDD VDD VSS VSS gf180mcu_fd_sc_mcu7t5v0__aoi22_1
X_1220_ _1616_/Q _1220_/A2 _1220_/B1 _1220_/B2 _1233_/A1 VDD VDD VSS VSS gf180mcu_fd_sc_mcu7t5v0__aoi22_1
Xload_slew759 _0774_/I0 _1457_/I0 VDD VDD VSS VSS gf180mcu_fd_sc_mcu7t5v0__clkbuf_2
XFILLER_80_527 VDD VDD VSS VSS gf180mcu_fd_sc_mcu7t5v0__fillcap_32
X_1082_ input57/Z wire529/Z _1231_/A2 input7/Z _1082_/C1 wire541/I _1084_/A3 VDD VDD
+ VSS VSS gf180mcu_fd_sc_mcu7t5v0__aoi222_1
XFILLER_52_207 VDD VDD VSS VSS gf180mcu_fd_sc_mcu7t5v0__fill_2
XFILLER_45_270 VDD VDD VSS VSS gf180mcu_fd_sc_mcu7t5v0__fill_1
X_0866_ _0866_/A1 _0921_/A2 _1194_/A2 VDD VDD VSS VSS gf180mcu_fd_sc_mcu7t5v0__nor2_4
X_0935_ _1509_/Q _1119_/A2 _1200_/C1 _1488_/Q _0935_/C1 _0935_/C2 _0936_/A4 VDD VDD
+ VSS VSS gf180mcu_fd_sc_mcu7t5v0__aoi222_2
X_0797_ _1554_/Q _0782_/B _0805_/B _1600_/Q _0798_/B VDD VDD VSS VSS gf180mcu_fd_sc_mcu7t5v0__aoi22_1
XFILLER_28_259 VDD VDD VSS VSS gf180mcu_fd_sc_mcu7t5v0__fill_2
X_1349_ wire685/I _1350_/S _1349_/B _1657_/D VDD VDD VSS VSS gf180mcu_fd_sc_mcu7t5v0__aoi21_1
X_1418_ _1576_/Q _1577_/Q _1593_/Q _1418_/A4 _1424_/S VDD VDD VSS VSS gf180mcu_fd_sc_mcu7t5v0__nand4_4
XFILLER_51_273 VDD VDD VSS VSS gf180mcu_fd_sc_mcu7t5v0__fillcap_4
XFILLER_24_432 VDD VDD VSS VSS gf180mcu_fd_sc_mcu7t5v0__fill_2
XFILLER_24_454 VDD VDD VSS VSS gf180mcu_fd_sc_mcu7t5v0__fill_1
XFILLER_24_465 VDD VDD VSS VSS gf180mcu_fd_sc_mcu7t5v0__fillcap_4
XFILLER_74_387 VDD VDD VSS VSS gf180mcu_fd_sc_mcu7t5v0__fillcap_8
XFILLER_62_527 VDD VDD VSS VSS gf180mcu_fd_sc_mcu7t5v0__fillcap_8
XFILLER_47_535 VDD VDD VSS VSS gf180mcu_fd_sc_mcu7t5v0__fill_1
XFILLER_47_41 VDD VDD VSS VSS gf180mcu_fd_sc_mcu7t5v0__fillcap_16
Xwire551 wire551/I wire551/Z VDD VDD VSS VSS gf180mcu_fd_sc_mcu7t5v0__buf_2
XFILLER_42_273 VDD VDD VSS VSS gf180mcu_fd_sc_mcu7t5v0__fill_1
XTAP_TAPCELL_ROW_40_496 VDD VSS gf180mcu_fd_sc_mcu7t5v0__filltie
Xload_slew523 _1226_/B1 _1147_/B1 VDD VDD VSS VSS gf180mcu_fd_sc_mcu7t5v0__buf_2
Xwire573 wire573/I wire573/Z VDD VDD VSS VSS gf180mcu_fd_sc_mcu7t5v0__buf_2
Xload_slew512 _1116_/B1 _1079_/B1 VDD VDD VSS VSS gf180mcu_fd_sc_mcu7t5v0__buf_2
XFILLER_10_181 VDD VDD VSS VSS gf180mcu_fd_sc_mcu7t5v0__fill_2
Xload_slew567 _1227_/B1 _1123_/A2 VDD VDD VSS VSS gf180mcu_fd_sc_mcu7t5v0__buf_2
Xload_slew545 _1090_/B1 _1221_/B1 VDD VDD VSS VSS gf180mcu_fd_sc_mcu7t5v0__buf_2
Xload_slew556 wire557/I _1199_/B1 VDD VDD VSS VSS gf180mcu_fd_sc_mcu7t5v0__buf_2
Xload_slew534 _1050_/B1 _1207_/A2 VDD VDD VSS VSS gf180mcu_fd_sc_mcu7t5v0__buf_2
X_1134_ _1134_/A1 _1185_/B1 wire552/I _1134_/B2 _1146_/A3 VDD VDD VSS VSS gf180mcu_fd_sc_mcu7t5v0__aoi22_1
Xload_slew578 _1185_/B1 _1218_/A2 VDD VDD VSS VSS gf180mcu_fd_sc_mcu7t5v0__buf_2
X_1203_ _1665_/Q _1229_/B1 wire547/Z input64/Z _1206_/A2 VDD VDD VSS VSS gf180mcu_fd_sc_mcu7t5v0__aoi22_1
Xload_slew589 _1119_/A2 _1216_/A2 VDD VDD VSS VSS gf180mcu_fd_sc_mcu7t5v0__buf_2
XFILLER_19_2 VDD VDD VSS VSS gf180mcu_fd_sc_mcu7t5v0__fillcap_4
XFILLER_53_527 VDD VDD VSS VSS gf180mcu_fd_sc_mcu7t5v0__fill_1
XTAP_TAPCELL_ROW_48_563 VDD VSS gf180mcu_fd_sc_mcu7t5v0__filltie
X_1065_ input70/Z _1140_/A2 _1224_/A2 _1478_/Q _1102_/A1 VDD VDD VSS VSS gf180mcu_fd_sc_mcu7t5v0__aoi22_1
XFILLER_21_402 VDD VDD VSS VSS gf180mcu_fd_sc_mcu7t5v0__fill_2
X_0918_ _0918_/A1 _0923_/A1 wire520/I VDD VDD VSS VSS gf180mcu_fd_sc_mcu7t5v0__nor2_4
X_0849_ _0849_/A1 _0857_/A1 wire600/I VDD VDD VSS VSS gf180mcu_fd_sc_mcu7t5v0__nor2_4
Xinput207 raw_edge2_x[17] _1002_/B2 VDD VDD VSS VSS gf180mcu_fd_sc_mcu7t5v0__buf_1
Xinput229 raw_edge2_y[18] _1054_/B2 VDD VDD VSS VSS gf180mcu_fd_sc_mcu7t5v0__buf_1
Xinput218 raw_edge2_x[8] _0942_/B2 VDD VDD VSS VSS gf180mcu_fd_sc_mcu7t5v0__buf_1
XFILLER_71_346 VDD VDD VSS VSS gf180mcu_fd_sc_mcu7t5v0__fillcap_4
XFILLER_68_192 VDD VDD VSS VSS gf180mcu_fd_sc_mcu7t5v0__fillcap_32
XFILLER_44_527 VDD VDD VSS VSS gf180mcu_fd_sc_mcu7t5v0__fill_2
XTAP_TAPCELL_ROW_3_199 VDD VSS gf180mcu_fd_sc_mcu7t5v0__filltie
XFILLER_17_33 VDD VDD VSS VSS gf180mcu_fd_sc_mcu7t5v0__fill_2
XFILLER_16_229 VDD VDD VSS VSS gf180mcu_fd_sc_mcu7t5v0__fill_1
XPHY_EDGE_ROW_49_Left_131 VDD VSS gf180mcu_fd_sc_mcu7t5v0__endcap
XFILLER_33_54 VDD VDD VSS VSS gf180mcu_fd_sc_mcu7t5v0__fillcap_4
XFILLER_24_262 VDD VDD VSS VSS gf180mcu_fd_sc_mcu7t5v0__fillcap_4
XFILLER_66_107 VDD VDD VSS VSS gf180mcu_fd_sc_mcu7t5v0__fillcap_16
XFILLER_66_129 VDD VDD VSS VSS gf180mcu_fd_sc_mcu7t5v0__fill_1
XPHY_EDGE_ROW_58_Left_140 VDD VSS gf180mcu_fd_sc_mcu7t5v0__endcap
XFILLER_47_310 VDD VDD VSS VSS gf180mcu_fd_sc_mcu7t5v0__fillcap_32
XFILLER_62_357 VDD VDD VSS VSS gf180mcu_fd_sc_mcu7t5v0__fillcap_4
XFILLER_62_313 VDD VDD VSS VSS gf180mcu_fd_sc_mcu7t5v0__fill_2
XTAP_TAPCELL_ROW_45_533 VDD VSS gf180mcu_fd_sc_mcu7t5v0__filltie
Xclkbuf_leaf_10_clk clkbuf_leaf_9_clk/I _1624_/CLK VDD VDD VSS VSS gf180mcu_fd_sc_mcu7t5v0__clkbuf_8
X_1117_ _1117_/A1 wire541/Z _1117_/B1 _1658_/Q _1118_/A4 VDD VDD VSS VSS gf180mcu_fd_sc_mcu7t5v0__aoi22_1
XFILLER_38_387 VDD VDD VSS VSS gf180mcu_fd_sc_mcu7t5v0__fillcap_16
XTAP_TAPCELL_ROW_0_169 VDD VSS gf180mcu_fd_sc_mcu7t5v0__filltie
X_1048_ _1543_/Q _1125_/B1 _1224_/A2 _1477_/Q _1049_/A3 VDD VDD VSS VSS gf180mcu_fd_sc_mcu7t5v0__aoi22_1
XPHY_EDGE_ROW_3_Right_3 VDD VSS gf180mcu_fd_sc_mcu7t5v0__endcap
XTAP_TAPCELL_ROW_8_236 VDD VSS gf180mcu_fd_sc_mcu7t5v0__filltie
XTAP_TAPCELL_ROW_59_647 VDD VSS gf180mcu_fd_sc_mcu7t5v0__filltie
XFILLER_48_107 VDD VDD VSS VSS gf180mcu_fd_sc_mcu7t5v0__fillcap_8
XFILLER_44_379 VDD VDD VSS VSS gf180mcu_fd_sc_mcu7t5v0__fillcap_4
XFILLER_44_313 VDD VDD VSS VSS gf180mcu_fd_sc_mcu7t5v0__fill_2
XTAP_TAPCELL_ROW_42_514 VDD VSS gf180mcu_fd_sc_mcu7t5v0__filltie
XFILLER_17_516 VDD VDD VSS VSS gf180mcu_fd_sc_mcu7t5v0__fill_1
XFILLER_8_247 VDD VDD VSS VSS gf180mcu_fd_sc_mcu7t5v0__fillcap_64
XFILLER_79_276 VDD VDD VSS VSS gf180mcu_fd_sc_mcu7t5v0__fillcap_4
XFILLER_69_72 VDD VDD VSS VSS gf180mcu_fd_sc_mcu7t5v0__fillcap_64
XFILLER_67_427 VDD VDD VSS VSS gf180mcu_fd_sc_mcu7t5v0__fill_2
XTAP_TAPCELL_ROW_13_282 VDD VSS gf180mcu_fd_sc_mcu7t5v0__filltie
X_1666_ _1666_/D _1666_/RN clkload0/I _1666_/Q VDD VDD VSS VSS gf180mcu_fd_sc_mcu7t5v0__dffrnq_1
X_1597_ _1597_/D wire880/I _1597_/CLK _1598_/D VDD VDD VSS VSS gf180mcu_fd_sc_mcu7t5v0__dffrnq_1
Xfanout727 _1588_/Q wire729/I VDD VDD VSS VSS gf180mcu_fd_sc_mcu7t5v0__dlyb_1
XTAP_TAPCELL_ROW_5_217 VDD VSS gf180mcu_fd_sc_mcu7t5v0__filltie
XFILLER_81_441 VDD VDD VSS VSS gf180mcu_fd_sc_mcu7t5v0__fill_1
XFILLER_53_154 VDD VDD VSS VSS gf180mcu_fd_sc_mcu7t5v0__fill_2
XFILLER_41_349 VDD VDD VSS VSS gf180mcu_fd_sc_mcu7t5v0__fill_1
XFILLER_41_327 VDD VDD VSS VSS gf180mcu_fd_sc_mcu7t5v0__fillcap_4
XFILLER_5_206 VDD VDD VSS VSS gf180mcu_fd_sc_mcu7t5v0__fillcap_4
XFILLER_14_45 VDD VDD VSS VSS gf180mcu_fd_sc_mcu7t5v0__fill_2
XFILLER_14_34 VDD VDD VSS VSS gf180mcu_fd_sc_mcu7t5v0__fill_1
XFILLER_30_99 VDD VDD VSS VSS gf180mcu_fd_sc_mcu7t5v0__fillcap_4
XFILLER_44_121 VDD VDD VSS VSS gf180mcu_fd_sc_mcu7t5v0__fill_1
XFILLER_72_452 VDD VDD VSS VSS gf180mcu_fd_sc_mcu7t5v0__fill_2
X_1520_ _1520_/D _1520_/RN clkload4/I _1520_/Q VDD VDD VSS VSS gf180mcu_fd_sc_mcu7t5v0__dffrnq_1
Xoutput319 _1614_/Q cfg_f_MEMS_fcw_x[5] VDD VDD VSS VSS gf180mcu_fd_sc_mcu7t5v0__buf_2
Xoutput308 _1609_/Q cfg_f_MEMS_fcw_x[0] VDD VDD VSS VSS gf180mcu_fd_sc_mcu7t5v0__buf_2
XTAP_TAPCELL_ROW_10_252 VDD VSS gf180mcu_fd_sc_mcu7t5v0__filltie
XFILLER_67_235 VDD VDD VSS VSS gf180mcu_fd_sc_mcu7t5v0__fill_1
X_1382_ _1576_/Q _1577_/Q _1593_/Q _1382_/A4 _1389_/S VDD VDD VSS VSS gf180mcu_fd_sc_mcu7t5v0__nand4_4
X_1451_ _1461_/I0 _1521_/Q _1454_/S _1521_/D VDD VDD VSS VSS gf180mcu_fd_sc_mcu7t5v0__mux2_2
XTAP_TAPCELL_ROW_78_797 VDD VSS gf180mcu_fd_sc_mcu7t5v0__filltie
XTAP_TAPCELL_ROW_61_664 VDD VSS gf180mcu_fd_sc_mcu7t5v0__filltie
XFILLER_50_168 VDD VDD VSS VSS gf180mcu_fd_sc_mcu7t5v0__fillcap_4
X_1649_ _1649_/D wire794/Z _1674_/CLK _1649_/Q VDD VDD VSS VSS gf180mcu_fd_sc_mcu7t5v0__dffrnq_1
XTAP_TAPCELL_ROW_69_731 VDD VSS gf180mcu_fd_sc_mcu7t5v0__filltie
XFILLER_41_102 VDD VDD VSS VSS gf180mcu_fd_sc_mcu7t5v0__fillcap_8
XFILLER_14_327 VDD VDD VSS VSS gf180mcu_fd_sc_mcu7t5v0__fill_2
XTAP_TAPCELL_ROW_24_366 VDD VSS gf180mcu_fd_sc_mcu7t5v0__filltie
XFILLER_41_76 VDD VDD VSS VSS gf180mcu_fd_sc_mcu7t5v0__fill_1
XFILLER_10_544 VDD VDD VSS VSS gf180mcu_fd_sc_mcu7t5v0__fill_1
XFILLER_2_26 VDD VDD VSS VSS gf180mcu_fd_sc_mcu7t5v0__fillcap_8
XFILLER_2_37 VDD VDD VSS VSS gf180mcu_fd_sc_mcu7t5v0__fillcap_64
XTAP_TAPCELL_ROW_75_778 VDD VSS gf180mcu_fd_sc_mcu7t5v0__filltie
XFILLER_45_496 VDD VDD VSS VSS gf180mcu_fd_sc_mcu7t5v0__fill_1
X_0882_ _0922_/A1 _0923_/A2 _1227_/B1 VDD VDD VSS VSS gf180mcu_fd_sc_mcu7t5v0__nor2_4
X_0951_ input87/Z _0951_/A2 _1117_/B1 _0951_/B2 _0953_/A3 VDD VDD VSS VSS gf180mcu_fd_sc_mcu7t5v0__aoi22_1
XFILLER_9_320 VDD VDD VSS VSS gf180mcu_fd_sc_mcu7t5v0__fill_1
XFILLER_49_2 VDD VDD VSS VSS gf180mcu_fd_sc_mcu7t5v0__fillcap_4
X_1503_ _1503_/D _1503_/RN _1624_/CLK _1503_/Q VDD VDD VSS VSS gf180mcu_fd_sc_mcu7t5v0__dffrnq_1
XTAP_TAPCELL_ROW_66_701 VDD VSS gf180mcu_fd_sc_mcu7t5v0__filltie
XFILLER_55_216 VDD VDD VSS VSS gf180mcu_fd_sc_mcu7t5v0__fill_2
XFILLER_55_205 VDD VDD VSS VSS gf180mcu_fd_sc_mcu7t5v0__fillcap_4
X_1296_ _1618_/Q _1306_/I0 _1303_/S _1618_/D VDD VDD VSS VSS gf180mcu_fd_sc_mcu7t5v0__mux2_2
X_1365_ _1668_/Q _1365_/I1 _1371_/S _1668_/D VDD VDD VSS VSS gf180mcu_fd_sc_mcu7t5v0__mux2_2
X_1434_ _1508_/Q wire733/Z _1434_/S _1508_/D VDD VDD VSS VSS gf180mcu_fd_sc_mcu7t5v0__mux2_2
XFILLER_63_282 VDD VDD VSS VSS gf180mcu_fd_sc_mcu7t5v0__fillcap_64
XFILLER_63_271 VDD VDD VSS VSS gf180mcu_fd_sc_mcu7t5v0__fillcap_8
XFILLER_63_260 VDD VDD VSS VSS gf180mcu_fd_sc_mcu7t5v0__fill_2
XFILLER_51_400 VDD VDD VSS VSS gf180mcu_fd_sc_mcu7t5v0__fill_1
XFILLER_23_146 VDD VDD VSS VSS gf180mcu_fd_sc_mcu7t5v0__fill_2
XTAP_TAPCELL_ROW_21_347 VDD VSS gf180mcu_fd_sc_mcu7t5v0__filltie
XPHY_EDGE_ROW_21_Left_103 VDD VSS gf180mcu_fd_sc_mcu7t5v0__endcap
XFILLER_46_238 VDD VDD VSS VSS gf180mcu_fd_sc_mcu7t5v0__fillcap_4
XFILLER_42_411 VDD VDD VSS VSS gf180mcu_fd_sc_mcu7t5v0__fillcap_8
XFILLER_14_102 VDD VDD VSS VSS gf180mcu_fd_sc_mcu7t5v0__fill_2
XFILLER_19_419 VDD VDD VSS VSS gf180mcu_fd_sc_mcu7t5v0__fill_1
XTAP_TAPCELL_ROW_72_748 VDD VSS gf180mcu_fd_sc_mcu7t5v0__filltie
Xwire711 wire711/I wire711/Z VDD VDD VSS VSS gf180mcu_fd_sc_mcu7t5v0__clkbuf_2
Xinput18 cal_phase0_offset_x[2] input18/Z VDD VDD VSS VSS gf180mcu_fd_sc_mcu7t5v0__buf_1
Xwire733 wire734/Z wire733/Z VDD VDD VSS VSS gf180mcu_fd_sc_mcu7t5v0__clkbuf_2
XPHY_EDGE_ROW_30_Left_112 VDD VSS gf180mcu_fd_sc_mcu7t5v0__endcap
XFILLER_14_157 VDD VDD VSS VSS gf180mcu_fd_sc_mcu7t5v0__fill_2
Xwire700 _1614_/Q wire700/Z VDD VDD VSS VSS gf180mcu_fd_sc_mcu7t5v0__buf_2
Xinput29 cal_phase0_offset_y[12] input29/Z VDD VDD VSS VSS gf180mcu_fd_sc_mcu7t5v0__buf_1
Xload_slew705 wire706/Z _1417_/I1 VDD VDD VSS VSS gf180mcu_fd_sc_mcu7t5v0__clkbuf_2
XFILLER_77_352 VDD VDD VSS VSS gf180mcu_fd_sc_mcu7t5v0__fillcap_32
XFILLER_77_72 VDD VDD VSS VSS gf180mcu_fd_sc_mcu7t5v0__fillcap_64
X_1150_ _1150_/A1 _1150_/A2 _1150_/A3 _1150_/A4 _1151_/B2 VDD VDD VSS VSS gf180mcu_fd_sc_mcu7t5v0__nor4_4
XFILLER_37_205 VDD VDD VSS VSS gf180mcu_fd_sc_mcu7t5v0__fillcap_4
Xload_slew749 wire750/Z _1467_/I0 VDD VDD VSS VSS gf180mcu_fd_sc_mcu7t5v0__buf_2
Xload_slew738 _1358_/I1 wire737/I VDD VDD VSS VSS gf180mcu_fd_sc_mcu7t5v0__buf_2
X_1081_ _1081_/A1 _1081_/A2 _1081_/A3 _1081_/A4 _1085_/A1 VDD VDD VSS VSS gf180mcu_fd_sc_mcu7t5v0__nand4_1
XFILLER_45_282 VDD VDD VSS VSS gf180mcu_fd_sc_mcu7t5v0__fillcap_16
XFILLER_33_422 VDD VDD VSS VSS gf180mcu_fd_sc_mcu7t5v0__fill_2
X_0865_ _0893_/A1 _0865_/A2 wire585/I VDD VDD VSS VSS gf180mcu_fd_sc_mcu7t5v0__nor2_4
X_0934_ input54/Z wire529/I _1116_/B1 _1483_/Q _1625_/Q wire548/Z _0936_/A3 VDD VDD
+ VSS VSS gf180mcu_fd_sc_mcu7t5v0__aoi222_1
X_0796_ _1553_/Q _1567_/Q _0796_/S _1553_/D VDD VDD VSS VSS gf180mcu_fd_sc_mcu7t5v0__mux2_2
X_1417_ _1417_/I0 _1417_/I1 _1417_/S _1495_/D VDD VDD VSS VSS gf180mcu_fd_sc_mcu7t5v0__mux2_2
X_1279_ _1605_/Q wire736/Z _1282_/S _1605_/D VDD VDD VSS VSS gf180mcu_fd_sc_mcu7t5v0__mux2_2
X_1348_ _1657_/Q _1350_/S _1349_/B VDD VDD VSS VSS gf180mcu_fd_sc_mcu7t5v0__nor2_1
XFILLER_51_296 VDD VDD VSS VSS gf180mcu_fd_sc_mcu7t5v0__fillcap_32
XTAP_TAPCELL_ROW_34_450 VDD VSS gf180mcu_fd_sc_mcu7t5v0__filltie
XFILLER_74_311 VDD VDD VSS VSS gf180mcu_fd_sc_mcu7t5v0__fillcap_4
XFILLER_59_352 VDD VDD VSS VSS gf180mcu_fd_sc_mcu7t5v0__fill_2
XFILLER_62_539 VDD VDD VSS VSS gf180mcu_fd_sc_mcu7t5v0__fill_2
XFILLER_42_263 VDD VDD VSS VSS gf180mcu_fd_sc_mcu7t5v0__fillcap_8
XFILLER_15_422 VDD VDD VSS VSS gf180mcu_fd_sc_mcu7t5v0__fillcap_16
Xwire585 wire585/I wire585/Z VDD VDD VSS VSS gf180mcu_fd_sc_mcu7t5v0__buf_2
Xwire541 wire541/I wire541/Z VDD VDD VSS VSS gf180mcu_fd_sc_mcu7t5v0__buf_2
Xwire552 wire552/I wire552/Z VDD VDD VSS VSS gf180mcu_fd_sc_mcu7t5v0__buf_2
Xwire574 wire574/I wire574/Z VDD VDD VSS VSS gf180mcu_fd_sc_mcu7t5v0__buf_2
XTAP_TAPCELL_ROW_40_497 VDD VSS gf180mcu_fd_sc_mcu7t5v0__filltie
XFILLER_8_14 VDD VDD VSS VSS gf180mcu_fd_sc_mcu7t5v0__fill_2
Xload_slew513 _1056_/B1 _1128_/C1 VDD VDD VSS VSS gf180mcu_fd_sc_mcu7t5v0__buf_2
Xload_slew524 _1073_/B1 _1117_/B1 VDD VDD VSS VSS gf180mcu_fd_sc_mcu7t5v0__buf_2
Xload_slew546 _0980_/B1 _1112_/A2 VDD VDD VSS VSS gf180mcu_fd_sc_mcu7t5v0__buf_2
XFILLER_2_381 VDD VDD VSS VSS gf180mcu_fd_sc_mcu7t5v0__fillcap_4
XFILLER_80_303 VDD VDD VSS VSS gf180mcu_fd_sc_mcu7t5v0__fillcap_4
X_1133_ _1133_/A1 _1133_/A2 wire547/Z input62/Z _1146_/A2 VDD VDD VSS VSS gf180mcu_fd_sc_mcu7t5v0__aoi22_2
X_1202_ _1481_/Q _1202_/A2 wire558/Z _1202_/B2 _1210_/A1 VDD VDD VSS VSS gf180mcu_fd_sc_mcu7t5v0__aoi22_1
X_1064_ _1507_/Q _1143_/A2 _1177_/B _1081_/A1 VDD VDD VSS VSS gf180mcu_fd_sc_mcu7t5v0__aoi21_1
XTAP_TAPCELL_ROW_31_420 VDD VSS gf180mcu_fd_sc_mcu7t5v0__filltie
X_0779_ wire774/Z _1546_/Q _0781_/S _1546_/D VDD VDD VSS VSS gf180mcu_fd_sc_mcu7t5v0__mux2_2
X_0848_ _0848_/A1 _0910_/A1 _1222_/A2 VDD VDD VSS VSS gf180mcu_fd_sc_mcu7t5v0__nor2_4
X_0917_ _0840_/Z _0921_/A2 _1226_/B1 VDD VDD VSS VSS gf180mcu_fd_sc_mcu7t5v0__nor2_4
Xinput208 raw_edge2_x[18] _1055_/A1 VDD VDD VSS VSS gf180mcu_fd_sc_mcu7t5v0__buf_1
Xinput219 raw_edge2_x[9] _1009_/A1 VDD VDD VSS VSS gf180mcu_fd_sc_mcu7t5v0__buf_1
XFILLER_17_89 VDD VDD VSS VSS gf180mcu_fd_sc_mcu7t5v0__fill_1
XFILLER_16_219 VDD VDD VSS VSS gf180mcu_fd_sc_mcu7t5v0__fillcap_8
XFILLER_33_66 VDD VDD VSS VSS gf180mcu_fd_sc_mcu7t5v0__fillcap_4
XFILLER_12_447 VDD VDD VSS VSS gf180mcu_fd_sc_mcu7t5v0__fillcap_8
XFILLER_20_480 VDD VDD VSS VSS gf180mcu_fd_sc_mcu7t5v0__fill_2
XTAP_TAPCELL_ROW_45_534 VDD VSS gf180mcu_fd_sc_mcu7t5v0__filltie
XFILLER_43_550 VDD VDD VSS VSS gf180mcu_fd_sc_mcu7t5v0__fillcap_4
XFILLER_30_244 VDD VDD VSS VSS gf180mcu_fd_sc_mcu7t5v0__fill_1
XFILLER_30_277 VDD VDD VSS VSS gf180mcu_fd_sc_mcu7t5v0__fill_1
XFILLER_53_347 VDD VDD VSS VSS gf180mcu_fd_sc_mcu7t5v0__fill_2
XFILLER_53_314 VDD VDD VSS VSS gf180mcu_fd_sc_mcu7t5v0__fillcap_4
X_1116_ input92/Z _1221_/B1 _1116_/B1 _1487_/Q _1118_/A3 VDD VDD VSS VSS gf180mcu_fd_sc_mcu7t5v0__aoi22_1
X_1047_ _1047_/A1 wire603/Z _1069_/B1 _1548_/Q _1619_/Q wire604/Z _1049_/A2 VDD VDD
+ VSS VSS gf180mcu_fd_sc_mcu7t5v0__aoi222_2
XFILLER_0_70 VDD VDD VSS VSS gf180mcu_fd_sc_mcu7t5v0__fillcap_32
XFILLER_80_177 VDD VDD VSS VSS gf180mcu_fd_sc_mcu7t5v0__fillcap_64
XTAP_TAPCELL_ROW_8_237 VDD VSS gf180mcu_fd_sc_mcu7t5v0__filltie
XFILLER_0_104 VDD VDD VSS VSS gf180mcu_fd_sc_mcu7t5v0__fillcap_32
XTAP_TAPCELL_ROW_59_648 VDD VSS gf180mcu_fd_sc_mcu7t5v0__filltie
XFILLER_56_174 VDD VDD VSS VSS gf180mcu_fd_sc_mcu7t5v0__fill_1
XFILLER_48_119 VDD VDD VSS VSS gf180mcu_fd_sc_mcu7t5v0__fill_1
XFILLER_44_303 VDD VDD VSS VSS gf180mcu_fd_sc_mcu7t5v0__fill_2
XFILLER_28_88 VDD VDD VSS VSS gf180mcu_fd_sc_mcu7t5v0__fill_2
XFILLER_44_325 VDD VDD VSS VSS gf180mcu_fd_sc_mcu7t5v0__fillcap_16
XTAP_TAPCELL_ROW_42_515 VDD VSS gf180mcu_fd_sc_mcu7t5v0__filltie
XFILLER_60_53 VDD VDD VSS VSS gf180mcu_fd_sc_mcu7t5v0__fill_2
XPHY_EDGE_ROW_13_Right_13 VDD VSS gf180mcu_fd_sc_mcu7t5v0__endcap
XFILLER_79_2 VDD VDD VSS VSS gf180mcu_fd_sc_mcu7t5v0__fillcap_64
XFILLER_62_177 VDD VDD VSS VSS gf180mcu_fd_sc_mcu7t5v0__fillcap_16
XFILLER_50_317 VDD VDD VSS VSS gf180mcu_fd_sc_mcu7t5v0__fillcap_8
XTAP_TAPCELL_ROW_13_283 VDD VSS gf180mcu_fd_sc_mcu7t5v0__filltie
XPHY_EDGE_ROW_22_Right_22 VDD VSS gf180mcu_fd_sc_mcu7t5v0__endcap
X_1596_ _1596_/D wire876/I _1597_/CLK _1596_/Q VDD VDD VSS VSS gf180mcu_fd_sc_mcu7t5v0__dffsnq_1
X_1665_ _1665_/D _1665_/RN clkload0/I _1665_/Q VDD VDD VSS VSS gf180mcu_fd_sc_mcu7t5v0__dffrnq_1
XPHY_EDGE_ROW_31_Right_31 VDD VSS gf180mcu_fd_sc_mcu7t5v0__endcap
XTAP_TAPCELL_ROW_5_218 VDD VSS gf180mcu_fd_sc_mcu7t5v0__filltie
XPHY_EDGE_ROW_77_Left_159 VDD VSS gf180mcu_fd_sc_mcu7t5v0__endcap
XTAP_TAPCELL_ROW_64_684 VDD VSS gf180mcu_fd_sc_mcu7t5v0__filltie
XFILLER_53_166 VDD VDD VSS VSS gf180mcu_fd_sc_mcu7t5v0__fillcap_16
XFILLER_41_339 VDD VDD VSS VSS gf180mcu_fd_sc_mcu7t5v0__fillcap_8
XFILLER_38_174 VDD VDD VSS VSS gf180mcu_fd_sc_mcu7t5v0__fill_1
XFILLER_22_531 VDD VDD VSS VSS gf180mcu_fd_sc_mcu7t5v0__fill_1
XFILLER_26_314 VDD VDD VSS VSS gf180mcu_fd_sc_mcu7t5v0__fill_1
XPHY_EDGE_ROW_40_Right_40 VDD VSS gf180mcu_fd_sc_mcu7t5v0__endcap
XFILLER_30_56 VDD VDD VSS VSS gf180mcu_fd_sc_mcu7t5v0__fill_1
XFILLER_76_247 VDD VDD VSS VSS gf180mcu_fd_sc_mcu7t5v0__fillcap_64
XFILLER_39_76 VDD VDD VSS VSS gf180mcu_fd_sc_mcu7t5v0__fill_2
XFILLER_44_177 VDD VDD VSS VSS gf180mcu_fd_sc_mcu7t5v0__fillcap_64
XFILLER_32_317 VDD VDD VSS VSS gf180mcu_fd_sc_mcu7t5v0__fill_2
X_1450_ wire690/Z _1454_/S _1450_/B _1520_/D VDD VDD VSS VSS gf180mcu_fd_sc_mcu7t5v0__oai21_1
Xoutput309 _1603_/Q cfg_f_MEMS_fcw_x[10] VDD VDD VSS VSS gf180mcu_fd_sc_mcu7t5v0__buf_2
XTAP_TAPCELL_ROW_10_253 VDD VSS gf180mcu_fd_sc_mcu7t5v0__filltie
XFILLER_67_258 VDD VDD VSS VSS gf180mcu_fd_sc_mcu7t5v0__fillcap_8
XFILLER_67_225 VDD VDD VSS VSS gf180mcu_fd_sc_mcu7t5v0__fill_1
X_1381_ _1679_/Q wire737/Z _1381_/S _1679_/D VDD VDD VSS VSS gf180mcu_fd_sc_mcu7t5v0__mux2_2
XTAP_TAPCELL_ROW_78_798 VDD VSS gf180mcu_fd_sc_mcu7t5v0__filltie
XFILLER_50_147 VDD VDD VSS VSS gf180mcu_fd_sc_mcu7t5v0__fillcap_4
XFILLER_35_144 VDD VDD VSS VSS gf180mcu_fd_sc_mcu7t5v0__fill_1
XTAP_TAPCELL_ROW_18_320 VDD VSS gf180mcu_fd_sc_mcu7t5v0__filltie
XTAP_TAPCELL_ROW_61_665 VDD VSS gf180mcu_fd_sc_mcu7t5v0__filltie
X_1579_ _1579_/D wire840/I _1593_/CLK _1579_/Q VDD VDD VSS VSS gf180mcu_fd_sc_mcu7t5v0__dffrnq_4
X_1648_ _1648_/D _1648_/RN _1663_/CLK _1648_/Q VDD VDD VSS VSS gf180mcu_fd_sc_mcu7t5v0__dffrnq_2
XFILLER_73_206 VDD VDD VSS VSS gf180mcu_fd_sc_mcu7t5v0__fillcap_4
XFILLER_66_280 VDD VDD VSS VSS gf180mcu_fd_sc_mcu7t5v0__fill_1
XFILLER_58_247 VDD VDD VSS VSS gf180mcu_fd_sc_mcu7t5v0__fill_1
XFILLER_58_225 VDD VDD VSS VSS gf180mcu_fd_sc_mcu7t5v0__fill_2
XFILLER_26_111 VDD VDD VSS VSS gf180mcu_fd_sc_mcu7t5v0__fill_2
XFILLER_41_114 VDD VDD VSS VSS gf180mcu_fd_sc_mcu7t5v0__fill_1
XFILLER_14_317 VDD VDD VSS VSS gf180mcu_fd_sc_mcu7t5v0__fill_2
XFILLER_22_383 VDD VDD VSS VSS gf180mcu_fd_sc_mcu7t5v0__fill_2
XTAP_TAPCELL_ROW_24_367 VDD VSS gf180mcu_fd_sc_mcu7t5v0__filltie
XFILLER_25_78 VDD VDD VSS VSS gf180mcu_fd_sc_mcu7t5v0__fill_1
XFILLER_26_177 VDD VDD VSS VSS gf180mcu_fd_sc_mcu7t5v0__fillcap_4
XFILLER_41_55 VDD VDD VSS VSS gf180mcu_fd_sc_mcu7t5v0__fillcap_8
XFILLER_9_2 VDD VDD VSS VSS gf180mcu_fd_sc_mcu7t5v0__fillcap_4
XFILLER_6_527 VDD VDD VSS VSS gf180mcu_fd_sc_mcu7t5v0__fill_1
XFILLER_77_556 VDD VDD VSS VSS gf180mcu_fd_sc_mcu7t5v0__fillcap_4
XFILLER_49_269 VDD VDD VSS VSS gf180mcu_fd_sc_mcu7t5v0__fill_1
XFILLER_1_276 VDD VDD VSS VSS gf180mcu_fd_sc_mcu7t5v0__fillcap_4
XTAP_TAPCELL_ROW_75_779 VDD VSS gf180mcu_fd_sc_mcu7t5v0__filltie
XFILLER_45_486 VDD VDD VSS VSS gf180mcu_fd_sc_mcu7t5v0__fillcap_4
XFILLER_32_136 VDD VDD VSS VSS gf180mcu_fd_sc_mcu7t5v0__fillcap_8
XFILLER_32_103 VDD VDD VSS VSS gf180mcu_fd_sc_mcu7t5v0__fill_2
X_0881_ _0883_/A3 _0881_/A2 _0923_/A2 VDD VDD VSS VSS gf180mcu_fd_sc_mcu7t5v0__nand2_2
X_0950_ _0950_/A1 wire573/Z _1219_/B1 _1496_/Q _0953_/A2 VDD VDD VSS VSS gf180mcu_fd_sc_mcu7t5v0__aoi22_2
XFILLER_9_376 VDD VDD VSS VSS gf180mcu_fd_sc_mcu7t5v0__fillcap_4
XFILLER_68_523 VDD VDD VSS VSS gf180mcu_fd_sc_mcu7t5v0__fill_2
X_1502_ _1502_/D _1503_/RN _1624_/CLK _1502_/Q VDD VDD VSS VSS gf180mcu_fd_sc_mcu7t5v0__dffrnq_1
X_1433_ wire690/I _1434_/S _1433_/B _1507_/D VDD VDD VSS VSS gf180mcu_fd_sc_mcu7t5v0__aoi21_1
XTAP_TAPCELL_ROW_66_702 VDD VSS gf180mcu_fd_sc_mcu7t5v0__filltie
XFILLER_55_239 VDD VDD VSS VSS gf180mcu_fd_sc_mcu7t5v0__fill_2
X_1295_ wire698/Z wire771/Z _1303_/S _1617_/D VDD VDD VSS VSS gf180mcu_fd_sc_mcu7t5v0__mux2_2
X_1364_ _1667_/Q _1364_/I1 _1371_/S _1667_/D VDD VDD VSS VSS gf180mcu_fd_sc_mcu7t5v0__mux2_2
XFILLER_51_489 VDD VDD VSS VSS gf180mcu_fd_sc_mcu7t5v0__fill_1
XFILLER_23_169 VDD VDD VSS VSS gf180mcu_fd_sc_mcu7t5v0__fillcap_4
XTAP_TAPCELL_ROW_72_749 VDD VSS gf180mcu_fd_sc_mcu7t5v0__filltie
XTAP_TAPCELL_ROW_37_470 VDD VSS gf180mcu_fd_sc_mcu7t5v0__filltie
XFILLER_36_77 VDD VDD VSS VSS gf180mcu_fd_sc_mcu7t5v0__fill_2
XTAP_TAPCELL_ROW_29_404 VDD VSS gf180mcu_fd_sc_mcu7t5v0__filltie
XFILLER_27_486 VDD VDD VSS VSS gf180mcu_fd_sc_mcu7t5v0__fillcap_4
Xinput19 cal_phase0_offset_x[3] input19/Z VDD VDD VSS VSS gf180mcu_fd_sc_mcu7t5v0__buf_1
XFILLER_52_43 VDD VDD VSS VSS gf180mcu_fd_sc_mcu7t5v0__fillcap_16
Xwire734 wire734/I wire734/Z VDD VDD VSS VSS gf180mcu_fd_sc_mcu7t5v0__clkbuf_2
XFILLER_10_353 VDD VDD VSS VSS gf180mcu_fd_sc_mcu7t5v0__fillcap_32
Xload_slew717 _1267_/I1 wire716/I VDD VDD VSS VSS gf180mcu_fd_sc_mcu7t5v0__clkbuf_2
Xload_slew739 _1587_/Q _1461_/I0 VDD VDD VSS VSS gf180mcu_fd_sc_mcu7t5v0__buf_2
XFILLER_2_541 VDD VDD VSS VSS gf180mcu_fd_sc_mcu7t5v0__fill_1
Xload_slew728 wire729/Z _1415_/I1 VDD VDD VSS VSS gf180mcu_fd_sc_mcu7t5v0__clkbuf_2
X_1080_ _1080_/A1 _1169_/C2 _1197_/B1 _1080_/B2 _1081_/A4 VDD VDD VSS VSS gf180mcu_fd_sc_mcu7t5v0__aoi22_1
XFILLER_37_239 VDD VDD VSS VSS gf180mcu_fd_sc_mcu7t5v0__fill_2
XFILLER_60_286 VDD VDD VSS VSS gf180mcu_fd_sc_mcu7t5v0__fill_2
X_0795_ _0795_/A1 _0795_/A2 _0822_/B VDD VDD VSS VSS gf180mcu_fd_sc_mcu7t5v0__nand2_1
X_0933_ _0933_/A1 _1078_/A2 _1193_/B1 _0933_/B2 wire559/Z _0933_/C2 wire500/I VDD
+ VDD VSS VSS gf180mcu_fd_sc_mcu7t5v0__aoi222_4
X_0864_ _0864_/A1 _0921_/A2 wire586/I VDD VDD VSS VSS gf180mcu_fd_sc_mcu7t5v0__nor2_4
XFILLER_9_184 VDD VDD VSS VSS gf180mcu_fd_sc_mcu7t5v0__fillcap_16
X_1416_ _1494_/Q _1416_/I1 _1416_/S _1494_/D VDD VDD VSS VSS gf180mcu_fd_sc_mcu7t5v0__mux2_2
X_1347_ _1656_/Q wire741/Z _1350_/S _1656_/D VDD VDD VSS VSS gf180mcu_fd_sc_mcu7t5v0__mux2_2
XFILLER_43_209 VDD VDD VSS VSS gf180mcu_fd_sc_mcu7t5v0__fill_1
XFILLER_36_294 VDD VDD VSS VSS gf180mcu_fd_sc_mcu7t5v0__fill_2
XFILLER_36_261 VDD VDD VSS VSS gf180mcu_fd_sc_mcu7t5v0__fill_1
X_1278_ wire685/Z _1282_/S _1278_/B _1604_/D VDD VDD VSS VSS gf180mcu_fd_sc_mcu7t5v0__aoi21_1
XFILLER_24_434 VDD VDD VSS VSS gf180mcu_fd_sc_mcu7t5v0__fill_1
XFILLER_51_286 VDD VDD VSS VSS gf180mcu_fd_sc_mcu7t5v0__fill_2
XTAP_TAPCELL_ROW_34_451 VDD VSS gf180mcu_fd_sc_mcu7t5v0__filltie
XFILLER_47_548 VDD VDD VSS VSS gf180mcu_fd_sc_mcu7t5v0__fill_2
XFILLER_19_206 VDD VDD VSS VSS gf180mcu_fd_sc_mcu7t5v0__fillcap_4
XPHY_EDGE_ROW_69_Right_69 VDD VSS gf180mcu_fd_sc_mcu7t5v0__endcap
XFILLER_62_518 VDD VDD VSS VSS gf180mcu_fd_sc_mcu7t5v0__fillcap_4
XFILLER_15_478 VDD VDD VSS VSS gf180mcu_fd_sc_mcu7t5v0__fillcap_4
Xwire575 wire575/I wire575/Z VDD VDD VSS VSS gf180mcu_fd_sc_mcu7t5v0__buf_2
Xwire586 wire586/I wire586/Z VDD VDD VSS VSS gf180mcu_fd_sc_mcu7t5v0__buf_2
Xwire553 wire553/I wire553/Z VDD VDD VSS VSS gf180mcu_fd_sc_mcu7t5v0__buf_2
XTAP_TAPCELL_ROW_40_498 VDD VSS gf180mcu_fd_sc_mcu7t5v0__filltie
Xwire520 wire520/I wire520/Z VDD VDD VSS VSS gf180mcu_fd_sc_mcu7t5v0__buf_2
XFILLER_10_161 VDD VDD VSS VSS gf180mcu_fd_sc_mcu7t5v0__fillcap_8
XPHY_EDGE_ROW_78_Right_78 VDD VSS gf180mcu_fd_sc_mcu7t5v0__endcap
Xload_slew503 _0796_/S _0805_/B VDD VDD VSS VSS gf180mcu_fd_sc_mcu7t5v0__buf_2
Xload_slew514 _1023_/C1 _1241_/B1 VDD VDD VSS VSS gf180mcu_fd_sc_mcu7t5v0__buf_2
Xload_slew525 _1057_/A2 _1217_/B1 VDD VDD VSS VSS gf180mcu_fd_sc_mcu7t5v0__buf_2
X_1201_ _1201_/A1 _1201_/A2 _1201_/A3 wire490/Z _1211_/A2 VDD VDD VSS VSS gf180mcu_fd_sc_mcu7t5v0__nand4_1
Xload_slew569 wire570/Z _1176_/B1 VDD VDD VSS VSS gf180mcu_fd_sc_mcu7t5v0__buf_2
X_1063_ _1571_/Q wire642/Z _1111_/B VDD VDD VSS VSS gf180mcu_fd_sc_mcu7t5v0__nand2_1
X_1132_ input83/Z _1221_/A2 _1156_/B1 input8/Z _1146_/A1 VDD VDD VSS VSS gf180mcu_fd_sc_mcu7t5v0__aoi22_1
X_0916_ wire675/Z _0916_/A2 _1073_/B1 VDD VDD VSS VSS gf180mcu_fd_sc_mcu7t5v0__nor2_4
XTAP_TAPCELL_ROW_31_421 VDD VSS gf180mcu_fd_sc_mcu7t5v0__filltie
X_0847_ _1555_/Q _1248_/A1 _0881_/A2 _0910_/A1 VDD VDD VSS VSS gf180mcu_fd_sc_mcu7t5v0__nand3_4
X_0778_ wire734/Z _1545_/Q _0778_/S _1545_/D VDD VDD VSS VSS gf180mcu_fd_sc_mcu7t5v0__mux2_2
XFILLER_0_308 VDD VDD VSS VSS gf180mcu_fd_sc_mcu7t5v0__fillcap_32
XFILLER_56_312 VDD VDD VSS VSS gf180mcu_fd_sc_mcu7t5v0__fill_2
Xinput209 raw_edge2_x[19] _1078_/B2 VDD VDD VSS VSS gf180mcu_fd_sc_mcu7t5v0__buf_1
XFILLER_29_559 VDD VDD VSS VSS gf180mcu_fd_sc_mcu7t5v0__fill_1
XFILLER_37_570 VDD VDD VSS VSS gf180mcu_fd_sc_mcu7t5v0__fillcap_4
XFILLER_59_183 VDD VDD VSS VSS gf180mcu_fd_sc_mcu7t5v0__fillcap_16
XFILLER_58_75 VDD VDD VSS VSS gf180mcu_fd_sc_mcu7t5v0__fillcap_16
XFILLER_47_378 VDD VDD VSS VSS gf180mcu_fd_sc_mcu7t5v0__fill_1
XTAP_TAPCELL_ROW_45_535 VDD VSS gf180mcu_fd_sc_mcu7t5v0__filltie
XTAP_TAPCELL_ROW_2_190 VDD VSS gf180mcu_fd_sc_mcu7t5v0__filltie
XFILLER_15_220 VDD VDD VSS VSS gf180mcu_fd_sc_mcu7t5v0__fillcap_8
XFILLER_70_381 VDD VDD VSS VSS gf180mcu_fd_sc_mcu7t5v0__fillcap_4
XFILLER_43_562 VDD VDD VSS VSS gf180mcu_fd_sc_mcu7t5v0__fillcap_4
XFILLER_30_234 VDD VDD VSS VSS gf180mcu_fd_sc_mcu7t5v0__fillcap_8
XFILLER_11_492 VDD VDD VSS VSS gf180mcu_fd_sc_mcu7t5v0__fillcap_4
XFILLER_80_101 VDD VDD VSS VSS gf180mcu_fd_sc_mcu7t5v0__fillcap_4
XFILLER_65_186 VDD VDD VSS VSS gf180mcu_fd_sc_mcu7t5v0__fillcap_8
XFILLER_65_142 VDD VDD VSS VSS gf180mcu_fd_sc_mcu7t5v0__fillcap_4
X_1046_ _1046_/A1 wire574/I _1046_/B1 _1469_/Q _1147_/B1 _1046_/C2 wire497/I VDD VDD
+ VSS VSS gf180mcu_fd_sc_mcu7t5v0__aoi222_4
X_1115_ _1115_/A1 wire576/I wire535/I _1115_/B2 _1621_/Q wire604/I _1118_/A2 VDD VDD
+ VSS VSS gf180mcu_fd_sc_mcu7t5v0__aoi222_2
XTAP_TAPCELL_ROW_8_238 VDD VSS gf180mcu_fd_sc_mcu7t5v0__filltie
XFILLER_0_138 VDD VDD VSS VSS gf180mcu_fd_sc_mcu7t5v0__fillcap_32
XFILLER_69_492 VDD VDD VSS VSS gf180mcu_fd_sc_mcu7t5v0__fillcap_8
XTAP_TAPCELL_ROW_59_649 VDD VSS gf180mcu_fd_sc_mcu7t5v0__filltie
XFILLER_56_186 VDD VDD VSS VSS gf180mcu_fd_sc_mcu7t5v0__fillcap_4
XFILLER_29_356 VDD VDD VSS VSS gf180mcu_fd_sc_mcu7t5v0__fill_2
XFILLER_17_529 VDD VDD VSS VSS gf180mcu_fd_sc_mcu7t5v0__fill_1
XFILLER_28_45 VDD VDD VSS VSS gf180mcu_fd_sc_mcu7t5v0__fill_1
XFILLER_28_34 VDD VDD VSS VSS gf180mcu_fd_sc_mcu7t5v0__fill_1
XFILLER_25_562 VDD VDD VSS VSS gf180mcu_fd_sc_mcu7t5v0__fillcap_4
XFILLER_79_212 VDD VDD VSS VSS gf180mcu_fd_sc_mcu7t5v0__fillcap_64
XFILLER_75_440 VDD VDD VSS VSS gf180mcu_fd_sc_mcu7t5v0__fill_2
XFILLER_75_473 VDD VDD VSS VSS gf180mcu_fd_sc_mcu7t5v0__fillcap_16
XFILLER_62_123 VDD VDD VSS VSS gf180mcu_fd_sc_mcu7t5v0__fillcap_4
XFILLER_62_101 VDD VDD VSS VSS gf180mcu_fd_sc_mcu7t5v0__fillcap_4
XFILLER_50_329 VDD VDD VSS VSS gf180mcu_fd_sc_mcu7t5v0__fill_1
XFILLER_50_307 VDD VDD VSS VSS gf180mcu_fd_sc_mcu7t5v0__fillcap_8
XFILLER_47_142 VDD VDD VSS VSS gf180mcu_fd_sc_mcu7t5v0__fillcap_16
Xclkbuf_2_3__f_clk clkbuf_0_clk/Z clkbuf_leaf_8_clk/I VDD VDD VSS VSS gf180mcu_fd_sc_mcu7t5v0__clkbuf_16
XFILLER_35_315 VDD VDD VSS VSS gf180mcu_fd_sc_mcu7t5v0__fillcap_8
X_1595_ _1595_/D _1563_/RN _1597_/CLK _1596_/D VDD VDD VSS VSS gf180mcu_fd_sc_mcu7t5v0__dffsnq_1
Xfanout718 _1589_/Q wire720/I VDD VDD VSS VSS gf180mcu_fd_sc_mcu7t5v0__dlyb_1
XFILLER_7_282 VDD VDD VSS VSS gf180mcu_fd_sc_mcu7t5v0__fillcap_64
XTAP_TAPCELL_ROW_5_219 VDD VSS gf180mcu_fd_sc_mcu7t5v0__filltie
X_1664_ _1664_/D _1665_/RN clkload0/I _1664_/Q VDD VDD VSS VSS gf180mcu_fd_sc_mcu7t5v0__dffrnq_1
XFILLER_81_410 VDD VDD VSS VSS gf180mcu_fd_sc_mcu7t5v0__fillcap_16
XTAP_TAPCELL_ROW_64_685 VDD VSS gf180mcu_fd_sc_mcu7t5v0__filltie
XFILLER_53_156 VDD VDD VSS VSS gf180mcu_fd_sc_mcu7t5v0__fill_1
X_1029_ input81/Z wire579/I wire520/I _1527_/Q _1030_/A3 VDD VDD VSS VSS gf180mcu_fd_sc_mcu7t5v0__aoi22_1
XFILLER_14_47 VDD VDD VSS VSS gf180mcu_fd_sc_mcu7t5v0__fill_1
XPHY_EDGE_ROW_12_Left_94 VDD VSS gf180mcu_fd_sc_mcu7t5v0__endcap
XFILLER_72_454 VDD VDD VSS VSS gf180mcu_fd_sc_mcu7t5v0__fill_1
XFILLER_29_142 VDD VDD VSS VSS gf180mcu_fd_sc_mcu7t5v0__fill_2
XFILLER_29_131 VDD VDD VSS VSS gf180mcu_fd_sc_mcu7t5v0__fill_1
XFILLER_17_348 VDD VDD VSS VSS gf180mcu_fd_sc_mcu7t5v0__fill_2
XFILLER_40_395 VDD VDD VSS VSS gf180mcu_fd_sc_mcu7t5v0__fillcap_4
XFILLER_40_373 VDD VDD VSS VSS gf180mcu_fd_sc_mcu7t5v0__fillcap_4
X_1380_ _1380_/A1 _1381_/S _1380_/B _1678_/D VDD VDD VSS VSS gf180mcu_fd_sc_mcu7t5v0__aoi21_1
XFILLER_4_241 VDD VDD VSS VSS gf180mcu_fd_sc_mcu7t5v0__fillcap_4
XTAP_TAPCELL_ROW_10_254 VDD VSS gf180mcu_fd_sc_mcu7t5v0__filltie
XTAP_TAPCELL_ROW_78_799 VDD VSS gf180mcu_fd_sc_mcu7t5v0__filltie
XTAP_TAPCELL_ROW_61_666 VDD VSS gf180mcu_fd_sc_mcu7t5v0__filltie
XFILLER_35_134 VDD VDD VSS VSS gf180mcu_fd_sc_mcu7t5v0__fillcap_4
XTAP_TAPCELL_ROW_18_321 VDD VSS gf180mcu_fd_sc_mcu7t5v0__filltie
X_1578_ _1578_/D wire840/I _1593_/CLK _1578_/Q VDD VDD VSS VSS gf180mcu_fd_sc_mcu7t5v0__dffrnq_2
X_1647_ _1647_/D _1647_/RN _1659_/CLK _1647_/Q VDD VDD VSS VSS gf180mcu_fd_sc_mcu7t5v0__dffrnq_1
XFILLER_81_240 VDD VDD VSS VSS gf180mcu_fd_sc_mcu7t5v0__fillcap_16
XFILLER_14_329 VDD VDD VSS VSS gf180mcu_fd_sc_mcu7t5v0__fill_1
XFILLER_41_137 VDD VDD VSS VSS gf180mcu_fd_sc_mcu7t5v0__fill_2
XTAP_TAPCELL_ROW_24_368 VDD VSS gf180mcu_fd_sc_mcu7t5v0__filltie
XFILLER_41_67 VDD VDD VSS VSS gf180mcu_fd_sc_mcu7t5v0__fill_2
XFILLER_64_229 VDD VDD VSS VSS gf180mcu_fd_sc_mcu7t5v0__fillcap_4
XFILLER_49_237 VDD VDD VSS VSS gf180mcu_fd_sc_mcu7t5v0__fillcap_8
XFILLER_32_126 VDD VDD VSS VSS gf180mcu_fd_sc_mcu7t5v0__fill_2
X_0880_ _0880_/A1 _0880_/A2 _1129_/A2 VDD VDD VSS VSS gf180mcu_fd_sc_mcu7t5v0__nor2_4
XFILLER_9_344 VDD VDD VSS VSS gf180mcu_fd_sc_mcu7t5v0__fillcap_4
XFILLER_5_550 VDD VDD VSS VSS gf180mcu_fd_sc_mcu7t5v0__fill_2
X_1501_ _1501_/D _1503_/RN _1624_/CLK _1501_/Q VDD VDD VSS VSS gf180mcu_fd_sc_mcu7t5v0__dffrnq_1
X_1363_ _1343_/I _1375_/A1 _1372_/S VDD VDD VSS VSS gf180mcu_fd_sc_mcu7t5v0__nor2_4
X_1432_ _1507_/Q _1434_/S _1433_/B VDD VDD VSS VSS gf180mcu_fd_sc_mcu7t5v0__nor2_1
XTAP_TAPCELL_ROW_66_703 VDD VSS gf180mcu_fd_sc_mcu7t5v0__filltie
XFILLER_63_262 VDD VDD VSS VSS gf180mcu_fd_sc_mcu7t5v0__fill_1
XFILLER_55_218 VDD VDD VSS VSS gf180mcu_fd_sc_mcu7t5v0__fill_1
XFILLER_36_487 VDD VDD VSS VSS gf180mcu_fd_sc_mcu7t5v0__fillcap_4
XFILLER_36_421 VDD VDD VSS VSS gf180mcu_fd_sc_mcu7t5v0__fillcap_4
X_1294_ _1455_/A2 _1331_/A3 _1455_/A3 _1303_/S VDD VDD VSS VSS gf180mcu_fd_sc_mcu7t5v0__and3_4
XFILLER_74_527 VDD VDD VSS VSS gf180mcu_fd_sc_mcu7t5v0__fillcap_16
XFILLER_74_505 VDD VDD VSS VSS gf180mcu_fd_sc_mcu7t5v0__fillcap_16
XTAP_TAPCELL_ROW_29_405 VDD VSS gf180mcu_fd_sc_mcu7t5v0__filltie
XFILLER_54_295 VDD VDD VSS VSS gf180mcu_fd_sc_mcu7t5v0__fill_1
XFILLER_42_435 VDD VDD VSS VSS gf180mcu_fd_sc_mcu7t5v0__fillcap_4
XTAP_TAPCELL_ROW_37_471 VDD VSS gf180mcu_fd_sc_mcu7t5v0__filltie
XFILLER_14_104 VDD VDD VSS VSS gf180mcu_fd_sc_mcu7t5v0__fill_1
XFILLER_14_159 VDD VDD VSS VSS gf180mcu_fd_sc_mcu7t5v0__fill_1
Xwire746 wire747/Z wire746/Z VDD VDD VSS VSS gf180mcu_fd_sc_mcu7t5v0__clkbuf_2
XFILLER_10_387 VDD VDD VSS VSS gf180mcu_fd_sc_mcu7t5v0__fillcap_16
XFILLER_22_181 VDD VDD VSS VSS gf180mcu_fd_sc_mcu7t5v0__fill_2
Xwire768 wire768/I wire768/Z VDD VDD VSS VSS gf180mcu_fd_sc_mcu7t5v0__buf_2
Xload_slew707 _0770_/I0 wire706/I VDD VDD VSS VSS gf180mcu_fd_sc_mcu7t5v0__buf_1
XFILLER_18_465 VDD VDD VSS VSS gf180mcu_fd_sc_mcu7t5v0__fill_2
X_0932_ input68/Z wire579/Z wire576/Z _0932_/B2 _1217_/B1 _0932_/C2 wire501/I VDD
+ VDD VSS VSS gf180mcu_fd_sc_mcu7t5v0__aoi222_4
XFILLER_33_479 VDD VDD VSS VSS gf180mcu_fd_sc_mcu7t5v0__fillcap_4
XFILLER_20_107 VDD VDD VSS VSS gf180mcu_fd_sc_mcu7t5v0__fill_2
X_0794_ _1549_/Q _0782_/B _0796_/S VDD VDD VSS VSS gf180mcu_fd_sc_mcu7t5v0__nor2_4
X_0863_ _0923_/A1 _0921_/A2 _1037_/A2 VDD VDD VSS VSS gf180mcu_fd_sc_mcu7t5v0__nor2_4
XFILLER_68_310 VDD VDD VSS VSS gf180mcu_fd_sc_mcu7t5v0__fillcap_4
XFILLER_56_527 VDD VDD VSS VSS gf180mcu_fd_sc_mcu7t5v0__fill_2
X_1415_ _1493_/Q _1415_/I1 _1417_/S _1493_/D VDD VDD VSS VSS gf180mcu_fd_sc_mcu7t5v0__mux2_2
X_1346_ _1655_/Q _1346_/I1 _1346_/S _1655_/D VDD VDD VSS VSS gf180mcu_fd_sc_mcu7t5v0__mux2_2
X_1277_ _1604_/Q _1282_/S _1278_/B VDD VDD VSS VSS gf180mcu_fd_sc_mcu7t5v0__nor2_1
XFILLER_78_107 VDD VDD VSS VSS gf180mcu_fd_sc_mcu7t5v0__fillcap_64
Xoutput460 _1513_/Q cfg_phase90_offset_y[4] VDD VDD VSS VSS gf180mcu_fd_sc_mcu7t5v0__buf_2
XFILLER_59_354 VDD VDD VSS VSS gf180mcu_fd_sc_mcu7t5v0__fill_1
XFILLER_19_218 VDD VDD VSS VSS gf180mcu_fd_sc_mcu7t5v0__fill_2
XFILLER_42_243 VDD VDD VSS VSS gf180mcu_fd_sc_mcu7t5v0__fill_2
XTAP_TAPCELL_ROW_40_499 VDD VSS gf180mcu_fd_sc_mcu7t5v0__filltie
Xwire576 wire576/I wire576/Z VDD VDD VSS VSS gf180mcu_fd_sc_mcu7t5v0__buf_2
Xwire598 wire598/I wire598/Z VDD VDD VSS VSS gf180mcu_fd_sc_mcu7t5v0__buf_2
XFILLER_6_177 VDD VDD VSS VSS gf180mcu_fd_sc_mcu7t5v0__fillcap_64
XFILLER_10_173 VDD VDD VSS VSS gf180mcu_fd_sc_mcu7t5v0__fill_2
Xwire510 _1358_/S _1361_/S VDD VDD VSS VSS gf180mcu_fd_sc_mcu7t5v0__buf_2
XFILLER_65_302 VDD VDD VSS VSS gf180mcu_fd_sc_mcu7t5v0__fill_2
Xload_slew526 _1057_/A2 _1119_/C1 VDD VDD VSS VSS gf180mcu_fd_sc_mcu7t5v0__buf_2
XFILLER_40_8 VDD VDD VSS VSS gf180mcu_fd_sc_mcu7t5v0__fillcap_4
Xload_slew537 _1219_/B1 _1205_/A2 VDD VDD VSS VSS gf180mcu_fd_sc_mcu7t5v0__buf_2
X_1200_ input22/Z _1200_/A2 wire548/Z _1631_/Q _1200_/C1 _1494_/Q wire490/I VDD VDD
+ VSS VSS gf180mcu_fd_sc_mcu7t5v0__aoi222_4
Xload_slew504 _1457_/S _1464_/S VDD VDD VSS VSS gf180mcu_fd_sc_mcu7t5v0__buf_4
XPHY_EDGE_ROW_0_Left_82 VDD VSS gf180mcu_fd_sc_mcu7t5v0__endcap
XFILLER_65_368 VDD VDD VSS VSS gf180mcu_fd_sc_mcu7t5v0__fillcap_4
XFILLER_65_324 VDD VDD VSS VSS gf180mcu_fd_sc_mcu7t5v0__fill_2
X_1062_ wire642/Z _1062_/A2 _1062_/A3 _1062_/B _1570_/D VDD VDD VSS VSS gf180mcu_fd_sc_mcu7t5v0__oai31_1
X_1131_ _1131_/A1 _1131_/A2 _1131_/A3 _1131_/A4 _1151_/B1 VDD VDD VSS VSS gf180mcu_fd_sc_mcu7t5v0__nor4_2
XFILLER_18_251 VDD VDD VSS VSS gf180mcu_fd_sc_mcu7t5v0__fill_2
X_0915_ _0915_/A1 _0915_/A2 _1057_/A2 VDD VDD VSS VSS gf180mcu_fd_sc_mcu7t5v0__nor2_4
XFILLER_33_298 VDD VDD VSS VSS gf180mcu_fd_sc_mcu7t5v0__fillcap_4
XTAP_TAPCELL_ROW_31_422 VDD VSS gf180mcu_fd_sc_mcu7t5v0__filltie
Xclkbuf_leaf_13_clk clkbuf_leaf_9_clk/I _1629_/CLK VDD VDD VSS VSS gf180mcu_fd_sc_mcu7t5v0__clkbuf_8
XFILLER_21_438 VDD VDD VSS VSS gf180mcu_fd_sc_mcu7t5v0__fill_2
X_0846_ _1556_/Q _1557_/Q _0881_/A2 VDD VDD VSS VSS gf180mcu_fd_sc_mcu7t5v0__nor2_4
X_0777_ wire690/Z _0778_/S _0777_/B _1544_/D VDD VDD VSS VSS gf180mcu_fd_sc_mcu7t5v0__oai21_1
XFILLER_68_173 VDD VDD VSS VSS gf180mcu_fd_sc_mcu7t5v0__fill_2
X_1329_ _1644_/Q _1400_/I1 _1330_/S _1644_/D VDD VDD VSS VSS gf180mcu_fd_sc_mcu7t5v0__mux2_2
XFILLER_12_427 VDD VDD VSS VSS gf180mcu_fd_sc_mcu7t5v0__fillcap_4
XFILLER_17_69 VDD VDD VSS VSS gf180mcu_fd_sc_mcu7t5v0__fill_1
XPHY_EDGE_ROW_18_Left_100 VDD VSS gf180mcu_fd_sc_mcu7t5v0__endcap
XFILLER_20_482 VDD VDD VSS VSS gf180mcu_fd_sc_mcu7t5v0__fill_1
XFILLER_79_416 VDD VDD VSS VSS gf180mcu_fd_sc_mcu7t5v0__fillcap_4
XFILLER_58_43 VDD VDD VSS VSS gf180mcu_fd_sc_mcu7t5v0__fillcap_32
XFILLER_3_136 VDD VDD VSS VSS gf180mcu_fd_sc_mcu7t5v0__fillcap_4
XFILLER_74_20 VDD VDD VSS VSS gf180mcu_fd_sc_mcu7t5v0__fillcap_8
XFILLER_62_349 VDD VDD VSS VSS gf180mcu_fd_sc_mcu7t5v0__fillcap_8
XFILLER_62_305 VDD VDD VSS VSS gf180mcu_fd_sc_mcu7t5v0__fillcap_8
XTAP_TAPCELL_ROW_45_536 VDD VSS gf180mcu_fd_sc_mcu7t5v0__filltie
XTAP_TAPCELL_ROW_2_191 VDD VSS gf180mcu_fd_sc_mcu7t5v0__filltie
XFILLER_70_393 VDD VDD VSS VSS gf180mcu_fd_sc_mcu7t5v0__fillcap_8
X_1680_ _1680_/D _1680_/RN clkload1/I _1680_/Q VDD VDD VSS VSS gf180mcu_fd_sc_mcu7t5v0__dffrnq_1
XFILLER_7_486 VDD VDD VSS VSS gf180mcu_fd_sc_mcu7t5v0__fillcap_4
XFILLER_38_313 VDD VDD VSS VSS gf180mcu_fd_sc_mcu7t5v0__fill_2
X_1114_ _1650_/Q wire593/Z _1144_/A2 VDD VDD VSS VSS gf180mcu_fd_sc_mcu7t5v0__nand2_1
Xclkbuf_leaf_2_clk clkbuf_leaf_3_clk/I clkload2/I VDD VDD VSS VSS gf180mcu_fd_sc_mcu7t5v0__clkbuf_8
XFILLER_53_349 VDD VDD VSS VSS gf180mcu_fd_sc_mcu7t5v0__fill_1
X_1045_ _1045_/A1 _1045_/A2 _1045_/A3 _1045_/A4 _1059_/A1 VDD VDD VSS VSS gf180mcu_fd_sc_mcu7t5v0__nand4_1
XFILLER_34_541 VDD VDD VSS VSS gf180mcu_fd_sc_mcu7t5v0__fill_1
X_0829_ _1563_/Q _1562_/Q _0829_/S _1563_/D VDD VDD VSS VSS gf180mcu_fd_sc_mcu7t5v0__mux2_2
XTAP_TAPCELL_ROW_8_239 VDD VSS gf180mcu_fd_sc_mcu7t5v0__filltie
XFILLER_52_360 VDD VDD VSS VSS gf180mcu_fd_sc_mcu7t5v0__fillcap_4
XTAP_TAPCELL_ROW_50_572 VDD VSS gf180mcu_fd_sc_mcu7t5v0__filltie
XFILLER_44_56 VDD VDD VSS VSS gf180mcu_fd_sc_mcu7t5v0__fillcap_16
XFILLER_35_327 VDD VDD VSS VSS gf180mcu_fd_sc_mcu7t5v0__fill_2
XFILLER_31_500 VDD VDD VSS VSS gf180mcu_fd_sc_mcu7t5v0__fill_1
X_1663_ _1663_/D _1663_/RN _1663_/CLK _1663_/Q VDD VDD VSS VSS gf180mcu_fd_sc_mcu7t5v0__dffrnq_2
X_1594_ _1598_/Q _1594_/RN clkload7/I _1594_/Q VDD VDD VSS VSS gf180mcu_fd_sc_mcu7t5v0__dffrnq_1
Xfanout708 _1590_/Q wire711/I VDD VDD VSS VSS gf180mcu_fd_sc_mcu7t5v0__dlyb_1
XPHY_EDGE_ROW_7_Right_7 VDD VSS gf180mcu_fd_sc_mcu7t5v0__endcap
XTAP_TAPCELL_ROW_64_686 VDD VSS gf180mcu_fd_sc_mcu7t5v0__filltie
X_1028_ input14/Z _1129_/A2 _1073_/B1 _1656_/Q _1030_/A2 VDD VDD VSS VSS gf180mcu_fd_sc_mcu7t5v0__aoi22_2
XFILLER_41_319 VDD VDD VSS VSS gf180mcu_fd_sc_mcu7t5v0__fillcap_8
XFILLER_34_393 VDD VDD VSS VSS gf180mcu_fd_sc_mcu7t5v0__fill_2
XFILLER_69_290 VDD VDD VSS VSS gf180mcu_fd_sc_mcu7t5v0__fill_2
XFILLER_32_319 VDD VDD VSS VSS gf180mcu_fd_sc_mcu7t5v0__fill_1
XTAP_TAPCELL_ROW_27_388 VDD VSS gf180mcu_fd_sc_mcu7t5v0__filltie
XTAP_TAPCELL_ROW_10_255 VDD VSS gf180mcu_fd_sc_mcu7t5v0__filltie
XFILLER_75_282 VDD VDD VSS VSS gf180mcu_fd_sc_mcu7t5v0__fillcap_64
XFILLER_67_216 VDD VDD VSS VSS gf180mcu_fd_sc_mcu7t5v0__fill_1
XFILLER_63_422 VDD VDD VSS VSS gf180mcu_fd_sc_mcu7t5v0__fill_2
XFILLER_63_400 VDD VDD VSS VSS gf180mcu_fd_sc_mcu7t5v0__fillcap_4
XFILLER_48_496 VDD VDD VSS VSS gf180mcu_fd_sc_mcu7t5v0__fillcap_8
XTAP_TAPCELL_ROW_18_322 VDD VSS gf180mcu_fd_sc_mcu7t5v0__filltie
XFILLER_63_488 VDD VDD VSS VSS gf180mcu_fd_sc_mcu7t5v0__fill_2
XTAP_TAPCELL_ROW_61_667 VDD VSS gf180mcu_fd_sc_mcu7t5v0__filltie
XFILLER_31_352 VDD VDD VSS VSS gf180mcu_fd_sc_mcu7t5v0__fill_2
XFILLER_23_319 VDD VDD VSS VSS gf180mcu_fd_sc_mcu7t5v0__fillcap_4
XFILLER_6_93 VDD VDD VSS VSS gf180mcu_fd_sc_mcu7t5v0__fillcap_8
X_1646_ _1646_/D _1646_/RN _1674_/CLK _1646_/Q VDD VDD VSS VSS gf180mcu_fd_sc_mcu7t5v0__dffrnq_1
X_1577_ _1577_/D wire840/Z _1593_/CLK _1577_/Q VDD VDD VSS VSS gf180mcu_fd_sc_mcu7t5v0__dffrnq_2
XFILLER_81_274 VDD VDD VSS VSS gf180mcu_fd_sc_mcu7t5v0__fillcap_32
XFILLER_26_113 VDD VDD VSS VSS gf180mcu_fd_sc_mcu7t5v0__fill_1
XTAP_TAPCELL_ROW_24_369 VDD VSS gf180mcu_fd_sc_mcu7t5v0__filltie
XFILLER_1_212 VDD VDD VSS VSS gf180mcu_fd_sc_mcu7t5v0__fillcap_64
XFILLER_57_293 VDD VDD VSS VSS gf180mcu_fd_sc_mcu7t5v0__fillcap_16
XFILLER_72_241 VDD VDD VSS VSS gf180mcu_fd_sc_mcu7t5v0__fillcap_4
XFILLER_13_352 VDD VDD VSS VSS gf180mcu_fd_sc_mcu7t5v0__fillcap_16
XFILLER_56_6 VDD VDD VSS VSS gf180mcu_fd_sc_mcu7t5v0__fill_1
XFILLER_40_193 VDD VDD VSS VSS gf180mcu_fd_sc_mcu7t5v0__fillcap_8
XFILLER_5_562 VDD VDD VSS VSS gf180mcu_fd_sc_mcu7t5v0__fillcap_4
X_1500_ _1500_/D _1509_/RN clkload6/I _1500_/Q VDD VDD VSS VSS gf180mcu_fd_sc_mcu7t5v0__dffrnq_1
X_1431_ _1506_/Q wire746/Z _1434_/S _1506_/D VDD VDD VSS VSS gf180mcu_fd_sc_mcu7t5v0__mux2_2
X_1362_ _1593_/Q _1435_/A2 _1375_/A1 VDD VDD VSS VSS gf180mcu_fd_sc_mcu7t5v0__nand2_1
X_1293_ _1576_/Q _1577_/Q _1455_/A3 VDD VDD VSS VSS gf180mcu_fd_sc_mcu7t5v0__nor2_2
XTAP_TAPCELL_ROW_74_770 VDD VSS gf180mcu_fd_sc_mcu7t5v0__filltie
XTAP_TAPCELL_ROW_66_704 VDD VSS gf180mcu_fd_sc_mcu7t5v0__filltie
Xinput190 raw_edge1_y[20] _1137_/A1 VDD VDD VSS VSS gf180mcu_fd_sc_mcu7t5v0__buf_1
X_1629_ _1629_/D _1629_/RN _1629_/CLK _1629_/Q VDD VDD VSS VSS gf180mcu_fd_sc_mcu7t5v0__dffrnq_2
XFILLER_39_282 VDD VDD VSS VSS gf180mcu_fd_sc_mcu7t5v0__fillcap_32
XTAP_TAPCELL_ROW_29_406 VDD VSS gf180mcu_fd_sc_mcu7t5v0__filltie
XFILLER_27_422 VDD VDD VSS VSS gf180mcu_fd_sc_mcu7t5v0__fillcap_4
XFILLER_52_34 VDD VDD VSS VSS gf180mcu_fd_sc_mcu7t5v0__fill_1
XTAP_TAPCELL_ROW_37_472 VDD VSS gf180mcu_fd_sc_mcu7t5v0__filltie
XFILLER_14_149 VDD VDD VSS VSS gf180mcu_fd_sc_mcu7t5v0__fillcap_8
XFILLER_52_67 VDD VDD VSS VSS gf180mcu_fd_sc_mcu7t5v0__fill_1
Xwire725 wire725/I wire725/Z VDD VDD VSS VSS gf180mcu_fd_sc_mcu7t5v0__clkbuf_2
Xwire747 wire747/I wire747/Z VDD VDD VSS VSS gf180mcu_fd_sc_mcu7t5v0__buf_1
Xwire736 wire737/Z wire736/Z VDD VDD VSS VSS gf180mcu_fd_sc_mcu7t5v0__clkbuf_2
XFILLER_2_521 VDD VDD VSS VSS gf180mcu_fd_sc_mcu7t5v0__fillcap_4
Xload_slew719 wire720/Z _1416_/I1 VDD VDD VSS VSS gf180mcu_fd_sc_mcu7t5v0__clkbuf_2
XTAP_TAPCELL_ROW_71_740 VDD VSS gf180mcu_fd_sc_mcu7t5v0__filltie
X_0862_ _1250_/A1 _1554_/Q _0881_/A2 _0921_/A2 VDD VDD VSS VSS gf180mcu_fd_sc_mcu7t5v0__nand3_4
X_0931_ _0931_/A1 _0931_/A2 wire502/Z _0931_/A4 _0937_/A1 VDD VDD VSS VSS gf180mcu_fd_sc_mcu7t5v0__nand4_1
XFILLER_9_142 VDD VDD VSS VSS gf180mcu_fd_sc_mcu7t5v0__fillcap_8
XFILLER_13_182 VDD VDD VSS VSS gf180mcu_fd_sc_mcu7t5v0__fill_2
X_0793_ _0793_/A1 _0793_/A2 _0793_/B _1552_/D VDD VDD VSS VSS gf180mcu_fd_sc_mcu7t5v0__oai21_1
XFILLER_47_2 VDD VDD VSS VSS gf180mcu_fd_sc_mcu7t5v0__fillcap_4
XFILLER_3_72 VDD VDD VSS VSS gf180mcu_fd_sc_mcu7t5v0__fillcap_64
X_1276_ _1603_/Q wire741/Z _1282_/S _1603_/D VDD VDD VSS VSS gf180mcu_fd_sc_mcu7t5v0__mux2_2
X_1414_ _1492_/Q _1414_/I1 _1417_/S _1492_/D VDD VDD VSS VSS gf180mcu_fd_sc_mcu7t5v0__mux2_2
X_1345_ _1654_/Q wire768/I _1350_/S _1654_/D VDD VDD VSS VSS gf180mcu_fd_sc_mcu7t5v0__mux2_2
XFILLER_51_277 VDD VDD VSS VSS gf180mcu_fd_sc_mcu7t5v0__fill_2
XFILLER_51_244 VDD VDD VSS VSS gf180mcu_fd_sc_mcu7t5v0__fill_2
XFILLER_11_119 VDD VDD VSS VSS gf180mcu_fd_sc_mcu7t5v0__fillcap_4
XFILLER_24_469 VDD VDD VSS VSS gf180mcu_fd_sc_mcu7t5v0__fill_1
XFILLER_22_37 VDD VDD VSS VSS gf180mcu_fd_sc_mcu7t5v0__fill_2
XFILLER_59_322 VDD VDD VSS VSS gf180mcu_fd_sc_mcu7t5v0__fill_2
Xoutput461 _1514_/Q cfg_phase90_offset_y[5] VDD VDD VSS VSS gf180mcu_fd_sc_mcu7t5v0__buf_2
Xoutput450 _1523_/Q cfg_phase90_offset_y[14] VDD VDD VSS VSS gf180mcu_fd_sc_mcu7t5v0__buf_2
XFILLER_15_403 VDD VDD VSS VSS gf180mcu_fd_sc_mcu7t5v0__fill_2
XFILLER_63_66 VDD VDD VSS VSS gf180mcu_fd_sc_mcu7t5v0__fillcap_4
Xwire500 wire500/I wire500/Z VDD VDD VSS VSS gf180mcu_fd_sc_mcu7t5v0__clkbuf_1
Xwire511 wire511/I wire511/Z VDD VDD VSS VSS gf180mcu_fd_sc_mcu7t5v0__buf_2
XFILLER_6_101 VDD VDD VSS VSS gf180mcu_fd_sc_mcu7t5v0__fillcap_4
Xload_slew505 _1448_/S _1454_/S VDD VDD VSS VSS gf180mcu_fd_sc_mcu7t5v0__buf_4
Xload_slew549 _0935_/C1 _1099_/A2 VDD VDD VSS VSS gf180mcu_fd_sc_mcu7t5v0__buf_2
Xload_slew516 wire515/I _1023_/C1 VDD VDD VSS VSS gf180mcu_fd_sc_mcu7t5v0__buf_2
X_1130_ _1130_/A1 _1130_/A2 _1130_/A3 _1131_/A4 VDD VDD VSS VSS gf180mcu_fd_sc_mcu7t5v0__nand3_1
Xload_slew527 _1165_/B1 _1218_/B1 VDD VDD VSS VSS gf180mcu_fd_sc_mcu7t5v0__buf_2
XFILLER_80_317 VDD VDD VSS VSS gf180mcu_fd_sc_mcu7t5v0__fillcap_64
X_1061_ _1569_/Q _1245_/A2 _1062_/A3 VDD VDD VSS VSS gf180mcu_fd_sc_mcu7t5v0__nor2_1
XTAP_TAPCELL_ROW_48_556 VDD VSS gf180mcu_fd_sc_mcu7t5v0__filltie
XFILLER_33_244 VDD VDD VSS VSS gf180mcu_fd_sc_mcu7t5v0__fillcap_16
XFILLER_33_200 VDD VDD VSS VSS gf180mcu_fd_sc_mcu7t5v0__fillcap_4
XFILLER_18_241 VDD VDD VSS VSS gf180mcu_fd_sc_mcu7t5v0__fillcap_4
X_0914_ _0914_/A1 _0915_/A2 _1046_/B1 VDD VDD VSS VSS gf180mcu_fd_sc_mcu7t5v0__nor2_4
X_0845_ _0845_/A1 _0857_/A1 wire603/I VDD VDD VSS VSS gf180mcu_fd_sc_mcu7t5v0__nor2_4
XTAP_TAPCELL_ROW_31_423 VDD VSS gf180mcu_fd_sc_mcu7t5v0__filltie
X_0776_ _1544_/Q _0778_/S _0777_/B VDD VDD VSS VSS gf180mcu_fd_sc_mcu7t5v0__nand2_1
XFILLER_56_314 VDD VDD VSS VSS gf180mcu_fd_sc_mcu7t5v0__fill_1
X_1259_ _1259_/A1 wire476/Z _1259_/B _1582_/D VDD VDD VSS VSS gf180mcu_fd_sc_mcu7t5v0__oai21_1
X_1328_ _1643_/Q _1328_/I1 _1330_/S _1643_/D VDD VDD VSS VSS gf180mcu_fd_sc_mcu7t5v0__mux2_2
XFILLER_24_266 VDD VDD VSS VSS gf180mcu_fd_sc_mcu7t5v0__fill_1
XFILLER_59_174 VDD VDD VSS VSS gf180mcu_fd_sc_mcu7t5v0__fill_2
XFILLER_58_99 VDD VDD VSS VSS gf180mcu_fd_sc_mcu7t5v0__fillcap_4
XFILLER_74_177 VDD VDD VSS VSS gf180mcu_fd_sc_mcu7t5v0__fillcap_64
XFILLER_74_32 VDD VDD VSS VSS gf180mcu_fd_sc_mcu7t5v0__fill_2
XFILLER_62_317 VDD VDD VSS VSS gf180mcu_fd_sc_mcu7t5v0__fillcap_32
XTAP_TAPCELL_ROW_45_537 VDD VSS gf180mcu_fd_sc_mcu7t5v0__filltie
XTAP_TAPCELL_ROW_2_192 VDD VSS gf180mcu_fd_sc_mcu7t5v0__filltie
X_1113_ _1113_/A1 wire574/Z _1118_/A1 VDD VDD VSS VSS gf180mcu_fd_sc_mcu7t5v0__nand2_1
X_1044_ _1044_/A1 wire586/Z _1174_/A2 _1044_/B2 wire575/I _1677_/Q _1045_/A4 VDD VDD
+ VSS VSS gf180mcu_fd_sc_mcu7t5v0__aoi222_4
XFILLER_34_531 VDD VDD VSS VSS gf180mcu_fd_sc_mcu7t5v0__fill_1
X_0828_ _1562_/Q _1561_/Q _0829_/S _1562_/D VDD VDD VSS VSS gf180mcu_fd_sc_mcu7t5v0__mux2_2
X_0759_ _0795_/A1 _0782_/B _0825_/B2 VDD VDD VSS VSS gf180mcu_fd_sc_mcu7t5v0__nor2_2
XFILLER_69_472 VDD VDD VSS VSS gf180mcu_fd_sc_mcu7t5v0__fill_2
XFILLER_71_136 VDD VDD VSS VSS gf180mcu_fd_sc_mcu7t5v0__fillcap_4
XFILLER_56_155 VDD VDD VSS VSS gf180mcu_fd_sc_mcu7t5v0__fill_2
XFILLER_56_166 VDD VDD VSS VSS gf180mcu_fd_sc_mcu7t5v0__fillcap_8
XFILLER_44_317 VDD VDD VSS VSS gf180mcu_fd_sc_mcu7t5v0__fill_2
XFILLER_60_34 VDD VDD VSS VSS gf180mcu_fd_sc_mcu7t5v0__fill_1
XFILLER_52_383 VDD VDD VSS VSS gf180mcu_fd_sc_mcu7t5v0__fill_2
XTAP_TAPCELL_ROW_50_573 VDD VSS gf180mcu_fd_sc_mcu7t5v0__filltie
XFILLER_12_247 VDD VDD VSS VSS gf180mcu_fd_sc_mcu7t5v0__fillcap_4
XFILLER_4_457 VDD VDD VSS VSS gf180mcu_fd_sc_mcu7t5v0__fillcap_64
XFILLER_75_464 VDD VDD VSS VSS gf180mcu_fd_sc_mcu7t5v0__fill_1
XTAP_TAPCELL_ROW_58_640 VDD VSS gf180mcu_fd_sc_mcu7t5v0__filltie
XFILLER_47_199 VDD VDD VSS VSS gf180mcu_fd_sc_mcu7t5v0__fillcap_8
XFILLER_43_361 VDD VDD VSS VSS gf180mcu_fd_sc_mcu7t5v0__fillcap_16
X_1662_ _1662_/D _1662_/RN _1674_/CLK _1662_/Q VDD VDD VSS VSS gf180mcu_fd_sc_mcu7t5v0__dffrnq_1
XPHY_EDGE_ROW_37_Left_119 VDD VSS gf180mcu_fd_sc_mcu7t5v0__endcap
X_1593_ _1593_/D _1593_/RN _1593_/CLK _1593_/Q VDD VDD VSS VSS gf180mcu_fd_sc_mcu7t5v0__dffrnq_2
XFILLER_81_434 VDD VDD VSS VSS gf180mcu_fd_sc_mcu7t5v0__fill_1
X_1027_ _1648_/Q wire593/I _1229_/A2 input27/Z _1041_/A1 VDD VDD VSS VSS gf180mcu_fd_sc_mcu7t5v0__aoi22_1
XFILLER_38_177 VDD VDD VSS VSS gf180mcu_fd_sc_mcu7t5v0__fillcap_64
XFILLER_38_166 VDD VDD VSS VSS gf180mcu_fd_sc_mcu7t5v0__fillcap_8
XTAP_TAPCELL_ROW_64_687 VDD VSS gf180mcu_fd_sc_mcu7t5v0__filltie
XPHY_EDGE_ROW_46_Left_128 VDD VSS gf180mcu_fd_sc_mcu7t5v0__endcap
XPHY_EDGE_ROW_55_Left_137 VDD VSS gf180mcu_fd_sc_mcu7t5v0__endcap
XFILLER_1_416 VDD VDD VSS VSS gf180mcu_fd_sc_mcu7t5v0__fillcap_4
XFILLER_72_401 VDD VDD VSS VSS gf180mcu_fd_sc_mcu7t5v0__fill_1
XFILLER_29_144 VDD VDD VSS VSS gf180mcu_fd_sc_mcu7t5v0__fill_1
XTAP_TAPCELL_ROW_4_210 VDD VSS gf180mcu_fd_sc_mcu7t5v0__filltie
XPHY_EDGE_ROW_64_Left_146 VDD VSS gf180mcu_fd_sc_mcu7t5v0__endcap
XFILLER_55_89 VDD VDD VSS VSS gf180mcu_fd_sc_mcu7t5v0__fillcap_16
XTAP_TAPCELL_ROW_27_389 VDD VSS gf180mcu_fd_sc_mcu7t5v0__filltie
XFILLER_71_66 VDD VDD VSS VSS gf180mcu_fd_sc_mcu7t5v0__fillcap_4
XTAP_TAPCELL_ROW_10_256 VDD VSS gf180mcu_fd_sc_mcu7t5v0__filltie
XPHY_EDGE_ROW_73_Left_155 VDD VSS gf180mcu_fd_sc_mcu7t5v0__endcap
XFILLER_48_486 VDD VDD VSS VSS gf180mcu_fd_sc_mcu7t5v0__fill_2
XTAP_TAPCELL_ROW_18_323 VDD VSS gf180mcu_fd_sc_mcu7t5v0__filltie
XFILLER_77_2 VDD VDD VSS VSS gf180mcu_fd_sc_mcu7t5v0__fillcap_64
XFILLER_50_139 VDD VDD VSS VSS gf180mcu_fd_sc_mcu7t5v0__fillcap_8
X_1576_ _1576_/D _1580_/RN clkload9/I _1576_/Q VDD VDD VSS VSS gf180mcu_fd_sc_mcu7t5v0__dffrnq_2
XFILLER_8_560 VDD VDD VSS VSS gf180mcu_fd_sc_mcu7t5v0__fillcap_4
X_1645_ _1645_/D wire786/I _1674_/CLK _1645_/Q VDD VDD VSS VSS gf180mcu_fd_sc_mcu7t5v0__dffrnq_1
XTAP_TAPCELL_ROW_69_724 VDD VSS gf180mcu_fd_sc_mcu7t5v0__filltie
XTAP_TAPCELL_ROW_77_790 VDD VSS gf180mcu_fd_sc_mcu7t5v0__filltie
XFILLER_41_139 VDD VDD VSS VSS gf180mcu_fd_sc_mcu7t5v0__fill_1
XFILLER_41_69 VDD VDD VSS VSS gf180mcu_fd_sc_mcu7t5v0__fill_1
XFILLER_49_206 VDD VDD VSS VSS gf180mcu_fd_sc_mcu7t5v0__fillcap_4
XFILLER_60_404 VDD VDD VSS VSS gf180mcu_fd_sc_mcu7t5v0__fill_1
XFILLER_45_478 VDD VDD VSS VSS gf180mcu_fd_sc_mcu7t5v0__fillcap_8
XFILLER_9_368 VDD VDD VSS VSS gf180mcu_fd_sc_mcu7t5v0__fillcap_8
XFILLER_13_320 VDD VDD VSS VSS gf180mcu_fd_sc_mcu7t5v0__fill_1
XFILLER_49_6 VDD VDD VSS VSS gf180mcu_fd_sc_mcu7t5v0__fill_1
X_1430_ _1505_/Q _1437_/I0 _1434_/S _1505_/D VDD VDD VSS VSS gf180mcu_fd_sc_mcu7t5v0__mux2_2
XTAP_TAPCELL_ROW_66_705 VDD VSS gf180mcu_fd_sc_mcu7t5v0__filltie
XFILLER_55_209 VDD VDD VSS VSS gf180mcu_fd_sc_mcu7t5v0__fill_1
Xinput180 raw_edge1_y[11] _1088_/A1 VDD VDD VSS VSS gf180mcu_fd_sc_mcu7t5v0__buf_1
X_1292_ _1616_/Q _1330_/I1 _1292_/S _1616_/D VDD VDD VSS VSS gf180mcu_fd_sc_mcu7t5v0__mux2_2
X_1361_ _1666_/Q wire704/Z _1361_/S _1666_/D VDD VDD VSS VSS gf180mcu_fd_sc_mcu7t5v0__mux2_2
XTAP_TAPCELL_ROW_74_771 VDD VSS gf180mcu_fd_sc_mcu7t5v0__filltie
Xinput191 raw_edge1_y[2] _1057_/A1 VDD VDD VSS VSS gf180mcu_fd_sc_mcu7t5v0__buf_1
X_1559_ _1559_/D _1564_/RN clkload8/I _1559_/Q VDD VDD VSS VSS gf180mcu_fd_sc_mcu7t5v0__dffrnq_1
X_1628_ _1628_/D _1628_/RN clkload5/I _1628_/Q VDD VDD VSS VSS gf180mcu_fd_sc_mcu7t5v0__dffrnq_1
XFILLER_39_272 VDD VDD VSS VSS gf180mcu_fd_sc_mcu7t5v0__fillcap_8
XFILLER_36_69 VDD VDD VSS VSS gf180mcu_fd_sc_mcu7t5v0__fillcap_8
XTAP_TAPCELL_ROW_29_407 VDD VSS gf180mcu_fd_sc_mcu7t5v0__filltie
XFILLER_54_275 VDD VDD VSS VSS gf180mcu_fd_sc_mcu7t5v0__fillcap_4
XFILLER_50_481 VDD VDD VSS VSS gf180mcu_fd_sc_mcu7t5v0__fillcap_4
XTAP_TAPCELL_ROW_37_473 VDD VSS gf180mcu_fd_sc_mcu7t5v0__filltie
XFILLER_10_312 VDD VDD VSS VSS gf180mcu_fd_sc_mcu7t5v0__fill_2
Xwire715 wire716/Z wire715/Z VDD VDD VSS VSS gf180mcu_fd_sc_mcu7t5v0__clkbuf_2
XFILLER_22_172 VDD VDD VSS VSS gf180mcu_fd_sc_mcu7t5v0__fill_2
XFILLER_22_183 VDD VDD VSS VSS gf180mcu_fd_sc_mcu7t5v0__fill_1
Xwire704 wire706/Z wire704/Z VDD VDD VSS VSS gf180mcu_fd_sc_mcu7t5v0__clkbuf_2
Xwire737 wire737/I wire737/Z VDD VDD VSS VSS gf180mcu_fd_sc_mcu7t5v0__clkbuf_2
Xfanout881 _1563_/RN _1560_/RN VDD VDD VSS VSS gf180mcu_fd_sc_mcu7t5v0__dlyb_1
Xfanout870 _1557_/RN _1575_/RN VDD VDD VSS VSS gf180mcu_fd_sc_mcu7t5v0__dlyb_1
XFILLER_37_209 VDD VDD VSS VSS gf180mcu_fd_sc_mcu7t5v0__fill_1
XFILLER_7_2 VDD VDD VSS VSS gf180mcu_fd_sc_mcu7t5v0__fillcap_4
Xload_slew709 wire710/Z _1464_/I0 VDD VDD VSS VSS gf180mcu_fd_sc_mcu7t5v0__clkbuf_1
XFILLER_73_540 VDD VDD VSS VSS gf180mcu_fd_sc_mcu7t5v0__fillcap_8
XTAP_TAPCELL_ROW_71_741 VDD VSS gf180mcu_fd_sc_mcu7t5v0__filltie
XFILLER_45_242 VDD VDD VSS VSS gf180mcu_fd_sc_mcu7t5v0__fillcap_16
XFILLER_26_91 VDD VDD VSS VSS gf180mcu_fd_sc_mcu7t5v0__fillcap_4
X_0792_ _0792_/A1 wire667/Z _0793_/A2 VDD VDD VSS VSS gf180mcu_fd_sc_mcu7t5v0__nand2_1
X_0930_ input96/Z _1092_/B1 _1169_/C2 _0930_/B2 _0931_/A4 VDD VDD VSS VSS gf180mcu_fd_sc_mcu7t5v0__aoi22_1
X_0861_ _1646_/Q wire593/I _1229_/A2 input45/Z _0939_/A1 VDD VDD VSS VSS gf180mcu_fd_sc_mcu7t5v0__aoi22_1
XFILLER_41_492 VDD VDD VSS VSS gf180mcu_fd_sc_mcu7t5v0__fill_2
XFILLER_20_109 VDD VDD VSS VSS gf180mcu_fd_sc_mcu7t5v0__fill_1
X_1413_ _1413_/A1 _1417_/S _1413_/B _1491_/D VDD VDD VSS VSS gf180mcu_fd_sc_mcu7t5v0__aoi21_1
XFILLER_56_529 VDD VDD VSS VSS gf180mcu_fd_sc_mcu7t5v0__fill_1
X_1275_ _1602_/Q _1365_/I1 _1282_/S _1602_/D VDD VDD VSS VSS gf180mcu_fd_sc_mcu7t5v0__mux2_2
X_1344_ _1408_/A1 _1343_/I _1346_/S VDD VDD VSS VSS gf180mcu_fd_sc_mcu7t5v0__nor2_4
XFILLER_51_212 VDD VDD VSS VSS gf180mcu_fd_sc_mcu7t5v0__fillcap_32
Xoutput462 _1515_/Q cfg_phase90_offset_y[6] VDD VDD VSS VSS gf180mcu_fd_sc_mcu7t5v0__buf_2
Xoutput451 _1524_/Q cfg_phase90_offset_y[15] VDD VDD VSS VSS gf180mcu_fd_sc_mcu7t5v0__buf_2
Xoutput440 _1664_/Q cfg_phase90_offset_x[5] VDD VDD VSS VSS gf180mcu_fd_sc_mcu7t5v0__buf_2
XFILLER_70_543 VDD VDD VSS VSS gf180mcu_fd_sc_mcu7t5v0__fillcap_4
XFILLER_55_562 VDD VDD VSS VSS gf180mcu_fd_sc_mcu7t5v0__fillcap_4
XFILLER_47_68 VDD VDD VSS VSS gf180mcu_fd_sc_mcu7t5v0__fill_2
XFILLER_47_57 VDD VDD VSS VSS gf180mcu_fd_sc_mcu7t5v0__fill_2
XFILLER_42_223 VDD VDD VSS VSS gf180mcu_fd_sc_mcu7t5v0__fillcap_16
XPHY_EDGE_ROW_29_Right_29 VDD VSS gf180mcu_fd_sc_mcu7t5v0__endcap
XPHY_EDGE_ROW_38_Right_38 VDD VSS gf180mcu_fd_sc_mcu7t5v0__endcap
Xwire501 wire501/I wire501/Z VDD VDD VSS VSS gf180mcu_fd_sc_mcu7t5v0__buf_1
XFILLER_23_492 VDD VDD VSS VSS gf180mcu_fd_sc_mcu7t5v0__fill_2
Xload_slew528 _1046_/B1 _1165_/B1 VDD VDD VSS VSS gf180mcu_fd_sc_mcu7t5v0__buf_2
Xload_slew517 _1220_/B1 _1154_/B1 VDD VDD VSS VSS gf180mcu_fd_sc_mcu7t5v0__buf_2
Xload_slew506 _1437_/S _1444_/S VDD VDD VSS VSS gf180mcu_fd_sc_mcu7t5v0__buf_4
XFILLER_80_307 VDD VDD VSS VSS gf180mcu_fd_sc_mcu7t5v0__fill_2
XFILLER_77_142 VDD VDD VSS VSS gf180mcu_fd_sc_mcu7t5v0__fillcap_64
XFILLER_65_326 VDD VDD VSS VSS gf180mcu_fd_sc_mcu7t5v0__fill_1
XFILLER_65_304 VDD VDD VSS VSS gf180mcu_fd_sc_mcu7t5v0__fill_1
X_1060_ _1060_/A1 _1060_/A2 _1060_/A3 _1059_/Z _1062_/A2 VDD VDD VSS VSS gf180mcu_fd_sc_mcu7t5v0__nor4_2
XTAP_TAPCELL_ROW_48_557 VDD VSS gf180mcu_fd_sc_mcu7t5v0__filltie
XPHY_EDGE_ROW_47_Right_47 VDD VSS gf180mcu_fd_sc_mcu7t5v0__endcap
XFILLER_61_532 VDD VDD VSS VSS gf180mcu_fd_sc_mcu7t5v0__fillcap_4
XPHY_EDGE_ROW_56_Right_56 VDD VSS gf180mcu_fd_sc_mcu7t5v0__endcap
XFILLER_33_212 VDD VDD VSS VSS gf180mcu_fd_sc_mcu7t5v0__fillcap_32
XTAP_TAPCELL_ROW_31_424 VDD VSS gf180mcu_fd_sc_mcu7t5v0__filltie
XFILLER_18_297 VDD VDD VSS VSS gf180mcu_fd_sc_mcu7t5v0__fill_2
X_0913_ _0913_/A1 _0913_/A2 wire529/I VDD VDD VSS VSS gf180mcu_fd_sc_mcu7t5v0__nor2_4
X_0844_ _1250_/A1 _1554_/Q _1556_/Q _1254_/A1 _0922_/A2 VDD VDD VSS VSS gf180mcu_fd_sc_mcu7t5v0__nand4_4
X_0775_ wire746/Z _1543_/Q _0778_/S _1543_/D VDD VDD VSS VSS gf180mcu_fd_sc_mcu7t5v0__mux2_2
XPHY_EDGE_ROW_65_Right_65 VDD VSS gf180mcu_fd_sc_mcu7t5v0__endcap
X_1258_ _1582_/Q wire476/Z _1259_/B VDD VDD VSS VSS gf180mcu_fd_sc_mcu7t5v0__nand2_1
X_1189_ _1189_/A1 wire598/Z _1241_/B1 _1189_/B2 _1190_/A4 VDD VDD VSS VSS gf180mcu_fd_sc_mcu7t5v0__aoi22_1
X_1327_ _1642_/Q wire736/Z _1330_/S _1642_/D VDD VDD VSS VSS gf180mcu_fd_sc_mcu7t5v0__mux2_2
XPHY_EDGE_ROW_74_Right_74 VDD VSS gf180mcu_fd_sc_mcu7t5v0__endcap
XFILLER_74_101 VDD VDD VSS VSS gf180mcu_fd_sc_mcu7t5v0__fillcap_4
XFILLER_59_142 VDD VDD VSS VSS gf180mcu_fd_sc_mcu7t5v0__fillcap_32
XFILLER_70_373 VDD VDD VSS VSS gf180mcu_fd_sc_mcu7t5v0__fillcap_8
XTAP_TAPCELL_ROW_45_538 VDD VSS gf180mcu_fd_sc_mcu7t5v0__filltie
XTAP_TAPCELL_ROW_2_193 VDD VSS gf180mcu_fd_sc_mcu7t5v0__filltie
XFILLER_7_422 VDD VDD VSS VSS gf180mcu_fd_sc_mcu7t5v0__fillcap_64
XFILLER_11_473 VDD VDD VSS VSS gf180mcu_fd_sc_mcu7t5v0__fill_2
XFILLER_2_171 VDD VDD VSS VSS gf180mcu_fd_sc_mcu7t5v0__fillcap_4
XFILLER_53_318 VDD VDD VSS VSS gf180mcu_fd_sc_mcu7t5v0__fill_2
X_1043_ _1043_/A1 wire573/Z wire568/Z _1043_/B2 _1045_/A3 VDD VDD VSS VSS gf180mcu_fd_sc_mcu7t5v0__aoi22_4
X_1112_ _1112_/A1 _1112_/A2 _1122_/A1 VDD VDD VSS VSS gf180mcu_fd_sc_mcu7t5v0__nand2_1
XFILLER_19_540 VDD VDD VSS VSS gf180mcu_fd_sc_mcu7t5v0__fillcap_4
XFILLER_19_562 VDD VDD VSS VSS gf180mcu_fd_sc_mcu7t5v0__fillcap_4
XFILLER_61_362 VDD VDD VSS VSS gf180mcu_fd_sc_mcu7t5v0__fill_2
XFILLER_9_72 VDD VDD VSS VSS gf180mcu_fd_sc_mcu7t5v0__fillcap_16
XFILLER_21_226 VDD VDD VSS VSS gf180mcu_fd_sc_mcu7t5v0__fill_2
X_0827_ _1561_/Q _1600_/Q _0832_/S _1561_/D VDD VDD VSS VSS gf180mcu_fd_sc_mcu7t5v0__mux2_2
X_0758_ _0782_/B _0795_/A2 VDD VDD VSS VSS gf180mcu_fd_sc_mcu7t5v0__clkinv_1
XTAP_TAPCELL_ROW_42_508 VDD VSS gf180mcu_fd_sc_mcu7t5v0__filltie
XTAP_TAPCELL_ROW_50_574 VDD VSS gf180mcu_fd_sc_mcu7t5v0__filltie
XFILLER_69_66 VDD VDD VSS VSS gf180mcu_fd_sc_mcu7t5v0__fillcap_4
XTAP_TAPCELL_ROW_7_230 VDD VSS gf180mcu_fd_sc_mcu7t5v0__filltie
XTAP_TAPCELL_ROW_58_641 VDD VSS gf180mcu_fd_sc_mcu7t5v0__filltie
XFILLER_47_123 VDD VDD VSS VSS gf180mcu_fd_sc_mcu7t5v0__fillcap_4
XFILLER_47_112 VDD VDD VSS VSS gf180mcu_fd_sc_mcu7t5v0__fill_2
XFILLER_28_381 VDD VDD VSS VSS gf180mcu_fd_sc_mcu7t5v0__fillcap_4
XFILLER_43_340 VDD VDD VSS VSS gf180mcu_fd_sc_mcu7t5v0__fill_1
XFILLER_31_535 VDD VDD VSS VSS gf180mcu_fd_sc_mcu7t5v0__fill_2
X_1592_ _1592_/D _1594_/RN clkload7/I _1592_/Q VDD VDD VSS VSS gf180mcu_fd_sc_mcu7t5v0__dffrnq_1
XTAP_TAPCELL_ROW_13_276 VDD VSS gf180mcu_fd_sc_mcu7t5v0__filltie
X_1661_ _1661_/D _1661_/RN clkload3/I _1661_/Q VDD VDD VSS VSS gf180mcu_fd_sc_mcu7t5v0__dffrnq_1
XFILLER_38_134 VDD VDD VSS VSS gf180mcu_fd_sc_mcu7t5v0__fillcap_32
XFILLER_38_123 VDD VDD VSS VSS gf180mcu_fd_sc_mcu7t5v0__fill_2
XFILLER_22_2 VDD VDD VSS VSS gf180mcu_fd_sc_mcu7t5v0__fill_1
XTAP_TAPCELL_ROW_64_688 VDD VSS gf180mcu_fd_sc_mcu7t5v0__filltie
X_1026_ _1026_/A1 _1026_/A2 _1026_/A3 _1026_/A4 _1060_/A2 VDD VDD VSS VSS gf180mcu_fd_sc_mcu7t5v0__nand4_1
XFILLER_53_137 VDD VDD VSS VSS gf180mcu_fd_sc_mcu7t5v0__fill_2
XFILLER_34_395 VDD VDD VSS VSS gf180mcu_fd_sc_mcu7t5v0__fill_1
XFILLER_69_292 VDD VDD VSS VSS gf180mcu_fd_sc_mcu7t5v0__fill_1
XFILLER_57_498 VDD VDD VSS VSS gf180mcu_fd_sc_mcu7t5v0__fill_1
XFILLER_57_487 VDD VDD VSS VSS gf180mcu_fd_sc_mcu7t5v0__fill_2
XFILLER_44_115 VDD VDD VSS VSS gf180mcu_fd_sc_mcu7t5v0__fillcap_4
XFILLER_44_104 VDD VDD VSS VSS gf180mcu_fd_sc_mcu7t5v0__fill_1
XTAP_TAPCELL_ROW_4_211 VDD VSS gf180mcu_fd_sc_mcu7t5v0__filltie
XFILLER_52_170 VDD VDD VSS VSS gf180mcu_fd_sc_mcu7t5v0__fillcap_4
XFILLER_40_387 VDD VDD VSS VSS gf180mcu_fd_sc_mcu7t5v0__fillcap_8
XFILLER_40_365 VDD VDD VSS VSS gf180mcu_fd_sc_mcu7t5v0__fillcap_8
XTAP_TAPCELL_ROW_10_257 VDD VSS gf180mcu_fd_sc_mcu7t5v0__filltie
XFILLER_48_454 VDD VDD VSS VSS gf180mcu_fd_sc_mcu7t5v0__fill_1
XFILLER_63_424 VDD VDD VSS VSS gf180mcu_fd_sc_mcu7t5v0__fill_1
XFILLER_50_107 VDD VDD VSS VSS gf180mcu_fd_sc_mcu7t5v0__fillcap_32
XFILLER_48_465 VDD VDD VSS VSS gf180mcu_fd_sc_mcu7t5v0__fillcap_4
XFILLER_31_398 VDD VDD VSS VSS gf180mcu_fd_sc_mcu7t5v0__fill_1
X_1575_ _1575_/D _1575_/RN _1575_/CLK _1575_/Q VDD VDD VSS VSS gf180mcu_fd_sc_mcu7t5v0__dffrnq_1
X_1644_ _1644_/D _1644_/RN _1670_/CLK _1644_/Q VDD VDD VSS VSS gf180mcu_fd_sc_mcu7t5v0__dffrnq_1
XTAP_TAPCELL_ROW_77_791 VDD VSS gf180mcu_fd_sc_mcu7t5v0__filltie
XTAP_TAPCELL_ROW_69_725 VDD VSS gf180mcu_fd_sc_mcu7t5v0__filltie
XPHY_EDGE_ROW_16_Left_98 VDD VSS gf180mcu_fd_sc_mcu7t5v0__endcap
XFILLER_26_104 VDD VDD VSS VSS gf180mcu_fd_sc_mcu7t5v0__fill_1
X_1009_ _1009_/A1 _1185_/B1 _1116_/B1 _1484_/Q _1010_/A4 VDD VDD VSS VSS gf180mcu_fd_sc_mcu7t5v0__aoi22_1
XFILLER_26_148 VDD VDD VSS VSS gf180mcu_fd_sc_mcu7t5v0__fillcap_4
XFILLER_66_34 VDD VDD VSS VSS gf180mcu_fd_sc_mcu7t5v0__fill_1
XFILLER_9_6 VDD VDD VSS VSS gf180mcu_fd_sc_mcu7t5v0__fill_2
XFILLER_32_118 VDD VDD VSS VSS gf180mcu_fd_sc_mcu7t5v0__fill_2
XFILLER_32_107 VDD VDD VSS VSS gf180mcu_fd_sc_mcu7t5v0__fill_1
XFILLER_17_148 VDD VDD VSS VSS gf180mcu_fd_sc_mcu7t5v0__fill_2
XFILLER_40_173 VDD VDD VSS VSS gf180mcu_fd_sc_mcu7t5v0__fill_2
XFILLER_9_336 VDD VDD VSS VSS gf180mcu_fd_sc_mcu7t5v0__fillcap_8
XFILLER_9_314 VDD VDD VSS VSS gf180mcu_fd_sc_mcu7t5v0__fillcap_4
XTAP_TAPCELL_ROW_23_360 VDD VSS gf180mcu_fd_sc_mcu7t5v0__filltie
X_1360_ _1665_/Q _1390_/I0 _1361_/S _1665_/D VDD VDD VSS VSS gf180mcu_fd_sc_mcu7t5v0__mux2_2
XFILLER_68_527 VDD VDD VSS VSS gf180mcu_fd_sc_mcu7t5v0__fillcap_16
XTAP_TAPCELL_ROW_66_706 VDD VSS gf180mcu_fd_sc_mcu7t5v0__filltie
Xinput170 raw_edge1_x[2] _1031_/A1 VDD VDD VSS VSS gf180mcu_fd_sc_mcu7t5v0__buf_1
X_1291_ _1615_/Q wire716/Z _1292_/S _1615_/D VDD VDD VSS VSS gf180mcu_fd_sc_mcu7t5v0__mux2_2
Xinput192 raw_edge1_y[3] _1077_/B2 VDD VDD VSS VSS gf180mcu_fd_sc_mcu7t5v0__buf_1
Xinput181 raw_edge1_y[12] _1115_/A1 VDD VDD VSS VSS gf180mcu_fd_sc_mcu7t5v0__buf_1
XFILLER_44_490 VDD VDD VSS VSS gf180mcu_fd_sc_mcu7t5v0__fillcap_4
XFILLER_23_129 VDD VDD VSS VSS gf180mcu_fd_sc_mcu7t5v0__fill_2
X_1558_ _1558_/D _1564_/RN clkload7/I _1558_/Q VDD VDD VSS VSS gf180mcu_fd_sc_mcu7t5v0__dffrnq_2
X_1627_ _1627_/D wire843/Z clkload5/I _1627_/Q VDD VDD VSS VSS gf180mcu_fd_sc_mcu7t5v0__dffrnq_1
X_1489_ _1489_/D _1494_/RN _1663_/CLK _1489_/Q VDD VDD VSS VSS gf180mcu_fd_sc_mcu7t5v0__dffrnq_2
XTAP_TAPCELL_ROW_37_474 VDD VSS gf180mcu_fd_sc_mcu7t5v0__filltie
XTAP_TAPCELL_ROW_29_408 VDD VSS gf180mcu_fd_sc_mcu7t5v0__filltie
XFILLER_27_435 VDD VDD VSS VSS gf180mcu_fd_sc_mcu7t5v0__fill_1
XFILLER_14_107 VDD VDD VSS VSS gf180mcu_fd_sc_mcu7t5v0__fillcap_16
Xwire716 wire716/I wire716/Z VDD VDD VSS VSS gf180mcu_fd_sc_mcu7t5v0__buf_2
XFILLER_6_317 VDD VDD VSS VSS gf180mcu_fd_sc_mcu7t5v0__fillcap_64
XFILLER_77_346 VDD VDD VSS VSS gf180mcu_fd_sc_mcu7t5v0__fillcap_4
XFILLER_77_66 VDD VDD VSS VSS gf180mcu_fd_sc_mcu7t5v0__fillcap_4
Xfanout860 wire867/Z wire863/I VDD VDD VSS VSS gf180mcu_fd_sc_mcu7t5v0__dlyb_1
XFILLER_73_552 VDD VDD VSS VSS gf180mcu_fd_sc_mcu7t5v0__fill_2
XTAP_TAPCELL_ROW_71_742 VDD VSS gf180mcu_fd_sc_mcu7t5v0__filltie
XFILLER_45_232 VDD VDD VSS VSS gf180mcu_fd_sc_mcu7t5v0__fill_1
XFILLER_18_457 VDD VDD VSS VSS gf180mcu_fd_sc_mcu7t5v0__fillcap_8
X_0791_ _1550_/Q _1551_/Q _1552_/Q _0793_/A1 VDD VDD VSS VSS gf180mcu_fd_sc_mcu7t5v0__aoi21_1
X_0860_ _0860_/A1 _0911_/A2 _1157_/A2 VDD VDD VSS VSS gf180mcu_fd_sc_mcu7t5v0__nor2_4
X_1343_ _1343_/I _1382_/A4 VDD VDD VSS VSS gf180mcu_fd_sc_mcu7t5v0__clkinv_1
X_1412_ _1491_/Q _1417_/S _1413_/B VDD VDD VSS VSS gf180mcu_fd_sc_mcu7t5v0__nor2_1
XFILLER_68_357 VDD VDD VSS VSS gf180mcu_fd_sc_mcu7t5v0__fill_2
XFILLER_56_519 VDD VDD VSS VSS gf180mcu_fd_sc_mcu7t5v0__fillcap_4
XFILLER_49_571 VDD VDD VSS VSS gf180mcu_fd_sc_mcu7t5v0__fill_2
XFILLER_36_232 VDD VDD VSS VSS gf180mcu_fd_sc_mcu7t5v0__fillcap_4
X_1274_ _1601_/Q _1364_/I1 _1282_/S _1601_/D VDD VDD VSS VSS gf180mcu_fd_sc_mcu7t5v0__mux2_2
XFILLER_51_279 VDD VDD VSS VSS gf180mcu_fd_sc_mcu7t5v0__fill_1
XFILLER_51_246 VDD VDD VSS VSS gf180mcu_fd_sc_mcu7t5v0__fill_1
XTAP_TAPCELL_ROW_34_444 VDD VSS gf180mcu_fd_sc_mcu7t5v0__filltie
Xclkbuf_leaf_16_clk clkbuf_leaf_0_clk/I _1663_/CLK VDD VDD VSS VSS gf180mcu_fd_sc_mcu7t5v0__clkbuf_8
XFILLER_22_39 VDD VDD VSS VSS gf180mcu_fd_sc_mcu7t5v0__fill_1
X_0989_ _0989_/A1 _1103_/B1 _1197_/A2 _0989_/B2 _0990_/A4 VDD VDD VSS VSS gf180mcu_fd_sc_mcu7t5v0__aoi22_4
Xoutput441 _1665_/Q cfg_phase90_offset_x[6] VDD VDD VSS VSS gf180mcu_fd_sc_mcu7t5v0__buf_2
Xoutput452 _1504_/Q cfg_phase90_offset_y[16] VDD VDD VSS VSS gf180mcu_fd_sc_mcu7t5v0__buf_2
Xoutput430 _1674_/Q cfg_phase90_offset_x[15] VDD VDD VSS VSS gf180mcu_fd_sc_mcu7t5v0__buf_2
XFILLER_47_508 VDD VDD VSS VSS gf180mcu_fd_sc_mcu7t5v0__fill_2
Xoutput463 _1516_/Q cfg_phase90_offset_y[7] VDD VDD VSS VSS gf180mcu_fd_sc_mcu7t5v0__buf_2
XFILLER_42_213 VDD VDD VSS VSS gf180mcu_fd_sc_mcu7t5v0__fill_1
XFILLER_27_298 VDD VDD VSS VSS gf180mcu_fd_sc_mcu7t5v0__fill_2
XFILLER_27_254 VDD VDD VSS VSS gf180mcu_fd_sc_mcu7t5v0__fillcap_8
XFILLER_15_438 VDD VDD VSS VSS gf180mcu_fd_sc_mcu7t5v0__fillcap_4
Xwire557 wire557/I wire557/Z VDD VDD VSS VSS gf180mcu_fd_sc_mcu7t5v0__buf_2
Xwire579 wire579/I wire579/Z VDD VDD VSS VSS gf180mcu_fd_sc_mcu7t5v0__buf_2
Xwire568 wire568/I wire568/Z VDD VDD VSS VSS gf180mcu_fd_sc_mcu7t5v0__buf_2
Xwire502 wire502/I wire502/Z VDD VDD VSS VSS gf180mcu_fd_sc_mcu7t5v0__clkbuf_1
Xwire535 wire535/I wire535/Z VDD VDD VSS VSS gf180mcu_fd_sc_mcu7t5v0__buf_2
XFILLER_10_198 VDD VDD VSS VSS gf180mcu_fd_sc_mcu7t5v0__fillcap_16
Xload_slew518 _1220_/B1 _1197_/B1 VDD VDD VSS VSS gf180mcu_fd_sc_mcu7t5v0__buf_2
XTAP_TAPCELL_ROW_48_558 VDD VSS gf180mcu_fd_sc_mcu7t5v0__filltie
X_0912_ _0912_/A1 _0916_/A2 _1023_/B1 VDD VDD VSS VSS gf180mcu_fd_sc_mcu7t5v0__nor2_4
XFILLER_33_268 VDD VDD VSS VSS gf180mcu_fd_sc_mcu7t5v0__fill_2
XTAP_TAPCELL_ROW_31_425 VDD VSS gf180mcu_fd_sc_mcu7t5v0__filltie
XFILLER_21_419 VDD VDD VSS VSS gf180mcu_fd_sc_mcu7t5v0__fill_1
X_0843_ _1257_/A1 _1558_/Q _1560_/Q _0843_/Z VDD VDD VSS VSS gf180mcu_fd_sc_mcu7t5v0__or3_1
X_0774_ _0774_/I0 _1542_/Q _0778_/S _1542_/D VDD VDD VSS VSS gf180mcu_fd_sc_mcu7t5v0__mux2_2
Xclkbuf_leaf_5_clk clkbuf_leaf_8_clk/I clkload7/I VDD VDD VSS VSS gf180mcu_fd_sc_mcu7t5v0__clkbuf_8
XFILLER_68_165 VDD VDD VSS VSS gf180mcu_fd_sc_mcu7t5v0__fillcap_8
X_1326_ wire685/Z _1330_/S _1326_/B _1641_/D VDD VDD VSS VSS gf180mcu_fd_sc_mcu7t5v0__aoi21_1
X_1257_ _1257_/A1 wire476/Z _1257_/B _1581_/D VDD VDD VSS VSS gf180mcu_fd_sc_mcu7t5v0__oai21_1
X_1188_ _1188_/A1 _1188_/A2 _1218_/B1 _1473_/Q _1190_/A3 VDD VDD VSS VSS gf180mcu_fd_sc_mcu7t5v0__aoi22_1
XFILLER_12_419 VDD VDD VSS VSS gf180mcu_fd_sc_mcu7t5v0__fillcap_8
XFILLER_74_34 VDD VDD VSS VSS gf180mcu_fd_sc_mcu7t5v0__fill_1
XFILLER_59_176 VDD VDD VSS VSS gf180mcu_fd_sc_mcu7t5v0__fill_1
XFILLER_43_500 VDD VDD VSS VSS gf180mcu_fd_sc_mcu7t5v0__fill_2
XFILLER_43_511 VDD VDD VSS VSS gf180mcu_fd_sc_mcu7t5v0__fillcap_4
XTAP_TAPCELL_ROW_45_539 VDD VSS gf180mcu_fd_sc_mcu7t5v0__filltie
XPHY_EDGE_ROW_4_Left_86 VDD VSS gf180mcu_fd_sc_mcu7t5v0__endcap
XTAP_TAPCELL_ROW_2_194 VDD VSS gf180mcu_fd_sc_mcu7t5v0__filltie
XFILLER_23_290 VDD VDD VSS VSS gf180mcu_fd_sc_mcu7t5v0__fillcap_8
XFILLER_11_496 VDD VDD VSS VSS gf180mcu_fd_sc_mcu7t5v0__fill_2
XFILLER_65_146 VDD VDD VSS VSS gf180mcu_fd_sc_mcu7t5v0__fill_1
X_1111_ wire642/Z _1109_/Z _1111_/A3 _1111_/B _1571_/D VDD VDD VSS VSS gf180mcu_fd_sc_mcu7t5v0__oai31_1
XFILLER_61_352 VDD VDD VSS VSS gf180mcu_fd_sc_mcu7t5v0__fillcap_4
X_1042_ _1042_/A1 _1218_/A2 _1231_/A2 input6/Z _1045_/A2 VDD VDD VSS VSS gf180mcu_fd_sc_mcu7t5v0__aoi22_1
XFILLER_46_382 VDD VDD VSS VSS gf180mcu_fd_sc_mcu7t5v0__fill_2
X_0757_ _1552_/Q _1550_/Q _1551_/Q _0757_/A4 wire607/I VDD VDD VSS VSS gf180mcu_fd_sc_mcu7t5v0__nand4_4
X_0826_ _0826_/A1 _0826_/A2 _1560_/D VDD VDD VSS VSS gf180mcu_fd_sc_mcu7t5v0__nand2_1
XFILLER_69_474 VDD VDD VSS VSS gf180mcu_fd_sc_mcu7t5v0__fill_1
Xload_slew882 _1589_/RN _1590_/RN VDD VDD VSS VSS gf180mcu_fd_sc_mcu7t5v0__buf_2
X_1309_ _1440_/A1 _1313_/S _1309_/B _1628_/D VDD VDD VSS VSS gf180mcu_fd_sc_mcu7t5v0__oai21_1
XFILLER_44_37 VDD VDD VSS VSS gf180mcu_fd_sc_mcu7t5v0__fill_1
XTAP_TAPCELL_ROW_42_509 VDD VSS gf180mcu_fd_sc_mcu7t5v0__filltie
XFILLER_12_205 VDD VDD VSS VSS gf180mcu_fd_sc_mcu7t5v0__fillcap_4
XTAP_TAPCELL_ROW_50_575 VDD VSS gf180mcu_fd_sc_mcu7t5v0__filltie
XTAP_TAPCELL_ROW_7_231 VDD VSS gf180mcu_fd_sc_mcu7t5v0__filltie
XTAP_TAPCELL_ROW_58_642 VDD VSS gf180mcu_fd_sc_mcu7t5v0__filltie
XFILLER_70_171 VDD VDD VSS VSS gf180mcu_fd_sc_mcu7t5v0__fillcap_4
XFILLER_43_385 VDD VDD VSS VSS gf180mcu_fd_sc_mcu7t5v0__fillcap_4
XFILLER_11_271 VDD VDD VSS VSS gf180mcu_fd_sc_mcu7t5v0__fillcap_8
XFILLER_11_282 VDD VDD VSS VSS gf180mcu_fd_sc_mcu7t5v0__fillcap_32
XTAP_TAPCELL_ROW_13_277 VDD VSS gf180mcu_fd_sc_mcu7t5v0__filltie
X_1591_ _1591_/D wire805/Z clkload2/I _1591_/Q VDD VDD VSS VSS gf180mcu_fd_sc_mcu7t5v0__dffrnq_1
X_1660_ _1660_/D _1665_/RN clkload0/I _1660_/Q VDD VDD VSS VSS gf180mcu_fd_sc_mcu7t5v0__dffrnq_1
XFILLER_3_492 VDD VDD VSS VSS gf180mcu_fd_sc_mcu7t5v0__fillcap_32
XTAP_TAPCELL_ROW_64_689 VDD VSS gf180mcu_fd_sc_mcu7t5v0__filltie
X_1025_ _1603_/Q _1198_/A2 _1025_/B1 _1025_/B2 _1026_/A4 VDD VDD VSS VSS gf180mcu_fd_sc_mcu7t5v0__aoi22_1
XFILLER_14_18 VDD VDD VSS VSS gf180mcu_fd_sc_mcu7t5v0__fill_1
X_0809_ _1563_/Q _0805_/B _0806_/B _1557_/Q _0810_/B VDD VDD VSS VSS gf180mcu_fd_sc_mcu7t5v0__aoi22_1
XFILLER_39_48 VDD VDD VSS VSS gf180mcu_fd_sc_mcu7t5v0__fillcap_4
XFILLER_69_282 VDD VDD VSS VSS gf180mcu_fd_sc_mcu7t5v0__fillcap_8
XTAP_TAPCELL_ROW_55_612 VDD VSS gf180mcu_fd_sc_mcu7t5v0__filltie
XTAP_TAPCELL_ROW_10_258 VDD VSS gf180mcu_fd_sc_mcu7t5v0__filltie
XFILLER_48_433 VDD VDD VSS VSS gf180mcu_fd_sc_mcu7t5v0__fill_2
XFILLER_35_138 VDD VDD VSS VSS gf180mcu_fd_sc_mcu7t5v0__fill_2
XTAP_TAPCELL_ROW_26_380 VDD VSS gf180mcu_fd_sc_mcu7t5v0__filltie
X_1643_ _1643_/D _1652_/RN _1659_/CLK _1643_/Q VDD VDD VSS VSS gf180mcu_fd_sc_mcu7t5v0__dffrnq_1
XTAP_TAPCELL_ROW_69_726 VDD VSS gf180mcu_fd_sc_mcu7t5v0__filltie
X_1574_ _1574_/D wire887/Z _1575_/CLK _1574_/Q VDD VDD VSS VSS gf180mcu_fd_sc_mcu7t5v0__dffrnq_1
XFILLER_81_233 VDD VDD VSS VSS gf180mcu_fd_sc_mcu7t5v0__fillcap_4
XFILLER_81_222 VDD VDD VSS VSS gf180mcu_fd_sc_mcu7t5v0__fill_2
XTAP_TAPCELL_ROW_77_792 VDD VSS gf180mcu_fd_sc_mcu7t5v0__filltie
XFILLER_39_422 VDD VDD VSS VSS gf180mcu_fd_sc_mcu7t5v0__fill_1
XFILLER_19_190 VDD VDD VSS VSS gf180mcu_fd_sc_mcu7t5v0__fill_1
X_1008_ _1647_/Q wire593/Z _1174_/A2 _1008_/B2 _1010_/A3 VDD VDD VSS VSS gf180mcu_fd_sc_mcu7t5v0__aoi22_1
XFILLER_57_274 VDD VDD VSS VSS gf180mcu_fd_sc_mcu7t5v0__fillcap_4
XFILLER_25_193 VDD VDD VSS VSS gf180mcu_fd_sc_mcu7t5v0__fill_1
XFILLER_9_348 VDD VDD VSS VSS gf180mcu_fd_sc_mcu7t5v0__fill_2
XFILLER_5_532 VDD VDD VSS VSS gf180mcu_fd_sc_mcu7t5v0__fill_2
XTAP_TAPCELL_ROW_23_361 VDD VSS gf180mcu_fd_sc_mcu7t5v0__filltie
XFILLER_31_93 VDD VDD VSS VSS gf180mcu_fd_sc_mcu7t5v0__fill_2
XFILLER_76_561 VDD VDD VSS VSS gf180mcu_fd_sc_mcu7t5v0__fill_1
XTAP_TAPCELL_ROW_66_707 VDD VSS gf180mcu_fd_sc_mcu7t5v0__filltie
Xinput160 raw_edge1_x[12] _1142_/A1 VDD VDD VSS VSS gf180mcu_fd_sc_mcu7t5v0__buf_1
Xinput171 raw_edge1_x[3] _1075_/A1 VDD VDD VSS VSS gf180mcu_fd_sc_mcu7t5v0__buf_1
Xinput182 raw_edge1_y[13] _1174_/A1 VDD VDD VSS VSS gf180mcu_fd_sc_mcu7t5v0__buf_1
X_1290_ _1614_/Q _1328_/I1 _1292_/S _1614_/D VDD VDD VSS VSS gf180mcu_fd_sc_mcu7t5v0__mux2_2
Xinput193 raw_edge1_y[4] _1119_/C2 VDD VDD VSS VSS gf180mcu_fd_sc_mcu7t5v0__buf_1
X_1626_ _1626_/D _1626_/RN clkload6/I _1626_/Q VDD VDD VSS VSS gf180mcu_fd_sc_mcu7t5v0__dffrnq_1
XFILLER_8_381 VDD VDD VSS VSS gf180mcu_fd_sc_mcu7t5v0__fillcap_4
X_1557_ _1557_/D _1557_/RN _1597_/CLK _1557_/Q VDD VDD VSS VSS gf180mcu_fd_sc_mcu7t5v0__dffrnq_4
XTAP_TAPCELL_ROW_29_409 VDD VSS gf180mcu_fd_sc_mcu7t5v0__filltie
X_1488_ _1488_/D _1629_/RN _1629_/CLK _1488_/Q VDD VDD VSS VSS gf180mcu_fd_sc_mcu7t5v0__dffrnq_2
XFILLER_42_439 VDD VDD VSS VSS gf180mcu_fd_sc_mcu7t5v0__fill_1
XTAP_TAPCELL_ROW_37_475 VDD VSS gf180mcu_fd_sc_mcu7t5v0__filltie
XFILLER_52_59 VDD VDD VSS VSS gf180mcu_fd_sc_mcu7t5v0__fillcap_8
Xwire706 wire706/I wire706/Z VDD VDD VSS VSS gf180mcu_fd_sc_mcu7t5v0__buf_2
XFILLER_10_314 VDD VDD VSS VSS gf180mcu_fd_sc_mcu7t5v0__fill_1
XFILLER_22_174 VDD VDD VSS VSS gf180mcu_fd_sc_mcu7t5v0__fill_1
XFILLER_2_535 VDD VDD VSS VSS gf180mcu_fd_sc_mcu7t5v0__fillcap_4
XTAP_TAPCELL_ROW_71_743 VDD VSS gf180mcu_fd_sc_mcu7t5v0__filltie
XFILLER_60_247 VDD VDD VSS VSS gf180mcu_fd_sc_mcu7t5v0__fill_2
XFILLER_60_236 VDD VDD VSS VSS gf180mcu_fd_sc_mcu7t5v0__fill_2
XFILLER_45_266 VDD VDD VSS VSS gf180mcu_fd_sc_mcu7t5v0__fillcap_4
XFILLER_41_494 VDD VDD VSS VSS gf180mcu_fd_sc_mcu7t5v0__fill_1
XFILLER_33_417 VDD VDD VSS VSS gf180mcu_fd_sc_mcu7t5v0__fill_2
XFILLER_13_174 VDD VDD VSS VSS gf180mcu_fd_sc_mcu7t5v0__fillcap_8
X_0790_ _1552_/Q _0790_/A2 _0793_/B VDD VDD VSS VSS gf180mcu_fd_sc_mcu7t5v0__nand2_1
XTAP_TAPCELL_ROW_79_810 VDD VSS gf180mcu_fd_sc_mcu7t5v0__filltie
XPHY_EDGE_ROW_79_Left_161 VDD VSS gf180mcu_fd_sc_mcu7t5v0__endcap
XFILLER_68_314 VDD VDD VSS VSS gf180mcu_fd_sc_mcu7t5v0__fill_1
X_1411_ _1490_/Q wire747/I _1416_/S _1490_/D VDD VDD VSS VSS gf180mcu_fd_sc_mcu7t5v0__mux2_2
X_1273_ _0771_/Z _1445_/A3 _1331_/A3 _1282_/S VDD VDD VSS VSS gf180mcu_fd_sc_mcu7t5v0__and3_4
X_1342_ _1579_/Q _1428_/A1 _1373_/A3 _1343_/I VDD VDD VSS VSS gf180mcu_fd_sc_mcu7t5v0__nand3_2
XFILLER_36_255 VDD VDD VSS VSS gf180mcu_fd_sc_mcu7t5v0__fillcap_4
XFILLER_24_428 VDD VDD VSS VSS gf180mcu_fd_sc_mcu7t5v0__fillcap_4
X_0988_ input67/Z _1154_/A2 _1154_/B1 _0988_/B2 _0988_/C1 _1070_/B1 _0990_/A3 VDD
+ VDD VSS VSS gf180mcu_fd_sc_mcu7t5v0__aoi222_2
XTAP_TAPCELL_ROW_34_445 VDD VSS gf180mcu_fd_sc_mcu7t5v0__filltie
Xoutput464 _1517_/Q cfg_phase90_offset_y[8] VDD VDD VSS VSS gf180mcu_fd_sc_mcu7t5v0__buf_2
Xoutput453 _1505_/Q cfg_phase90_offset_y[17] VDD VDD VSS VSS gf180mcu_fd_sc_mcu7t5v0__buf_2
X_1609_ _1609_/D _1646_/RN _1674_/CLK _1609_/Q VDD VDD VSS VSS gf180mcu_fd_sc_mcu7t5v0__dffrnq_1
Xoutput431 _1654_/Q cfg_phase90_offset_x[16] VDD VDD VSS VSS gf180mcu_fd_sc_mcu7t5v0__buf_2
Xoutput442 _1666_/Q cfg_phase90_offset_x[7] VDD VDD VSS VSS gf180mcu_fd_sc_mcu7t5v0__buf_2
Xoutput420 _1531_/Q cfg_phase270_offset_y[6] VDD VDD VSS VSS gf180mcu_fd_sc_mcu7t5v0__buf_2
XFILLER_74_317 VDD VDD VSS VSS gf180mcu_fd_sc_mcu7t5v0__fillcap_64
XFILLER_63_58 VDD VDD VSS VSS gf180mcu_fd_sc_mcu7t5v0__fillcap_8
XFILLER_42_247 VDD VDD VSS VSS gf180mcu_fd_sc_mcu7t5v0__fillcap_16
XFILLER_10_100 VDD VDD VSS VSS gf180mcu_fd_sc_mcu7t5v0__fillcap_4
Xwire536 wire536/I wire536/Z VDD VDD VSS VSS gf180mcu_fd_sc_mcu7t5v0__buf_2
Xwire547 wire547/I wire547/Z VDD VDD VSS VSS gf180mcu_fd_sc_mcu7t5v0__buf_2
Xwire558 wire559/Z wire558/Z VDD VDD VSS VSS gf180mcu_fd_sc_mcu7t5v0__buf_2
XFILLER_50_291 VDD VDD VSS VSS gf180mcu_fd_sc_mcu7t5v0__fillcap_16
XFILLER_10_122 VDD VDD VSS VSS gf180mcu_fd_sc_mcu7t5v0__fillcap_4
XFILLER_10_177 VDD VDD VSS VSS gf180mcu_fd_sc_mcu7t5v0__fillcap_4
XFILLER_12_84 VDD VDD VSS VSS gf180mcu_fd_sc_mcu7t5v0__fillcap_4
XFILLER_23_494 VDD VDD VSS VSS gf180mcu_fd_sc_mcu7t5v0__fill_1
Xload_slew519 _1156_/B1 _1231_/A2 VDD VDD VSS VSS gf180mcu_fd_sc_mcu7t5v0__buf_2
XFILLER_2_387 VDD VDD VSS VSS gf180mcu_fd_sc_mcu7t5v0__fillcap_64
XTAP_TAPCELL_ROW_48_559 VDD VSS gf180mcu_fd_sc_mcu7t5v0__filltie
XFILLER_18_211 VDD VDD VSS VSS gf180mcu_fd_sc_mcu7t5v0__fill_1
XFILLER_18_233 VDD VDD VSS VSS gf180mcu_fd_sc_mcu7t5v0__fillcap_8
X_0842_ wire636/Z _0854_/A1 _0998_/A2 VDD VDD VSS VSS gf180mcu_fd_sc_mcu7t5v0__nor2_4
X_0911_ _0911_/A1 _0911_/A2 _1143_/B1 VDD VDD VSS VSS gf180mcu_fd_sc_mcu7t5v0__nor2_4
XTAP_TAPCELL_ROW_31_426 VDD VSS gf180mcu_fd_sc_mcu7t5v0__filltie
XFILLER_14_450 VDD VDD VSS VSS gf180mcu_fd_sc_mcu7t5v0__fillcap_4
X_0773_ wire771/I _1541_/Q _0778_/S _1541_/D VDD VDD VSS VSS gf180mcu_fd_sc_mcu7t5v0__mux2_2
XFILLER_56_317 VDD VDD VSS VSS gf180mcu_fd_sc_mcu7t5v0__fill_2
X_1256_ _1581_/Q wire476/Z _1257_/B VDD VDD VSS VSS gf180mcu_fd_sc_mcu7t5v0__nand2_1
XFILLER_37_542 VDD VDD VSS VSS gf180mcu_fd_sc_mcu7t5v0__fill_2
XFILLER_29_509 VDD VDD VSS VSS gf180mcu_fd_sc_mcu7t5v0__fillcap_4
X_1325_ _1641_/Q _1330_/S _1326_/B VDD VDD VSS VSS gf180mcu_fd_sc_mcu7t5v0__nor2_1
X_1187_ _1187_/A1 wire570/Z wire551/Z _1187_/B2 _1515_/Q _1216_/A2 _1190_/A2 VDD VDD
+ VSS VSS gf180mcu_fd_sc_mcu7t5v0__aoi222_2
XFILLER_59_199 VDD VDD VSS VSS gf180mcu_fd_sc_mcu7t5v0__fillcap_8
XTAP_TAPCELL_ROW_2_195 VDD VSS gf180mcu_fd_sc_mcu7t5v0__filltie
XFILLER_65_136 VDD VDD VSS VSS gf180mcu_fd_sc_mcu7t5v0__fillcap_4
X_1110_ _1570_/Q _1245_/A2 _1111_/A3 VDD VDD VSS VSS gf180mcu_fd_sc_mcu7t5v0__nor2_1
XFILLER_38_317 VDD VDD VSS VSS gf180mcu_fd_sc_mcu7t5v0__fillcap_4
XFILLER_61_364 VDD VDD VSS VSS gf180mcu_fd_sc_mcu7t5v0__fill_1
X_1041_ _1041_/A1 _1030_/Z _1035_/Z _1040_/Z _1060_/A3 VDD VDD VSS VSS gf180mcu_fd_sc_mcu7t5v0__nand4_1
XFILLER_21_228 VDD VDD VSS VSS gf180mcu_fd_sc_mcu7t5v0__fill_1
X_0825_ _1566_/Q _0796_/S _1091_/A2 _0825_/B2 _0826_/A2 VDD VDD VSS VSS gf180mcu_fd_sc_mcu7t5v0__aoi22_1
X_0756_ _0834_/A1 _1594_/Q _1596_/Q wire668/I VDD VDD VSS VSS gf180mcu_fd_sc_mcu7t5v0__nor3_2
Xload_slew850 _1628_/RN _1624_/RN VDD VDD VSS VSS gf180mcu_fd_sc_mcu7t5v0__buf_2
Xload_slew872 _1575_/RN wire871/I VDD VDD VSS VSS gf180mcu_fd_sc_mcu7t5v0__clkbuf_2
Xload_slew883 _1560_/RN _1589_/RN VDD VDD VSS VSS gf180mcu_fd_sc_mcu7t5v0__clkbuf_2
XFILLER_56_147 VDD VDD VSS VSS gf180mcu_fd_sc_mcu7t5v0__fillcap_8
X_1239_ _1239_/A1 _1239_/A2 _1239_/A3 _1239_/A4 _1243_/A3 VDD VDD VSS VSS gf180mcu_fd_sc_mcu7t5v0__nand4_1
X_1308_ _1628_/Q _1313_/S _1309_/B VDD VDD VSS VSS gf180mcu_fd_sc_mcu7t5v0__nand2_1
XFILLER_60_37 VDD VDD VSS VSS gf180mcu_fd_sc_mcu7t5v0__fillcap_16
XFILLER_52_364 VDD VDD VSS VSS gf180mcu_fd_sc_mcu7t5v0__fill_1
XTAP_TAPCELL_ROW_50_576 VDD VSS gf180mcu_fd_sc_mcu7t5v0__filltie
XFILLER_79_206 VDD VDD VSS VSS gf180mcu_fd_sc_mcu7t5v0__fillcap_4
XTAP_TAPCELL_ROW_7_232 VDD VSS gf180mcu_fd_sc_mcu7t5v0__filltie
XFILLER_75_489 VDD VDD VSS VSS gf180mcu_fd_sc_mcu7t5v0__fill_1
XTAP_TAPCELL_ROW_58_643 VDD VSS gf180mcu_fd_sc_mcu7t5v0__filltie
XFILLER_43_397 VDD VDD VSS VSS gf180mcu_fd_sc_mcu7t5v0__fillcap_16
XTAP_TAPCELL_ROW_13_278 VDD VSS gf180mcu_fd_sc_mcu7t5v0__filltie
X_1590_ _1590_/D _1590_/RN clkload8/I _1590_/Q VDD VDD VSS VSS gf180mcu_fd_sc_mcu7t5v0__dffrnq_1
XFILLER_7_276 VDD VDD VSS VSS gf180mcu_fd_sc_mcu7t5v0__fillcap_4
XFILLER_81_426 VDD VDD VSS VSS gf180mcu_fd_sc_mcu7t5v0__fillcap_8
X_1024_ _1024_/A1 _1099_/A2 wire536/Z _1669_/Q _1026_/A3 VDD VDD VSS VSS gf180mcu_fd_sc_mcu7t5v0__aoi22_1
XFILLER_53_139 VDD VDD VSS VSS gf180mcu_fd_sc_mcu7t5v0__fill_1
XFILLER_61_161 VDD VDD VSS VSS gf180mcu_fd_sc_mcu7t5v0__fillcap_4
X_0808_ _1556_/Q _1254_/A1 _0803_/Z _0893_/A1 VDD VDD VSS VSS gf180mcu_fd_sc_mcu7t5v0__nand3_4
X_0739_ _1549_/Q _0795_/A1 VDD VDD VSS VSS gf180mcu_fd_sc_mcu7t5v0__clkinv_1
Xload_slew680 _0914_/A1 _0898_/A1 VDD VDD VSS VSS gf180mcu_fd_sc_mcu7t5v0__clkbuf_1
XFILLER_39_38 VDD VDD VSS VSS gf180mcu_fd_sc_mcu7t5v0__fill_1
XPHY_EDGE_ROW_24_Left_106 VDD VSS gf180mcu_fd_sc_mcu7t5v0__endcap
Xload_slew691 wire690/I _1413_/A1 VDD VDD VSS VSS gf180mcu_fd_sc_mcu7t5v0__clkbuf_1
XFILLER_72_448 VDD VDD VSS VSS gf180mcu_fd_sc_mcu7t5v0__fillcap_4
XFILLER_57_489 VDD VDD VSS VSS gf180mcu_fd_sc_mcu7t5v0__fill_1
XTAP_TAPCELL_ROW_55_613 VDD VSS gf180mcu_fd_sc_mcu7t5v0__filltie
XFILLER_25_320 VDD VDD VSS VSS gf180mcu_fd_sc_mcu7t5v0__fill_2
XFILLER_25_331 VDD VDD VSS VSS gf180mcu_fd_sc_mcu7t5v0__fill_1
XFILLER_71_58 VDD VDD VSS VSS gf180mcu_fd_sc_mcu7t5v0__fillcap_8
XFILLER_40_312 VDD VDD VSS VSS gf180mcu_fd_sc_mcu7t5v0__fill_2
XPHY_EDGE_ROW_33_Left_115 VDD VSS gf180mcu_fd_sc_mcu7t5v0__endcap
XTAP_TAPCELL_ROW_10_259 VDD VSS gf180mcu_fd_sc_mcu7t5v0__filltie
XPHY_EDGE_ROW_42_Left_124 VDD VSS gf180mcu_fd_sc_mcu7t5v0__endcap
XFILLER_71_492 VDD VDD VSS VSS gf180mcu_fd_sc_mcu7t5v0__fillcap_32
XPHY_EDGE_ROW_51_Left_133 VDD VSS gf180mcu_fd_sc_mcu7t5v0__endcap
XFILLER_43_172 VDD VDD VSS VSS gf180mcu_fd_sc_mcu7t5v0__fillcap_16
XTAP_TAPCELL_ROW_26_381 VDD VSS gf180mcu_fd_sc_mcu7t5v0__filltie
X_1642_ _1642_/D _1644_/RN _1670_/CLK _1642_/Q VDD VDD VSS VSS gf180mcu_fd_sc_mcu7t5v0__dffrnq_1
XFILLER_79_570 VDD VDD VSS VSS gf180mcu_fd_sc_mcu7t5v0__fillcap_4
XTAP_TAPCELL_ROW_69_727 VDD VSS gf180mcu_fd_sc_mcu7t5v0__filltie
X_1573_ _1573_/D _1573_/RN _1575_/CLK _1573_/Q VDD VDD VSS VSS gf180mcu_fd_sc_mcu7t5v0__dffrnq_1
XPHY_EDGE_ROW_60_Left_142 VDD VSS gf180mcu_fd_sc_mcu7t5v0__endcap
XFILLER_58_209 VDD VDD VSS VSS gf180mcu_fd_sc_mcu7t5v0__fillcap_16
XFILLER_81_256 VDD VDD VSS VSS gf180mcu_fd_sc_mcu7t5v0__fillcap_8
XTAP_TAPCELL_ROW_77_793 VDD VSS gf180mcu_fd_sc_mcu7t5v0__filltie
X_1007_ _1007_/A1 _1078_/A2 _1193_/B1 _1007_/B2 _1010_/A2 VDD VDD VSS VSS gf180mcu_fd_sc_mcu7t5v0__aoi22_1
XFILLER_34_172 VDD VDD VSS VSS gf180mcu_fd_sc_mcu7t5v0__fill_2
XFILLER_9_8 VDD VDD VSS VSS gf180mcu_fd_sc_mcu7t5v0__fill_1
XFILLER_57_220 VDD VDD VSS VSS gf180mcu_fd_sc_mcu7t5v0__fill_1
XFILLER_17_139 VDD VDD VSS VSS gf180mcu_fd_sc_mcu7t5v0__fill_1
XFILLER_15_95 VDD VDD VSS VSS gf180mcu_fd_sc_mcu7t5v0__fillcap_4
XTAP_TAPCELL_ROW_23_362 VDD VSS gf180mcu_fd_sc_mcu7t5v0__filltie
Xinput150 jitter_flag_y _0998_/A1 VDD VDD VSS VSS gf180mcu_fd_sc_mcu7t5v0__buf_1
XFILLER_63_256 VDD VDD VSS VSS gf180mcu_fd_sc_mcu7t5v0__fillcap_4
XFILLER_63_212 VDD VDD VSS VSS gf180mcu_fd_sc_mcu7t5v0__fill_1
Xinput183 raw_edge1_y[14] _1191_/A1 VDD VDD VSS VSS gf180mcu_fd_sc_mcu7t5v0__buf_1
Xinput161 raw_edge1_x[13] _1174_/B2 VDD VDD VSS VSS gf180mcu_fd_sc_mcu7t5v0__buf_1
Xinput172 raw_edge1_x[4] _1125_/A1 VDD VDD VSS VSS gf180mcu_fd_sc_mcu7t5v0__buf_1
Xinput194 raw_edge1_y[5] _1159_/B2 VDD VDD VSS VSS gf180mcu_fd_sc_mcu7t5v0__buf_1
XFILLER_31_142 VDD VDD VSS VSS gf180mcu_fd_sc_mcu7t5v0__fillcap_4
XFILLER_16_172 VDD VDD VSS VSS gf180mcu_fd_sc_mcu7t5v0__fill_2
X_1556_ _1556_/D _1585_/RN _1597_/CLK _1556_/Q VDD VDD VSS VSS gf180mcu_fd_sc_mcu7t5v0__dffrnq_4
X_1625_ _1625_/D _1629_/RN _1629_/CLK _1625_/Q VDD VDD VSS VSS gf180mcu_fd_sc_mcu7t5v0__dffrnq_2
XFILLER_67_562 VDD VDD VSS VSS gf180mcu_fd_sc_mcu7t5v0__fillcap_4
XFILLER_27_426 VDD VDD VSS VSS gf180mcu_fd_sc_mcu7t5v0__fill_1
X_1487_ _1487_/D wire829/Z clkload6/I _1487_/Q VDD VDD VSS VSS gf180mcu_fd_sc_mcu7t5v0__dffrnq_1
XFILLER_50_451 VDD VDD VSS VSS gf180mcu_fd_sc_mcu7t5v0__fillcap_4
XFILLER_35_492 VDD VDD VSS VSS gf180mcu_fd_sc_mcu7t5v0__fill_1
Xwire729 wire729/I wire729/Z VDD VDD VSS VSS gf180mcu_fd_sc_mcu7t5v0__buf_1
XTAP_TAPCELL_ROW_20_332 VDD VSS gf180mcu_fd_sc_mcu7t5v0__filltie
XFILLER_22_164 VDD VDD VSS VSS gf180mcu_fd_sc_mcu7t5v0__fill_2
Xfanout884 fanout884/I _1557_/RN VDD VDD VSS VSS gf180mcu_fd_sc_mcu7t5v0__dlyb_1
XFILLER_45_212 VDD VDD VSS VSS gf180mcu_fd_sc_mcu7t5v0__fillcap_16
XTAP_TAPCELL_ROW_71_744 VDD VSS gf180mcu_fd_sc_mcu7t5v0__filltie
XFILLER_9_124 VDD VDD VSS VSS gf180mcu_fd_sc_mcu7t5v0__fillcap_16
XFILLER_13_142 VDD VDD VSS VSS gf180mcu_fd_sc_mcu7t5v0__fillcap_32
XFILLER_47_6 VDD VDD VSS VSS gf180mcu_fd_sc_mcu7t5v0__fill_1
XFILLER_5_352 VDD VDD VSS VSS gf180mcu_fd_sc_mcu7t5v0__fillcap_64
X_1410_ _1410_/I0 wire762/Z _1416_/S _1489_/D VDD VDD VSS VSS gf180mcu_fd_sc_mcu7t5v0__mux2_2
XTAP_TAPCELL_ROW_79_811 VDD VSS gf180mcu_fd_sc_mcu7t5v0__filltie
XFILLER_68_359 VDD VDD VSS VSS gf180mcu_fd_sc_mcu7t5v0__fill_1
XFILLER_49_573 VDD VDD VSS VSS gf180mcu_fd_sc_mcu7t5v0__fill_1
X_1272_ _1272_/I _1331_/A3 VDD VDD VSS VSS gf180mcu_fd_sc_mcu7t5v0__inv_2
X_1341_ _1593_/Q _0771_/Z _1408_/A1 VDD VDD VSS VSS gf180mcu_fd_sc_mcu7t5v0__nand2_1
XFILLER_76_381 VDD VDD VSS VSS gf180mcu_fd_sc_mcu7t5v0__fillcap_4
XFILLER_36_278 VDD VDD VSS VSS gf180mcu_fd_sc_mcu7t5v0__fillcap_16
XTAP_TAPCELL_ROW_34_446 VDD VSS gf180mcu_fd_sc_mcu7t5v0__filltie
XFILLER_17_492 VDD VDD VSS VSS gf180mcu_fd_sc_mcu7t5v0__fillcap_4
X_0987_ _1660_/Q _1087_/A2 _1218_/B1 _1468_/Q _0990_/A2 VDD VDD VSS VSS gf180mcu_fd_sc_mcu7t5v0__aoi22_1
X_1539_ _1539_/D _1539_/RN _1587_/CLK _1539_/Q VDD VDD VSS VSS gf180mcu_fd_sc_mcu7t5v0__dffrnq_1
Xoutput443 _1667_/Q cfg_phase90_offset_x[8] VDD VDD VSS VSS gf180mcu_fd_sc_mcu7t5v0__buf_2
X_1608_ _1608_/D _1648_/RN _1659_/CLK _1608_/Q VDD VDD VSS VSS gf180mcu_fd_sc_mcu7t5v0__dffrnq_2
Xoutput421 _1532_/Q cfg_phase270_offset_y[7] VDD VDD VSS VSS gf180mcu_fd_sc_mcu7t5v0__buf_2
Xoutput454 _1506_/Q cfg_phase90_offset_y[18] VDD VDD VSS VSS gf180mcu_fd_sc_mcu7t5v0__buf_2
Xoutput432 _1655_/Q cfg_phase90_offset_x[17] VDD VDD VSS VSS gf180mcu_fd_sc_mcu7t5v0__buf_2
Xoutput465 _1518_/Q cfg_phase90_offset_y[9] VDD VDD VSS VSS gf180mcu_fd_sc_mcu7t5v0__buf_2
Xoutput410 _1541_/Q cfg_phase270_offset_y[16] VDD VDD VSS VSS gf180mcu_fd_sc_mcu7t5v0__buf_2
XFILLER_63_26 VDD VDD VSS VSS gf180mcu_fd_sc_mcu7t5v0__fillcap_32
Xwire515 wire515/I wire515/Z VDD VDD VSS VSS gf180mcu_fd_sc_mcu7t5v0__buf_2
Xwire559 wire559/I wire559/Z VDD VDD VSS VSS gf180mcu_fd_sc_mcu7t5v0__buf_2
Xwire548 wire548/I wire548/Z VDD VDD VSS VSS gf180mcu_fd_sc_mcu7t5v0__buf_2
XFILLER_2_311 VDD VDD VSS VSS gf180mcu_fd_sc_mcu7t5v0__fillcap_4
Xfanout692 _0736_/ZN _1460_/A1 VDD VDD VSS VSS gf180mcu_fd_sc_mcu7t5v0__dlyb_1
Xload_slew509 _1401_/S _1400_/S VDD VDD VSS VSS gf180mcu_fd_sc_mcu7t5v0__buf_2
XPHY_EDGE_ROW_16_Right_16 VDD VSS gf180mcu_fd_sc_mcu7t5v0__endcap
XFILLER_18_289 VDD VDD VSS VSS gf180mcu_fd_sc_mcu7t5v0__fillcap_8
X_0841_ _1555_/Q _1248_/A1 _1556_/Q _1254_/A1 _0854_/A1 VDD VDD VSS VSS gf180mcu_fd_sc_mcu7t5v0__nand4_4
XFILLER_53_81 VDD VDD VSS VSS gf180mcu_fd_sc_mcu7t5v0__fillcap_4
X_0910_ _0910_/A1 _0923_/A1 _1050_/B1 VDD VDD VSS VSS gf180mcu_fd_sc_mcu7t5v0__nor2_4
XTAP_TAPCELL_ROW_31_427 VDD VSS gf180mcu_fd_sc_mcu7t5v0__filltie
X_0772_ _0749_/Z _1455_/A2 _0771_/Z _0778_/S VDD VDD VSS VSS gf180mcu_fd_sc_mcu7t5v0__nand3_4
XPHY_EDGE_ROW_25_Right_25 VDD VSS gf180mcu_fd_sc_mcu7t5v0__endcap
XFILLER_68_101 VDD VDD VSS VSS gf180mcu_fd_sc_mcu7t5v0__fillcap_4
X_1255_ _1558_/Q _1580_/Q _1255_/S _1580_/D VDD VDD VSS VSS gf180mcu_fd_sc_mcu7t5v0__mux2_2
X_1186_ _1186_/A1 _1238_/B1 _1201_/A1 VDD VDD VSS VSS gf180mcu_fd_sc_mcu7t5v0__nand2_1
XPHY_EDGE_ROW_34_Right_34 VDD VSS gf180mcu_fd_sc_mcu7t5v0__endcap
X_1324_ _1640_/Q wire741/Z _1330_/S _1640_/D VDD VDD VSS VSS gf180mcu_fd_sc_mcu7t5v0__mux2_2
XFILLER_64_395 VDD VDD VSS VSS gf180mcu_fd_sc_mcu7t5v0__fillcap_4
XFILLER_64_384 VDD VDD VSS VSS gf180mcu_fd_sc_mcu7t5v0__fill_1
XFILLER_32_270 VDD VDD VSS VSS gf180mcu_fd_sc_mcu7t5v0__fillcap_32
XPHY_EDGE_ROW_43_Right_43 VDD VSS gf180mcu_fd_sc_mcu7t5v0__endcap
XPHY_EDGE_ROW_52_Right_52 VDD VSS gf180mcu_fd_sc_mcu7t5v0__endcap
XFILLER_43_502 VDD VDD VSS VSS gf180mcu_fd_sc_mcu7t5v0__fill_1
XPHY_EDGE_ROW_61_Right_61 VDD VSS gf180mcu_fd_sc_mcu7t5v0__endcap
XTAP_TAPCELL_ROW_53_596 VDD VSS gf180mcu_fd_sc_mcu7t5v0__filltie
XFILLER_23_51 VDD VDD VSS VSS gf180mcu_fd_sc_mcu7t5v0__fill_1
XFILLER_23_84 VDD VDD VSS VSS gf180mcu_fd_sc_mcu7t5v0__fill_1
XPHY_EDGE_ROW_70_Right_70 VDD VSS gf180mcu_fd_sc_mcu7t5v0__endcap
XFILLER_78_498 VDD VDD VSS VSS gf180mcu_fd_sc_mcu7t5v0__fillcap_8
XFILLER_78_454 VDD VDD VSS VSS gf180mcu_fd_sc_mcu7t5v0__fill_1
X_1040_ _1040_/A1 _1040_/A2 _1040_/A3 _1040_/A4 _1040_/Z VDD VDD VSS VSS gf180mcu_fd_sc_mcu7t5v0__and4_1
XFILLER_48_92 VDD VDD VSS VSS gf180mcu_fd_sc_mcu7t5v0__fillcap_8
XFILLER_80_107 VDD VDD VSS VSS gf180mcu_fd_sc_mcu7t5v0__fillcap_64
XFILLER_46_384 VDD VDD VSS VSS gf180mcu_fd_sc_mcu7t5v0__fill_1
XTAP_TAPCELL_ROW_44_530 VDD VSS gf180mcu_fd_sc_mcu7t5v0__filltie
XFILLER_34_502 VDD VDD VSS VSS gf180mcu_fd_sc_mcu7t5v0__fill_1
X_0755_ _1552_/Q _1550_/Q _1551_/Q _0792_/A1 VDD VDD VSS VSS gf180mcu_fd_sc_mcu7t5v0__nand3_1
X_0824_ _0907_/A1 _0824_/A2 _1091_/A2 VDD VDD VSS VSS gf180mcu_fd_sc_mcu7t5v0__nor2_4
XFILLER_69_410 VDD VDD VSS VSS gf180mcu_fd_sc_mcu7t5v0__fill_2
Xload_slew873 _1575_/RN _1585_/RN VDD VDD VSS VSS gf180mcu_fd_sc_mcu7t5v0__clkbuf_2
Xload_slew862 wire863/Z _1539_/RN VDD VDD VSS VSS gf180mcu_fd_sc_mcu7t5v0__clkbuf_1
Xload_slew851 _1632_/RN _1628_/RN VDD VDD VSS VSS gf180mcu_fd_sc_mcu7t5v0__clkbuf_1
XFILLER_56_115 VDD VDD VSS VSS gf180mcu_fd_sc_mcu7t5v0__fillcap_32
X_1169_ _1606_/Q _1222_/A2 wire558/Z _1169_/B2 _1169_/C1 _1169_/C2 _1171_/A3 VDD VDD
+ VSS VSS gf180mcu_fd_sc_mcu7t5v0__aoi222_2
X_1238_ _1645_/Q wire600/Z _1238_/B1 _1238_/B2 _1239_/A4 VDD VDD VSS VSS gf180mcu_fd_sc_mcu7t5v0__aoi22_4
X_1307_ _1438_/I0 _1627_/Q _1313_/S _1627_/D VDD VDD VSS VSS gf180mcu_fd_sc_mcu7t5v0__mux2_2
XTAP_TAPCELL_ROW_50_577 VDD VSS gf180mcu_fd_sc_mcu7t5v0__filltie
XFILLER_69_58 VDD VDD VSS VSS gf180mcu_fd_sc_mcu7t5v0__fillcap_8
XFILLER_47_137 VDD VDD VSS VSS gf180mcu_fd_sc_mcu7t5v0__fill_2
XFILLER_47_104 VDD VDD VSS VSS gf180mcu_fd_sc_mcu7t5v0__fillcap_8
XTAP_TAPCELL_ROW_7_233 VDD VSS gf180mcu_fd_sc_mcu7t5v0__filltie
XFILLER_62_107 VDD VDD VSS VSS gf180mcu_fd_sc_mcu7t5v0__fillcap_16
XFILLER_55_181 VDD VDD VSS VSS gf180mcu_fd_sc_mcu7t5v0__fillcap_16
XFILLER_43_332 VDD VDD VSS VSS gf180mcu_fd_sc_mcu7t5v0__fillcap_8
XTAP_TAPCELL_ROW_41_500 VDD VSS gf180mcu_fd_sc_mcu7t5v0__filltie
XFILLER_18_73 VDD VDD VSS VSS gf180mcu_fd_sc_mcu7t5v0__fillcap_16
XTAP_TAPCELL_ROW_13_279 VDD VSS gf180mcu_fd_sc_mcu7t5v0__filltie
XFILLER_66_402 VDD VDD VSS VSS gf180mcu_fd_sc_mcu7t5v0__fill_1
XFILLER_66_457 VDD VDD VSS VSS gf180mcu_fd_sc_mcu7t5v0__fill_2
X_1023_ _1023_/A1 wire552/I _1023_/B1 _1023_/B2 _1023_/C1 _1023_/C2 _1026_/A2 VDD
+ VDD VSS VSS gf180mcu_fd_sc_mcu7t5v0__aoi222_4
XFILLER_34_321 VDD VDD VSS VSS gf180mcu_fd_sc_mcu7t5v0__fill_2
XFILLER_22_527 VDD VDD VSS VSS gf180mcu_fd_sc_mcu7t5v0__fillcap_4
X_0738_ _1596_/Q _1592_/D VDD VDD VSS VSS gf180mcu_fd_sc_mcu7t5v0__clkinv_1
X_0807_ _0807_/A1 _0807_/A2 _1556_/D VDD VDD VSS VSS gf180mcu_fd_sc_mcu7t5v0__nand2_1
Xload_slew681 _0911_/A1 _0914_/A1 VDD VDD VSS VSS gf180mcu_fd_sc_mcu7t5v0__buf_2
Xload_slew670 _0858_/A1 _0873_/A1 VDD VDD VSS VSS gf180mcu_fd_sc_mcu7t5v0__clkbuf_1
XPHY_EDGE_ROW_2_Right_2 VDD VSS gf180mcu_fd_sc_mcu7t5v0__endcap
XFILLER_71_26 VDD VDD VSS VSS gf180mcu_fd_sc_mcu7t5v0__fillcap_32
XTAP_TAPCELL_ROW_63_680 VDD VSS gf180mcu_fd_sc_mcu7t5v0__filltie
XTAP_TAPCELL_ROW_55_614 VDD VSS gf180mcu_fd_sc_mcu7t5v0__filltie
XFILLER_52_195 VDD VDD VSS VSS gf180mcu_fd_sc_mcu7t5v0__fillcap_8
XFILLER_52_162 VDD VDD VSS VSS gf180mcu_fd_sc_mcu7t5v0__fillcap_8
XFILLER_44_107 VDD VDD VSS VSS gf180mcu_fd_sc_mcu7t5v0__fillcap_8
XFILLER_4_247 VDD VDD VSS VSS gf180mcu_fd_sc_mcu7t5v0__fillcap_64
XFILLER_75_276 VDD VDD VSS VSS gf180mcu_fd_sc_mcu7t5v0__fillcap_4
XFILLER_48_435 VDD VDD VSS VSS gf180mcu_fd_sc_mcu7t5v0__fill_1
XFILLER_48_413 VDD VDD VSS VSS gf180mcu_fd_sc_mcu7t5v0__fill_2
XTAP_TAPCELL_ROW_18_316 VDD VSS gf180mcu_fd_sc_mcu7t5v0__filltie
XTAP_TAPCELL_ROW_26_382 VDD VSS gf180mcu_fd_sc_mcu7t5v0__filltie
X_1572_ _1572_/D _1573_/RN _1575_/CLK _1572_/Q VDD VDD VSS VSS gf180mcu_fd_sc_mcu7t5v0__dffrnq_1
XFILLER_8_564 VDD VDD VSS VSS gf180mcu_fd_sc_mcu7t5v0__fill_2
X_1641_ _1641_/D wire794/Z _1674_/CLK _1641_/Q VDD VDD VSS VSS gf180mcu_fd_sc_mcu7t5v0__dffrnq_1
XTAP_TAPCELL_ROW_69_728 VDD VSS gf180mcu_fd_sc_mcu7t5v0__filltie
XFILLER_81_224 VDD VDD VSS VSS gf180mcu_fd_sc_mcu7t5v0__fill_1
XTAP_TAPCELL_ROW_77_794 VDD VSS gf180mcu_fd_sc_mcu7t5v0__filltie
XFILLER_66_276 VDD VDD VSS VSS gf180mcu_fd_sc_mcu7t5v0__fillcap_4
XFILLER_54_405 VDD VDD VSS VSS gf180mcu_fd_sc_mcu7t5v0__fill_2
X_1006_ _1006_/A1 _1188_/A2 _1230_/A2 input16/Z _1010_/A1 VDD VDD VSS VSS gf180mcu_fd_sc_mcu7t5v0__aoi22_1
XFILLER_34_151 VDD VDD VSS VSS gf180mcu_fd_sc_mcu7t5v0__fillcap_4
XFILLER_26_107 VDD VDD VSS VSS gf180mcu_fd_sc_mcu7t5v0__fillcap_4
XFILLER_1_206 VDD VDD VSS VSS gf180mcu_fd_sc_mcu7t5v0__fillcap_4
XFILLER_66_37 VDD VDD VSS VSS gf180mcu_fd_sc_mcu7t5v0__fillcap_64
XFILLER_66_26 VDD VDD VSS VSS gf180mcu_fd_sc_mcu7t5v0__fillcap_8
XFILLER_40_165 VDD VDD VSS VSS gf180mcu_fd_sc_mcu7t5v0__fillcap_8
XFILLER_13_368 VDD VDD VSS VSS gf180mcu_fd_sc_mcu7t5v0__fill_1
XTAP_TAPCELL_ROW_23_363 VDD VSS gf180mcu_fd_sc_mcu7t5v0__filltie
XFILLER_21_390 VDD VDD VSS VSS gf180mcu_fd_sc_mcu7t5v0__fillcap_8
Xinput151 latch_error_x _1128_/A1 VDD VDD VSS VSS gf180mcu_fd_sc_mcu7t5v0__buf_1
XFILLER_48_243 VDD VDD VSS VSS gf180mcu_fd_sc_mcu7t5v0__fill_2
Xinput162 raw_edge1_x[14] _1187_/B2 VDD VDD VSS VSS gf180mcu_fd_sc_mcu7t5v0__buf_1
Xinput140 delay_wave_cycle_x[7] _1238_/B2 VDD VDD VSS VSS gf180mcu_fd_sc_mcu7t5v0__buf_1
XTAP_TAPCELL_ROW_74_764 VDD VSS gf180mcu_fd_sc_mcu7t5v0__filltie
XFILLER_63_279 VDD VDD VSS VSS gf180mcu_fd_sc_mcu7t5v0__fill_1
XFILLER_63_224 VDD VDD VSS VSS gf180mcu_fd_sc_mcu7t5v0__fillcap_32
XFILLER_56_81 VDD VDD VSS VSS gf180mcu_fd_sc_mcu7t5v0__fillcap_16
XFILLER_51_419 VDD VDD VSS VSS gf180mcu_fd_sc_mcu7t5v0__fill_1
XFILLER_44_482 VDD VDD VSS VSS gf180mcu_fd_sc_mcu7t5v0__fillcap_8
Xinput184 raw_edge1_y[15] _1237_/A1 VDD VDD VSS VSS gf180mcu_fd_sc_mcu7t5v0__buf_1
Xinput173 raw_edge1_x[5] _1163_/B2 VDD VDD VSS VSS gf180mcu_fd_sc_mcu7t5v0__buf_1
Xinput195 raw_edge1_y[6] _1205_/B2 VDD VDD VSS VSS gf180mcu_fd_sc_mcu7t5v0__buf_1
X_1555_ _1555_/D wire871/Z _1597_/CLK _1555_/Q VDD VDD VSS VSS gf180mcu_fd_sc_mcu7t5v0__dffrnq_4
X_1624_ _1624_/D _1624_/RN _1624_/CLK _1624_/Q VDD VDD VSS VSS gf180mcu_fd_sc_mcu7t5v0__dffrnq_1
XFILLER_67_530 VDD VDD VSS VSS gf180mcu_fd_sc_mcu7t5v0__fillcap_16
X_1486_ _1486_/D _1486_/RN _1593_/CLK _1486_/Q VDD VDD VSS VSS gf180mcu_fd_sc_mcu7t5v0__dffrnq_1
Xclkbuf_leaf_19_clk clkbuf_leaf_0_clk/I _1670_/CLK VDD VDD VSS VSS gf180mcu_fd_sc_mcu7t5v0__clkbuf_8
XFILLER_54_279 VDD VDD VSS VSS gf180mcu_fd_sc_mcu7t5v0__fill_2
XFILLER_42_419 VDD VDD VSS VSS gf180mcu_fd_sc_mcu7t5v0__fill_2
XTAP_TAPCELL_ROW_20_333 VDD VSS gf180mcu_fd_sc_mcu7t5v0__filltie
Xfanout874 wire880/I wire876/I VDD VDD VSS VSS gf180mcu_fd_sc_mcu7t5v0__dlyb_1
Xfanout852 wire867/Z _1521_/RN VDD VDD VSS VSS gf180mcu_fd_sc_mcu7t5v0__dlyb_1
Xfanout830 _1486_/RN _1508_/RN VDD VDD VSS VSS gf180mcu_fd_sc_mcu7t5v0__dlyb_1
Xfanout841 fanout847/I _1509_/RN VDD VDD VSS VSS gf180mcu_fd_sc_mcu7t5v0__dlyb_1
XFILLER_60_238 VDD VDD VSS VSS gf180mcu_fd_sc_mcu7t5v0__fill_1
XFILLER_33_419 VDD VDD VSS VSS gf180mcu_fd_sc_mcu7t5v0__fill_1
XTAP_TAPCELL_ROW_28_400 VDD VSS gf180mcu_fd_sc_mcu7t5v0__filltie
XTAP_TAPCELL_ROW_71_745 VDD VSS gf180mcu_fd_sc_mcu7t5v0__filltie
XFILLER_60_249 VDD VDD VSS VSS gf180mcu_fd_sc_mcu7t5v0__fill_1
X_1340_ _1653_/Q _1417_/I1 _1340_/S _1653_/D VDD VDD VSS VSS gf180mcu_fd_sc_mcu7t5v0__mux2_2
XFILLER_64_522 VDD VDD VSS VSS gf180mcu_fd_sc_mcu7t5v0__fill_2
XFILLER_36_213 VDD VDD VSS VSS gf180mcu_fd_sc_mcu7t5v0__fill_1
XFILLER_3_66 VDD VDD VSS VSS gf180mcu_fd_sc_mcu7t5v0__fillcap_4
X_1271_ _1593_/Q _1373_/A3 _1272_/I VDD VDD VSS VSS gf180mcu_fd_sc_mcu7t5v0__nand2_1
XTAP_TAPCELL_ROW_34_447 VDD VSS gf180mcu_fd_sc_mcu7t5v0__filltie
XFILLER_32_463 VDD VDD VSS VSS gf180mcu_fd_sc_mcu7t5v0__fillcap_4
Xclkbuf_leaf_8_clk clkbuf_leaf_8_clk/I _1587_/CLK VDD VDD VSS VSS gf180mcu_fd_sc_mcu7t5v0__clkbuf_8
X_0986_ _1505_/Q _1143_/A2 wire585/Z _1634_/Q wire570/Z _0986_/C2 _0990_/A1 VDD VDD
+ VSS VSS gf180mcu_fd_sc_mcu7t5v0__aoi222_4
Xoutput411 _1542_/Q cfg_phase270_offset_y[17] VDD VDD VSS VSS gf180mcu_fd_sc_mcu7t5v0__buf_2
Xoutput400 _1474_/Q cfg_phase270_offset_x[7] VDD VDD VSS VSS gf180mcu_fd_sc_mcu7t5v0__buf_2
Xoutput466 _1548_/Q phase_offset_imported VDD VDD VSS VSS gf180mcu_fd_sc_mcu7t5v0__buf_2
X_1538_ _1538_/D wire863/Z _1587_/CLK _1538_/Q VDD VDD VSS VSS gf180mcu_fd_sc_mcu7t5v0__dffrnq_2
Xoutput422 _1533_/Q cfg_phase270_offset_y[8] VDD VDD VSS VSS gf180mcu_fd_sc_mcu7t5v0__buf_2
X_1469_ _1469_/D wire840/Z clkload3/I _1469_/Q VDD VDD VSS VSS gf180mcu_fd_sc_mcu7t5v0__dffrnq_2
X_1607_ _1607_/D wire786/Z _1670_/CLK _1607_/Q VDD VDD VSS VSS gf180mcu_fd_sc_mcu7t5v0__dffrnq_1
Xoutput433 _1656_/Q cfg_phase90_offset_x[18] VDD VDD VSS VSS gf180mcu_fd_sc_mcu7t5v0__buf_2
Xoutput444 _1668_/Q cfg_phase90_offset_x[9] VDD VDD VSS VSS gf180mcu_fd_sc_mcu7t5v0__buf_2
Xoutput455 _1507_/Q cfg_phase90_offset_y[19] VDD VDD VSS VSS gf180mcu_fd_sc_mcu7t5v0__buf_2
XFILLER_70_547 VDD VDD VSS VSS gf180mcu_fd_sc_mcu7t5v0__fill_1
XFILLER_35_290 VDD VDD VSS VSS gf180mcu_fd_sc_mcu7t5v0__fillcap_8
XFILLER_23_430 VDD VDD VSS VSS gf180mcu_fd_sc_mcu7t5v0__fill_2
XFILLER_23_474 VDD VDD VSS VSS gf180mcu_fd_sc_mcu7t5v0__fill_2
XFILLER_73_352 VDD VDD VSS VSS gf180mcu_fd_sc_mcu7t5v0__fillcap_16
XFILLER_53_60 VDD VDD VSS VSS gf180mcu_fd_sc_mcu7t5v0__fill_1
X_0840_ _1559_/Q _1558_/Q _1259_/A1 _0840_/Z VDD VDD VSS VSS gf180mcu_fd_sc_mcu7t5v0__or3_2
X_0771_ _0771_/A1 _1577_/Q _0771_/Z VDD VDD VSS VSS gf180mcu_fd_sc_mcu7t5v0__and2_2
X_1323_ _1639_/Q wire754/I _1330_/S _1639_/D VDD VDD VSS VSS gf180mcu_fd_sc_mcu7t5v0__mux2_2
XFILLER_56_308 VDD VDD VSS VSS gf180mcu_fd_sc_mcu7t5v0__fillcap_4
XTAP_TAPCELL_ROW_47_550 VDD VSS gf180mcu_fd_sc_mcu7t5v0__filltie
X_1185_ _1623_/Q wire604/Z _1185_/B1 _1185_/B2 _1206_/A1 VDD VDD VSS VSS gf180mcu_fd_sc_mcu7t5v0__aoi22_1
X_1254_ _1254_/A1 _1254_/A2 _1254_/B _1579_/D VDD VDD VSS VSS gf180mcu_fd_sc_mcu7t5v0__oai21_1
XFILLER_17_290 VDD VDD VSS VSS gf180mcu_fd_sc_mcu7t5v0__fill_1
X_0969_ _1014_/A1 _0969_/A2 _1177_/B _0969_/B _1568_/D VDD VDD VSS VSS gf180mcu_fd_sc_mcu7t5v0__oai31_1
XFILLER_74_37 VDD VDD VSS VSS gf180mcu_fd_sc_mcu7t5v0__fillcap_64
XFILLER_70_311 VDD VDD VSS VSS gf180mcu_fd_sc_mcu7t5v0__fillcap_4
XTAP_TAPCELL_ROW_53_597 VDD VSS gf180mcu_fd_sc_mcu7t5v0__filltie
XFILLER_11_422 VDD VDD VSS VSS gf180mcu_fd_sc_mcu7t5v0__fillcap_4
XFILLER_78_411 VDD VDD VSS VSS gf180mcu_fd_sc_mcu7t5v0__fill_2
XFILLER_48_60 VDD VDD VSS VSS gf180mcu_fd_sc_mcu7t5v0__fillcap_32
XFILLER_46_341 VDD VDD VSS VSS gf180mcu_fd_sc_mcu7t5v0__fillcap_16
XFILLER_19_544 VDD VDD VSS VSS gf180mcu_fd_sc_mcu7t5v0__fill_1
XTAP_TAPCELL_ROW_44_531 VDD VSS gf180mcu_fd_sc_mcu7t5v0__filltie
XFILLER_21_208 VDD VDD VSS VSS gf180mcu_fd_sc_mcu7t5v0__fill_2
Xwire880 wire880/I wire880/Z VDD VDD VSS VSS gf180mcu_fd_sc_mcu7t5v0__buf_1
X_0823_ _1559_/Q _1558_/Q _1259_/A1 _0823_/ZN VDD VDD VSS VSS gf180mcu_fd_sc_mcu7t5v0__nand3_1
XFILLER_50_2 VDD VDD VSS VSS gf180mcu_fd_sc_mcu7t5v0__fillcap_4
X_0754_ _1380_/A1 _0781_/S _1591_/D VDD VDD VSS VSS gf180mcu_fd_sc_mcu7t5v0__nor2_1
XFILLER_69_422 VDD VDD VSS VSS gf180mcu_fd_sc_mcu7t5v0__fill_1
Xload_slew885 _1557_/RN _1563_/RN VDD VDD VSS VSS gf180mcu_fd_sc_mcu7t5v0__buf_2
X_1306_ _1306_/I0 _1626_/Q _1313_/S _1626_/D VDD VDD VSS VSS gf180mcu_fd_sc_mcu7t5v0__mux2_2
X_1099_ _1099_/A1 _1099_/A2 _1128_/C1 input78/Z _1100_/A3 VDD VDD VSS VSS gf180mcu_fd_sc_mcu7t5v0__aoi22_2
XFILLER_52_300 VDD VDD VSS VSS gf180mcu_fd_sc_mcu7t5v0__fillcap_4
X_1237_ _1237_/A1 wire576/Z _1237_/B1 _1524_/Q _1239_/A3 VDD VDD VSS VSS gf180mcu_fd_sc_mcu7t5v0__aoi22_1
XFILLER_37_352 VDD VDD VSS VSS gf180mcu_fd_sc_mcu7t5v0__fillcap_4
XFILLER_37_341 VDD VDD VSS VSS gf180mcu_fd_sc_mcu7t5v0__fillcap_8
X_1168_ _1651_/Q wire593/Z wire520/Z _1530_/Q _1171_/A2 VDD VDD VSS VSS gf180mcu_fd_sc_mcu7t5v0__aoi22_1
XFILLER_25_558 VDD VDD VSS VSS gf180mcu_fd_sc_mcu7t5v0__fill_2
XTAP_TAPCELL_ROW_50_578 VDD VSS gf180mcu_fd_sc_mcu7t5v0__filltie
XFILLER_69_26 VDD VDD VSS VSS gf180mcu_fd_sc_mcu7t5v0__fillcap_32
XTAP_TAPCELL_ROW_7_234 VDD VSS gf180mcu_fd_sc_mcu7t5v0__filltie
XFILLER_47_127 VDD VDD VSS VSS gf180mcu_fd_sc_mcu7t5v0__fill_1
XFILLER_43_377 VDD VDD VSS VSS gf180mcu_fd_sc_mcu7t5v0__fillcap_8
XTAP_TAPCELL_ROW_41_501 VDD VSS gf180mcu_fd_sc_mcu7t5v0__filltie
XFILLER_7_212 VDD VDD VSS VSS gf180mcu_fd_sc_mcu7t5v0__fillcap_64
XFILLER_78_241 VDD VDD VSS VSS gf180mcu_fd_sc_mcu7t5v0__fillcap_4
XFILLER_66_447 VDD VDD VSS VSS gf180mcu_fd_sc_mcu7t5v0__fillcap_8
X_1022_ wire498/Z _1022_/A2 _1060_/A1 VDD VDD VSS VSS gf180mcu_fd_sc_mcu7t5v0__nand2_1
XFILLER_46_193 VDD VDD VSS VSS gf180mcu_fd_sc_mcu7t5v0__fillcap_8
X_0737_ _1598_/Q _0834_/A1 VDD VDD VSS VSS gf180mcu_fd_sc_mcu7t5v0__clkinv_1
X_0806_ _1556_/Q _0806_/A2 _0806_/B _0807_/A2 VDD VDD VSS VSS gf180mcu_fd_sc_mcu7t5v0__oai21_1
XTAP_TAPCELL_ROW_55_615 VDD VSS gf180mcu_fd_sc_mcu7t5v0__filltie
Xload_slew671 _0848_/A1 _0858_/A1 VDD VDD VSS VSS gf180mcu_fd_sc_mcu7t5v0__buf_2
Xload_slew682 _0866_/A1 _0911_/A1 VDD VDD VSS VSS gf180mcu_fd_sc_mcu7t5v0__buf_2
Xload_slew660 _0874_/A1 _0901_/A1 VDD VDD VSS VSS gf180mcu_fd_sc_mcu7t5v0__buf_2
XFILLER_44_119 VDD VDD VSS VSS gf180mcu_fd_sc_mcu7t5v0__fill_2
Xload_slew693 fanout684/I _1319_/A1 VDD VDD VSS VSS gf180mcu_fd_sc_mcu7t5v0__clkbuf_1
XFILLER_29_127 VDD VDD VSS VSS gf180mcu_fd_sc_mcu7t5v0__fillcap_4
XTAP_TAPCELL_ROW_4_204 VDD VSS gf180mcu_fd_sc_mcu7t5v0__filltie
XTAP_TAPCELL_ROW_63_681 VDD VSS gf180mcu_fd_sc_mcu7t5v0__filltie
XFILLER_52_174 VDD VDD VSS VSS gf180mcu_fd_sc_mcu7t5v0__fill_1
XFILLER_52_141 VDD VDD VSS VSS gf180mcu_fd_sc_mcu7t5v0__fill_2
XFILLER_40_314 VDD VDD VSS VSS gf180mcu_fd_sc_mcu7t5v0__fill_1
Xinput300 votes_out_phase_x[2] _1024_/A1 VDD VDD VSS VSS gf180mcu_fd_sc_mcu7t5v0__buf_1
XFILLER_0_410 VDD VDD VSS VSS gf180mcu_fd_sc_mcu7t5v0__fillcap_32
XFILLER_48_469 VDD VDD VSS VSS gf180mcu_fd_sc_mcu7t5v0__fill_1
XFILLER_45_72 VDD VDD VSS VSS gf180mcu_fd_sc_mcu7t5v0__fillcap_32
XFILLER_28_171 VDD VDD VSS VSS gf180mcu_fd_sc_mcu7t5v0__fillcap_4
XFILLER_28_193 VDD VDD VSS VSS gf180mcu_fd_sc_mcu7t5v0__fillcap_4
XTAP_TAPCELL_ROW_18_317 VDD VSS gf180mcu_fd_sc_mcu7t5v0__filltie
XFILLER_31_347 VDD VDD VSS VSS gf180mcu_fd_sc_mcu7t5v0__fill_2
XFILLER_31_325 VDD VDD VSS VSS gf180mcu_fd_sc_mcu7t5v0__fill_1
XFILLER_8_510 VDD VDD VSS VSS gf180mcu_fd_sc_mcu7t5v0__fill_1
XTAP_TAPCELL_ROW_26_383 VDD VSS gf180mcu_fd_sc_mcu7t5v0__filltie
X_1571_ _1571_/D _1571_/RN _1575_/CLK _1571_/Q VDD VDD VSS VSS gf180mcu_fd_sc_mcu7t5v0__dffrnq_1
XFILLER_6_77 VDD VDD VSS VSS gf180mcu_fd_sc_mcu7t5v0__fillcap_16
X_1640_ _1640_/D wire786/I _1670_/CLK _1640_/Q VDD VDD VSS VSS gf180mcu_fd_sc_mcu7t5v0__dffrnq_1
XFILLER_81_203 VDD VDD VSS VSS gf180mcu_fd_sc_mcu7t5v0__fill_1
XTAP_TAPCELL_ROW_69_729 VDD VSS gf180mcu_fd_sc_mcu7t5v0__filltie
XFILLER_66_255 VDD VDD VSS VSS gf180mcu_fd_sc_mcu7t5v0__fill_1
XFILLER_66_244 VDD VDD VSS VSS gf180mcu_fd_sc_mcu7t5v0__fill_1
XTAP_TAPCELL_ROW_77_795 VDD VSS gf180mcu_fd_sc_mcu7t5v0__filltie
X_1005_ _1005_/A1 _1005_/A2 _1005_/A3 _1005_/A4 _1011_/A2 VDD VDD VSS VSS gf180mcu_fd_sc_mcu7t5v0__nand4_1
XFILLER_34_174 VDD VDD VSS VSS gf180mcu_fd_sc_mcu7t5v0__fill_1
XFILLER_34_185 VDD VDD VSS VSS gf180mcu_fd_sc_mcu7t5v0__fill_1
XFILLER_22_325 VDD VDD VSS VSS gf180mcu_fd_sc_mcu7t5v0__fillcap_4
XFILLER_72_247 VDD VDD VSS VSS gf180mcu_fd_sc_mcu7t5v0__fillcap_64
XFILLER_40_177 VDD VDD VSS VSS gf180mcu_fd_sc_mcu7t5v0__fillcap_16
XFILLER_9_318 VDD VDD VSS VSS gf180mcu_fd_sc_mcu7t5v0__fill_2
XFILLER_5_524 VDD VDD VSS VSS gf180mcu_fd_sc_mcu7t5v0__fillcap_8
Xinput152 latch_error_y _1155_/A1 VDD VDD VSS VSS gf180mcu_fd_sc_mcu7t5v0__buf_1
Xinput130 cal_phase90_offset_y[9] _0989_/B2 VDD VDD VSS VSS gf180mcu_fd_sc_mcu7t5v0__buf_1
XFILLER_48_255 VDD VDD VSS VSS gf180mcu_fd_sc_mcu7t5v0__fillcap_4
XFILLER_48_211 VDD VDD VSS VSS gf180mcu_fd_sc_mcu7t5v0__fill_2
Xinput163 raw_edge1_x[15] _1226_/A1 VDD VDD VSS VSS gf180mcu_fd_sc_mcu7t5v0__buf_1
Xinput185 raw_edge1_y[16] _0950_/A1 VDD VDD VSS VSS gf180mcu_fd_sc_mcu7t5v0__buf_1
Xinput196 raw_edge1_y[7] _1217_/B2 VDD VDD VSS VSS gf180mcu_fd_sc_mcu7t5v0__buf_1
Xinput174 raw_edge1_x[6] _1189_/A1 VDD VDD VSS VSS gf180mcu_fd_sc_mcu7t5v0__buf_1
XFILLER_0_240 VDD VDD VSS VSS gf180mcu_fd_sc_mcu7t5v0__fillcap_32
Xinput141 delay_wave_cycle_y[0] _0955_/A1 VDD VDD VSS VSS gf180mcu_fd_sc_mcu7t5v0__buf_1
XTAP_TAPCELL_ROW_74_765 VDD VSS gf180mcu_fd_sc_mcu7t5v0__filltie
XFILLER_48_299 VDD VDD VSS VSS gf180mcu_fd_sc_mcu7t5v0__fillcap_4
XFILLER_44_494 VDD VDD VSS VSS gf180mcu_fd_sc_mcu7t5v0__fill_2
XFILLER_16_174 VDD VDD VSS VSS gf180mcu_fd_sc_mcu7t5v0__fill_1
X_1554_ _1554_/D wire871/Z _1597_/CLK _1554_/Q VDD VDD VSS VSS gf180mcu_fd_sc_mcu7t5v0__dffrnq_4
X_1623_ _1623_/D wire829/Z clkload6/I _1623_/Q VDD VDD VSS VSS gf180mcu_fd_sc_mcu7t5v0__dffrnq_2
X_1485_ _1485_/D _1485_/RN _1629_/CLK _1485_/Q VDD VDD VSS VSS gf180mcu_fd_sc_mcu7t5v0__dffrnq_2
.ends
