* NGSPICE file created from wave_controller.ext - technology: gf180mcuD

* Black-box entry subcircuit for gf180mcu_fd_sc_mcu7t5v0__fill_2 abstract view
.subckt gf180mcu_fd_sc_mcu7t5v0__fill_2 VDD VNW VPW VSS
.ends

* Black-box entry subcircuit for gf180mcu_fd_sc_mcu7t5v0__xor2_1 abstract view
.subckt gf180mcu_fd_sc_mcu7t5v0__xor2_1 A1 A2 Z VDD VNW VPW VSS
.ends

* Black-box entry subcircuit for gf180mcu_fd_sc_mcu7t5v0__fillcap_4 abstract view
.subckt gf180mcu_fd_sc_mcu7t5v0__fillcap_4 VDD VNW VPW VSS
.ends

* Black-box entry subcircuit for gf180mcu_fd_sc_mcu7t5v0__and2_1 abstract view
.subckt gf180mcu_fd_sc_mcu7t5v0__and2_1 A1 A2 Z VDD VNW VPW VSS
.ends

* Black-box entry subcircuit for gf180mcu_fd_sc_mcu7t5v0__clkinv_1 abstract view
.subckt gf180mcu_fd_sc_mcu7t5v0__clkinv_1 I ZN VDD VNW VPW VSS
.ends

* Black-box entry subcircuit for gf180mcu_fd_sc_mcu7t5v0__nor2_1 abstract view
.subckt gf180mcu_fd_sc_mcu7t5v0__nor2_1 A1 A2 ZN VDD VNW VPW VSS
.ends

* Black-box entry subcircuit for gf180mcu_fd_sc_mcu7t5v0__fillcap_16 abstract view
.subckt gf180mcu_fd_sc_mcu7t5v0__fillcap_16 VDD VNW VPW VSS
.ends

* Black-box entry subcircuit for gf180mcu_fd_sc_mcu7t5v0__fillcap_64 abstract view
.subckt gf180mcu_fd_sc_mcu7t5v0__fillcap_64 VDD VNW VPW VSS
.ends

* Black-box entry subcircuit for gf180mcu_fd_sc_mcu7t5v0__oai21_1 abstract view
.subckt gf180mcu_fd_sc_mcu7t5v0__oai21_1 A1 A2 B ZN VDD VNW VPW VSS
.ends

* Black-box entry subcircuit for gf180mcu_fd_sc_mcu7t5v0__fillcap_8 abstract view
.subckt gf180mcu_fd_sc_mcu7t5v0__fillcap_8 VDD VNW VPW VSS
.ends

* Black-box entry subcircuit for gf180mcu_fd_sc_mcu7t5v0__filltie abstract view
.subckt gf180mcu_fd_sc_mcu7t5v0__filltie VDD VSS
.ends

* Black-box entry subcircuit for gf180mcu_fd_sc_mcu7t5v0__fill_1 abstract view
.subckt gf180mcu_fd_sc_mcu7t5v0__fill_1 VDD VNW VPW VSS
.ends

* Black-box entry subcircuit for gf180mcu_fd_sc_mcu7t5v0__fillcap_32 abstract view
.subckt gf180mcu_fd_sc_mcu7t5v0__fillcap_32 VDD VNW VPW VSS
.ends

* Black-box entry subcircuit for gf180mcu_fd_sc_mcu7t5v0__dffrnq_1 abstract view
.subckt gf180mcu_fd_sc_mcu7t5v0__dffrnq_1 D RN CLK Q VDD VNW VPW VSS
.ends

* Black-box entry subcircuit for gf180mcu_fd_sc_mcu7t5v0__oai22_1 abstract view
.subckt gf180mcu_fd_sc_mcu7t5v0__oai22_1 A1 A2 B1 B2 ZN VDD VNW VPW VSS
.ends

* Black-box entry subcircuit for gf180mcu_fd_sc_mcu7t5v0__aoi21_1 abstract view
.subckt gf180mcu_fd_sc_mcu7t5v0__aoi21_1 A1 A2 B ZN VDD VNW VPW VSS
.ends

* Black-box entry subcircuit for gf180mcu_fd_sc_mcu7t5v0__buf_1 abstract view
.subckt gf180mcu_fd_sc_mcu7t5v0__buf_1 I Z VDD VNW VPW VSS
.ends

* Black-box entry subcircuit for gf180mcu_fd_sc_mcu7t5v0__buf_2 abstract view
.subckt gf180mcu_fd_sc_mcu7t5v0__buf_2 I Z VDD VNW VPW VSS
.ends

* Black-box entry subcircuit for gf180mcu_fd_sc_mcu7t5v0__nand3_1 abstract view
.subckt gf180mcu_fd_sc_mcu7t5v0__nand3_1 A1 A2 A3 ZN VDD VNW VPW VSS
.ends

* Black-box entry subcircuit for gf180mcu_fd_sc_mcu7t5v0__clkbuf_8 abstract view
.subckt gf180mcu_fd_sc_mcu7t5v0__clkbuf_8 I Z VDD VNW VPW VSS
.ends

* Black-box entry subcircuit for gf180mcu_fd_sc_mcu7t5v0__dffrnq_2 abstract view
.subckt gf180mcu_fd_sc_mcu7t5v0__dffrnq_2 D RN CLK Q VDD VNW VPW VSS
.ends

* Black-box entry subcircuit for gf180mcu_fd_sc_mcu7t5v0__oai31_4 abstract view
.subckt gf180mcu_fd_sc_mcu7t5v0__oai31_4 A1 A2 A3 B ZN VDD VNW VPW VSS
.ends

* Black-box entry subcircuit for gf180mcu_fd_sc_mcu7t5v0__or3_1 abstract view
.subckt gf180mcu_fd_sc_mcu7t5v0__or3_1 A1 A2 A3 Z VDD VNW VPW VSS
.ends

* Black-box entry subcircuit for gf180mcu_fd_sc_mcu7t5v0__clkbuf_2 abstract view
.subckt gf180mcu_fd_sc_mcu7t5v0__clkbuf_2 I Z VDD VNW VPW VSS
.ends

* Black-box entry subcircuit for gf180mcu_fd_sc_mcu7t5v0__endcap abstract view
.subckt gf180mcu_fd_sc_mcu7t5v0__endcap VDD VSS
.ends

* Black-box entry subcircuit for gf180mcu_fd_sc_mcu7t5v0__nand2_1 abstract view
.subckt gf180mcu_fd_sc_mcu7t5v0__nand2_1 A1 A2 ZN VDD VNW VPW VSS
.ends

* Black-box entry subcircuit for gf180mcu_fd_sc_mcu7t5v0__xor2_2 abstract view
.subckt gf180mcu_fd_sc_mcu7t5v0__xor2_2 A1 A2 Z VDD VNW VPW VSS
.ends

* Black-box entry subcircuit for gf180mcu_fd_sc_mcu7t5v0__or2_1 abstract view
.subckt gf180mcu_fd_sc_mcu7t5v0__or2_1 A1 A2 Z VDD VNW VPW VSS
.ends

* Black-box entry subcircuit for gf180mcu_fd_sc_mcu7t5v0__xor3_1 abstract view
.subckt gf180mcu_fd_sc_mcu7t5v0__xor3_1 A1 A2 A3 Z VDD VNW VPW VSS
.ends

* Black-box entry subcircuit for gf180mcu_fd_sc_mcu7t5v0__oai32_1 abstract view
.subckt gf180mcu_fd_sc_mcu7t5v0__oai32_1 A1 A2 A3 B1 B2 ZN VDD VNW VPW VSS
.ends

* Black-box entry subcircuit for gf180mcu_fd_sc_mcu7t5v0__aoi22_1 abstract view
.subckt gf180mcu_fd_sc_mcu7t5v0__aoi22_1 A1 A2 B1 B2 ZN VDD VNW VPW VSS
.ends

* Black-box entry subcircuit for gf180mcu_fd_sc_mcu7t5v0__nor4_2 abstract view
.subckt gf180mcu_fd_sc_mcu7t5v0__nor4_2 A1 A2 A3 A4 ZN VDD VNW VPW VSS
.ends

* Black-box entry subcircuit for gf180mcu_fd_sc_mcu7t5v0__oai211_4 abstract view
.subckt gf180mcu_fd_sc_mcu7t5v0__oai211_4 A1 A2 B C ZN VDD VNW VPW VSS
.ends

* Black-box entry subcircuit for gf180mcu_fd_sc_mcu7t5v0__clkbuf_4 abstract view
.subckt gf180mcu_fd_sc_mcu7t5v0__clkbuf_4 I Z VDD VNW VPW VSS
.ends

* Black-box entry subcircuit for gf180mcu_fd_sc_mcu7t5v0__oai21_2 abstract view
.subckt gf180mcu_fd_sc_mcu7t5v0__oai21_2 A1 A2 B ZN VDD VNW VPW VSS
.ends

* Black-box entry subcircuit for gf180mcu_fd_sc_mcu7t5v0__dlyb_1 abstract view
.subckt gf180mcu_fd_sc_mcu7t5v0__dlyb_1 I Z VDD VNW VPW VSS
.ends

* Black-box entry subcircuit for gf180mcu_fd_sc_mcu7t5v0__aoi221_1 abstract view
.subckt gf180mcu_fd_sc_mcu7t5v0__aoi221_1 A1 A2 B1 B2 C ZN VDD VNW VPW VSS
.ends

* Black-box entry subcircuit for gf180mcu_fd_sc_mcu7t5v0__oai32_2 abstract view
.subckt gf180mcu_fd_sc_mcu7t5v0__oai32_2 A1 A2 A3 B1 B2 ZN VDD VNW VPW VSS
.ends

* Black-box entry subcircuit for gf180mcu_fd_sc_mcu7t5v0__and3_1 abstract view
.subckt gf180mcu_fd_sc_mcu7t5v0__and3_1 A1 A2 A3 Z VDD VNW VPW VSS
.ends

* Black-box entry subcircuit for gf180mcu_fd_sc_mcu7t5v0__nor3_1 abstract view
.subckt gf180mcu_fd_sc_mcu7t5v0__nor3_1 A1 A2 A3 ZN VDD VNW VPW VSS
.ends

* Black-box entry subcircuit for gf180mcu_fd_sc_mcu7t5v0__inv_2 abstract view
.subckt gf180mcu_fd_sc_mcu7t5v0__inv_2 I ZN VDD VNW VPW VSS
.ends

* Black-box entry subcircuit for gf180mcu_fd_sc_mcu7t5v0__xnor2_1 abstract view
.subckt gf180mcu_fd_sc_mcu7t5v0__xnor2_1 A1 A2 ZN VDD VNW VPW VSS
.ends

* Black-box entry subcircuit for gf180mcu_fd_sc_mcu7t5v0__buf_4 abstract view
.subckt gf180mcu_fd_sc_mcu7t5v0__buf_4 I Z VDD VNW VPW VSS
.ends

* Black-box entry subcircuit for gf180mcu_fd_sc_mcu7t5v0__oai211_1 abstract view
.subckt gf180mcu_fd_sc_mcu7t5v0__oai211_1 A1 A2 B C ZN VDD VNW VPW VSS
.ends

* Black-box entry subcircuit for gf180mcu_fd_sc_mcu7t5v0__aoi211_2 abstract view
.subckt gf180mcu_fd_sc_mcu7t5v0__aoi211_2 A1 A2 B C ZN VDD VNW VPW VSS
.ends

* Black-box entry subcircuit for gf180mcu_fd_sc_mcu7t5v0__xnor2_2 abstract view
.subckt gf180mcu_fd_sc_mcu7t5v0__xnor2_2 A1 A2 ZN VDD VNW VPW VSS
.ends

* Black-box entry subcircuit for gf180mcu_fd_sc_mcu7t5v0__aoi211_1 abstract view
.subckt gf180mcu_fd_sc_mcu7t5v0__aoi211_1 A1 A2 B C ZN VDD VNW VPW VSS
.ends

* Black-box entry subcircuit for gf180mcu_fd_sc_mcu7t5v0__oai221_1 abstract view
.subckt gf180mcu_fd_sc_mcu7t5v0__oai221_1 A1 A2 B1 B2 C ZN VDD VNW VPW VSS
.ends

* Black-box entry subcircuit for gf180mcu_fd_sc_mcu7t5v0__aoi21_2 abstract view
.subckt gf180mcu_fd_sc_mcu7t5v0__aoi21_2 A1 A2 B ZN VDD VNW VPW VSS
.ends

* Black-box entry subcircuit for gf180mcu_fd_sc_mcu7t5v0__nor2_2 abstract view
.subckt gf180mcu_fd_sc_mcu7t5v0__nor2_2 A1 A2 ZN VDD VNW VPW VSS
.ends

* Black-box entry subcircuit for gf180mcu_fd_sc_mcu7t5v0__nor3_2 abstract view
.subckt gf180mcu_fd_sc_mcu7t5v0__nor3_2 A1 A2 A3 ZN VDD VNW VPW VSS
.ends

* Black-box entry subcircuit for gf180mcu_fd_sc_mcu7t5v0__aoi221_4 abstract view
.subckt gf180mcu_fd_sc_mcu7t5v0__aoi221_4 A1 A2 B1 B2 C ZN VDD VNW VPW VSS
.ends

* Black-box entry subcircuit for gf180mcu_fd_sc_mcu7t5v0__nand2_2 abstract view
.subckt gf180mcu_fd_sc_mcu7t5v0__nand2_2 A1 A2 ZN VDD VNW VPW VSS
.ends

* Black-box entry subcircuit for gf180mcu_fd_sc_mcu7t5v0__clkbuf_1 abstract view
.subckt gf180mcu_fd_sc_mcu7t5v0__clkbuf_1 I Z VDD VNW VPW VSS
.ends

* Black-box entry subcircuit for gf180mcu_fd_sc_mcu7t5v0__xor3_2 abstract view
.subckt gf180mcu_fd_sc_mcu7t5v0__xor3_2 A1 A2 A3 Z VDD VNW VPW VSS
.ends

* Black-box entry subcircuit for gf180mcu_fd_sc_mcu7t5v0__oai32_4 abstract view
.subckt gf180mcu_fd_sc_mcu7t5v0__oai32_4 A1 A2 A3 B1 B2 ZN VDD VNW VPW VSS
.ends

* Black-box entry subcircuit for gf180mcu_fd_sc_mcu7t5v0__oai21_4 abstract view
.subckt gf180mcu_fd_sc_mcu7t5v0__oai21_4 A1 A2 B ZN VDD VNW VPW VSS
.ends

* Black-box entry subcircuit for gf180mcu_fd_sc_mcu7t5v0__aoi221_2 abstract view
.subckt gf180mcu_fd_sc_mcu7t5v0__aoi221_2 A1 A2 B1 B2 C ZN VDD VNW VPW VSS
.ends

* Black-box entry subcircuit for gf180mcu_fd_sc_mcu7t5v0__xnor3_1 abstract view
.subckt gf180mcu_fd_sc_mcu7t5v0__xnor3_1 A1 A2 A3 ZN VDD VNW VPW VSS
.ends

* Black-box entry subcircuit for gf180mcu_fd_sc_mcu7t5v0__nand4_1 abstract view
.subckt gf180mcu_fd_sc_mcu7t5v0__nand4_1 A1 A2 A3 A4 ZN VDD VNW VPW VSS
.ends

* Black-box entry subcircuit for gf180mcu_fd_sc_mcu7t5v0__mux2_2 abstract view
.subckt gf180mcu_fd_sc_mcu7t5v0__mux2_2 I0 I1 S Z VDD VNW VPW VSS
.ends

* Black-box entry subcircuit for gf180mcu_fd_sc_mcu7t5v0__oai31_1 abstract view
.subckt gf180mcu_fd_sc_mcu7t5v0__oai31_1 A1 A2 A3 B ZN VDD VNW VPW VSS
.ends

* Black-box entry subcircuit for gf180mcu_fd_sc_mcu7t5v0__and4_1 abstract view
.subckt gf180mcu_fd_sc_mcu7t5v0__and4_1 A1 A2 A3 A4 Z VDD VNW VPW VSS
.ends

* Black-box entry subcircuit for gf180mcu_fd_sc_mcu7t5v0__clkbuf_16 abstract view
.subckt gf180mcu_fd_sc_mcu7t5v0__clkbuf_16 I Z VDD VNW VPW VSS
.ends

* Black-box entry subcircuit for gf180mcu_fd_sc_mcu7t5v0__oai211_2 abstract view
.subckt gf180mcu_fd_sc_mcu7t5v0__oai211_2 A1 A2 B C ZN VDD VNW VPW VSS
.ends

* Black-box entry subcircuit for gf180mcu_fd_sc_mcu7t5v0__buf_3 abstract view
.subckt gf180mcu_fd_sc_mcu7t5v0__buf_3 I Z VDD VNW VPW VSS
.ends

* Black-box entry subcircuit for gf180mcu_fd_sc_mcu7t5v0__oai221_2 abstract view
.subckt gf180mcu_fd_sc_mcu7t5v0__oai221_2 A1 A2 B1 B2 C ZN VDD VNW VPW VSS
.ends

* Black-box entry subcircuit for gf180mcu_fd_sc_mcu7t5v0__oai31_2 abstract view
.subckt gf180mcu_fd_sc_mcu7t5v0__oai31_2 A1 A2 A3 B ZN VDD VNW VPW VSS
.ends

* Black-box entry subcircuit for gf180mcu_fd_sc_mcu7t5v0__nor2_4 abstract view
.subckt gf180mcu_fd_sc_mcu7t5v0__nor2_4 A1 A2 ZN VDD VNW VPW VSS
.ends

* Black-box entry subcircuit for gf180mcu_fd_sc_mcu7t5v0__aoi21_4 abstract view
.subckt gf180mcu_fd_sc_mcu7t5v0__aoi21_4 A1 A2 B ZN VDD VNW VPW VSS
.ends

* Black-box entry subcircuit for gf180mcu_fd_sc_mcu7t5v0__nor4_1 abstract view
.subckt gf180mcu_fd_sc_mcu7t5v0__nor4_1 A1 A2 A3 A4 ZN VDD VNW VPW VSS
.ends

* Black-box entry subcircuit for gf180mcu_fd_sc_mcu7t5v0__oai221_4 abstract view
.subckt gf180mcu_fd_sc_mcu7t5v0__oai221_4 A1 A2 B1 B2 C ZN VDD VNW VPW VSS
.ends

* Black-box entry subcircuit for gf180mcu_fd_sc_mcu7t5v0__aoi211_4 abstract view
.subckt gf180mcu_fd_sc_mcu7t5v0__aoi211_4 A1 A2 B C ZN VDD VNW VPW VSS
.ends

* Black-box entry subcircuit for gf180mcu_fd_sc_mcu7t5v0__xnor3_2 abstract view
.subckt gf180mcu_fd_sc_mcu7t5v0__xnor3_2 A1 A2 A3 ZN VDD VNW VPW VSS
.ends

* Black-box entry subcircuit for gf180mcu_fd_sc_mcu7t5v0__clkbuf_3 abstract view
.subckt gf180mcu_fd_sc_mcu7t5v0__clkbuf_3 I Z VDD VNW VPW VSS
.ends

* Black-box entry subcircuit for gf180mcu_fd_sc_mcu7t5v0__dffsnq_1 abstract view
.subckt gf180mcu_fd_sc_mcu7t5v0__dffsnq_1 D SETN CLK Q VDD VNW VPW VSS
.ends

* Black-box entry subcircuit for gf180mcu_fd_sc_mcu7t5v0__dffrnq_4 abstract view
.subckt gf180mcu_fd_sc_mcu7t5v0__dffrnq_4 D RN CLK Q VDD VNW VPW VSS
.ends

* Black-box entry subcircuit for gf180mcu_fd_sc_mcu7t5v0__oai33_4 abstract view
.subckt gf180mcu_fd_sc_mcu7t5v0__oai33_4 A1 A2 A3 B1 B2 B3 ZN VDD VNW VPW VSS
.ends

* Black-box entry subcircuit for gf180mcu_fd_sc_mcu7t5v0__oai22_2 abstract view
.subckt gf180mcu_fd_sc_mcu7t5v0__oai22_2 A1 A2 B1 B2 ZN VDD VNW VPW VSS
.ends

* Black-box entry subcircuit for gf180mcu_fd_sc_mcu7t5v0__nor3_4 abstract view
.subckt gf180mcu_fd_sc_mcu7t5v0__nor3_4 A1 A2 A3 ZN VDD VNW VPW VSS
.ends

* Black-box entry subcircuit for gf180mcu_fd_sc_mcu7t5v0__aoi22_2 abstract view
.subckt gf180mcu_fd_sc_mcu7t5v0__aoi22_2 A1 A2 B1 B2 ZN VDD VNW VPW VSS
.ends

* Black-box entry subcircuit for gf180mcu_fd_sc_mcu7t5v0__or4_1 abstract view
.subckt gf180mcu_fd_sc_mcu7t5v0__or4_1 A1 A2 A3 A4 Z VDD VNW VPW VSS
.ends

.subckt wave_controller VDD VSS cal_dir cal_done cal_phase0_offset[0] cal_phase0_offset[10]
+ cal_phase0_offset[11] cal_phase0_offset[12] cal_phase0_offset[13] cal_phase0_offset[14]
+ cal_phase0_offset[15] cal_phase0_offset[16] cal_phase0_offset[17] cal_phase0_offset[18]
+ cal_phase0_offset[19] cal_phase0_offset[1] cal_phase0_offset[20] cal_phase0_offset[2]
+ cal_phase0_offset[3] cal_phase0_offset[4] cal_phase0_offset[5] cal_phase0_offset[6]
+ cal_phase0_offset[7] cal_phase0_offset[8] cal_phase0_offset[9] cal_phase270_offset[0]
+ cal_phase270_offset[10] cal_phase270_offset[11] cal_phase270_offset[12] cal_phase270_offset[13]
+ cal_phase270_offset[14] cal_phase270_offset[15] cal_phase270_offset[16] cal_phase270_offset[17]
+ cal_phase270_offset[18] cal_phase270_offset[19] cal_phase270_offset[1] cal_phase270_offset[20]
+ cal_phase270_offset[2] cal_phase270_offset[3] cal_phase270_offset[4] cal_phase270_offset[5]
+ cal_phase270_offset[6] cal_phase270_offset[7] cal_phase270_offset[8] cal_phase270_offset[9]
+ cal_phase90_offset[0] cal_phase90_offset[10] cal_phase90_offset[11] cal_phase90_offset[12]
+ cal_phase90_offset[13] cal_phase90_offset[14] cal_phase90_offset[15] cal_phase90_offset[16]
+ cal_phase90_offset[17] cal_phase90_offset[18] cal_phase90_offset[19] cal_phase90_offset[1]
+ cal_phase90_offset[20] cal_phase90_offset[2] cal_phase90_offset[3] cal_phase90_offset[4]
+ cal_phase90_offset[5] cal_phase90_offset[6] cal_phase90_offset[7] cal_phase90_offset[8]
+ cal_phase90_offset[9] cal_start cal_timeout cfg_done cfg_f_MEMS_fcw[0] cfg_f_MEMS_fcw[10]
+ cfg_f_MEMS_fcw[11] cfg_f_MEMS_fcw[12] cfg_f_MEMS_fcw[13] cfg_f_MEMS_fcw[14] cfg_f_MEMS_fcw[15]
+ cfg_f_MEMS_fcw[1] cfg_f_MEMS_fcw[2] cfg_f_MEMS_fcw[3] cfg_f_MEMS_fcw[4] cfg_f_MEMS_fcw[5]
+ cfg_f_MEMS_fcw[6] cfg_f_MEMS_fcw[7] cfg_f_MEMS_fcw[8] cfg_f_MEMS_fcw[9] cfg_phase0_offset[0]
+ cfg_phase0_offset[10] cfg_phase0_offset[11] cfg_phase0_offset[12] cfg_phase0_offset[13]
+ cfg_phase0_offset[14] cfg_phase0_offset[15] cfg_phase0_offset[16] cfg_phase0_offset[17]
+ cfg_phase0_offset[18] cfg_phase0_offset[19] cfg_phase0_offset[1] cfg_phase0_offset[20]
+ cfg_phase0_offset[2] cfg_phase0_offset[3] cfg_phase0_offset[4] cfg_phase0_offset[5]
+ cfg_phase0_offset[6] cfg_phase0_offset[7] cfg_phase0_offset[8] cfg_phase0_offset[9]
+ cfg_phase270_offset[0] cfg_phase270_offset[10] cfg_phase270_offset[11] cfg_phase270_offset[12]
+ cfg_phase270_offset[13] cfg_phase270_offset[14] cfg_phase270_offset[15] cfg_phase270_offset[16]
+ cfg_phase270_offset[17] cfg_phase270_offset[18] cfg_phase270_offset[19] cfg_phase270_offset[1]
+ cfg_phase270_offset[20] cfg_phase270_offset[2] cfg_phase270_offset[3] cfg_phase270_offset[4]
+ cfg_phase270_offset[5] cfg_phase270_offset[6] cfg_phase270_offset[7] cfg_phase270_offset[8]
+ cfg_phase270_offset[9] cfg_phase90_offset[0] cfg_phase90_offset[10] cfg_phase90_offset[11]
+ cfg_phase90_offset[12] cfg_phase90_offset[13] cfg_phase90_offset[14] cfg_phase90_offset[15]
+ cfg_phase90_offset[16] cfg_phase90_offset[17] cfg_phase90_offset[18] cfg_phase90_offset[19]
+ cfg_phase90_offset[1] cfg_phase90_offset[20] cfg_phase90_offset[2] cfg_phase90_offset[3]
+ cfg_phase90_offset[4] cfg_phase90_offset[5] cfg_phase90_offset[6] cfg_phase90_offset[7]
+ cfg_phase90_offset[8] cfg_phase90_offset[9] clk comp delay_wave_cycle[0] delay_wave_cycle[1]
+ delay_wave_cycle[2] delay_wave_cycle[3] delay_wave_cycle[4] delay_wave_cycle[5]
+ delay_wave_cycle[6] delay_wave_cycle[7] latch_error latch_phase270 latch_phase270_ack
+ latch_phase90 latch_phase90_ack mems_drv raw_edge1[0] raw_edge1[10] raw_edge1[11]
+ raw_edge1[12] raw_edge1[13] raw_edge1[14] raw_edge1[15] raw_edge1[16] raw_edge1[17]
+ raw_edge1[18] raw_edge1[19] raw_edge1[1] raw_edge1[20] raw_edge1[2] raw_edge1[3]
+ raw_edge1[4] raw_edge1[5] raw_edge1[6] raw_edge1[7] raw_edge1[8] raw_edge1[9] raw_edge2[0]
+ raw_edge2[10] raw_edge2[11] raw_edge2[12] raw_edge2[13] raw_edge2[14] raw_edge2[15]
+ raw_edge2[16] raw_edge2[17] raw_edge2[18] raw_edge2[19] raw_edge2[1] raw_edge2[20]
+ raw_edge2[2] raw_edge2[3] raw_edge2[4] raw_edge2[5] raw_edge2[6] raw_edge2[7] raw_edge2[8]
+ raw_edge2[9] raw_edge3[0] raw_edge3[10] raw_edge3[11] raw_edge3[12] raw_edge3[13]
+ raw_edge3[14] raw_edge3[15] raw_edge3[16] raw_edge3[17] raw_edge3[18] raw_edge3[19]
+ raw_edge3[1] raw_edge3[20] raw_edge3[2] raw_edge3[3] raw_edge3[4] raw_edge3[5] raw_edge3[6]
+ raw_edge3[7] raw_edge3[8] raw_edge3[9] ref_wave rst_n soft_rst_n
XFILLER_67_531 VDD VDD VSS VSS gf180mcu_fd_sc_mcu7t5v0__fill_2
X_3155_ wire516/Z _3715_/Q _3156_/B VDD VDD VSS VSS gf180mcu_fd_sc_mcu7t5v0__xor2_1
XFILLER_67_586 VDD VDD VSS VSS gf180mcu_fd_sc_mcu7t5v0__fillcap_4
X_2106_ _2093_/Z _2105_/Z _2112_/C VDD VDD VSS VSS gf180mcu_fd_sc_mcu7t5v0__and2_1
X_3086_ _3738_/Q _3086_/ZN VDD VDD VSS VSS gf180mcu_fd_sc_mcu7t5v0__clkinv_1
X_2037_ _1995_/I _2022_/Z _2038_/A2 VDD VDD VSS VSS gf180mcu_fd_sc_mcu7t5v0__nor2_1
XFILLER_54_247 VDD VDD VSS VSS gf180mcu_fd_sc_mcu7t5v0__fillcap_4
XFILLER_62_280 VDD VDD VSS VSS gf180mcu_fd_sc_mcu7t5v0__fillcap_16
XFILLER_10_317 VDD VDD VSS VSS gf180mcu_fd_sc_mcu7t5v0__fillcap_4
XFILLER_22_177 VDD VDD VSS VSS gf180mcu_fd_sc_mcu7t5v0__fillcap_64
X_2939_ _2939_/A1 _2939_/A2 _2939_/B _3707_/D VDD VDD VSS VSS gf180mcu_fd_sc_mcu7t5v0__oai21_1
XFILLER_2_527 VDD VDD VSS VSS gf180mcu_fd_sc_mcu7t5v0__fill_2
XFILLER_77_339 VDD VDD VSS VSS gf180mcu_fd_sc_mcu7t5v0__fill_2
XFILLER_58_597 VDD VDD VSS VSS gf180mcu_fd_sc_mcu7t5v0__fillcap_8
XFILLER_73_534 VDD VDD VSS VSS gf180mcu_fd_sc_mcu7t5v0__fillcap_8
XTAP_TAPCELL_ROW_56_743 VDD VSS gf180mcu_fd_sc_mcu7t5v0__filltie
XFILLER_14_623 VDD VDD VSS VSS gf180mcu_fd_sc_mcu7t5v0__fill_1
XTAP_TAPCELL_ROW_28_478 VDD VSS gf180mcu_fd_sc_mcu7t5v0__filltie
XFILLER_14_667 VDD VDD VSS VSS gf180mcu_fd_sc_mcu7t5v0__fill_2
XTAP_TAPCELL_ROW_11_312 VDD VSS gf180mcu_fd_sc_mcu7t5v0__filltie
XFILLER_41_486 VDD VDD VSS VSS gf180mcu_fd_sc_mcu7t5v0__fillcap_4
XFILLER_96_648 VDD VDD VSS VSS gf180mcu_fd_sc_mcu7t5v0__fillcap_16
XFILLER_95_136 VDD VDD VSS VSS gf180mcu_fd_sc_mcu7t5v0__fillcap_4
XFILLER_36_247 VDD VDD VSS VSS gf180mcu_fd_sc_mcu7t5v0__fill_1
XFILLER_64_578 VDD VDD VSS VSS gf180mcu_fd_sc_mcu7t5v0__fillcap_4
XFILLER_32_431 VDD VDD VSS VSS gf180mcu_fd_sc_mcu7t5v0__fillcap_4
XFILLER_20_615 VDD VDD VSS VSS gf180mcu_fd_sc_mcu7t5v0__fill_1
XFILLER_80_2 VDD VDD VSS VSS gf180mcu_fd_sc_mcu7t5v0__fillcap_32
X_3773_ _3773_/D wire552/I clkload7/I _3773_/Q VDD VDD VSS VSS gf180mcu_fd_sc_mcu7t5v0__dffrnq_1
X_2724_ _3003_/I _2684_/Z _2724_/B1 _2724_/B2 _2732_/A1 VDD VDD VSS VSS gf180mcu_fd_sc_mcu7t5v0__oai22_1
X_2655_ _2981_/ZN _3000_/I _2655_/B _2689_/A1 VDD VDD VSS VSS gf180mcu_fd_sc_mcu7t5v0__aoi21_1
X_2586_ _2559_/Z _2586_/A2 _2586_/B _2587_/C VDD VDD VSS VSS gf180mcu_fd_sc_mcu7t5v0__oai21_1
X_3207_ _3207_/A1 _3207_/A2 _3207_/B _3208_/A2 VDD VDD VSS VSS gf180mcu_fd_sc_mcu7t5v0__aoi21_1
XFILLER_27_203 VDD VDD VSS VSS gf180mcu_fd_sc_mcu7t5v0__fillcap_4
X_3138_ _2743_/B _3138_/A2 _3779_/D VDD VDD VSS VSS gf180mcu_fd_sc_mcu7t5v0__nor2_1
XFILLER_42_217 VDD VDD VSS VSS gf180mcu_fd_sc_mcu7t5v0__fill_1
XTAP_TAPCELL_ROW_53_713 VDD VSS gf180mcu_fd_sc_mcu7t5v0__filltie
X_3069_ _3683_/Q _3601_/A1 VDD VDD VSS VSS gf180mcu_fd_sc_mcu7t5v0__clkinv_1
XFILLER_82_397 VDD VDD VSS VSS gf180mcu_fd_sc_mcu7t5v0__fill_1
XTAP_TAPCELL_ROW_25_448 VDD VSS gf180mcu_fd_sc_mcu7t5v0__filltie
XTAP_TAPCELL_ROW_61_790 VDD VSS gf180mcu_fd_sc_mcu7t5v0__filltie
Xwire528 wire528/I wire528/Z VDD VDD VSS VSS gf180mcu_fd_sc_mcu7t5v0__buf_1
XFILLER_6_107 VDD VDD VSS VSS gf180mcu_fd_sc_mcu7t5v0__fillcap_64
Xwire517 wire517/I wire517/Z VDD VDD VSS VSS gf180mcu_fd_sc_mcu7t5v0__buf_2
XFILLER_77_136 VDD VDD VSS VSS gf180mcu_fd_sc_mcu7t5v0__fillcap_4
XFILLER_18_225 VDD VDD VSS VSS gf180mcu_fd_sc_mcu7t5v0__fillcap_8
XFILLER_33_217 VDD VDD VSS VSS gf180mcu_fd_sc_mcu7t5v0__fillcap_16
XFILLER_73_386 VDD VDD VSS VSS gf180mcu_fd_sc_mcu7t5v0__fill_1
XFILLER_53_72 VDD VDD VSS VSS gf180mcu_fd_sc_mcu7t5v0__fillcap_32
XFILLER_14_497 VDD VDD VSS VSS gf180mcu_fd_sc_mcu7t5v0__fill_1
X_2440_ _2445_/A1 _2119_/Z _2444_/A4 _2441_/A2 VDD VDD VSS VSS gf180mcu_fd_sc_mcu7t5v0__nand3_1
X_2371_ _2388_/B1 _2371_/A2 _2371_/B _3733_/D VDD VDD VSS VSS gf180mcu_fd_sc_mcu7t5v0__aoi21_1
XFILLER_96_478 VDD VDD VSS VSS gf180mcu_fd_sc_mcu7t5v0__fillcap_32
XFILLER_37_512 VDD VDD VSS VSS gf180mcu_fd_sc_mcu7t5v0__fill_2
XFILLER_37_523 VDD VDD VSS VSS gf180mcu_fd_sc_mcu7t5v0__fill_2
XFILLER_49_394 VDD VDD VSS VSS gf180mcu_fd_sc_mcu7t5v0__fill_1
XFILLER_64_342 VDD VDD VSS VSS gf180mcu_fd_sc_mcu7t5v0__fill_2
XTAP_TAPCELL_ROW_22_418 VDD VSS gf180mcu_fd_sc_mcu7t5v0__filltie
XFILLER_32_283 VDD VDD VSS VSS gf180mcu_fd_sc_mcu7t5v0__fill_1
XFILLER_20_434 VDD VDD VSS VSS gf180mcu_fd_sc_mcu7t5v0__fill_1
X_3756_ _3756_/D wire552/Z clkload8/I _3756_/Q VDD VDD VSS VSS gf180mcu_fd_sc_mcu7t5v0__dffrnq_1
Xclkbuf_4_12_0_clk clkbuf_0_clk/Z _3717_/CLK VDD VDD VSS VSS gf180mcu_fd_sc_mcu7t5v0__clkbuf_8
X_2707_ wire515/Z _2706_/B _2709_/B1 VDD VDD VSS VSS gf180mcu_fd_sc_mcu7t5v0__nor2_1
XTAP_TAPCELL_ROW_30_495 VDD VSS gf180mcu_fd_sc_mcu7t5v0__filltie
X_3687_ _3687_/D _3687_/RN clkload0/I _3687_/Q VDD VDD VSS VSS gf180mcu_fd_sc_mcu7t5v0__dffrnq_2
X_2638_ _2638_/A1 _2623_/Z _2638_/A3 _2638_/B wire304/I VDD VDD VSS VSS gf180mcu_fd_sc_mcu7t5v0__oai31_4
Xoutput220 _3712_/Q raw_edge3[2] VDD VDD VSS VSS gf180mcu_fd_sc_mcu7t5v0__buf_2
X_2569_ _2569_/A1 _2573_/A2 _2497_/B _2569_/Z VDD VDD VSS VSS gf180mcu_fd_sc_mcu7t5v0__or3_1
XFILLER_59_136 VDD VDD VSS VSS gf180mcu_fd_sc_mcu7t5v0__fillcap_4
XFILLER_15_206 VDD VDD VSS VSS gf180mcu_fd_sc_mcu7t5v0__fillcap_4
XTAP_TAPCELL_ROW_38_573 VDD VSS gf180mcu_fd_sc_mcu7t5v0__filltie
XFILLER_55_375 VDD VDD VSS VSS gf180mcu_fd_sc_mcu7t5v0__fill_1
XFILLER_43_537 VDD VDD VSS VSS gf180mcu_fd_sc_mcu7t5v0__fillcap_4
XFILLER_90_37 VDD VDD VSS VSS gf180mcu_fd_sc_mcu7t5v0__fillcap_64
XFILLER_51_570 VDD VDD VSS VSS gf180mcu_fd_sc_mcu7t5v0__fillcap_4
XFILLER_7_416 VDD VDD VSS VSS gf180mcu_fd_sc_mcu7t5v0__fillcap_4
Xwire358 wire358/I wire358/Z VDD VDD VSS VSS gf180mcu_fd_sc_mcu7t5v0__clkbuf_2
XFILLER_34_515 VDD VDD VSS VSS gf180mcu_fd_sc_mcu7t5v0__fillcap_4
XTAP_TAPCELL_ROW_64_819 VDD VSS gf180mcu_fd_sc_mcu7t5v0__filltie
XPHY_EDGE_ROW_14_Left_111 VDD VSS gf180mcu_fd_sc_mcu7t5v0__endcap
XFILLER_61_378 VDD VDD VSS VSS gf180mcu_fd_sc_mcu7t5v0__fill_1
X_1940_ _1958_/B1 _1958_/B2 _1961_/A1 VDD VDD VSS VSS gf180mcu_fd_sc_mcu7t5v0__nand2_1
XTAP_TAPCELL_ROW_72_896 VDD VSS gf180mcu_fd_sc_mcu7t5v0__filltie
XFILLER_9_66 VDD VDD VSS VSS gf180mcu_fd_sc_mcu7t5v0__fillcap_4
X_1871_ _3399_/A1 _1870_/Z _1871_/Z VDD VDD VSS VSS gf180mcu_fd_sc_mcu7t5v0__xor2_2
X_3610_ _3636_/C _3609_/Z _3610_/Z VDD VDD VSS VSS gf180mcu_fd_sc_mcu7t5v0__xor2_2
X_3541_ _3538_/Z _3541_/A2 _3541_/Z VDD VDD VSS VSS gf180mcu_fd_sc_mcu7t5v0__or2_1
XPHY_EDGE_ROW_23_Left_120 VDD VSS gf180mcu_fd_sc_mcu7t5v0__endcap
X_3472_ _3472_/A1 _3485_/A2 _3472_/A3 _3472_/Z VDD VDD VSS VSS gf180mcu_fd_sc_mcu7t5v0__xor3_1
X_2423_ _2423_/A1 _2341_/B _2421_/Z wire362/Z _2981_/ZN _3751_/D VDD VDD VSS VSS gf180mcu_fd_sc_mcu7t5v0__oai32_1
XFILLER_43_2 VDD VDD VSS VSS gf180mcu_fd_sc_mcu7t5v0__fillcap_64
X_2354_ _2354_/A1 input7/Z wire622/Z _3753_/Q _2432_/A2 VDD VDD VSS VSS gf180mcu_fd_sc_mcu7t5v0__aoi22_1
X_2285_ _3757_/Q _2446_/B _2935_/A1 VDD VDD VSS VSS gf180mcu_fd_sc_mcu7t5v0__nand2_1
XFILLER_37_342 VDD VDD VSS VSS gf180mcu_fd_sc_mcu7t5v0__fill_1
XFILLER_25_515 VDD VDD VSS VSS gf180mcu_fd_sc_mcu7t5v0__fillcap_8
XFILLER_64_194 VDD VDD VSS VSS gf180mcu_fd_sc_mcu7t5v0__fillcap_8
XFILLER_12_209 VDD VDD VSS VSS gf180mcu_fd_sc_mcu7t5v0__fillcap_16
XTAP_TAPCELL_ROW_35_543 VDD VSS gf180mcu_fd_sc_mcu7t5v0__filltie
XFILLER_4_419 VDD VDD VSS VSS gf180mcu_fd_sc_mcu7t5v0__fillcap_8
X_3739_ _3739_/D _3739_/RN _3739_/CLK _3739_/Q VDD VDD VSS VSS gf180mcu_fd_sc_mcu7t5v0__dffrnq_1
XFILLER_0_614 VDD VDD VSS VSS gf180mcu_fd_sc_mcu7t5v0__fillcap_32
XFILLER_43_301 VDD VDD VSS VSS gf180mcu_fd_sc_mcu7t5v0__fill_2
XFILLER_71_632 VDD VDD VSS VSS gf180mcu_fd_sc_mcu7t5v0__fill_1
XFILLER_71_676 VDD VDD VSS VSS gf180mcu_fd_sc_mcu7t5v0__fill_1
XFILLER_7_279 VDD VDD VSS VSS gf180mcu_fd_sc_mcu7t5v0__fill_1
XTAP_TAPCELL_ROW_94_1099 VDD VSS gf180mcu_fd_sc_mcu7t5v0__filltie
XFILLER_93_212 VDD VDD VSS VSS gf180mcu_fd_sc_mcu7t5v0__fillcap_64
XFILLER_39_629 VDD VDD VSS VSS gf180mcu_fd_sc_mcu7t5v0__fill_1
X_2070_ _1995_/I _2022_/Z _2036_/I _2056_/Z _2073_/A2 VDD VDD VSS VSS gf180mcu_fd_sc_mcu7t5v0__nor4_2
XFILLER_19_397 VDD VDD VSS VSS gf180mcu_fd_sc_mcu7t5v0__fillcap_4
X_2972_ _2972_/I _3129_/B2 VDD VDD VSS VSS gf180mcu_fd_sc_mcu7t5v0__clkinv_1
XTAP_TAPCELL_ROW_32_513 VDD VSS gf180mcu_fd_sc_mcu7t5v0__filltie
X_1923_ _1942_/A1 _1959_/A1 _1923_/Z VDD VDD VSS VSS gf180mcu_fd_sc_mcu7t5v0__xor2_1
X_1854_ _3419_/A1 _1840_/Z _1854_/B _1856_/A2 VDD VDD VSS VSS gf180mcu_fd_sc_mcu7t5v0__oai21_1
XTAP_TAPCELL_ROW_40_590 VDD VSS gf180mcu_fd_sc_mcu7t5v0__filltie
X_3524_ wire642/Z _3523_/Z _3539_/B VDD VDD VSS VSS gf180mcu_fd_sc_mcu7t5v0__or2_1
XFILLER_89_529 VDD VDD VSS VSS gf180mcu_fd_sc_mcu7t5v0__fill_1
X_3455_ _3455_/A1 _3455_/A2 _3455_/B _3455_/C _3518_/A1 VDD VDD VSS VSS gf180mcu_fd_sc_mcu7t5v0__oai211_4
X_2406_ _3745_/Q wire544/I _2953_/A2 VDD VDD VSS VSS gf180mcu_fd_sc_mcu7t5v0__nand2_1
Xload_slew650 _3010_/I _3472_/A1 VDD VDD VSS VSS gf180mcu_fd_sc_mcu7t5v0__clkbuf_4
X_3386_ _3386_/A1 _3672_/Q _3387_/I VDD VDD VSS VSS gf180mcu_fd_sc_mcu7t5v0__xor2_1
Xload_slew661 wire660/I _3014_/I VDD VDD VSS VSS gf180mcu_fd_sc_mcu7t5v0__buf_2
X_2337_ wire358/I _3178_/A1 _2337_/B _2339_/B VDD VDD VSS VSS gf180mcu_fd_sc_mcu7t5v0__oai21_1
XFILLER_57_404 VDD VDD VSS VSS gf180mcu_fd_sc_mcu7t5v0__fill_2
XFILLER_69_275 VDD VDD VSS VSS gf180mcu_fd_sc_mcu7t5v0__fillcap_4
XTAP_TAPCELL_ROW_4_249 VDD VSS gf180mcu_fd_sc_mcu7t5v0__filltie
X_2268_ _2121_/Z _2268_/A2 _2269_/A2 VDD VDD VSS VSS gf180mcu_fd_sc_mcu7t5v0__nor2_1
X_2199_ _2199_/A1 _2199_/A2 _2199_/B _2208_/A1 VDD VDD VSS VSS gf180mcu_fd_sc_mcu7t5v0__oai21_1
XFILLER_53_632 VDD VDD VSS VSS gf180mcu_fd_sc_mcu7t5v0__fillcap_4
XFILLER_65_492 VDD VDD VSS VSS gf180mcu_fd_sc_mcu7t5v0__fillcap_16
XFILLER_53_676 VDD VDD VSS VSS gf180mcu_fd_sc_mcu7t5v0__fill_1
XFILLER_96_36 VDD VDD VSS VSS gf180mcu_fd_sc_mcu7t5v0__fillcap_32
XFILLER_0_444 VDD VDD VSS VSS gf180mcu_fd_sc_mcu7t5v0__fillcap_32
XFILLER_75_212 VDD VDD VSS VSS gf180mcu_fd_sc_mcu7t5v0__fillcap_64
XFILLER_29_640 VDD VDD VSS VSS gf180mcu_fd_sc_mcu7t5v0__fill_1
XTAP_TAPCELL_ROW_74_914 VDD VSS gf180mcu_fd_sc_mcu7t5v0__filltie
XTAP_TAPCELL_ROW_46_649 VDD VSS gf180mcu_fd_sc_mcu7t5v0__filltie
XFILLER_16_334 VDD VDD VSS VSS gf180mcu_fd_sc_mcu7t5v0__fillcap_8
XFILLER_43_142 VDD VDD VSS VSS gf180mcu_fd_sc_mcu7t5v0__fill_1
XTAP_TAPCELL_ROW_82_991 VDD VSS gf180mcu_fd_sc_mcu7t5v0__filltie
XFILLER_12_562 VDD VDD VSS VSS gf180mcu_fd_sc_mcu7t5v0__fill_1
XFILLER_61_72 VDD VDD VSS VSS gf180mcu_fd_sc_mcu7t5v0__fillcap_64
XTAP_TAPCELL_ROW_96_1128 VDD VSS gf180mcu_fd_sc_mcu7t5v0__filltie
XTAP_TAPCELL_ROW_96_1117 VDD VSS gf180mcu_fd_sc_mcu7t5v0__filltie
XFILLER_8_566 VDD VDD VSS VSS gf180mcu_fd_sc_mcu7t5v0__fill_1
XFILLER_6_34 VDD VDD VSS VSS gf180mcu_fd_sc_mcu7t5v0__fill_1
X_3240_ _3332_/A1 _3309_/A2 _3271_/B _3272_/B VDD VDD VSS VSS gf180mcu_fd_sc_mcu7t5v0__oai21_2
XFILLER_3_282 VDD VDD VSS VSS gf180mcu_fd_sc_mcu7t5v0__fill_2
XFILLER_79_573 VDD VDD VSS VSS gf180mcu_fd_sc_mcu7t5v0__fillcap_8
XFILLER_79_562 VDD VDD VSS VSS gf180mcu_fd_sc_mcu7t5v0__fill_2
X_3171_ _3176_/A1 _3176_/A3 _3172_/A2 VDD VDD VSS VSS gf180mcu_fd_sc_mcu7t5v0__nor2_1
XFILLER_94_521 VDD VDD VSS VSS gf180mcu_fd_sc_mcu7t5v0__fillcap_4
X_2122_ _3138_/A2 _3779_/Q _2301_/A2 VDD VDD VSS VSS gf180mcu_fd_sc_mcu7t5v0__nand2_1
XTAP_TAPCELL_ROW_1_219 VDD VSS gf180mcu_fd_sc_mcu7t5v0__filltie
X_2053_ _3066_/I _2053_/A2 _2053_/B _2056_/A2 VDD VDD VSS VSS gf180mcu_fd_sc_mcu7t5v0__aoi21_1
XFILLER_35_632 VDD VDD VSS VSS gf180mcu_fd_sc_mcu7t5v0__fill_1
XFILLER_50_613 VDD VDD VSS VSS gf180mcu_fd_sc_mcu7t5v0__fill_1
XTAP_TAPCELL_ROW_17_373 VDD VSS gf180mcu_fd_sc_mcu7t5v0__filltie
X_2955_ wire258/I _2955_/A2 _2955_/B _3715_/D VDD VDD VSS VSS gf180mcu_fd_sc_mcu7t5v0__oai21_1
X_1906_ _3431_/A1 _1904_/Z _1907_/I VDD VDD VSS VSS gf180mcu_fd_sc_mcu7t5v0__xor2_1
X_2886_ _3612_/A2 wire346/I _2886_/B1 _2886_/B2 _3685_/D VDD VDD VSS VSS gf180mcu_fd_sc_mcu7t5v0__oai22_1
X_1837_ _1865_/A1 _1865_/A2 _1865_/C _1849_/A2 VDD VDD VSS VSS gf180mcu_fd_sc_mcu7t5v0__oai21_1
X_3507_ _3677_/Q _3507_/A2 _3507_/B _3509_/A2 VDD VDD VSS VSS gf180mcu_fd_sc_mcu7t5v0__aoi21_1
Xmax_cap285 wire286/Z _3410_/A2 VDD VDD VSS VSS gf180mcu_fd_sc_mcu7t5v0__dlyb_1
X_3438_ _3439_/A1 _3437_/Z _3447_/B VDD VDD VSS VSS gf180mcu_fd_sc_mcu7t5v0__nor2_1
X_3369_ _3419_/A1 _3671_/Q _3420_/C VDD VDD VSS VSS gf180mcu_fd_sc_mcu7t5v0__nand2_1
Xload_slew480 _3723_/Q _3194_/A2 VDD VDD VSS VSS gf180mcu_fd_sc_mcu7t5v0__buf_2
Xload_slew491 _3701_/Q _3520_/A1 VDD VDD VSS VSS gf180mcu_fd_sc_mcu7t5v0__buf_2
XFILLER_45_407 VDD VDD VSS VSS gf180mcu_fd_sc_mcu7t5v0__fillcap_4
XTAP_TAPCELL_ROW_84_1010 VDD VSS gf180mcu_fd_sc_mcu7t5v0__filltie
XFILLER_25_142 VDD VDD VSS VSS gf180mcu_fd_sc_mcu7t5v0__fillcap_64
XFILLER_40_101 VDD VDD VSS VSS gf180mcu_fd_sc_mcu7t5v0__fillcap_4
XTAP_TAPCELL_ROW_43_619 VDD VSS gf180mcu_fd_sc_mcu7t5v0__filltie
XFILLER_13_337 VDD VDD VSS VSS gf180mcu_fd_sc_mcu7t5v0__fillcap_8
XTAP_TAPCELL_ROW_51_696 VDD VSS gf180mcu_fd_sc_mcu7t5v0__filltie
XTAP_TAPCELL_ROW_91_1069 VDD VSS gf180mcu_fd_sc_mcu7t5v0__filltie
Xoutput97 _3212_/Z cal_phase0_offset[17] VDD VDD VSS VSS gf180mcu_fd_sc_mcu7t5v0__buf_2
XFILLER_0_274 VDD VDD VSS VSS gf180mcu_fd_sc_mcu7t5v0__fillcap_4
XFILLER_17_632 VDD VDD VSS VSS gf180mcu_fd_sc_mcu7t5v0__fill_1
XFILLER_29_492 VDD VDD VSS VSS gf180mcu_fd_sc_mcu7t5v0__fillcap_8
XTAP_TAPCELL_ROW_14_343 VDD VSS gf180mcu_fd_sc_mcu7t5v0__filltie
X_2740_ _2740_/A1 _2740_/A2 _2740_/B _3656_/D VDD VDD VSS VSS gf180mcu_fd_sc_mcu7t5v0__aoi21_1
XFILLER_8_341 VDD VDD VSS VSS gf180mcu_fd_sc_mcu7t5v0__fill_1
X_2671_ _2675_/C _2675_/B _2672_/I VDD VDD VSS VSS gf180mcu_fd_sc_mcu7t5v0__xor2_1
X_3223_ _3260_/A2 _3226_/A2 _3223_/Z VDD VDD VSS VSS gf180mcu_fd_sc_mcu7t5v0__xor2_2
XFILLER_39_212 VDD VDD VSS VSS gf180mcu_fd_sc_mcu7t5v0__fillcap_32
XPHY_EDGE_ROW_6_Left_103 VDD VSS gf180mcu_fd_sc_mcu7t5v0__endcap
X_3154_ wire516/Z _3715_/Q _3163_/A1 VDD VDD VSS VSS gf180mcu_fd_sc_mcu7t5v0__nand2_1
X_2105_ _3627_/A1 _2103_/Z _2105_/Z VDD VDD VSS VSS gf180mcu_fd_sc_mcu7t5v0__xor2_1
XFILLER_82_513 VDD VDD VSS VSS gf180mcu_fd_sc_mcu7t5v0__fill_2
X_3085_ _3736_/Q _3085_/ZN VDD VDD VSS VSS gf180mcu_fd_sc_mcu7t5v0__clkinv_1
X_2036_ _2036_/I _2057_/A1 VDD VDD VSS VSS gf180mcu_fd_sc_mcu7t5v0__clkinv_1
XFILLER_23_602 VDD VDD VSS VSS gf180mcu_fd_sc_mcu7t5v0__fill_2
XFILLER_35_451 VDD VDD VSS VSS gf180mcu_fd_sc_mcu7t5v0__fillcap_16
XFILLER_90_590 VDD VDD VSS VSS gf180mcu_fd_sc_mcu7t5v0__fillcap_4
XFILLER_22_101 VDD VDD VSS VSS gf180mcu_fd_sc_mcu7t5v0__fillcap_4
XFILLER_10_329 VDD VDD VSS VSS gf180mcu_fd_sc_mcu7t5v0__fillcap_16
X_2938_ _3707_/Q _2939_/A2 _2939_/B VDD VDD VSS VSS gf180mcu_fd_sc_mcu7t5v0__nand2_1
X_2869_ _3063_/I wire233/Z _2871_/B1 VDD VDD VSS VSS gf180mcu_fd_sc_mcu7t5v0__nor2_1
XFILLER_85_362 VDD VDD VSS VSS gf180mcu_fd_sc_mcu7t5v0__fill_1
XFILLER_26_440 VDD VDD VSS VSS gf180mcu_fd_sc_mcu7t5v0__fill_1
XTAP_TAPCELL_ROW_56_744 VDD VSS gf180mcu_fd_sc_mcu7t5v0__filltie
XFILLER_73_557 VDD VDD VSS VSS gf180mcu_fd_sc_mcu7t5v0__fill_2
XFILLER_26_473 VDD VDD VSS VSS gf180mcu_fd_sc_mcu7t5v0__fill_2
XTAP_TAPCELL_ROW_11_313 VDD VSS gf180mcu_fd_sc_mcu7t5v0__filltie
XFILLER_68_307 VDD VDD VSS VSS gf180mcu_fd_sc_mcu7t5v0__fillcap_8
XPHY_EDGE_ROW_79_Left_176 VDD VSS gf180mcu_fd_sc_mcu7t5v0__endcap
XFILLER_76_351 VDD VDD VSS VSS gf180mcu_fd_sc_mcu7t5v0__fillcap_16
XFILLER_76_340 VDD VDD VSS VSS gf180mcu_fd_sc_mcu7t5v0__fillcap_4
XFILLER_76_384 VDD VDD VSS VSS gf180mcu_fd_sc_mcu7t5v0__fill_1
XFILLER_49_598 VDD VDD VSS VSS gf180mcu_fd_sc_mcu7t5v0__fill_1
XFILLER_44_270 VDD VDD VSS VSS gf180mcu_fd_sc_mcu7t5v0__fill_2
XFILLER_72_590 VDD VDD VSS VSS gf180mcu_fd_sc_mcu7t5v0__fillcap_4
XPHY_EDGE_ROW_88_Left_185 VDD VSS gf180mcu_fd_sc_mcu7t5v0__endcap
X_3772_ _3772_/D wire552/I clkload7/I _3772_/Q VDD VDD VSS VSS gf180mcu_fd_sc_mcu7t5v0__dffrnq_1
X_2723_ _3004_/ZN _2685_/Z _2723_/B1 _2723_/B2 _2723_/C _2724_/B2 VDD VDD VSS VSS
+ gf180mcu_fd_sc_mcu7t5v0__aoi221_1
XFILLER_73_2 VDD VDD VSS VSS gf180mcu_fd_sc_mcu7t5v0__fillcap_64
XFILLER_9_672 VDD VDD VSS VSS gf180mcu_fd_sc_mcu7t5v0__fillcap_4
XFILLER_8_171 VDD VDD VSS VSS gf180mcu_fd_sc_mcu7t5v0__fillcap_4
XFILLER_8_193 VDD VDD VSS VSS gf180mcu_fd_sc_mcu7t5v0__fillcap_8
X_2654_ _2654_/A1 _2654_/A2 _2654_/B _2655_/B VDD VDD VSS VSS gf180mcu_fd_sc_mcu7t5v0__aoi21_1
X_2585_ _2586_/B _2559_/Z _2586_/A2 _2561_/Z _2696_/B _2587_/B2 VDD VDD VSS VSS gf180mcu_fd_sc_mcu7t5v0__oai32_2
XFILLER_87_638 VDD VDD VSS VSS gf180mcu_fd_sc_mcu7t5v0__fill_2
X_3206_ _3207_/A1 _3207_/B _3207_/A2 _3206_/Z VDD VDD VSS VSS gf180mcu_fd_sc_mcu7t5v0__and3_1
X_3137_ _3326_/A1 _3136_/Z _3765_/D VDD VDD VSS VSS gf180mcu_fd_sc_mcu7t5v0__nor2_1
XFILLER_55_557 VDD VDD VSS VSS gf180mcu_fd_sc_mcu7t5v0__fill_2
X_3068_ _3704_/Q _3582_/A1 VDD VDD VSS VSS gf180mcu_fd_sc_mcu7t5v0__clkinv_1
XFILLER_82_387 VDD VDD VSS VSS gf180mcu_fd_sc_mcu7t5v0__fillcap_8
XTAP_TAPCELL_ROW_53_714 VDD VSS gf180mcu_fd_sc_mcu7t5v0__filltie
XFILLER_70_527 VDD VDD VSS VSS gf180mcu_fd_sc_mcu7t5v0__fillcap_8
X_2019_ _3550_/A1 _2017_/Z _2020_/B VDD VDD VSS VSS gf180mcu_fd_sc_mcu7t5v0__xor2_1
XTAP_TAPCELL_ROW_25_449 VDD VSS gf180mcu_fd_sc_mcu7t5v0__filltie
XFILLER_35_270 VDD VDD VSS VSS gf180mcu_fd_sc_mcu7t5v0__fillcap_8
XFILLER_50_273 VDD VDD VSS VSS gf180mcu_fd_sc_mcu7t5v0__fill_2
XTAP_TAPCELL_ROW_61_791 VDD VSS gf180mcu_fd_sc_mcu7t5v0__filltie
XFILLER_88_37 VDD VDD VSS VSS gf180mcu_fd_sc_mcu7t5v0__fillcap_64
XFILLER_92_107 VDD VDD VSS VSS gf180mcu_fd_sc_mcu7t5v0__fillcap_64
XFILLER_46_524 VDD VDD VSS VSS gf180mcu_fd_sc_mcu7t5v0__fill_1
XFILLER_58_373 VDD VDD VSS VSS gf180mcu_fd_sc_mcu7t5v0__fillcap_8
XFILLER_58_395 VDD VDD VSS VSS gf180mcu_fd_sc_mcu7t5v0__fill_2
XFILLER_46_579 VDD VDD VSS VSS gf180mcu_fd_sc_mcu7t5v0__fill_2
XFILLER_14_465 VDD VDD VSS VSS gf180mcu_fd_sc_mcu7t5v0__fill_1
XFILLER_14_454 VDD VDD VSS VSS gf180mcu_fd_sc_mcu7t5v0__fill_1
XFILLER_41_251 VDD VDD VSS VSS gf180mcu_fd_sc_mcu7t5v0__fillcap_8
XFILLER_14_476 VDD VDD VSS VSS gf180mcu_fd_sc_mcu7t5v0__fill_2
XFILLER_41_284 VDD VDD VSS VSS gf180mcu_fd_sc_mcu7t5v0__fill_1
XFILLER_6_675 VDD VDD VSS VSS gf180mcu_fd_sc_mcu7t5v0__fill_2
X_2370_ _2375_/A1 _2373_/A2 _2371_/A2 VDD VDD VSS VSS gf180mcu_fd_sc_mcu7t5v0__nand2_1
XFILLER_52_505 VDD VDD VSS VSS gf180mcu_fd_sc_mcu7t5v0__fill_1
XFILLER_52_527 VDD VDD VSS VSS gf180mcu_fd_sc_mcu7t5v0__fillcap_8
XFILLER_64_387 VDD VDD VSS VSS gf180mcu_fd_sc_mcu7t5v0__fillcap_4
XFILLER_64_398 VDD VDD VSS VSS gf180mcu_fd_sc_mcu7t5v0__fillcap_16
XTAP_TAPCELL_ROW_22_419 VDD VSS gf180mcu_fd_sc_mcu7t5v0__filltie
X_3755_ _3755_/D wire594/Z clkload8/I _3755_/Q VDD VDD VSS VSS gf180mcu_fd_sc_mcu7t5v0__dffrnq_2
X_2706_ wire515/Z _2628_/B _2706_/B _2709_/C VDD VDD VSS VSS gf180mcu_fd_sc_mcu7t5v0__oai21_1
XTAP_TAPCELL_ROW_30_496 VDD VSS gf180mcu_fd_sc_mcu7t5v0__filltie
X_3686_ _3686_/D _3686_/RN clkload5/I _3686_/Q VDD VDD VSS VSS gf180mcu_fd_sc_mcu7t5v0__dffrnq_2
XPHY_EDGE_ROW_12_Right_12 VDD VSS gf180mcu_fd_sc_mcu7t5v0__endcap
X_2637_ _2623_/Z _2638_/A3 _2699_/A3 VDD VDD VSS VSS gf180mcu_fd_sc_mcu7t5v0__nor2_1
Xoutput210 _3722_/Q raw_edge3[12] VDD VDD VSS VSS gf180mcu_fd_sc_mcu7t5v0__buf_2
Xoutput221 _3713_/Q raw_edge3[3] VDD VDD VSS VSS gf180mcu_fd_sc_mcu7t5v0__buf_2
X_2568_ _3012_/I _2568_/A2 _2566_/Z _2579_/A1 VDD VDD VSS VSS gf180mcu_fd_sc_mcu7t5v0__nor3_1
X_2499_ _2499_/I _2500_/B VDD VDD VSS VSS gf180mcu_fd_sc_mcu7t5v0__clkinv_1
XFILLER_28_524 VDD VDD VSS VSS gf180mcu_fd_sc_mcu7t5v0__fill_1
XFILLER_74_107 VDD VDD VSS VSS gf180mcu_fd_sc_mcu7t5v0__fillcap_64
XFILLER_28_535 VDD VDD VSS VSS gf180mcu_fd_sc_mcu7t5v0__fillcap_4
XFILLER_28_557 VDD VDD VSS VSS gf180mcu_fd_sc_mcu7t5v0__fillcap_16
XPHY_EDGE_ROW_21_Right_21 VDD VSS gf180mcu_fd_sc_mcu7t5v0__endcap
XFILLER_70_379 VDD VDD VSS VSS gf180mcu_fd_sc_mcu7t5v0__fillcap_4
XFILLER_23_251 VDD VDD VSS VSS gf180mcu_fd_sc_mcu7t5v0__fill_1
Xwire304 wire304/I wire304/Z VDD VDD VSS VSS gf180mcu_fd_sc_mcu7t5v0__clkbuf_2
Xwire359 wire359/I _2675_/C VDD VDD VSS VSS gf180mcu_fd_sc_mcu7t5v0__buf_2
XPHY_EDGE_ROW_30_Right_30 VDD VSS gf180mcu_fd_sc_mcu7t5v0__endcap
XFILLER_3_2 VDD VDD VSS VSS gf180mcu_fd_sc_mcu7t5v0__fillcap_64
Xload_slew309 _2775_/A2 _2795_/A2 VDD VDD VSS VSS gf180mcu_fd_sc_mcu7t5v0__buf_1
XFILLER_2_177 VDD VDD VSS VSS gf180mcu_fd_sc_mcu7t5v0__fillcap_32
XFILLER_78_457 VDD VDD VSS VSS gf180mcu_fd_sc_mcu7t5v0__fillcap_8
XFILLER_93_416 VDD VDD VSS VSS gf180mcu_fd_sc_mcu7t5v0__fillcap_4
XFILLER_19_502 VDD VDD VSS VSS gf180mcu_fd_sc_mcu7t5v0__fillcap_4
XFILLER_58_170 VDD VDD VSS VSS gf180mcu_fd_sc_mcu7t5v0__fillcap_4
XFILLER_0_36 VDD VDD VSS VSS gf180mcu_fd_sc_mcu7t5v0__fillcap_32
XFILLER_46_387 VDD VDD VSS VSS gf180mcu_fd_sc_mcu7t5v0__fillcap_16
XFILLER_42_571 VDD VDD VSS VSS gf180mcu_fd_sc_mcu7t5v0__fill_2
X_1870_ _3425_/A1 _1868_/Z _1870_/Z VDD VDD VSS VSS gf180mcu_fd_sc_mcu7t5v0__xor2_1
X_3540_ _3538_/Z _3541_/A2 _3563_/B VDD VDD VSS VSS gf180mcu_fd_sc_mcu7t5v0__nand2_1
X_3471_ _3472_/A1 _3469_/Z _3471_/Z VDD VDD VSS VSS gf180mcu_fd_sc_mcu7t5v0__or2_1
X_2422_ _2422_/A1 _2422_/A2 _2965_/A2 VDD VDD VSS VSS gf180mcu_fd_sc_mcu7t5v0__nand2_1
X_2353_ _3119_/A2 input7/Z _2353_/Z VDD VDD VSS VSS gf180mcu_fd_sc_mcu7t5v0__xor2_2
XFILLER_36_2 VDD VDD VSS VSS gf180mcu_fd_sc_mcu7t5v0__fillcap_32
XFILLER_69_424 VDD VDD VSS VSS gf180mcu_fd_sc_mcu7t5v0__fill_1
XFILLER_69_446 VDD VDD VSS VSS gf180mcu_fd_sc_mcu7t5v0__fillcap_32
XFILLER_56_107 VDD VDD VSS VSS gf180mcu_fd_sc_mcu7t5v0__fillcap_16
X_2284_ _3726_/Q _2290_/A2 _2286_/B VDD VDD VSS VSS gf180mcu_fd_sc_mcu7t5v0__nand2_1
XFILLER_25_549 VDD VDD VSS VSS gf180mcu_fd_sc_mcu7t5v0__fill_1
XFILLER_37_387 VDD VDD VSS VSS gf180mcu_fd_sc_mcu7t5v0__fill_2
XFILLER_52_313 VDD VDD VSS VSS gf180mcu_fd_sc_mcu7t5v0__fill_2
XTAP_TAPCELL_ROW_35_544 VDD VSS gf180mcu_fd_sc_mcu7t5v0__filltie
XFILLER_40_519 VDD VDD VSS VSS gf180mcu_fd_sc_mcu7t5v0__fillcap_4
XFILLER_52_379 VDD VDD VSS VSS gf180mcu_fd_sc_mcu7t5v0__fillcap_4
X_1999_ _1999_/A1 _1999_/A2 _1999_/A3 _1999_/Z VDD VDD VSS VSS gf180mcu_fd_sc_mcu7t5v0__and3_1
X_3738_ _3738_/D _3738_/RN _3739_/CLK _3738_/Q VDD VDD VSS VSS gf180mcu_fd_sc_mcu7t5v0__dffrnq_1
X_3669_ _3669_/D _3670_/RN _3694_/CLK _3669_/Q VDD VDD VSS VSS gf180mcu_fd_sc_mcu7t5v0__dffrnq_2
XFILLER_0_648 VDD VDD VSS VSS gf180mcu_fd_sc_mcu7t5v0__fill_2
XFILLER_0_659 VDD VDD VSS VSS gf180mcu_fd_sc_mcu7t5v0__fillcap_16
XFILLER_87_276 VDD VDD VSS VSS gf180mcu_fd_sc_mcu7t5v0__fillcap_4
XFILLER_75_427 VDD VDD VSS VSS gf180mcu_fd_sc_mcu7t5v0__fillcap_4
XTAP_TAPCELL_ROW_87_1030 VDD VSS gf180mcu_fd_sc_mcu7t5v0__filltie
XFILLER_28_365 VDD VDD VSS VSS gf180mcu_fd_sc_mcu7t5v0__fillcap_8
XFILLER_16_527 VDD VDD VSS VSS gf180mcu_fd_sc_mcu7t5v0__fill_2
XFILLER_43_368 VDD VDD VSS VSS gf180mcu_fd_sc_mcu7t5v0__fillcap_4
XFILLER_24_593 VDD VDD VSS VSS gf180mcu_fd_sc_mcu7t5v0__fill_2
XFILLER_3_486 VDD VDD VSS VSS gf180mcu_fd_sc_mcu7t5v0__fillcap_4
XFILLER_59_72 VDD VDD VSS VSS gf180mcu_fd_sc_mcu7t5v0__fillcap_64
Xclkbuf_4_11_0_clk clkbuf_0_clk/Z _3774_/CLK VDD VDD VSS VSS gf180mcu_fd_sc_mcu7t5v0__clkbuf_8
XTAP_TAPCELL_ROW_49_669 VDD VSS gf180mcu_fd_sc_mcu7t5v0__filltie
XFILLER_34_313 VDD VDD VSS VSS gf180mcu_fd_sc_mcu7t5v0__fill_2
XFILLER_22_508 VDD VDD VSS VSS gf180mcu_fd_sc_mcu7t5v0__fill_2
XFILLER_34_346 VDD VDD VSS VSS gf180mcu_fd_sc_mcu7t5v0__fillcap_16
X_2971_ _3757_/Q wire359/I VDD VDD VSS VSS gf180mcu_fd_sc_mcu7t5v0__inv_2
XTAP_TAPCELL_ROW_32_514 VDD VSS gf180mcu_fd_sc_mcu7t5v0__filltie
X_1922_ _1919_/Z _1958_/A2 _1959_/A1 VDD VDD VSS VSS gf180mcu_fd_sc_mcu7t5v0__xnor2_1
X_1853_ wire655/Z _3046_/I _1850_/Z _1853_/Z VDD VDD VSS VSS gf180mcu_fd_sc_mcu7t5v0__xor3_1
XTAP_TAPCELL_ROW_40_591 VDD VSS gf180mcu_fd_sc_mcu7t5v0__filltie
X_3523_ _3523_/A1 _3549_/A1 _3523_/Z VDD VDD VSS VSS gf180mcu_fd_sc_mcu7t5v0__xor2_1
X_3454_ _3454_/A1 _3456_/A2 _3454_/A3 _3455_/A2 VDD VDD VSS VSS gf180mcu_fd_sc_mcu7t5v0__nand3_1
X_2405_ _3104_/B2 wire362/I _2404_/Z wire368/Z _3744_/D VDD VDD VSS VSS gf180mcu_fd_sc_mcu7t5v0__oai22_1
X_3385_ _3693_/Q _3385_/A2 _3401_/B VDD VDD VSS VSS gf180mcu_fd_sc_mcu7t5v0__nand2_1
Xload_slew651 input14/Z _3011_/I VDD VDD VSS VSS gf180mcu_fd_sc_mcu7t5v0__buf_4
Xload_slew662 input10/Z _3395_/A1 VDD VDD VSS VSS gf180mcu_fd_sc_mcu7t5v0__clkbuf_2
X_2336_ _2337_/B _2418_/A2 VDD VDD VSS VSS gf180mcu_fd_sc_mcu7t5v0__clkinv_1
XFILLER_69_287 VDD VDD VSS VSS gf180mcu_fd_sc_mcu7t5v0__fillcap_32
X_2267_ _3097_/ZN _2756_/A1 _2831_/A1 _2748_/A1 _2267_/C _2268_/A2 VDD VDD VSS VSS
+ gf180mcu_fd_sc_mcu7t5v0__aoi221_1
XFILLER_57_438 VDD VDD VSS VSS gf180mcu_fd_sc_mcu7t5v0__fillcap_8
XFILLER_25_324 VDD VDD VSS VSS gf180mcu_fd_sc_mcu7t5v0__fill_1
X_2198_ wire448/Z _2198_/A2 _2198_/B _2198_/C _2199_/A2 VDD VDD VSS VSS gf180mcu_fd_sc_mcu7t5v0__oai211_1
XFILLER_53_611 VDD VDD VSS VSS gf180mcu_fd_sc_mcu7t5v0__fill_2
XFILLER_80_452 VDD VDD VSS VSS gf180mcu_fd_sc_mcu7t5v0__fill_2
XFILLER_52_187 VDD VDD VSS VSS gf180mcu_fd_sc_mcu7t5v0__fill_2
XFILLER_4_217 VDD VDD VSS VSS gf180mcu_fd_sc_mcu7t5v0__fillcap_4
XFILLER_88_552 VDD VDD VSS VSS gf180mcu_fd_sc_mcu7t5v0__fill_1
XFILLER_0_478 VDD VDD VSS VSS gf180mcu_fd_sc_mcu7t5v0__fillcap_16
XPHY_EDGE_ROW_42_Left_139 VDD VSS gf180mcu_fd_sc_mcu7t5v0__endcap
XTAP_TAPCELL_ROW_74_915 VDD VSS gf180mcu_fd_sc_mcu7t5v0__filltie
XFILLER_63_419 VDD VDD VSS VSS gf180mcu_fd_sc_mcu7t5v0__fill_1
XFILLER_71_430 VDD VDD VSS VSS gf180mcu_fd_sc_mcu7t5v0__fillcap_4
XFILLER_45_96 VDD VDD VSS VSS gf180mcu_fd_sc_mcu7t5v0__fill_2
XFILLER_31_349 VDD VDD VSS VSS gf180mcu_fd_sc_mcu7t5v0__fill_1
XPHY_EDGE_ROW_51_Left_148 VDD VSS gf180mcu_fd_sc_mcu7t5v0__endcap
XFILLER_71_496 VDD VDD VSS VSS gf180mcu_fd_sc_mcu7t5v0__fill_2
XFILLER_8_501 VDD VDD VSS VSS gf180mcu_fd_sc_mcu7t5v0__fill_1
XTAP_TAPCELL_ROW_96_1129 VDD VSS gf180mcu_fd_sc_mcu7t5v0__filltie
XTAP_TAPCELL_ROW_96_1118 VDD VSS gf180mcu_fd_sc_mcu7t5v0__filltie
XPHY_EDGE_ROW_60_Left_157 VDD VSS gf180mcu_fd_sc_mcu7t5v0__endcap
X_3170_ _3170_/A1 _3170_/A2 _3170_/B _3170_/C _3176_/A3 VDD VDD VSS VSS gf180mcu_fd_sc_mcu7t5v0__aoi211_2
XFILLER_39_438 VDD VDD VSS VSS gf180mcu_fd_sc_mcu7t5v0__fillcap_8
X_2121_ _3658_/Q _3659_/Q _2121_/A3 _2121_/Z VDD VDD VSS VSS gf180mcu_fd_sc_mcu7t5v0__or3_1
X_2052_ _3587_/A1 _3704_/Q _2052_/A3 _2052_/Z VDD VDD VSS VSS gf180mcu_fd_sc_mcu7t5v0__xor3_1
XFILLER_22_305 VDD VDD VSS VSS gf180mcu_fd_sc_mcu7t5v0__fill_2
X_2954_ _3715_/Q wire258/I _2955_/B VDD VDD VSS VSS gf180mcu_fd_sc_mcu7t5v0__nand2_1
X_1905_ _3431_/A1 _1904_/Z _1920_/A2 VDD VDD VSS VSS gf180mcu_fd_sc_mcu7t5v0__nor2_1
X_2885_ _2885_/A1 _2894_/A2 _2885_/B _2886_/B2 VDD VDD VSS VSS gf180mcu_fd_sc_mcu7t5v0__oai21_1
X_1836_ _1836_/A1 _1836_/A2 _1865_/A2 VDD VDD VSS VSS gf180mcu_fd_sc_mcu7t5v0__nand2_1
XPHY_EDGE_ROW_6_Right_6 VDD VSS gf180mcu_fd_sc_mcu7t5v0__endcap
X_3506_ _3506_/A1 _3504_/Z _3506_/Z VDD VDD VSS VSS gf180mcu_fd_sc_mcu7t5v0__xor2_1
X_3437_ _3437_/A1 _3437_/A2 _3437_/A3 _3437_/Z VDD VDD VSS VSS gf180mcu_fd_sc_mcu7t5v0__xor3_1
X_3368_ _3388_/A1 _3670_/Q _3368_/B _3375_/A2 VDD VDD VSS VSS gf180mcu_fd_sc_mcu7t5v0__oai21_1
Xload_slew470 _3744_/Q _2905_/A1 VDD VDD VSS VSS gf180mcu_fd_sc_mcu7t5v0__buf_2
X_2319_ _3743_/Q _2578_/A1 _2319_/Z VDD VDD VSS VSS gf180mcu_fd_sc_mcu7t5v0__or2_1
Xload_slew481 _3722_/Q _2006_/C VDD VDD VSS VSS gf180mcu_fd_sc_mcu7t5v0__buf_2
X_3299_ _3223_/Z _3225_/Z _3299_/B _3302_/A2 VDD VDD VSS VSS gf180mcu_fd_sc_mcu7t5v0__oai21_1
XFILLER_57_268 VDD VDD VSS VSS gf180mcu_fd_sc_mcu7t5v0__fillcap_8
XFILLER_45_419 VDD VDD VSS VSS gf180mcu_fd_sc_mcu7t5v0__fill_1
XFILLER_15_66 VDD VDD VSS VSS gf180mcu_fd_sc_mcu7t5v0__fillcap_4
XFILLER_13_349 VDD VDD VSS VSS gf180mcu_fd_sc_mcu7t5v0__fill_1
XFILLER_40_168 VDD VDD VSS VSS gf180mcu_fd_sc_mcu7t5v0__fillcap_4
Xoutput98 _3216_/Z cal_phase0_offset[18] VDD VDD VSS VSS gf180mcu_fd_sc_mcu7t5v0__buf_2
Xoutput87 _3731_/Q cal_dir VDD VDD VSS VSS gf180mcu_fd_sc_mcu7t5v0__buf_2
XFILLER_88_382 VDD VDD VSS VSS gf180mcu_fd_sc_mcu7t5v0__fill_2
XFILLER_76_555 VDD VDD VSS VSS gf180mcu_fd_sc_mcu7t5v0__fillcap_16
XTAP_TAPCELL_ROW_59_764 VDD VSS gf180mcu_fd_sc_mcu7t5v0__filltie
XFILLER_63_205 VDD VDD VSS VSS gf180mcu_fd_sc_mcu7t5v0__fill_1
XFILLER_32_636 VDD VDD VSS VSS gf180mcu_fd_sc_mcu7t5v0__fill_1
XTAP_TAPCELL_ROW_14_344 VDD VSS gf180mcu_fd_sc_mcu7t5v0__filltie
XFILLER_31_135 VDD VDD VSS VSS gf180mcu_fd_sc_mcu7t5v0__fillcap_4
XFILLER_31_146 VDD VDD VSS VSS gf180mcu_fd_sc_mcu7t5v0__fill_2
XFILLER_12_371 VDD VDD VSS VSS gf180mcu_fd_sc_mcu7t5v0__fill_1
XPHY_EDGE_ROW_59_Right_59 VDD VSS gf180mcu_fd_sc_mcu7t5v0__endcap
X_2670_ _2970_/I input48/Z _2670_/Z VDD VDD VSS VSS gf180mcu_fd_sc_mcu7t5v0__xor2_1
X_3222_ _3222_/A1 _3225_/A2 wire351/I VDD VDD VSS VSS gf180mcu_fd_sc_mcu7t5v0__xnor2_2
X_3153_ _3150_/I _3153_/A2 _3153_/Z VDD VDD VSS VSS gf180mcu_fd_sc_mcu7t5v0__xor2_1
XFILLER_67_511 VDD VDD VSS VSS gf180mcu_fd_sc_mcu7t5v0__fillcap_16
XFILLER_67_533 VDD VDD VSS VSS gf180mcu_fd_sc_mcu7t5v0__fill_1
XPHY_EDGE_ROW_68_Right_68 VDD VSS gf180mcu_fd_sc_mcu7t5v0__endcap
X_2104_ _3708_/Q _2103_/Z _2113_/A2 VDD VDD VSS VSS gf180mcu_fd_sc_mcu7t5v0__nor2_1
XFILLER_39_268 VDD VDD VSS VSS gf180mcu_fd_sc_mcu7t5v0__fillcap_4
X_3084_ _3734_/Q _3084_/ZN VDD VDD VSS VSS gf180mcu_fd_sc_mcu7t5v0__clkinv_1
X_2035_ _2034_/B _2035_/A2 _2036_/I VDD VDD VSS VSS gf180mcu_fd_sc_mcu7t5v0__xor2_1
XPHY_EDGE_ROW_77_Right_77 VDD VSS gf180mcu_fd_sc_mcu7t5v0__endcap
X_2937_ _2937_/A1 _2937_/A2 _2937_/B _3706_/D VDD VDD VSS VSS gf180mcu_fd_sc_mcu7t5v0__oai21_1
X_2868_ _3539_/A1 _2868_/A2 _2868_/B1 _2868_/B2 _3679_/D VDD VDD VSS VSS gf180mcu_fd_sc_mcu7t5v0__oai22_1
X_1819_ _1865_/C _1836_/A2 _1823_/A3 VDD VDD VSS VSS gf180mcu_fd_sc_mcu7t5v0__nand2_1
X_2799_ _3093_/ZN wire334/Z _2799_/B1 _2799_/B2 _3664_/D VDD VDD VSS VSS gf180mcu_fd_sc_mcu7t5v0__oai22_1
XFILLER_2_529 VDD VDD VSS VSS gf180mcu_fd_sc_mcu7t5v0__fill_1
XPHY_EDGE_ROW_86_Right_86 VDD VSS gf180mcu_fd_sc_mcu7t5v0__endcap
XFILLER_58_522 VDD VDD VSS VSS gf180mcu_fd_sc_mcu7t5v0__fill_2
XFILLER_85_352 VDD VDD VSS VSS gf180mcu_fd_sc_mcu7t5v0__fillcap_8
XFILLER_73_514 VDD VDD VSS VSS gf180mcu_fd_sc_mcu7t5v0__fill_2
XTAP_TAPCELL_ROW_28_469 VDD VSS gf180mcu_fd_sc_mcu7t5v0__filltie
XPHY_EDGE_ROW_95_Right_95 VDD VSS gf180mcu_fd_sc_mcu7t5v0__endcap
XFILLER_41_422 VDD VDD VSS VSS gf180mcu_fd_sc_mcu7t5v0__fill_2
XTAP_TAPCELL_ROW_11_314 VDD VSS gf180mcu_fd_sc_mcu7t5v0__filltie
XFILLER_1_562 VDD VDD VSS VSS gf180mcu_fd_sc_mcu7t5v0__fillcap_64
XFILLER_49_566 VDD VDD VSS VSS gf180mcu_fd_sc_mcu7t5v0__fill_1
XFILLER_67_72 VDD VDD VSS VSS gf180mcu_fd_sc_mcu7t5v0__fillcap_64
XFILLER_49_588 VDD VDD VSS VSS gf180mcu_fd_sc_mcu7t5v0__fillcap_8
XFILLER_64_514 VDD VDD VSS VSS gf180mcu_fd_sc_mcu7t5v0__fillcap_4
XFILLER_29_290 VDD VDD VSS VSS gf180mcu_fd_sc_mcu7t5v0__fill_2
XFILLER_32_444 VDD VDD VSS VSS gf180mcu_fd_sc_mcu7t5v0__fill_2
X_3771_ _3771_/D wire554/Z clkload1/I _3771_/Q VDD VDD VSS VSS gf180mcu_fd_sc_mcu7t5v0__dffrnq_1
X_2722_ wire622/I _2687_/Z _2689_/Z _3005_/I _2723_/B2 VDD VDD VSS VSS gf180mcu_fd_sc_mcu7t5v0__aoi22_1
X_2653_ _2657_/B _2654_/B VDD VDD VSS VSS gf180mcu_fd_sc_mcu7t5v0__clkinv_1
XFILLER_66_2 VDD VDD VSS VSS gf180mcu_fd_sc_mcu7t5v0__fillcap_32
X_2584_ _3008_/I _2561_/Z _2584_/B _2584_/C _2587_/B1 VDD VDD VSS VSS gf180mcu_fd_sc_mcu7t5v0__aoi211_1
X_3205_ _2051_/B _3205_/A2 _3205_/B1 _3205_/B2 _3205_/C _3207_/A2 VDD VDD VSS VSS
+ gf180mcu_fd_sc_mcu7t5v0__oai221_1
XFILLER_67_352 VDD VDD VSS VSS gf180mcu_fd_sc_mcu7t5v0__fillcap_4
XFILLER_95_672 VDD VDD VSS VSS gf180mcu_fd_sc_mcu7t5v0__fillcap_4
XFILLER_94_171 VDD VDD VSS VSS gf180mcu_fd_sc_mcu7t5v0__fillcap_4
XFILLER_82_311 VDD VDD VSS VSS gf180mcu_fd_sc_mcu7t5v0__fillcap_4
X_3136_ wire405/Z input31/Z _3136_/A3 _3136_/Z VDD VDD VSS VSS gf180mcu_fd_sc_mcu7t5v0__xor3_1
X_3067_ _3682_/Q _3571_/A1 VDD VDD VSS VSS gf180mcu_fd_sc_mcu7t5v0__clkinv_1
XFILLER_82_377 VDD VDD VSS VSS gf180mcu_fd_sc_mcu7t5v0__fillcap_8
X_2018_ _3064_/I _2017_/Z _2034_/A2 VDD VDD VSS VSS gf180mcu_fd_sc_mcu7t5v0__nand2_1
XTAP_TAPCELL_ROW_53_715 VDD VSS gf180mcu_fd_sc_mcu7t5v0__filltie
XFILLER_23_422 VDD VDD VSS VSS gf180mcu_fd_sc_mcu7t5v0__fillcap_8
XFILLER_23_477 VDD VDD VSS VSS gf180mcu_fd_sc_mcu7t5v0__fill_2
XFILLER_23_488 VDD VDD VSS VSS gf180mcu_fd_sc_mcu7t5v0__fill_2
XFILLER_12_34 VDD VDD VSS VSS gf180mcu_fd_sc_mcu7t5v0__fill_1
XFILLER_73_344 VDD VDD VSS VSS gf180mcu_fd_sc_mcu7t5v0__fillcap_4
XFILLER_73_333 VDD VDD VSS VSS gf180mcu_fd_sc_mcu7t5v0__fill_2
XFILLER_41_263 VDD VDD VSS VSS gf180mcu_fd_sc_mcu7t5v0__fill_1
XFILLER_5_142 VDD VDD VSS VSS gf180mcu_fd_sc_mcu7t5v0__fillcap_64
XFILLER_84_609 VDD VDD VSS VSS gf180mcu_fd_sc_mcu7t5v0__fillcap_8
XFILLER_37_514 VDD VDD VSS VSS gf180mcu_fd_sc_mcu7t5v0__fill_1
XFILLER_37_525 VDD VDD VSS VSS gf180mcu_fd_sc_mcu7t5v0__fill_1
XFILLER_76_171 VDD VDD VSS VSS gf180mcu_fd_sc_mcu7t5v0__fillcap_4
XFILLER_92_675 VDD VDD VSS VSS gf180mcu_fd_sc_mcu7t5v0__fill_2
XFILLER_17_282 VDD VDD VSS VSS gf180mcu_fd_sc_mcu7t5v0__fillcap_16
XFILLER_52_539 VDD VDD VSS VSS gf180mcu_fd_sc_mcu7t5v0__fill_2
XFILLER_20_403 VDD VDD VSS VSS gf180mcu_fd_sc_mcu7t5v0__fill_1
XFILLER_60_572 VDD VDD VSS VSS gf180mcu_fd_sc_mcu7t5v0__fill_2
X_3754_ _3754_/D wire557/Z clkload8/I _3754_/Q VDD VDD VSS VSS gf180mcu_fd_sc_mcu7t5v0__dffrnq_1
XFILLER_9_492 VDD VDD VSS VSS gf180mcu_fd_sc_mcu7t5v0__fill_2
X_2705_ _2705_/A1 _2631_/B _2705_/Z VDD VDD VSS VSS gf180mcu_fd_sc_mcu7t5v0__xor2_1
XTAP_TAPCELL_ROW_30_497 VDD VSS gf180mcu_fd_sc_mcu7t5v0__filltie
X_3685_ _3685_/D _3723_/RN clkload5/I _3685_/Q VDD VDD VSS VSS gf180mcu_fd_sc_mcu7t5v0__dffrnq_2
X_2636_ _2636_/A1 _2703_/A1 _2636_/B _2638_/A3 VDD VDD VSS VSS gf180mcu_fd_sc_mcu7t5v0__aoi21_2
Xoutput200 _3692_/Q raw_edge2[3] VDD VDD VSS VSS gf180mcu_fd_sc_mcu7t5v0__buf_2
Xoutput222 _3714_/Q raw_edge3[4] VDD VDD VSS VSS gf180mcu_fd_sc_mcu7t5v0__buf_2
Xoutput211 _3194_/A2 raw_edge3[13] VDD VDD VSS VSS gf180mcu_fd_sc_mcu7t5v0__buf_2
X_2567_ _2568_/A2 _2566_/Z _3012_/I _2579_/B VDD VDD VSS VSS gf180mcu_fd_sc_mcu7t5v0__oai21_1
XFILLER_87_436 VDD VDD VSS VSS gf180mcu_fd_sc_mcu7t5v0__fillcap_4
X_2498_ _3106_/B1 input76/Z _2499_/I VDD VDD VSS VSS gf180mcu_fd_sc_mcu7t5v0__xor2_1
XFILLER_28_514 VDD VDD VSS VSS gf180mcu_fd_sc_mcu7t5v0__fill_1
X_3119_ _2975_/I _3119_/A2 _2148_/C input22/Z _3124_/C VDD VDD VSS VSS gf180mcu_fd_sc_mcu7t5v0__oai22_1
XTAP_TAPCELL_ROW_38_564 VDD VSS gf180mcu_fd_sc_mcu7t5v0__filltie
XFILLER_55_344 VDD VDD VSS VSS gf180mcu_fd_sc_mcu7t5v0__fillcap_4
XFILLER_23_230 VDD VDD VSS VSS gf180mcu_fd_sc_mcu7t5v0__fill_1
XFILLER_11_414 VDD VDD VSS VSS gf180mcu_fd_sc_mcu7t5v0__fillcap_4
Xwire305 wire305/I wire305/Z VDD VDD VSS VSS gf180mcu_fd_sc_mcu7t5v0__clkbuf_2
XFILLER_23_66 VDD VDD VSS VSS gf180mcu_fd_sc_mcu7t5v0__fillcap_4
XFILLER_2_101 VDD VDD VSS VSS gf180mcu_fd_sc_mcu7t5v0__fillcap_4
Xfanout471 _3097_/I _2393_/A1 VDD VDD VSS VSS gf180mcu_fd_sc_mcu7t5v0__dlyb_1
XFILLER_34_539 VDD VDD VSS VSS gf180mcu_fd_sc_mcu7t5v0__fill_2
XFILLER_14_263 VDD VDD VSS VSS gf180mcu_fd_sc_mcu7t5v0__fill_2
XTAP_TAPCELL_ROW_72_887 VDD VSS gf180mcu_fd_sc_mcu7t5v0__filltie
XFILLER_6_440 VDD VDD VSS VSS gf180mcu_fd_sc_mcu7t5v0__fillcap_8
X_3470_ _3472_/A1 _3469_/Z _3495_/A1 VDD VDD VSS VSS gf180mcu_fd_sc_mcu7t5v0__nor2_1
X_2421_ _2303_/Z _2421_/A2 _2421_/A3 _2421_/Z VDD VDD VSS VSS gf180mcu_fd_sc_mcu7t5v0__and3_1
X_2352_ _2354_/A1 input7/Z _2432_/B VDD VDD VSS VSS gf180mcu_fd_sc_mcu7t5v0__nor2_1
XFILLER_29_2 VDD VDD VSS VSS gf180mcu_fd_sc_mcu7t5v0__fillcap_64
X_2283_ _2290_/A2 _2933_/A1 _2283_/B _3725_/D VDD VDD VSS VSS gf180mcu_fd_sc_mcu7t5v0__oai21_1
XTAP_TAPCELL_ROW_63_810 VDD VSS gf180mcu_fd_sc_mcu7t5v0__filltie
XFILLER_80_667 VDD VDD VSS VSS gf180mcu_fd_sc_mcu7t5v0__fill_2
XFILLER_20_233 VDD VDD VSS VSS gf180mcu_fd_sc_mcu7t5v0__fillcap_4
X_1998_ _1998_/A1 _1982_/Z _1998_/Z VDD VDD VSS VSS gf180mcu_fd_sc_mcu7t5v0__or2_1
X_3737_ _3737_/D _3738_/RN _3739_/CLK _3737_/Q VDD VDD VSS VSS gf180mcu_fd_sc_mcu7t5v0__dffrnq_1
X_3668_ _3668_/D wire588/Z _3694_/CLK _3668_/Q VDD VDD VSS VSS gf180mcu_fd_sc_mcu7t5v0__dffrnq_1
X_3599_ _3071_/I _3598_/Z _3618_/B VDD VDD VSS VSS gf180mcu_fd_sc_mcu7t5v0__nand2_1
X_2619_ _2620_/A1 input57/Z _2640_/C VDD VDD VSS VSS gf180mcu_fd_sc_mcu7t5v0__nand2_1
XTAP_TAPCELL_ROW_87_1031 VDD VSS gf180mcu_fd_sc_mcu7t5v0__filltie
XFILLER_83_450 VDD VDD VSS VSS gf180mcu_fd_sc_mcu7t5v0__fillcap_16
XFILLER_43_303 VDD VDD VSS VSS gf180mcu_fd_sc_mcu7t5v0__fill_1
XFILLER_43_347 VDD VDD VSS VSS gf180mcu_fd_sc_mcu7t5v0__fill_2
XFILLER_31_509 VDD VDD VSS VSS gf180mcu_fd_sc_mcu7t5v0__fill_2
XFILLER_70_177 VDD VDD VSS VSS gf180mcu_fd_sc_mcu7t5v0__fillcap_64
XFILLER_66_417 VDD VDD VSS VSS gf180mcu_fd_sc_mcu7t5v0__fillcap_4
XFILLER_78_299 VDD VDD VSS VSS gf180mcu_fd_sc_mcu7t5v0__fill_1
XTAP_TAPCELL_ROW_77_935 VDD VSS gf180mcu_fd_sc_mcu7t5v0__filltie
XFILLER_59_480 VDD VDD VSS VSS gf180mcu_fd_sc_mcu7t5v0__fill_2
XFILLER_75_72 VDD VDD VSS VSS gf180mcu_fd_sc_mcu7t5v0__fillcap_64
XFILLER_62_667 VDD VDD VSS VSS gf180mcu_fd_sc_mcu7t5v0__fill_2
X_2970_ _2970_/I _2442_/B VDD VDD VSS VSS gf180mcu_fd_sc_mcu7t5v0__inv_2
XFILLER_61_177 VDD VDD VSS VSS gf180mcu_fd_sc_mcu7t5v0__fillcap_4
X_1921_ _1919_/Z _1958_/A2 _1942_/B VDD VDD VSS VSS gf180mcu_fd_sc_mcu7t5v0__or2_1
XFILLER_30_520 VDD VDD VSS VSS gf180mcu_fd_sc_mcu7t5v0__fillcap_4
XTAP_TAPCELL_ROW_32_515 VDD VSS gf180mcu_fd_sc_mcu7t5v0__filltie
X_1852_ wire655/Z _1850_/Z _1859_/A2 VDD VDD VSS VSS gf180mcu_fd_sc_mcu7t5v0__nand2_1
XFILLER_30_597 VDD VDD VSS VSS gf180mcu_fd_sc_mcu7t5v0__fill_1
XTAP_TAPCELL_ROW_40_592 VDD VSS gf180mcu_fd_sc_mcu7t5v0__filltie
X_3522_ _3550_/B _3533_/A2 _3549_/A1 VDD VDD VSS VSS gf180mcu_fd_sc_mcu7t5v0__nand2_1
X_3453_ _3454_/A1 _3456_/A2 _3454_/A3 _3453_/Z VDD VDD VSS VSS gf180mcu_fd_sc_mcu7t5v0__and3_1
X_2404_ _3744_/Q _3013_/I _2404_/A3 _2404_/Z VDD VDD VSS VSS gf180mcu_fd_sc_mcu7t5v0__xor3_1
Xload_slew641 _2586_/B wire640/I VDD VDD VSS VSS gf180mcu_fd_sc_mcu7t5v0__buf_2
X_3384_ _3381_/I _3409_/B3 _3398_/A1 VDD VDD VSS VSS gf180mcu_fd_sc_mcu7t5v0__nor2_1
XFILLER_69_244 VDD VDD VSS VSS gf180mcu_fd_sc_mcu7t5v0__fillcap_16
Xload_slew652 _3012_/I _3437_/A1 VDD VDD VSS VSS gf180mcu_fd_sc_mcu7t5v0__buf_4
X_2335_ _2417_/A1 _2334_/Z _2337_/B VDD VDD VSS VSS gf180mcu_fd_sc_mcu7t5v0__nand2_1
XFILLER_57_406 VDD VDD VSS VSS gf180mcu_fd_sc_mcu7t5v0__fill_1
X_2266_ _2123_/Z _2266_/A2 _2831_/A1 VDD VDD VSS VSS gf180mcu_fd_sc_mcu7t5v0__nor2_2
XFILLER_84_247 VDD VDD VSS VSS gf180mcu_fd_sc_mcu7t5v0__fillcap_64
X_2197_ _2201_/B1 _2197_/A2 _2198_/C VDD VDD VSS VSS gf180mcu_fd_sc_mcu7t5v0__nor2_1
XFILLER_80_475 VDD VDD VSS VSS gf180mcu_fd_sc_mcu7t5v0__fillcap_8
XFILLER_40_317 VDD VDD VSS VSS gf180mcu_fd_sc_mcu7t5v0__fillcap_8
XFILLER_20_34 VDD VDD VSS VSS gf180mcu_fd_sc_mcu7t5v0__fill_1
XTAP_TAPCELL_ROW_93_1090 VDD VSS gf180mcu_fd_sc_mcu7t5v0__filltie
XTAP_TAPCELL_ROW_3_240 VDD VSS gf180mcu_fd_sc_mcu7t5v0__filltie
XFILLER_44_667 VDD VDD VSS VSS gf180mcu_fd_sc_mcu7t5v0__fill_2
XTAP_TAPCELL_ROW_82_982 VDD VSS gf180mcu_fd_sc_mcu7t5v0__filltie
XFILLER_71_486 VDD VDD VSS VSS gf180mcu_fd_sc_mcu7t5v0__fillcap_4
XFILLER_12_520 VDD VDD VSS VSS gf180mcu_fd_sc_mcu7t5v0__fill_1
XFILLER_12_597 VDD VDD VSS VSS gf180mcu_fd_sc_mcu7t5v0__fillcap_4
XFILLER_8_535 VDD VDD VSS VSS gf180mcu_fd_sc_mcu7t5v0__fill_2
XTAP_TAPCELL_ROW_96_1119 VDD VSS gf180mcu_fd_sc_mcu7t5v0__filltie
XFILLER_79_564 VDD VDD VSS VSS gf180mcu_fd_sc_mcu7t5v0__fill_1
X_2120_ _3658_/Q _3659_/Q _2121_/A3 _2261_/A1 VDD VDD VSS VSS gf180mcu_fd_sc_mcu7t5v0__nor3_2
X_2051_ _2051_/A1 _2048_/Z _2051_/B _2066_/A2 VDD VDD VSS VSS gf180mcu_fd_sc_mcu7t5v0__oai21_1
XFILLER_66_247 VDD VDD VSS VSS gf180mcu_fd_sc_mcu7t5v0__fillcap_8
XFILLER_81_206 VDD VDD VSS VSS gf180mcu_fd_sc_mcu7t5v0__fillcap_4
XFILLER_62_453 VDD VDD VSS VSS gf180mcu_fd_sc_mcu7t5v0__fill_2
XFILLER_96_2 VDD VDD VSS VSS gf180mcu_fd_sc_mcu7t5v0__fillcap_32
XFILLER_22_317 VDD VDD VSS VSS gf180mcu_fd_sc_mcu7t5v0__fillcap_4
XFILLER_34_177 VDD VDD VSS VSS gf180mcu_fd_sc_mcu7t5v0__fillcap_8
X_2953_ wire263/Z _2953_/A2 _2953_/B _3714_/D VDD VDD VSS VSS gf180mcu_fd_sc_mcu7t5v0__oai21_1
X_1904_ _3170_/A1 _1904_/A2 _1904_/Z VDD VDD VSS VSS gf180mcu_fd_sc_mcu7t5v0__xor2_1
X_2884_ wire429/Z _2893_/A2 _2886_/B1 VDD VDD VSS VSS gf180mcu_fd_sc_mcu7t5v0__nor2_1
X_1835_ _1836_/A1 _1836_/A2 _1835_/Z VDD VDD VSS VSS gf180mcu_fd_sc_mcu7t5v0__and2_1
X_3505_ _3678_/Q _3504_/Z _3505_/Z VDD VDD VSS VSS gf180mcu_fd_sc_mcu7t5v0__and2_1
Xmax_cap298 wire299/Z _1858_/A2 VDD VDD VSS VSS gf180mcu_fd_sc_mcu7t5v0__dlyb_1
X_3436_ _3437_/A2 _3437_/A3 _3436_/Z VDD VDD VSS VSS gf180mcu_fd_sc_mcu7t5v0__xor2_1
X_3367_ _2116_/B _3365_/Z _3367_/ZN VDD VDD VSS VSS gf180mcu_fd_sc_mcu7t5v0__xnor2_2
Xload_slew460 _3750_/Q _2920_/A1 VDD VDD VSS VSS gf180mcu_fd_sc_mcu7t5v0__clkbuf_2
X_2318_ _2318_/I _2325_/B VDD VDD VSS VSS gf180mcu_fd_sc_mcu7t5v0__clkinv_1
Xload_slew482 _3720_/Q _3179_/A2 VDD VDD VSS VSS gf180mcu_fd_sc_mcu7t5v0__buf_2
XFILLER_85_578 VDD VDD VSS VSS gf180mcu_fd_sc_mcu7t5v0__fillcap_8
XFILLER_85_556 VDD VDD VSS VSS gf180mcu_fd_sc_mcu7t5v0__fillcap_4
X_3298_ _3298_/A1 _3298_/A2 _3317_/A1 VDD VDD VSS VSS gf180mcu_fd_sc_mcu7t5v0__nand2_1
Xload_slew493 _3056_/I _1954_/A1 VDD VDD VSS VSS gf180mcu_fd_sc_mcu7t5v0__buf_2
XTAP_TAPCELL_ROW_0_210 VDD VSS gf180mcu_fd_sc_mcu7t5v0__filltie
X_2249_ _2749_/A1 _2756_/A1 _2263_/A1 VDD VDD VSS VSS gf180mcu_fd_sc_mcu7t5v0__nor2_1
XTAP_TAPCELL_ROW_84_1001 VDD VSS gf180mcu_fd_sc_mcu7t5v0__filltie
XFILLER_26_667 VDD VDD VSS VSS gf180mcu_fd_sc_mcu7t5v0__fill_2
XFILLER_40_125 VDD VDD VSS VSS gf180mcu_fd_sc_mcu7t5v0__fill_1
XFILLER_40_158 VDD VDD VSS VSS gf180mcu_fd_sc_mcu7t5v0__fillcap_4
Xclkbuf_4_10_0_clk clkbuf_0_clk/Z clkload9/I VDD VDD VSS VSS gf180mcu_fd_sc_mcu7t5v0__clkbuf_8
XFILLER_5_516 VDD VDD VSS VSS gf180mcu_fd_sc_mcu7t5v0__fill_2
XFILLER_31_66 VDD VDD VSS VSS gf180mcu_fd_sc_mcu7t5v0__fillcap_4
Xoutput88 output88/I cal_done VDD VDD VSS VSS gf180mcu_fd_sc_mcu7t5v0__buf_2
Xoutput99 _3218_/Z cal_phase0_offset[19] VDD VDD VSS VSS gf180mcu_fd_sc_mcu7t5v0__buf_2
XFILLER_76_523 VDD VDD VSS VSS gf180mcu_fd_sc_mcu7t5v0__fill_2
XFILLER_0_287 VDD VDD VSS VSS gf180mcu_fd_sc_mcu7t5v0__fillcap_16
XFILLER_48_247 VDD VDD VSS VSS gf180mcu_fd_sc_mcu7t5v0__fill_2
XTAP_TAPCELL_ROW_59_765 VDD VSS gf180mcu_fd_sc_mcu7t5v0__filltie
XFILLER_29_450 VDD VDD VSS VSS gf180mcu_fd_sc_mcu7t5v0__fillcap_4
XFILLER_16_177 VDD VDD VSS VSS gf180mcu_fd_sc_mcu7t5v0__fillcap_32
XTAP_TAPCELL_ROW_42_610 VDD VSS gf180mcu_fd_sc_mcu7t5v0__filltie
XTAP_TAPCELL_ROW_14_345 VDD VSS gf180mcu_fd_sc_mcu7t5v0__filltie
XFILLER_8_310 VDD VDD VSS VSS gf180mcu_fd_sc_mcu7t5v0__fillcap_4
XFILLER_8_387 VDD VDD VSS VSS gf180mcu_fd_sc_mcu7t5v0__fillcap_64
X_3221_ _3222_/A1 _3225_/A2 _3299_/B VDD VDD VSS VSS gf180mcu_fd_sc_mcu7t5v0__xor2_2
X_3152_ _3152_/A1 _3152_/A2 _3152_/B _3157_/A2 VDD VDD VSS VSS gf180mcu_fd_sc_mcu7t5v0__aoi21_1
X_2103_ wire476/Z _3709_/Q _2103_/A3 _2103_/Z VDD VDD VSS VSS gf180mcu_fd_sc_mcu7t5v0__xor3_1
XFILLER_11_2 VDD VDD VSS VSS gf180mcu_fd_sc_mcu7t5v0__fillcap_64
XFILLER_67_556 VDD VDD VSS VSS gf180mcu_fd_sc_mcu7t5v0__fillcap_4
XFILLER_82_515 VDD VDD VSS VSS gf180mcu_fd_sc_mcu7t5v0__fill_1
XFILLER_27_409 VDD VDD VSS VSS gf180mcu_fd_sc_mcu7t5v0__fill_1
X_3083_ _3735_/Q _3083_/ZN VDD VDD VSS VSS gf180mcu_fd_sc_mcu7t5v0__clkinv_1
X_2034_ _2034_/A1 _2034_/A2 _2034_/B _2069_/B VDD VDD VSS VSS gf180mcu_fd_sc_mcu7t5v0__aoi21_1
XFILLER_23_604 VDD VDD VSS VSS gf180mcu_fd_sc_mcu7t5v0__fill_1
XFILLER_35_475 VDD VDD VSS VSS gf180mcu_fd_sc_mcu7t5v0__fillcap_4
X_2936_ _3706_/Q _2937_/A2 _2937_/B VDD VDD VSS VSS gf180mcu_fd_sc_mcu7t5v0__nand2_1
X_2867_ _3679_/Q wire233/Z _2867_/B _2868_/B2 VDD VDD VSS VSS gf180mcu_fd_sc_mcu7t5v0__oai21_1
X_1818_ _3713_/Q _3419_/A1 _1836_/A2 VDD VDD VSS VSS gf180mcu_fd_sc_mcu7t5v0__nand2_1
X_2798_ _2798_/A1 _2798_/A2 _2799_/B2 VDD VDD VSS VSS gf180mcu_fd_sc_mcu7t5v0__nand2_1
XFILLER_89_136 VDD VDD VSS VSS gf180mcu_fd_sc_mcu7t5v0__fillcap_4
X_3419_ _3419_/A1 _3671_/Q _3368_/B _3419_/B2 _3419_/C _3455_/A1 VDD VDD VSS VSS gf180mcu_fd_sc_mcu7t5v0__aoi221_4
XTAP_TAPCELL_ROW_90_1060 VDD VSS gf180mcu_fd_sc_mcu7t5v0__filltie
XFILLER_73_504 VDD VDD VSS VSS gf180mcu_fd_sc_mcu7t5v0__fill_2
XTAP_TAPCELL_ROW_56_735 VDD VSS gf180mcu_fd_sc_mcu7t5v0__filltie
XFILLER_73_559 VDD VDD VSS VSS gf180mcu_fd_sc_mcu7t5v0__fill_1
XFILLER_26_486 VDD VDD VSS VSS gf180mcu_fd_sc_mcu7t5v0__fillcap_4
XFILLER_13_136 VDD VDD VSS VSS gf180mcu_fd_sc_mcu7t5v0__fillcap_4
XTAP_TAPCELL_ROW_11_315 VDD VSS gf180mcu_fd_sc_mcu7t5v0__filltie
XFILLER_5_324 VDD VDD VSS VSS gf180mcu_fd_sc_mcu7t5v0__fillcap_8
XFILLER_76_397 VDD VDD VSS VSS gf180mcu_fd_sc_mcu7t5v0__fillcap_8
XFILLER_83_72 VDD VDD VSS VSS gf180mcu_fd_sc_mcu7t5v0__fillcap_64
XFILLER_44_272 VDD VDD VSS VSS gf180mcu_fd_sc_mcu7t5v0__fill_1
X_3770_ _3770_/D wire554/Z clkload1/I _3770_/Q VDD VDD VSS VSS gf180mcu_fd_sc_mcu7t5v0__dffrnq_1
X_2721_ wire630/I _2689_/Z _2721_/B1 _2721_/B2 _2721_/C _2723_/B1 VDD VDD VSS VSS
+ gf180mcu_fd_sc_mcu7t5v0__oai221_1
X_2652_ _2981_/ZN _3000_/I _2657_/B VDD VDD VSS VSS gf180mcu_fd_sc_mcu7t5v0__xor2_1
X_2583_ _3491_/A1 _2562_/Z _2584_/C VDD VDD VSS VSS gf180mcu_fd_sc_mcu7t5v0__nor2_1
XFILLER_59_2 VDD VDD VSS VSS gf180mcu_fd_sc_mcu7t5v0__fillcap_64
X_3204_ _3598_/A1 _3726_/Q _3207_/B VDD VDD VSS VSS gf180mcu_fd_sc_mcu7t5v0__xor2_1
XFILLER_67_342 VDD VDD VSS VSS gf180mcu_fd_sc_mcu7t5v0__fillcap_8
X_3135_ _3135_/A1 wire636/Z _3326_/A1 VDD VDD VSS VSS gf180mcu_fd_sc_mcu7t5v0__nand2_2
X_3066_ _3066_/I _3553_/A1 VDD VDD VSS VSS gf180mcu_fd_sc_mcu7t5v0__clkinv_1
XFILLER_55_548 VDD VDD VSS VSS gf180mcu_fd_sc_mcu7t5v0__fill_1
XFILLER_55_559 VDD VDD VSS VSS gf180mcu_fd_sc_mcu7t5v0__fill_1
X_2017_ _3558_/A1 _2017_/A2 _2014_/B _2017_/Z VDD VDD VSS VSS gf180mcu_fd_sc_mcu7t5v0__xor3_1
XFILLER_70_518 VDD VDD VSS VSS gf180mcu_fd_sc_mcu7t5v0__fill_1
XFILLER_11_629 VDD VDD VSS VSS gf180mcu_fd_sc_mcu7t5v0__fill_1
XFILLER_50_275 VDD VDD VSS VSS gf180mcu_fd_sc_mcu7t5v0__fill_1
XFILLER_50_264 VDD VDD VSS VSS gf180mcu_fd_sc_mcu7t5v0__fill_2
X_2919_ _3698_/Q wire249/I _2921_/B VDD VDD VSS VSS gf180mcu_fd_sc_mcu7t5v0__nand2_1
XTAP_TAPCELL_ROW_69_860 VDD VSS gf180mcu_fd_sc_mcu7t5v0__filltie
XFILLER_46_559 VDD VDD VSS VSS gf180mcu_fd_sc_mcu7t5v0__fillcap_16
XFILLER_58_397 VDD VDD VSS VSS gf180mcu_fd_sc_mcu7t5v0__fill_1
XFILLER_54_581 VDD VDD VSS VSS gf180mcu_fd_sc_mcu7t5v0__fillcap_8
XFILLER_14_489 VDD VDD VSS VSS gf180mcu_fd_sc_mcu7t5v0__fillcap_8
XFILLER_14_478 VDD VDD VSS VSS gf180mcu_fd_sc_mcu7t5v0__fill_1
XTAP_TAPCELL_ROW_24_440 VDD VSS gf180mcu_fd_sc_mcu7t5v0__filltie
XFILLER_10_662 VDD VDD VSS VSS gf180mcu_fd_sc_mcu7t5v0__fill_2
XFILLER_96_437 VDD VDD VSS VSS gf180mcu_fd_sc_mcu7t5v0__fillcap_4
XFILLER_96_426 VDD VDD VSS VSS gf180mcu_fd_sc_mcu7t5v0__fill_1
XFILLER_91_142 VDD VDD VSS VSS gf180mcu_fd_sc_mcu7t5v0__fillcap_64
XFILLER_24_209 VDD VDD VSS VSS gf180mcu_fd_sc_mcu7t5v0__fill_2
XFILLER_60_551 VDD VDD VSS VSS gf180mcu_fd_sc_mcu7t5v0__fill_1
X_3753_ _3753_/D wire594/Z clkload8/I _3753_/Q VDD VDD VSS VSS gf180mcu_fd_sc_mcu7t5v0__dffrnq_2
X_2704_ wire516/Z _2703_/Z _2712_/B1 VDD VDD VSS VSS gf180mcu_fd_sc_mcu7t5v0__nand2_1
X_3684_ _3684_/D _3684_/RN clkload0/I _3684_/Q VDD VDD VSS VSS gf180mcu_fd_sc_mcu7t5v0__dffrnq_2
X_2635_ _3745_/Q input55/Z _2636_/B VDD VDD VSS VSS gf180mcu_fd_sc_mcu7t5v0__xor2_1
Xoutput201 _3693_/Q raw_edge2[4] VDD VDD VSS VSS gf180mcu_fd_sc_mcu7t5v0__buf_2
Xoutput223 _3715_/Q raw_edge3[5] VDD VDD VSS VSS gf180mcu_fd_sc_mcu7t5v0__buf_2
Xoutput212 _3724_/Q raw_edge3[14] VDD VDD VSS VSS gf180mcu_fd_sc_mcu7t5v0__buf_2
X_2566_ _2566_/A1 _2577_/A1 _2500_/B _2566_/Z VDD VDD VSS VSS gf180mcu_fd_sc_mcu7t5v0__and3_1
X_2497_ _2569_/A1 _2573_/A2 _2497_/B _2577_/A1 VDD VDD VSS VSS gf180mcu_fd_sc_mcu7t5v0__oai21_1
XFILLER_68_651 VDD VDD VSS VSS gf180mcu_fd_sc_mcu7t5v0__fill_1
XFILLER_95_492 VDD VDD VSS VSS gf180mcu_fd_sc_mcu7t5v0__fillcap_64
X_3118_ input24/Z _3118_/A2 _3118_/B _3118_/C _3124_/B VDD VDD VSS VSS gf180mcu_fd_sc_mcu7t5v0__aoi211_1
XTAP_TAPCELL_ROW_66_830 VDD VSS gf180mcu_fd_sc_mcu7t5v0__filltie
X_3049_ _3673_/Q _3426_/A1 VDD VDD VSS VSS gf180mcu_fd_sc_mcu7t5v0__clkinv_1
XTAP_TAPCELL_ROW_38_565 VDD VSS gf180mcu_fd_sc_mcu7t5v0__filltie
XFILLER_43_529 VDD VDD VSS VSS gf180mcu_fd_sc_mcu7t5v0__fillcap_8
XFILLER_70_304 VDD VDD VSS VSS gf180mcu_fd_sc_mcu7t5v0__fill_2
XFILLER_51_562 VDD VDD VSS VSS gf180mcu_fd_sc_mcu7t5v0__fillcap_8
Xwire306 wire306/I wire306/Z VDD VDD VSS VSS gf180mcu_fd_sc_mcu7t5v0__clkbuf_1
XTAP_TAPCELL_ROW_21_410 VDD VSS gf180mcu_fd_sc_mcu7t5v0__filltie
XFILLER_7_408 VDD VDD VSS VSS gf180mcu_fd_sc_mcu7t5v0__fillcap_8
Xfanout461 _3748_/Q _2984_/I VDD VDD VSS VSS gf180mcu_fd_sc_mcu7t5v0__dlyb_1
XFILLER_46_334 VDD VDD VSS VSS gf180mcu_fd_sc_mcu7t5v0__fillcap_4
XFILLER_34_507 VDD VDD VSS VSS gf180mcu_fd_sc_mcu7t5v0__fillcap_8
XFILLER_73_142 VDD VDD VSS VSS gf180mcu_fd_sc_mcu7t5v0__fillcap_64
XFILLER_27_592 VDD VDD VSS VSS gf180mcu_fd_sc_mcu7t5v0__fill_2
XFILLER_42_562 VDD VDD VSS VSS gf180mcu_fd_sc_mcu7t5v0__fillcap_4
XTAP_TAPCELL_ROW_72_888 VDD VSS gf180mcu_fd_sc_mcu7t5v0__filltie
XFILLER_6_452 VDD VDD VSS VSS gf180mcu_fd_sc_mcu7t5v0__fill_2
X_2420_ _2186_/B wire362/Z _2419_/Z _2423_/A1 _3750_/D VDD VDD VSS VSS gf180mcu_fd_sc_mcu7t5v0__oai22_1
X_2351_ _2349_/Z _2350_/Z _2359_/A2 VDD VDD VSS VSS gf180mcu_fd_sc_mcu7t5v0__nand2_1
XTAP_TAPCELL_ROW_9_290 VDD VSS gf180mcu_fd_sc_mcu7t5v0__filltie
X_2282_ _2282_/A1 wire255/Z _2283_/B VDD VDD VSS VSS gf180mcu_fd_sc_mcu7t5v0__nand2_1
XFILLER_96_267 VDD VDD VSS VSS gf180mcu_fd_sc_mcu7t5v0__fillcap_4
XFILLER_49_150 VDD VDD VSS VSS gf180mcu_fd_sc_mcu7t5v0__fillcap_4
XFILLER_77_492 VDD VDD VSS VSS gf180mcu_fd_sc_mcu7t5v0__fillcap_8
XFILLER_65_632 VDD VDD VSS VSS gf180mcu_fd_sc_mcu7t5v0__fill_2
XFILLER_92_451 VDD VDD VSS VSS gf180mcu_fd_sc_mcu7t5v0__fillcap_4
XFILLER_37_334 VDD VDD VSS VSS gf180mcu_fd_sc_mcu7t5v0__fillcap_8
XFILLER_65_676 VDD VDD VSS VSS gf180mcu_fd_sc_mcu7t5v0__fill_1
XFILLER_37_389 VDD VDD VSS VSS gf180mcu_fd_sc_mcu7t5v0__fill_1
XFILLER_52_304 VDD VDD VSS VSS gf180mcu_fd_sc_mcu7t5v0__fill_2
XFILLER_33_562 VDD VDD VSS VSS gf180mcu_fd_sc_mcu7t5v0__fillcap_4
X_1997_ _1999_/A2 _1999_/A3 _1997_/Z VDD VDD VSS VSS gf180mcu_fd_sc_mcu7t5v0__and2_1
X_3736_ _3736_/D _3736_/RN _3739_/CLK _3736_/Q VDD VDD VSS VSS gf180mcu_fd_sc_mcu7t5v0__dffrnq_1
X_3667_ _3667_/D _3667_/RN _3739_/CLK _3667_/Q VDD VDD VSS VSS gf180mcu_fd_sc_mcu7t5v0__dffrnq_2
X_3598_ _3598_/A1 _3595_/Z _3598_/A3 _3598_/Z VDD VDD VSS VSS gf180mcu_fd_sc_mcu7t5v0__xor3_1
X_2618_ wire462/Z _3001_/ZN _2694_/A1 VDD VDD VSS VSS gf180mcu_fd_sc_mcu7t5v0__nand2_1
XFILLER_87_212 VDD VDD VSS VSS gf180mcu_fd_sc_mcu7t5v0__fillcap_64
X_2549_ wire525/Z _2548_/Z _2593_/A1 VDD VDD VSS VSS gf180mcu_fd_sc_mcu7t5v0__nand2_1
XFILLER_18_34 VDD VDD VSS VSS gf180mcu_fd_sc_mcu7t5v0__fill_1
XTAP_TAPCELL_ROW_87_1032 VDD VSS gf180mcu_fd_sc_mcu7t5v0__filltie
XFILLER_55_142 VDD VDD VSS VSS gf180mcu_fd_sc_mcu7t5v0__fillcap_4
XFILLER_16_529 VDD VDD VSS VSS gf180mcu_fd_sc_mcu7t5v0__fill_1
XFILLER_55_153 VDD VDD VSS VSS gf180mcu_fd_sc_mcu7t5v0__fillcap_16
XFILLER_70_101 VDD VDD VSS VSS gf180mcu_fd_sc_mcu7t5v0__fillcap_4
XFILLER_24_562 VDD VDD VSS VSS gf180mcu_fd_sc_mcu7t5v0__fillcap_16
XFILLER_11_212 VDD VDD VSS VSS gf180mcu_fd_sc_mcu7t5v0__fillcap_4
XFILLER_51_392 VDD VDD VSS VSS gf180mcu_fd_sc_mcu7t5v0__fillcap_4
XTAP_TAPCELL_ROW_6_260 VDD VSS gf180mcu_fd_sc_mcu7t5v0__filltie
XTAP_TAPCELL_ROW_77_936 VDD VSS gf180mcu_fd_sc_mcu7t5v0__filltie
XFILLER_47_632 VDD VDD VSS VSS gf180mcu_fd_sc_mcu7t5v0__fill_1
XFILLER_19_345 VDD VDD VSS VSS gf180mcu_fd_sc_mcu7t5v0__fillcap_4
XFILLER_47_676 VDD VDD VSS VSS gf180mcu_fd_sc_mcu7t5v0__fill_1
XFILLER_34_337 VDD VDD VSS VSS gf180mcu_fd_sc_mcu7t5v0__fill_2
XFILLER_15_540 VDD VDD VSS VSS gf180mcu_fd_sc_mcu7t5v0__fillcap_8
XFILLER_91_72 VDD VDD VSS VSS gf180mcu_fd_sc_mcu7t5v0__fillcap_64
X_1920_ _1920_/A1 _1920_/A2 _1958_/A2 VDD VDD VSS VSS gf180mcu_fd_sc_mcu7t5v0__nor2_1
XFILLER_15_595 VDD VDD VSS VSS gf180mcu_fd_sc_mcu7t5v0__fill_2
XTAP_TAPCELL_ROW_32_516 VDD VSS gf180mcu_fd_sc_mcu7t5v0__filltie
X_1851_ wire655/Z _1850_/Z _1859_/B VDD VDD VSS VSS gf180mcu_fd_sc_mcu7t5v0__nor2_1
X_3521_ _2006_/B _3063_/I _3533_/A2 VDD VDD VSS VSS gf180mcu_fd_sc_mcu7t5v0__nand2_1
XFILLER_6_271 VDD VDD VSS VSS gf180mcu_fd_sc_mcu7t5v0__fill_2
X_3452_ _3456_/A1 _3456_/A2 _3455_/B VDD VDD VSS VSS gf180mcu_fd_sc_mcu7t5v0__nand2_1
X_2403_ _3103_/B2 wire362/I _2402_/Z wire368/Z _3743_/D VDD VDD VSS VSS gf180mcu_fd_sc_mcu7t5v0__oai22_1
XFILLER_41_2 VDD VDD VSS VSS gf180mcu_fd_sc_mcu7t5v0__fillcap_64
X_3383_ _3382_/B _3383_/A2 _3383_/B1 _3409_/B3 _3383_/ZN VDD VDD VSS VSS gf180mcu_fd_sc_mcu7t5v0__aoi22_1
Xload_slew631 wire630/I _2588_/A1 VDD VDD VSS VSS gf180mcu_fd_sc_mcu7t5v0__buf_2
X_2334_ _3749_/Q _3008_/I _2334_/Z VDD VDD VSS VSS gf180mcu_fd_sc_mcu7t5v0__xor2_2
Xload_slew620 input7/Z _2051_/B VDD VDD VSS VSS gf180mcu_fd_sc_mcu7t5v0__buf_4
XFILLER_69_212 VDD VDD VSS VSS gf180mcu_fd_sc_mcu7t5v0__fillcap_32
Xload_slew653 _3013_/I _3425_/A1 VDD VDD VSS VSS gf180mcu_fd_sc_mcu7t5v0__buf_2
X_2265_ wire536/Z _3088_/ZN wire319/I _2265_/B2 _2269_/A1 VDD VDD VSS VSS gf180mcu_fd_sc_mcu7t5v0__aoi22_1
XFILLER_37_142 VDD VDD VSS VSS gf180mcu_fd_sc_mcu7t5v0__fillcap_4
X_2196_ _3520_/A2 _2196_/A2 _2196_/B _2977_/I _2197_/A2 VDD VDD VSS VSS gf180mcu_fd_sc_mcu7t5v0__aoi211_1
XTAP_TAPCELL_ROW_48_660 VDD VSS gf180mcu_fd_sc_mcu7t5v0__filltie
XFILLER_52_101 VDD VDD VSS VSS gf180mcu_fd_sc_mcu7t5v0__fillcap_4
XFILLER_80_421 VDD VDD VSS VSS gf180mcu_fd_sc_mcu7t5v0__fill_1
XFILLER_37_186 VDD VDD VSS VSS gf180mcu_fd_sc_mcu7t5v0__fillcap_4
XFILLER_52_123 VDD VDD VSS VSS gf180mcu_fd_sc_mcu7t5v0__fillcap_4
XFILLER_80_454 VDD VDD VSS VSS gf180mcu_fd_sc_mcu7t5v0__fill_1
XFILLER_80_487 VDD VDD VSS VSS gf180mcu_fd_sc_mcu7t5v0__fill_2
XFILLER_80_498 VDD VDD VSS VSS gf180mcu_fd_sc_mcu7t5v0__fillcap_4
XFILLER_21_543 VDD VDD VSS VSS gf180mcu_fd_sc_mcu7t5v0__fill_2
X_3719_ _3719_/D _3719_/RN _3774_/CLK _3719_/Q VDD VDD VSS VSS gf180mcu_fd_sc_mcu7t5v0__dffrnq_2
XTAP_TAPCELL_ROW_93_1091 VDD VSS gf180mcu_fd_sc_mcu7t5v0__filltie
XFILLER_0_414 VDD VDD VSS VSS gf180mcu_fd_sc_mcu7t5v0__fill_2
XFILLER_0_425 VDD VDD VSS VSS gf180mcu_fd_sc_mcu7t5v0__fillcap_16
XFILLER_29_66 VDD VDD VSS VSS gf180mcu_fd_sc_mcu7t5v0__fillcap_4
XTAP_TAPCELL_ROW_74_906 VDD VSS gf180mcu_fd_sc_mcu7t5v0__filltie
XFILLER_56_451 VDD VDD VSS VSS gf180mcu_fd_sc_mcu7t5v0__fillcap_4
XFILLER_43_112 VDD VDD VSS VSS gf180mcu_fd_sc_mcu7t5v0__fillcap_4
XTAP_TAPCELL_ROW_82_983 VDD VSS gf180mcu_fd_sc_mcu7t5v0__filltie
XFILLER_71_498 VDD VDD VSS VSS gf180mcu_fd_sc_mcu7t5v0__fill_1
XFILLER_6_37 VDD VDD VSS VSS gf180mcu_fd_sc_mcu7t5v0__fillcap_64
XFILLER_79_543 VDD VDD VSS VSS gf180mcu_fd_sc_mcu7t5v0__fill_1
X_2050_ _2051_/B _2051_/A1 _2048_/Z _2066_/B VDD VDD VSS VSS gf180mcu_fd_sc_mcu7t5v0__nor3_1
XFILLER_19_142 VDD VDD VSS VSS gf180mcu_fd_sc_mcu7t5v0__fillcap_64
XFILLER_47_473 VDD VDD VSS VSS gf180mcu_fd_sc_mcu7t5v0__fill_1
XFILLER_34_101 VDD VDD VSS VSS gf180mcu_fd_sc_mcu7t5v0__fillcap_4
XTAP_TAPCELL_ROW_17_365 VDD VSS gf180mcu_fd_sc_mcu7t5v0__filltie
X_2952_ _3714_/Q wire263/Z _2953_/B VDD VDD VSS VSS gf180mcu_fd_sc_mcu7t5v0__nand2_1
X_1903_ _3011_/I _1904_/A2 _1920_/A1 VDD VDD VSS VSS gf180mcu_fd_sc_mcu7t5v0__nor2_1
XFILLER_89_2 VDD VDD VSS VSS gf180mcu_fd_sc_mcu7t5v0__fillcap_64
X_2883_ _3585_/A2 _2892_/A2 _2883_/B1 _2883_/B2 _3684_/D VDD VDD VSS VSS gf180mcu_fd_sc_mcu7t5v0__oai22_1
X_1834_ _3714_/Q _3046_/I _1834_/Z VDD VDD VSS VSS gf180mcu_fd_sc_mcu7t5v0__xor2_2
X_3504_ _2696_/B _3500_/Z _3504_/A3 _3504_/Z VDD VDD VSS VSS gf180mcu_fd_sc_mcu7t5v0__xor3_1
X_3435_ _3435_/A1 _3435_/A2 _3435_/B _3437_/A3 VDD VDD VSS VSS gf180mcu_fd_sc_mcu7t5v0__aoi21_1
Xmax_cap288 wire289/Z wire286/I VDD VDD VSS VSS gf180mcu_fd_sc_mcu7t5v0__dlyb_1
X_3366_ _2116_/B _3365_/Z _3382_/B VDD VDD VSS VSS gf180mcu_fd_sc_mcu7t5v0__nor2_1
Xload_slew450 _2518_/A1 _2979_/I VDD VDD VSS VSS gf180mcu_fd_sc_mcu7t5v0__clkbuf_1
X_2317_ _3743_/Q _2578_/A1 _2318_/I VDD VDD VSS VSS gf180mcu_fd_sc_mcu7t5v0__nand2_1
X_3297_ _3297_/A1 _3295_/Z _3768_/D VDD VDD VSS VSS gf180mcu_fd_sc_mcu7t5v0__xor2_1
Xload_slew472 _2763_/B _2793_/B VDD VDD VSS VSS gf180mcu_fd_sc_mcu7t5v0__clkbuf_2
Xload_slew494 _3698_/Q _3056_/I VDD VDD VSS VSS gf180mcu_fd_sc_mcu7t5v0__buf_2
XFILLER_38_440 VDD VDD VSS VSS gf180mcu_fd_sc_mcu7t5v0__fillcap_8
X_2248_ wire374/I wire334/I _2255_/A2 VDD VDD VSS VSS gf180mcu_fd_sc_mcu7t5v0__nand2_1
XTAP_TAPCELL_ROW_0_200 VDD VSS gf180mcu_fd_sc_mcu7t5v0__filltie
XTAP_TAPCELL_ROW_0_211 VDD VSS gf180mcu_fd_sc_mcu7t5v0__filltie
XTAP_TAPCELL_ROW_84_1002 VDD VSS gf180mcu_fd_sc_mcu7t5v0__filltie
XFILLER_26_624 VDD VDD VSS VSS gf180mcu_fd_sc_mcu7t5v0__fill_1
X_2179_ _3450_/A1 _2183_/A2 _2179_/B _2181_/A2 VDD VDD VSS VSS gf180mcu_fd_sc_mcu7t5v0__oai21_1
XTAP_TAPCELL_ROW_51_688 VDD VSS gf180mcu_fd_sc_mcu7t5v0__filltie
Xoutput89 _3780_/I cal_phase0_offset[0] VDD VDD VSS VSS gf180mcu_fd_sc_mcu7t5v0__buf_2
XFILLER_88_395 VDD VDD VSS VSS gf180mcu_fd_sc_mcu7t5v0__fillcap_4
XFILLER_88_384 VDD VDD VSS VSS gf180mcu_fd_sc_mcu7t5v0__fill_1
XFILLER_76_535 VDD VDD VSS VSS gf180mcu_fd_sc_mcu7t5v0__fill_2
XTAP_TAPCELL_ROW_59_766 VDD VSS gf180mcu_fd_sc_mcu7t5v0__filltie
XFILLER_84_590 VDD VDD VSS VSS gf180mcu_fd_sc_mcu7t5v0__fillcap_4
XFILLER_16_101 VDD VDD VSS VSS gf180mcu_fd_sc_mcu7t5v0__fillcap_4
XFILLER_32_605 VDD VDD VSS VSS gf180mcu_fd_sc_mcu7t5v0__fill_2
XFILLER_31_104 VDD VDD VSS VSS gf180mcu_fd_sc_mcu7t5v0__fillcap_16
XTAP_TAPCELL_ROW_42_611 VDD VSS gf180mcu_fd_sc_mcu7t5v0__filltie
XFILLER_31_148 VDD VDD VSS VSS gf180mcu_fd_sc_mcu7t5v0__fill_1
XFILLER_12_395 VDD VDD VSS VSS gf180mcu_fd_sc_mcu7t5v0__fill_1
XFILLER_12_384 VDD VDD VSS VSS gf180mcu_fd_sc_mcu7t5v0__fill_1
XFILLER_4_583 VDD VDD VSS VSS gf180mcu_fd_sc_mcu7t5v0__fillcap_4
X_3220_ _3015_/I _3712_/Q _3220_/Z VDD VDD VSS VSS gf180mcu_fd_sc_mcu7t5v0__xor2_1
XFILLER_79_384 VDD VDD VSS VSS gf180mcu_fd_sc_mcu7t5v0__fillcap_32
X_3151_ _3152_/A1 _3152_/A2 _3153_/A2 VDD VDD VSS VSS gf180mcu_fd_sc_mcu7t5v0__nand2_1
X_2102_ _3218_/A1 _3627_/A1 _2102_/B _2103_/A3 VDD VDD VSS VSS gf180mcu_fd_sc_mcu7t5v0__oai21_1
XFILLER_94_387 VDD VDD VSS VSS gf180mcu_fd_sc_mcu7t5v0__fillcap_64
XFILLER_82_527 VDD VDD VSS VSS gf180mcu_fd_sc_mcu7t5v0__fill_2
X_3082_ _3732_/Q _2366_/S VDD VDD VSS VSS gf180mcu_fd_sc_mcu7t5v0__clkinv_1
X_2033_ _2034_/A1 _2034_/A2 _2035_/A2 VDD VDD VSS VSS gf180mcu_fd_sc_mcu7t5v0__nand2_1
XFILLER_23_638 VDD VDD VSS VSS gf180mcu_fd_sc_mcu7t5v0__fill_2
XFILLER_62_273 VDD VDD VSS VSS gf180mcu_fd_sc_mcu7t5v0__fill_2
XFILLER_50_457 VDD VDD VSS VSS gf180mcu_fd_sc_mcu7t5v0__fillcap_4
X_2935_ _2935_/A1 _2935_/A2 _2935_/B _3705_/D VDD VDD VSS VSS gf180mcu_fd_sc_mcu7t5v0__oai21_1
X_2866_ wire451/Z wire269/Z _2868_/B1 VDD VDD VSS VSS gf180mcu_fd_sc_mcu7t5v0__nor2_1
X_1817_ _3028_/ZN _3692_/Q _1865_/C VDD VDD VSS VSS gf180mcu_fd_sc_mcu7t5v0__nand2_1
X_2797_ _2827_/A1 _2797_/A2 _2797_/A3 _2798_/A2 VDD VDD VSS VSS gf180mcu_fd_sc_mcu7t5v0__nand3_1
X_3418_ _3387_/I _3399_/Z _3419_/C VDD VDD VSS VSS gf180mcu_fd_sc_mcu7t5v0__nand2_1
XTAP_TAPCELL_ROW_90_1061 VDD VSS gf180mcu_fd_sc_mcu7t5v0__filltie
X_3349_ _3349_/A1 _3349_/A2 _3773_/D VDD VDD VSS VSS gf180mcu_fd_sc_mcu7t5v0__xor2_1
XFILLER_58_524 VDD VDD VSS VSS gf180mcu_fd_sc_mcu7t5v0__fill_1
XFILLER_58_535 VDD VDD VSS VSS gf180mcu_fd_sc_mcu7t5v0__fillcap_4
XFILLER_58_557 VDD VDD VSS VSS gf180mcu_fd_sc_mcu7t5v0__fillcap_16
XFILLER_45_207 VDD VDD VSS VSS gf180mcu_fd_sc_mcu7t5v0__fill_2
XTAP_TAPCELL_ROW_56_736 VDD VSS gf180mcu_fd_sc_mcu7t5v0__filltie
XFILLER_26_34 VDD VDD VSS VSS gf180mcu_fd_sc_mcu7t5v0__fill_1
XFILLER_41_424 VDD VDD VSS VSS gf180mcu_fd_sc_mcu7t5v0__fill_1
XTAP_TAPCELL_ROW_11_316 VDD VSS gf180mcu_fd_sc_mcu7t5v0__filltie
XPHY_EDGE_ROW_39_Left_136 VDD VSS gf180mcu_fd_sc_mcu7t5v0__endcap
XFILLER_76_387 VDD VDD VSS VSS gf180mcu_fd_sc_mcu7t5v0__fillcap_4
XPHY_EDGE_ROW_48_Left_145 VDD VSS gf180mcu_fd_sc_mcu7t5v0__endcap
XFILLER_91_346 VDD VDD VSS VSS gf180mcu_fd_sc_mcu7t5v0__fillcap_4
XFILLER_17_454 VDD VDD VSS VSS gf180mcu_fd_sc_mcu7t5v0__fill_2
XTAP_TAPCELL_ROW_27_460 VDD VSS gf180mcu_fd_sc_mcu7t5v0__filltie
XFILLER_72_582 VDD VDD VSS VSS gf180mcu_fd_sc_mcu7t5v0__fillcap_8
XFILLER_44_295 VDD VDD VSS VSS gf180mcu_fd_sc_mcu7t5v0__fillcap_16
X_2720_ _3526_/A1 _2693_/Z _2720_/B _2721_/B2 VDD VDD VSS VSS gf180mcu_fd_sc_mcu7t5v0__oai21_1
XFILLER_9_664 VDD VDD VSS VSS gf180mcu_fd_sc_mcu7t5v0__fillcap_8
X_2651_ _2651_/I _2654_/A2 VDD VDD VSS VSS gf180mcu_fd_sc_mcu7t5v0__clkinv_1
XPHY_EDGE_ROW_57_Left_154 VDD VSS gf180mcu_fd_sc_mcu7t5v0__endcap
X_2582_ _3491_/A1 _2562_/Z _2582_/B1 _2582_/B2 _2582_/C _2584_/B VDD VDD VSS VSS gf180mcu_fd_sc_mcu7t5v0__aoi221_1
X_3203_ input8/Z _3203_/A2 _3213_/A1 VDD VDD VSS VSS gf180mcu_fd_sc_mcu7t5v0__nor2_1
XFILLER_86_107 VDD VDD VSS VSS gf180mcu_fd_sc_mcu7t5v0__fillcap_64
X_3134_ _3134_/A1 _3134_/A2 _3136_/A3 VDD VDD VSS VSS gf180mcu_fd_sc_mcu7t5v0__nand2_1
XFILLER_27_207 VDD VDD VSS VSS gf180mcu_fd_sc_mcu7t5v0__fill_2
XPHY_EDGE_ROW_66_Left_163 VDD VSS gf180mcu_fd_sc_mcu7t5v0__endcap
XFILLER_67_376 VDD VDD VSS VSS gf180mcu_fd_sc_mcu7t5v0__fillcap_4
X_3065_ _3065_/I _3558_/A2 VDD VDD VSS VSS gf180mcu_fd_sc_mcu7t5v0__clkinv_1
XFILLER_48_590 VDD VDD VSS VSS gf180mcu_fd_sc_mcu7t5v0__fillcap_4
XFILLER_82_357 VDD VDD VSS VSS gf180mcu_fd_sc_mcu7t5v0__fillcap_4
X_2016_ _3558_/A1 _2015_/Z _2034_/A1 VDD VDD VSS VSS gf180mcu_fd_sc_mcu7t5v0__nand2_1
XFILLER_11_608 VDD VDD VSS VSS gf180mcu_fd_sc_mcu7t5v0__fill_2
XFILLER_10_107 VDD VDD VSS VSS gf180mcu_fd_sc_mcu7t5v0__fillcap_64
XFILLER_23_479 VDD VDD VSS VSS gf180mcu_fd_sc_mcu7t5v0__fill_1
XPHY_EDGE_ROW_75_Left_172 VDD VSS gf180mcu_fd_sc_mcu7t5v0__endcap
XFILLER_50_298 VDD VDD VSS VSS gf180mcu_fd_sc_mcu7t5v0__fill_2
X_2918_ _2918_/A1 _2961_/A2 _2918_/B _3697_/D VDD VDD VSS VSS gf180mcu_fd_sc_mcu7t5v0__oai21_1
XTAP_TAPCELL_ROW_61_783 VDD VSS gf180mcu_fd_sc_mcu7t5v0__filltie
X_2849_ _3673_/Q wire235/Z _2855_/B _2850_/B2 VDD VDD VSS VSS gf180mcu_fd_sc_mcu7t5v0__oai21_1
Xfanout621 input6/Z wire622/I VDD VDD VSS VSS gf180mcu_fd_sc_mcu7t5v0__dlyb_1
Xfanout610 wire616/Z fanout610/Z VDD VDD VSS VSS gf180mcu_fd_sc_mcu7t5v0__dlyb_1
XPHY_EDGE_ROW_84_Left_181 VDD VSS gf180mcu_fd_sc_mcu7t5v0__endcap
Xfanout654 input11/Z wire656/I VDD VDD VSS VSS gf180mcu_fd_sc_mcu7t5v0__dlyb_1
XTAP_TAPCELL_ROW_69_861 VDD VSS gf180mcu_fd_sc_mcu7t5v0__filltie
XFILLER_37_66 VDD VDD VSS VSS gf180mcu_fd_sc_mcu7t5v0__fillcap_4
XFILLER_46_527 VDD VDD VSS VSS gf180mcu_fd_sc_mcu7t5v0__fillcap_32
XFILLER_73_335 VDD VDD VSS VSS gf180mcu_fd_sc_mcu7t5v0__fill_1
XFILLER_73_357 VDD VDD VSS VSS gf180mcu_fd_sc_mcu7t5v0__fillcap_4
XFILLER_14_424 VDD VDD VSS VSS gf180mcu_fd_sc_mcu7t5v0__fillcap_4
XFILLER_54_593 VDD VDD VSS VSS gf180mcu_fd_sc_mcu7t5v0__fill_2
XPHY_EDGE_ROW_93_Left_190 VDD VSS gf180mcu_fd_sc_mcu7t5v0__endcap
XFILLER_10_652 VDD VDD VSS VSS gf180mcu_fd_sc_mcu7t5v0__fill_2
XFILLER_6_667 VDD VDD VSS VSS gf180mcu_fd_sc_mcu7t5v0__fillcap_8
XFILLER_68_107 VDD VDD VSS VSS gf180mcu_fd_sc_mcu7t5v0__fillcap_64
XFILLER_77_652 VDD VDD VSS VSS gf180mcu_fd_sc_mcu7t5v0__fill_1
XFILLER_17_273 VDD VDD VSS VSS gf180mcu_fd_sc_mcu7t5v0__fill_2
XFILLER_32_265 VDD VDD VSS VSS gf180mcu_fd_sc_mcu7t5v0__fillcap_16
XFILLER_20_416 VDD VDD VSS VSS gf180mcu_fd_sc_mcu7t5v0__fillcap_16
X_3752_ _3752_/D wire594/Z clkload7/I _3752_/Q VDD VDD VSS VSS gf180mcu_fd_sc_mcu7t5v0__dffrnq_1
XFILLER_71_2 VDD VDD VSS VSS gf180mcu_fd_sc_mcu7t5v0__fillcap_64
XFILLER_9_494 VDD VDD VSS VSS gf180mcu_fd_sc_mcu7t5v0__fill_1
X_2703_ _2703_/A1 _2702_/Z _2703_/Z VDD VDD VSS VSS gf180mcu_fd_sc_mcu7t5v0__and2_1
XTAP_TAPCELL_ROW_30_488 VDD VSS gf180mcu_fd_sc_mcu7t5v0__filltie
X_3683_ _3683_/D _3686_/RN clkload6/I _3683_/Q VDD VDD VSS VSS gf180mcu_fd_sc_mcu7t5v0__dffrnq_2
X_2634_ _2636_/A1 _2703_/A1 _2700_/A1 VDD VDD VSS VSS gf180mcu_fd_sc_mcu7t5v0__nand2_1
X_2565_ _3107_/B2 _3025_/I _2565_/A3 _2565_/Z VDD VDD VSS VSS gf180mcu_fd_sc_mcu7t5v0__xor3_1
Xoutput202 _3048_/I raw_edge2[5] VDD VDD VSS VSS gf180mcu_fd_sc_mcu7t5v0__buf_2
Xoutput224 _3716_/Q raw_edge3[6] VDD VDD VSS VSS gf180mcu_fd_sc_mcu7t5v0__buf_2
Xoutput213 _2282_/A1 raw_edge3[15] VDD VDD VSS VSS gf180mcu_fd_sc_mcu7t5v0__buf_2
X_2496_ _2496_/I _2497_/B VDD VDD VSS VSS gf180mcu_fd_sc_mcu7t5v0__clkinv_1
X_3117_ input25/Z _3117_/A2 _3123_/A2 VDD VDD VSS VSS gf180mcu_fd_sc_mcu7t5v0__nand2_1
XFILLER_28_527 VDD VDD VSS VSS gf180mcu_fd_sc_mcu7t5v0__fillcap_8
XTAP_TAPCELL_ROW_66_831 VDD VSS gf180mcu_fd_sc_mcu7t5v0__filltie
XTAP_TAPCELL_ROW_38_566 VDD VSS gf180mcu_fd_sc_mcu7t5v0__filltie
X_3048_ _3048_/I _3399_/A1 VDD VDD VSS VSS gf180mcu_fd_sc_mcu7t5v0__clkinv_1
XFILLER_63_390 VDD VDD VSS VSS gf180mcu_fd_sc_mcu7t5v0__fill_1
XFILLER_70_349 VDD VDD VSS VSS gf180mcu_fd_sc_mcu7t5v0__fill_1
XFILLER_51_574 VDD VDD VSS VSS gf180mcu_fd_sc_mcu7t5v0__fill_2
XTAP_TAPCELL_ROW_21_411 VDD VSS gf180mcu_fd_sc_mcu7t5v0__filltie
XFILLER_3_626 VDD VDD VSS VSS gf180mcu_fd_sc_mcu7t5v0__fillcap_4
XFILLER_86_493 VDD VDD VSS VSS gf180mcu_fd_sc_mcu7t5v0__fillcap_4
XFILLER_61_349 VDD VDD VSS VSS gf180mcu_fd_sc_mcu7t5v0__fill_1
XFILLER_14_265 VDD VDD VSS VSS gf180mcu_fd_sc_mcu7t5v0__fill_1
XTAP_TAPCELL_ROW_72_889 VDD VSS gf180mcu_fd_sc_mcu7t5v0__filltie
XFILLER_14_298 VDD VDD VSS VSS gf180mcu_fd_sc_mcu7t5v0__fill_1
XFILLER_89_72 VDD VDD VSS VSS gf180mcu_fd_sc_mcu7t5v0__fillcap_64
X_2350_ _2356_/C _3003_/I _2350_/Z VDD VDD VSS VSS gf180mcu_fd_sc_mcu7t5v0__xor2_1
XTAP_TAPCELL_ROW_9_291 VDD VSS gf180mcu_fd_sc_mcu7t5v0__filltie
X_2281_ wire435/Z _2288_/A2 _2933_/A1 VDD VDD VSS VSS gf180mcu_fd_sc_mcu7t5v0__nand2_1
XFILLER_65_655 VDD VDD VSS VSS gf180mcu_fd_sc_mcu7t5v0__fill_2
XTAP_TAPCELL_ROW_35_536 VDD VSS gf180mcu_fd_sc_mcu7t5v0__filltie
XFILLER_60_382 VDD VDD VSS VSS gf180mcu_fd_sc_mcu7t5v0__fill_2
X_1996_ _1996_/A1 _1980_/Z _1996_/B _1999_/A3 VDD VDD VSS VSS gf180mcu_fd_sc_mcu7t5v0__oai21_1
XFILLER_20_257 VDD VDD VSS VSS gf180mcu_fd_sc_mcu7t5v0__fillcap_4
X_3735_ _3735_/D _3735_/RN _3739_/CLK _3735_/Q VDD VDD VSS VSS gf180mcu_fd_sc_mcu7t5v0__dffrnq_1
X_3666_ _3666_/D _3667_/RN _3739_/CLK _3666_/Q VDD VDD VSS VSS gf180mcu_fd_sc_mcu7t5v0__dffrnq_2
X_3597_ _3595_/Z _3598_/A3 _3618_/A2 VDD VDD VSS VSS gf180mcu_fd_sc_mcu7t5v0__xnor2_1
X_2617_ _2186_/B input60/Z _2650_/A1 VDD VDD VSS VSS gf180mcu_fd_sc_mcu7t5v0__nand2_1
X_2548_ _3117_/A2 _3018_/ZN _2548_/A3 _2548_/Z VDD VDD VSS VSS gf180mcu_fd_sc_mcu7t5v0__xor3_1
X_2479_ _2479_/A1 input78/Z _2504_/B1 VDD VDD VSS VSS gf180mcu_fd_sc_mcu7t5v0__nor2_2
XFILLER_28_313 VDD VDD VSS VSS gf180mcu_fd_sc_mcu7t5v0__fill_2
XTAP_TAPCELL_ROW_87_1033 VDD VSS gf180mcu_fd_sc_mcu7t5v0__filltie
XFILLER_43_349 VDD VDD VSS VSS gf180mcu_fd_sc_mcu7t5v0__fill_1
XFILLER_34_34 VDD VDD VSS VSS gf180mcu_fd_sc_mcu7t5v0__fill_1
XFILLER_7_206 VDD VDD VSS VSS gf180mcu_fd_sc_mcu7t5v0__fillcap_4
Xclkload0 clkload0/I clkload0/Z VDD VDD VSS VSS gf180mcu_fd_sc_mcu7t5v0__clkbuf_2
XFILLER_1_2 VDD VDD VSS VSS gf180mcu_fd_sc_mcu7t5v0__fillcap_64
XTAP_TAPCELL_ROW_6_261 VDD VSS gf180mcu_fd_sc_mcu7t5v0__filltie
XFILLER_78_279 VDD VDD VSS VSS gf180mcu_fd_sc_mcu7t5v0__fillcap_16
XTAP_TAPCELL_ROW_77_937 VDD VSS gf180mcu_fd_sc_mcu7t5v0__filltie
XFILLER_46_143 VDD VDD VSS VSS gf180mcu_fd_sc_mcu7t5v0__fill_2
XFILLER_15_585 VDD VDD VSS VSS gf180mcu_fd_sc_mcu7t5v0__fill_1
X_1850_ _1848_/Z _1850_/A2 _1850_/Z VDD VDD VSS VSS gf180mcu_fd_sc_mcu7t5v0__xor2_1
XTAP_TAPCELL_ROW_40_583 VDD VSS gf180mcu_fd_sc_mcu7t5v0__filltie
Xwire660 wire660/I wire660/Z VDD VDD VSS VSS gf180mcu_fd_sc_mcu7t5v0__buf_2
X_3520_ _3520_/A1 _3520_/A2 _3550_/B VDD VDD VSS VSS gf180mcu_fd_sc_mcu7t5v0__nand2_1
X_3451_ _3435_/B _3455_/C _3454_/A3 VDD VDD VSS VSS gf180mcu_fd_sc_mcu7t5v0__nand2_1
X_2402_ _2402_/A1 _2402_/A2 _2402_/Z VDD VDD VSS VSS gf180mcu_fd_sc_mcu7t5v0__xor2_1
X_3382_ _3382_/A1 _3379_/I _3382_/B _3409_/B3 VDD VDD VSS VSS gf180mcu_fd_sc_mcu7t5v0__aoi21_2
X_2333_ _2414_/A3 _2333_/A2 _2333_/B _2417_/A1 VDD VDD VSS VSS gf180mcu_fd_sc_mcu7t5v0__oai21_2
XFILLER_34_2 VDD VDD VSS VSS gf180mcu_fd_sc_mcu7t5v0__fillcap_32
XFILLER_69_268 VDD VDD VSS VSS gf180mcu_fd_sc_mcu7t5v0__fill_2
X_2264_ _3088_/ZN _2264_/A2 _2264_/B _3763_/D VDD VDD VSS VSS gf180mcu_fd_sc_mcu7t5v0__oai21_1
XFILLER_57_419 VDD VDD VSS VSS gf180mcu_fd_sc_mcu7t5v0__fill_1
XFILLER_69_279 VDD VDD VSS VSS gf180mcu_fd_sc_mcu7t5v0__fill_1
XFILLER_77_290 VDD VDD VSS VSS gf180mcu_fd_sc_mcu7t5v0__fillcap_4
X_2195_ _2195_/A1 _2195_/A2 _2195_/B _2201_/B1 VDD VDD VSS VSS gf180mcu_fd_sc_mcu7t5v0__aoi21_2
XTAP_TAPCELL_ROW_48_661 VDD VSS gf180mcu_fd_sc_mcu7t5v0__filltie
XFILLER_53_603 VDD VDD VSS VSS gf180mcu_fd_sc_mcu7t5v0__fillcap_8
XFILLER_53_636 VDD VDD VSS VSS gf180mcu_fd_sc_mcu7t5v0__fill_1
XFILLER_52_168 VDD VDD VSS VSS gf180mcu_fd_sc_mcu7t5v0__fillcap_4
XFILLER_21_511 VDD VDD VSS VSS gf180mcu_fd_sc_mcu7t5v0__fillcap_4
XFILLER_21_500 VDD VDD VSS VSS gf180mcu_fd_sc_mcu7t5v0__fillcap_4
X_1979_ wire640/Z _1977_/Z _1992_/A2 VDD VDD VSS VSS gf180mcu_fd_sc_mcu7t5v0__nand2_1
XFILLER_4_209 VDD VDD VSS VSS gf180mcu_fd_sc_mcu7t5v0__fillcap_8
X_3718_ _3718_/D _3721_/RN _3721_/CLK _3718_/Q VDD VDD VSS VSS gf180mcu_fd_sc_mcu7t5v0__dffrnq_2
X_3649_ _3647_/Z _3649_/A2 _3649_/ZN VDD VDD VSS VSS gf180mcu_fd_sc_mcu7t5v0__xnor2_2
XTAP_TAPCELL_ROW_93_1092 VDD VSS gf180mcu_fd_sc_mcu7t5v0__filltie
XTAP_TAPCELL_ROW_74_907 VDD VSS gf180mcu_fd_sc_mcu7t5v0__filltie
XPHY_EDGE_ROW_11_Left_108 VDD VSS gf180mcu_fd_sc_mcu7t5v0__endcap
XFILLER_83_282 VDD VDD VSS VSS gf180mcu_fd_sc_mcu7t5v0__fillcap_64
XFILLER_71_422 VDD VDD VSS VSS gf180mcu_fd_sc_mcu7t5v0__fillcap_8
XFILLER_43_135 VDD VDD VSS VSS gf180mcu_fd_sc_mcu7t5v0__fillcap_4
XFILLER_45_88 VDD VDD VSS VSS gf180mcu_fd_sc_mcu7t5v0__fillcap_8
XFILLER_45_66 VDD VDD VSS VSS gf180mcu_fd_sc_mcu7t5v0__fillcap_4
XTAP_TAPCELL_ROW_82_984 VDD VSS gf180mcu_fd_sc_mcu7t5v0__filltie
XFILLER_24_371 VDD VDD VSS VSS gf180mcu_fd_sc_mcu7t5v0__fill_1
XPHY_EDGE_ROW_20_Left_117 VDD VSS gf180mcu_fd_sc_mcu7t5v0__endcap
XFILLER_47_430 VDD VDD VSS VSS gf180mcu_fd_sc_mcu7t5v0__fillcap_4
XTAP_TAPCELL_ROW_45_631 VDD VSS gf180mcu_fd_sc_mcu7t5v0__filltie
XTAP_TAPCELL_ROW_17_366 VDD VSS gf180mcu_fd_sc_mcu7t5v0__filltie
X_2951_ wire258/Z _2951_/A2 _2951_/B _3713_/D VDD VDD VSS VSS gf180mcu_fd_sc_mcu7t5v0__oai21_1
X_1902_ _1915_/A1 _1901_/Z _1904_/A2 VDD VDD VSS VSS gf180mcu_fd_sc_mcu7t5v0__xnor2_1
X_2882_ _3071_/I wire233/I _2882_/B _2883_/B2 VDD VDD VSS VSS gf180mcu_fd_sc_mcu7t5v0__oai21_1
X_1833_ _3714_/Q _3386_/A1 _1849_/B VDD VDD VSS VSS gf180mcu_fd_sc_mcu7t5v0__nand2_1
XFILLER_7_570 VDD VDD VSS VSS gf180mcu_fd_sc_mcu7t5v0__fillcap_4
X_3503_ _2696_/B _3502_/Z _3528_/A1 VDD VDD VSS VSS gf180mcu_fd_sc_mcu7t5v0__nor2_1
X_3434_ _3455_/C _3456_/A2 _3437_/A2 VDD VDD VSS VSS gf180mcu_fd_sc_mcu7t5v0__nand2_1
Xload_slew440 _2469_/A1 _2356_/C VDD VDD VSS VSS gf180mcu_fd_sc_mcu7t5v0__buf_2
X_3365_ _3365_/A1 _3365_/A2 _3365_/Z VDD VDD VSS VSS gf180mcu_fd_sc_mcu7t5v0__xor2_1
X_2316_ _3744_/Q _3013_/I _2327_/B VDD VDD VSS VSS gf180mcu_fd_sc_mcu7t5v0__nand2_1
X_3296_ _3297_/A1 _3295_/Z _3298_/A2 VDD VDD VSS VSS gf180mcu_fd_sc_mcu7t5v0__nand2_1
Xload_slew473 _2749_/A1 _2763_/B VDD VDD VSS VSS gf180mcu_fd_sc_mcu7t5v0__clkbuf_1
X_2247_ wire536/Z _2121_/Z _2247_/ZN VDD VDD VSS VSS gf180mcu_fd_sc_mcu7t5v0__nand2_1
Xload_slew484 _3718_/Q _3169_/A2 VDD VDD VSS VSS gf180mcu_fd_sc_mcu7t5v0__buf_2
XTAP_TAPCELL_ROW_0_201 VDD VSS gf180mcu_fd_sc_mcu7t5v0__filltie
XTAP_TAPCELL_ROW_0_212 VDD VSS gf180mcu_fd_sc_mcu7t5v0__filltie
XTAP_TAPCELL_ROW_84_1003 VDD VSS gf180mcu_fd_sc_mcu7t5v0__filltie
X_2178_ _3055_/I _2183_/A2 _2179_/B VDD VDD VSS VSS gf180mcu_fd_sc_mcu7t5v0__nand2_1
XFILLER_65_260 VDD VDD VSS VSS gf180mcu_fd_sc_mcu7t5v0__fill_1
XFILLER_80_241 VDD VDD VSS VSS gf180mcu_fd_sc_mcu7t5v0__fillcap_4
XFILLER_53_466 VDD VDD VSS VSS gf180mcu_fd_sc_mcu7t5v0__fillcap_4
XFILLER_21_352 VDD VDD VSS VSS gf180mcu_fd_sc_mcu7t5v0__fill_1
XTAP_TAPCELL_ROW_51_689 VDD VSS gf180mcu_fd_sc_mcu7t5v0__filltie
XTAP_TAPCELL_ROW_95_1110 VDD VSS gf180mcu_fd_sc_mcu7t5v0__filltie
XFILLER_0_201 VDD VDD VSS VSS gf180mcu_fd_sc_mcu7t5v0__fill_2
XFILLER_76_503 VDD VDD VSS VSS gf180mcu_fd_sc_mcu7t5v0__fillcap_16
XFILLER_0_278 VDD VDD VSS VSS gf180mcu_fd_sc_mcu7t5v0__fill_1
XFILLER_0_256 VDD VDD VSS VSS gf180mcu_fd_sc_mcu7t5v0__fillcap_4
XFILLER_48_238 VDD VDD VSS VSS gf180mcu_fd_sc_mcu7t5v0__fill_1
XFILLER_48_249 VDD VDD VSS VSS gf180mcu_fd_sc_mcu7t5v0__fill_1
XTAP_TAPCELL_ROW_59_767 VDD VSS gf180mcu_fd_sc_mcu7t5v0__filltie
XFILLER_29_485 VDD VDD VSS VSS gf180mcu_fd_sc_mcu7t5v0__fillcap_4
XPHY_EDGE_ROW_19_Right_19 VDD VSS gf180mcu_fd_sc_mcu7t5v0__endcap
XFILLER_71_252 VDD VDD VSS VSS gf180mcu_fd_sc_mcu7t5v0__fillcap_4
XTAP_TAPCELL_ROW_14_336 VDD VSS gf180mcu_fd_sc_mcu7t5v0__filltie
XFILLER_31_127 VDD VDD VSS VSS gf180mcu_fd_sc_mcu7t5v0__fillcap_8
XPHY_EDGE_ROW_28_Right_28 VDD VSS gf180mcu_fd_sc_mcu7t5v0__endcap
XFILLER_94_311 VDD VDD VSS VSS gf180mcu_fd_sc_mcu7t5v0__fillcap_4
X_3150_ _3150_/I _3152_/B VDD VDD VSS VSS gf180mcu_fd_sc_mcu7t5v0__clkinv_1
X_2101_ _2077_/Z _2101_/A2 _2101_/B _2101_/C _2102_/B VDD VDD VSS VSS gf180mcu_fd_sc_mcu7t5v0__oai211_1
X_3081_ _3081_/I _3081_/ZN VDD VDD VSS VSS gf180mcu_fd_sc_mcu7t5v0__clkinv_1
X_2032_ _3553_/A1 _2053_/A2 _2034_/B VDD VDD VSS VSS gf180mcu_fd_sc_mcu7t5v0__xor2_1
XPHY_EDGE_ROW_37_Right_37 VDD VSS gf180mcu_fd_sc_mcu7t5v0__endcap
XFILLER_62_263 VDD VDD VSS VSS gf180mcu_fd_sc_mcu7t5v0__fill_2
XFILLER_90_594 VDD VDD VSS VSS gf180mcu_fd_sc_mcu7t5v0__fill_1
XFILLER_62_296 VDD VDD VSS VSS gf180mcu_fd_sc_mcu7t5v0__fill_1
X_2934_ _3705_/Q _2939_/A2 _2935_/B VDD VDD VSS VSS gf180mcu_fd_sc_mcu7t5v0__nand2_1
X_2865_ _3506_/A1 _2865_/A2 _2865_/B1 _2865_/B2 _3678_/D VDD VDD VSS VSS gf180mcu_fd_sc_mcu7t5v0__oai22_1
X_1816_ _1836_/A1 _1864_/B1 _1816_/Z VDD VDD VSS VSS gf180mcu_fd_sc_mcu7t5v0__and2_1
XFILLER_30_193 VDD VDD VSS VSS gf180mcu_fd_sc_mcu7t5v0__fillcap_4
XPHY_EDGE_ROW_46_Right_46 VDD VSS gf180mcu_fd_sc_mcu7t5v0__endcap
X_2796_ _2796_/A1 _2796_/A2 _2796_/B _2797_/A3 VDD VDD VSS VSS gf180mcu_fd_sc_mcu7t5v0__oai21_1
X_3417_ _3387_/I _3399_/Z _3420_/B VDD VDD VSS VSS gf180mcu_fd_sc_mcu7t5v0__and2_1
XTAP_TAPCELL_ROW_90_1062 VDD VSS gf180mcu_fd_sc_mcu7t5v0__filltie
X_3348_ _3773_/Q _3348_/A2 _3349_/A2 VDD VDD VSS VSS gf180mcu_fd_sc_mcu7t5v0__xnor2_1
XFILLER_58_514 VDD VDD VSS VSS gf180mcu_fd_sc_mcu7t5v0__fill_2
Xload_slew270 wire269/I _2893_/A2 VDD VDD VSS VSS gf180mcu_fd_sc_mcu7t5v0__buf_1
X_3279_ _3767_/Q _3280_/A1 _3279_/A3 _3767_/D VDD VDD VSS VSS gf180mcu_fd_sc_mcu7t5v0__xor3_1
XPHY_EDGE_ROW_55_Right_55 VDD VSS gf180mcu_fd_sc_mcu7t5v0__endcap
XTAP_TAPCELL_ROW_56_737 VDD VSS gf180mcu_fd_sc_mcu7t5v0__filltie
XFILLER_66_591 VDD VDD VSS VSS gf180mcu_fd_sc_mcu7t5v0__fillcap_4
XFILLER_81_572 VDD VDD VSS VSS gf180mcu_fd_sc_mcu7t5v0__fill_2
XFILLER_42_34 VDD VDD VSS VSS gf180mcu_fd_sc_mcu7t5v0__fill_1
XPHY_EDGE_ROW_64_Right_64 VDD VSS gf180mcu_fd_sc_mcu7t5v0__endcap
XFILLER_88_171 VDD VDD VSS VSS gf180mcu_fd_sc_mcu7t5v0__fillcap_4
XPHY_EDGE_ROW_73_Right_73 VDD VSS gf180mcu_fd_sc_mcu7t5v0__endcap
XFILLER_76_344 VDD VDD VSS VSS gf180mcu_fd_sc_mcu7t5v0__fill_2
XFILLER_17_422 VDD VDD VSS VSS gf180mcu_fd_sc_mcu7t5v0__fillcap_32
XFILLER_29_282 VDD VDD VSS VSS gf180mcu_fd_sc_mcu7t5v0__fillcap_8
XTAP_TAPCELL_ROW_27_461 VDD VSS gf180mcu_fd_sc_mcu7t5v0__filltie
XFILLER_72_594 VDD VDD VSS VSS gf180mcu_fd_sc_mcu7t5v0__fill_1
XPHY_EDGE_ROW_82_Right_82 VDD VSS gf180mcu_fd_sc_mcu7t5v0__endcap
XFILLER_32_469 VDD VDD VSS VSS gf180mcu_fd_sc_mcu7t5v0__fillcap_16
XFILLER_12_171 VDD VDD VSS VSS gf180mcu_fd_sc_mcu7t5v0__fillcap_4
XFILLER_9_632 VDD VDD VSS VSS gf180mcu_fd_sc_mcu7t5v0__fillcap_4
XFILLER_9_676 VDD VDD VSS VSS gf180mcu_fd_sc_mcu7t5v0__fill_1
X_2650_ _2650_/A1 _2650_/A2 _2651_/I VDD VDD VSS VSS gf180mcu_fd_sc_mcu7t5v0__nand2_1
X_2581_ _3010_/I _2563_/Z _2565_/Z input14/Z _2582_/B2 VDD VDD VSS VSS gf180mcu_fd_sc_mcu7t5v0__aoi22_1
XPHY_EDGE_ROW_91_Right_91 VDD VSS gf180mcu_fd_sc_mcu7t5v0__endcap
X_3202_ _2051_/B _3205_/A2 _3202_/A3 _3202_/Z VDD VDD VSS VSS gf180mcu_fd_sc_mcu7t5v0__xor3_2
XFILLER_67_300 VDD VDD VSS VSS gf180mcu_fd_sc_mcu7t5v0__fill_1
XFILLER_95_664 VDD VDD VSS VSS gf180mcu_fd_sc_mcu7t5v0__fillcap_8
X_3133_ _3128_/C _3133_/A2 _3133_/B _3134_/A2 VDD VDD VSS VSS gf180mcu_fd_sc_mcu7t5v0__oai21_1
X_3064_ _3064_/I _3550_/A1 VDD VDD VSS VSS gf180mcu_fd_sc_mcu7t5v0__clkinv_1
X_2015_ _2017_/A2 _2014_/B _2015_/Z VDD VDD VSS VSS gf180mcu_fd_sc_mcu7t5v0__xor2_1
XTAP_TAPCELL_ROW_53_707 VDD VSS gf180mcu_fd_sc_mcu7t5v0__filltie
XFILLER_50_266 VDD VDD VSS VSS gf180mcu_fd_sc_mcu7t5v0__fill_1
X_2917_ _3697_/Q _2918_/A1 _2918_/B VDD VDD VSS VSS gf180mcu_fd_sc_mcu7t5v0__nand2_1
XTAP_TAPCELL_ROW_61_784 VDD VSS gf180mcu_fd_sc_mcu7t5v0__filltie
XFILLER_12_37 VDD VDD VSS VSS gf180mcu_fd_sc_mcu7t5v0__fillcap_64
X_2848_ _3746_/Q _2848_/A2 _2850_/B1 VDD VDD VSS VSS gf180mcu_fd_sc_mcu7t5v0__nor2_1
X_2779_ _3091_/ZN _2779_/A2 _2779_/B1 _2779_/B2 _3662_/D VDD VDD VSS VSS gf180mcu_fd_sc_mcu7t5v0__oai22_1
Xfanout644 wire649/I _3009_/I VDD VDD VSS VSS gf180mcu_fd_sc_mcu7t5v0__dlyb_1
XTAP_TAPCELL_ROW_69_862 VDD VSS gf180mcu_fd_sc_mcu7t5v0__filltie
XFILLER_54_561 VDD VDD VSS VSS gf180mcu_fd_sc_mcu7t5v0__fill_2
XFILLER_54_572 VDD VDD VSS VSS gf180mcu_fd_sc_mcu7t5v0__fillcap_4
XFILLER_41_233 VDD VDD VSS VSS gf180mcu_fd_sc_mcu7t5v0__fill_1
XTAP_TAPCELL_ROW_24_431 VDD VSS gf180mcu_fd_sc_mcu7t5v0__filltie
XFILLER_53_66 VDD VDD VSS VSS gf180mcu_fd_sc_mcu7t5v0__fillcap_4
XFILLER_10_664 VDD VDD VSS VSS gf180mcu_fd_sc_mcu7t5v0__fill_1
XFILLER_77_620 VDD VDD VSS VSS gf180mcu_fd_sc_mcu7t5v0__fill_2
XFILLER_92_667 VDD VDD VSS VSS gf180mcu_fd_sc_mcu7t5v0__fillcap_8
XFILLER_17_230 VDD VDD VSS VSS gf180mcu_fd_sc_mcu7t5v0__fill_1
XFILLER_45_583 VDD VDD VSS VSS gf180mcu_fd_sc_mcu7t5v0__fill_2
XFILLER_32_233 VDD VDD VSS VSS gf180mcu_fd_sc_mcu7t5v0__fillcap_4
X_3751_ _3751_/D _3751_/RN clkload7/I _3751_/Q VDD VDD VSS VSS gf180mcu_fd_sc_mcu7t5v0__dffrnq_1
XFILLER_60_586 VDD VDD VSS VSS gf180mcu_fd_sc_mcu7t5v0__fill_2
XFILLER_60_597 VDD VDD VSS VSS gf180mcu_fd_sc_mcu7t5v0__fill_2
X_2702_ _2625_/Z _2702_/A2 _2633_/B _2702_/Z VDD VDD VSS VSS gf180mcu_fd_sc_mcu7t5v0__or3_1
XTAP_TAPCELL_ROW_30_489 VDD VSS gf180mcu_fd_sc_mcu7t5v0__filltie
X_3682_ _3682_/D _3684_/RN clkload5/I _3682_/Q VDD VDD VSS VSS gf180mcu_fd_sc_mcu7t5v0__dffrnq_2
X_2633_ _2625_/Z _2702_/A2 _2633_/B _2703_/A1 VDD VDD VSS VSS gf180mcu_fd_sc_mcu7t5v0__oai21_1
XFILLER_64_2 VDD VDD VSS VSS gf180mcu_fd_sc_mcu7t5v0__fillcap_32
X_2564_ _3010_/I _2563_/Z _2582_/C VDD VDD VSS VSS gf180mcu_fd_sc_mcu7t5v0__nor2_1
Xoutput203 _3050_/I raw_edge2[6] VDD VDD VSS VSS gf180mcu_fd_sc_mcu7t5v0__buf_2
Xoutput225 _3170_/A2 raw_edge3[7] VDD VDD VSS VSS gf180mcu_fd_sc_mcu7t5v0__buf_2
Xoutput214 _3726_/Q raw_edge3[16] VDD VDD VSS VSS gf180mcu_fd_sc_mcu7t5v0__buf_2
X_2495_ _2905_/A1 input75/Z _2496_/I VDD VDD VSS VSS gf180mcu_fd_sc_mcu7t5v0__xor2_1
X_3116_ input25/Z _3117_/A2 _3118_/C VDD VDD VSS VSS gf180mcu_fd_sc_mcu7t5v0__and2_1
XFILLER_28_539 VDD VDD VSS VSS gf180mcu_fd_sc_mcu7t5v0__fill_1
XTAP_TAPCELL_ROW_66_832 VDD VSS gf180mcu_fd_sc_mcu7t5v0__filltie
XFILLER_82_177 VDD VDD VSS VSS gf180mcu_fd_sc_mcu7t5v0__fillcap_64
XTAP_TAPCELL_ROW_38_567 VDD VSS gf180mcu_fd_sc_mcu7t5v0__filltie
X_3047_ _3672_/Q _3385_/A2 VDD VDD VSS VSS gf180mcu_fd_sc_mcu7t5v0__clkinv_1
XFILLER_70_306 VDD VDD VSS VSS gf180mcu_fd_sc_mcu7t5v0__fill_1
XFILLER_70_317 VDD VDD VSS VSS gf180mcu_fd_sc_mcu7t5v0__fillcap_32
XFILLER_51_542 VDD VDD VSS VSS gf180mcu_fd_sc_mcu7t5v0__fillcap_16
Xwire319 wire319/I wire319/Z VDD VDD VSS VSS gf180mcu_fd_sc_mcu7t5v0__clkbuf_2
Xfanout430 _3756_/Q _2973_/I VDD VDD VSS VSS gf180mcu_fd_sc_mcu7t5v0__dlyb_1
XFILLER_19_506 VDD VDD VSS VSS gf180mcu_fd_sc_mcu7t5v0__fill_1
Xfanout452 _3751_/Q _2517_/A1 VDD VDD VSS VSS gf180mcu_fd_sc_mcu7t5v0__dlyb_1
XFILLER_58_174 VDD VDD VSS VSS gf180mcu_fd_sc_mcu7t5v0__fill_1
XFILLER_74_667 VDD VDD VSS VSS gf180mcu_fd_sc_mcu7t5v0__fill_2
XFILLER_58_185 VDD VDD VSS VSS gf180mcu_fd_sc_mcu7t5v0__fillcap_4
XFILLER_27_594 VDD VDD VSS VSS gf180mcu_fd_sc_mcu7t5v0__fill_1
XFILLER_14_255 VDD VDD VSS VSS gf180mcu_fd_sc_mcu7t5v0__fillcap_8
XFILLER_42_597 VDD VDD VSS VSS gf180mcu_fd_sc_mcu7t5v0__fillcap_4
XFILLER_6_454 VDD VDD VSS VSS gf180mcu_fd_sc_mcu7t5v0__fill_1
XFILLER_6_465 VDD VDD VSS VSS gf180mcu_fd_sc_mcu7t5v0__fill_2
XTAP_TAPCELL_ROW_9_292 VDD VSS gf180mcu_fd_sc_mcu7t5v0__filltie
X_2280_ _2280_/A1 _2931_/A1 _2280_/B _3724_/D VDD VDD VSS VSS gf180mcu_fd_sc_mcu7t5v0__oai21_1
XFILLER_69_439 VDD VDD VSS VSS gf180mcu_fd_sc_mcu7t5v0__fill_1
XFILLER_65_623 VDD VDD VSS VSS gf180mcu_fd_sc_mcu7t5v0__fill_2
XFILLER_52_306 VDD VDD VSS VSS gf180mcu_fd_sc_mcu7t5v0__fill_1
XTAP_TAPCELL_ROW_63_802 VDD VSS gf180mcu_fd_sc_mcu7t5v0__filltie
XFILLER_64_177 VDD VDD VSS VSS gf180mcu_fd_sc_mcu7t5v0__fill_2
XTAP_TAPCELL_ROW_35_537 VDD VSS gf180mcu_fd_sc_mcu7t5v0__filltie
XFILLER_45_391 VDD VDD VSS VSS gf180mcu_fd_sc_mcu7t5v0__fill_2
X_1995_ _1995_/I _2023_/A1 VDD VDD VSS VSS gf180mcu_fd_sc_mcu7t5v0__clkinv_1
XFILLER_20_225 VDD VDD VSS VSS gf180mcu_fd_sc_mcu7t5v0__fillcap_8
X_3734_ _3734_/D wire559/Z clkload2/I _3734_/Q VDD VDD VSS VSS gf180mcu_fd_sc_mcu7t5v0__dffrnq_1
X_3665_ _3665_/D wire586/Z clkload2/I _3665_/Q VDD VDD VSS VSS gf180mcu_fd_sc_mcu7t5v0__dffrnq_2
X_2616_ _2977_/I input43/Z _2661_/B VDD VDD VSS VSS gf180mcu_fd_sc_mcu7t5v0__xor2_1
X_3596_ _3612_/B1 _3612_/B2 _3612_/C _3598_/A3 VDD VDD VSS VSS gf180mcu_fd_sc_mcu7t5v0__aoi21_1
X_2547_ _2469_/Z _2547_/A2 _2528_/Z _3019_/ZN _2547_/B2 _2548_/A3 VDD VDD VSS VSS
+ gf180mcu_fd_sc_mcu7t5v0__oai32_4
X_2478_ _2479_/A1 input78/Z _2504_/C VDD VDD VSS VSS gf180mcu_fd_sc_mcu7t5v0__nand2_1
XTAP_TAPCELL_ROW_87_1034 VDD VSS gf180mcu_fd_sc_mcu7t5v0__filltie
XFILLER_56_667 VDD VDD VSS VSS gf180mcu_fd_sc_mcu7t5v0__fill_2
XFILLER_11_225 VDD VDD VSS VSS gf180mcu_fd_sc_mcu7t5v0__fillcap_4
Xclkload1 clkload1/I clkload1/Z VDD VDD VSS VSS gf180mcu_fd_sc_mcu7t5v0__clkbuf_2
XFILLER_50_34 VDD VDD VSS VSS gf180mcu_fd_sc_mcu7t5v0__fill_1
XFILLER_78_247 VDD VDD VSS VSS gf180mcu_fd_sc_mcu7t5v0__fillcap_32
XTAP_TAPCELL_ROW_6_262 VDD VSS gf180mcu_fd_sc_mcu7t5v0__filltie
XFILLER_93_206 VDD VDD VSS VSS gf180mcu_fd_sc_mcu7t5v0__fillcap_4
XTAP_TAPCELL_ROW_77_938 VDD VSS gf180mcu_fd_sc_mcu7t5v0__filltie
XFILLER_59_450 VDD VDD VSS VSS gf180mcu_fd_sc_mcu7t5v0__fillcap_8
XFILLER_34_317 VDD VDD VSS VSS gf180mcu_fd_sc_mcu7t5v0__fillcap_16
XFILLER_34_339 VDD VDD VSS VSS gf180mcu_fd_sc_mcu7t5v0__fill_1
XFILLER_46_177 VDD VDD VSS VSS gf180mcu_fd_sc_mcu7t5v0__fillcap_16
XFILLER_46_199 VDD VDD VSS VSS gf180mcu_fd_sc_mcu7t5v0__fillcap_8
XFILLER_61_136 VDD VDD VSS VSS gf180mcu_fd_sc_mcu7t5v0__fillcap_4
XTAP_TAPCELL_ROW_32_507 VDD VSS gf180mcu_fd_sc_mcu7t5v0__filltie
XFILLER_42_361 VDD VDD VSS VSS gf180mcu_fd_sc_mcu7t5v0__fillcap_16
XTAP_TAPCELL_ROW_40_584 VDD VSS gf180mcu_fd_sc_mcu7t5v0__filltie
XFILLER_6_273 VDD VDD VSS VSS gf180mcu_fd_sc_mcu7t5v0__fill_1
X_3450_ _3450_/A1 _3055_/I _3450_/Z VDD VDD VSS VSS gf180mcu_fd_sc_mcu7t5v0__xor2_2
X_2401_ _3101_/B2 wire362/I _2400_/Z _2401_/B2 _3742_/D VDD VDD VSS VSS gf180mcu_fd_sc_mcu7t5v0__oai22_1
X_3381_ _3381_/I _3383_/B1 VDD VDD VSS VSS gf180mcu_fd_sc_mcu7t5v0__clkinv_1
X_2332_ _2984_/I _2414_/A2 _2333_/A2 VDD VDD VSS VSS gf180mcu_fd_sc_mcu7t5v0__nor2_1
Xload_slew600 _3677_/RN _3719_/RN VDD VDD VSS VSS gf180mcu_fd_sc_mcu7t5v0__clkbuf_1
Xload_slew611 wire612/Z _3712_/RN VDD VDD VSS VSS gf180mcu_fd_sc_mcu7t5v0__clkbuf_2
Xload_slew633 _2691_/B _3006_/I VDD VDD VSS VSS gf180mcu_fd_sc_mcu7t5v0__buf_2
XFILLER_27_2 VDD VDD VSS VSS gf180mcu_fd_sc_mcu7t5v0__fillcap_64
X_2263_ _2263_/A1 wire319/Z _2806_/A1 _2264_/A2 VDD VDD VSS VSS gf180mcu_fd_sc_mcu7t5v0__nand3_1
X_2194_ _3118_/A2 _2194_/A2 _2194_/B1 _3119_/A2 _2198_/B VDD VDD VSS VSS gf180mcu_fd_sc_mcu7t5v0__aoi22_1
XFILLER_80_401 VDD VDD VSS VSS gf180mcu_fd_sc_mcu7t5v0__fillcap_16
XFILLER_1_72 VDD VDD VSS VSS gf180mcu_fd_sc_mcu7t5v0__fillcap_64
XFILLER_38_667 VDD VDD VSS VSS gf180mcu_fd_sc_mcu7t5v0__fill_2
XTAP_TAPCELL_ROW_48_662 VDD VSS gf180mcu_fd_sc_mcu7t5v0__filltie
XFILLER_65_464 VDD VDD VSS VSS gf180mcu_fd_sc_mcu7t5v0__fillcap_4
XFILLER_80_489 VDD VDD VSS VSS gf180mcu_fd_sc_mcu7t5v0__fill_1
XFILLER_21_545 VDD VDD VSS VSS gf180mcu_fd_sc_mcu7t5v0__fill_1
X_3717_ _3717_/D _3717_/RN _3717_/CLK _3717_/Q VDD VDD VSS VSS gf180mcu_fd_sc_mcu7t5v0__dffrnq_2
X_1978_ wire640/Z _1977_/Z _1992_/B VDD VDD VSS VSS gf180mcu_fd_sc_mcu7t5v0__nor2_1
XFILLER_20_37 VDD VDD VSS VSS gf180mcu_fd_sc_mcu7t5v0__fillcap_64
X_3648_ _3648_/A1 _3648_/A2 _3648_/B _3649_/A2 VDD VDD VSS VSS gf180mcu_fd_sc_mcu7t5v0__oai21_1
X_3579_ _3606_/A1 _3592_/A2 _3579_/Z VDD VDD VSS VSS gf180mcu_fd_sc_mcu7t5v0__xor2_2
XTAP_TAPCELL_ROW_93_1093 VDD VSS gf180mcu_fd_sc_mcu7t5v0__filltie
XFILLER_0_416 VDD VDD VSS VSS gf180mcu_fd_sc_mcu7t5v0__fill_1
XFILLER_75_206 VDD VDD VSS VSS gf180mcu_fd_sc_mcu7t5v0__fillcap_4
XTAP_TAPCELL_ROW_3_232 VDD VSS gf180mcu_fd_sc_mcu7t5v0__filltie
XFILLER_68_291 VDD VDD VSS VSS gf180mcu_fd_sc_mcu7t5v0__fillcap_16
XTAP_TAPCELL_ROW_74_908 VDD VSS gf180mcu_fd_sc_mcu7t5v0__filltie
XFILLER_28_177 VDD VDD VSS VSS gf180mcu_fd_sc_mcu7t5v0__fillcap_16
XFILLER_71_434 VDD VDD VSS VSS gf180mcu_fd_sc_mcu7t5v0__fill_1
XFILLER_43_147 VDD VDD VSS VSS gf180mcu_fd_sc_mcu7t5v0__fillcap_4
XTAP_TAPCELL_ROW_82_985 VDD VSS gf180mcu_fd_sc_mcu7t5v0__filltie
XFILLER_71_478 VDD VDD VSS VSS gf180mcu_fd_sc_mcu7t5v0__fillcap_8
XFILLER_24_383 VDD VDD VSS VSS gf180mcu_fd_sc_mcu7t5v0__fill_2
XFILLER_12_589 VDD VDD VSS VSS gf180mcu_fd_sc_mcu7t5v0__fillcap_4
XFILLER_12_556 VDD VDD VSS VSS gf180mcu_fd_sc_mcu7t5v0__fillcap_4
XFILLER_8_527 VDD VDD VSS VSS gf180mcu_fd_sc_mcu7t5v0__fillcap_8
XFILLER_61_66 VDD VDD VSS VSS gf180mcu_fd_sc_mcu7t5v0__fillcap_4
XFILLER_79_534 VDD VDD VSS VSS gf180mcu_fd_sc_mcu7t5v0__fill_2
XFILLER_79_556 VDD VDD VSS VSS gf180mcu_fd_sc_mcu7t5v0__fillcap_4
XFILLER_66_217 VDD VDD VSS VSS gf180mcu_fd_sc_mcu7t5v0__fillcap_4
XFILLER_47_464 VDD VDD VSS VSS gf180mcu_fd_sc_mcu7t5v0__fill_2
XTAP_TAPCELL_ROW_45_632 VDD VSS gf180mcu_fd_sc_mcu7t5v0__filltie
XFILLER_62_434 VDD VDD VSS VSS gf180mcu_fd_sc_mcu7t5v0__fill_2
XTAP_TAPCELL_ROW_17_367 VDD VSS gf180mcu_fd_sc_mcu7t5v0__filltie
X_2950_ _3713_/Q wire258/Z _2951_/B VDD VDD VSS VSS gf180mcu_fd_sc_mcu7t5v0__nand2_1
X_2881_ _3757_/Q wire269/I _2883_/B1 VDD VDD VSS VSS gf180mcu_fd_sc_mcu7t5v0__nor2_1
X_1901_ _3718_/Q _3697_/Q _1901_/Z VDD VDD VSS VSS gf180mcu_fd_sc_mcu7t5v0__xor2_1
X_1832_ _1829_/I _1857_/B3 _1846_/A1 VDD VDD VSS VSS gf180mcu_fd_sc_mcu7t5v0__nor2_1
XFILLER_30_342 VDD VDD VSS VSS gf180mcu_fd_sc_mcu7t5v0__fillcap_16
X_3502_ _3500_/Z _3504_/A3 _3502_/Z VDD VDD VSS VSS gf180mcu_fd_sc_mcu7t5v0__xor2_1
X_3433_ _3696_/Q _3433_/A2 _3456_/A2 VDD VDD VSS VSS gf180mcu_fd_sc_mcu7t5v0__nand2_1
X_3364_ _3669_/Q _3365_/A2 _3382_/A1 VDD VDD VSS VSS gf180mcu_fd_sc_mcu7t5v0__nor2_1
Xload_slew463 wire462/I _2504_/A1 VDD VDD VSS VSS gf180mcu_fd_sc_mcu7t5v0__buf_2
Xload_slew441 _3755_/Q _2974_/I VDD VDD VSS VSS gf180mcu_fd_sc_mcu7t5v0__buf_2
X_2315_ _3745_/Q _3012_/I _2315_/Z VDD VDD VSS VSS gf180mcu_fd_sc_mcu7t5v0__xor2_1
X_3295_ _3768_/Q _3295_/A2 _3295_/Z VDD VDD VSS VSS gf180mcu_fd_sc_mcu7t5v0__xor2_1
Xload_slew474 _2393_/A1 _2749_/A1 VDD VDD VSS VSS gf180mcu_fd_sc_mcu7t5v0__clkbuf_2
XFILLER_38_431 VDD VDD VSS VSS gf180mcu_fd_sc_mcu7t5v0__fill_1
X_2246_ _2246_/A1 _2216_/Z _2246_/B _2756_/A1 VDD VDD VSS VSS gf180mcu_fd_sc_mcu7t5v0__oai21_4
Xload_slew485 _3717_/Q _3170_/A2 VDD VDD VSS VSS gf180mcu_fd_sc_mcu7t5v0__buf_2
XTAP_TAPCELL_ROW_0_202 VDD VSS gf180mcu_fd_sc_mcu7t5v0__filltie
XTAP_TAPCELL_ROW_84_1004 VDD VSS gf180mcu_fd_sc_mcu7t5v0__filltie
X_2177_ _2177_/A1 _2177_/A2 _2185_/A2 wire462/Z _2177_/C _2188_/A1 VDD VDD VSS VSS
+ gf180mcu_fd_sc_mcu7t5v0__aoi221_2
XFILLER_25_136 VDD VDD VSS VSS gf180mcu_fd_sc_mcu7t5v0__fillcap_4
XTAP_TAPCELL_ROW_95_1111 VDD VSS gf180mcu_fd_sc_mcu7t5v0__filltie
XFILLER_5_508 VDD VDD VSS VSS gf180mcu_fd_sc_mcu7t5v0__fillcap_8
XFILLER_29_442 VDD VDD VSS VSS gf180mcu_fd_sc_mcu7t5v0__fillcap_8
XTAP_TAPCELL_ROW_59_768 VDD VSS gf180mcu_fd_sc_mcu7t5v0__filltie
XTAP_TAPCELL_ROW_42_602 VDD VSS gf180mcu_fd_sc_mcu7t5v0__filltie
XTAP_TAPCELL_ROW_14_337 VDD VSS gf180mcu_fd_sc_mcu7t5v0__filltie
XFILLER_31_139 VDD VDD VSS VSS gf180mcu_fd_sc_mcu7t5v0__fill_1
XFILLER_8_302 VDD VDD VSS VSS gf180mcu_fd_sc_mcu7t5v0__fillcap_8
XFILLER_40_662 VDD VDD VSS VSS gf180mcu_fd_sc_mcu7t5v0__fill_2
XFILLER_79_320 VDD VDD VSS VSS gf180mcu_fd_sc_mcu7t5v0__fill_1
X_2100_ _2096_/Z _2112_/B2 _2100_/Z VDD VDD VSS VSS gf180mcu_fd_sc_mcu7t5v0__xor2_1
X_3080_ _3080_/I _3080_/ZN VDD VDD VSS VSS gf180mcu_fd_sc_mcu7t5v0__clkinv_1
X_2031_ _3066_/I _2053_/A2 _2031_/Z VDD VDD VSS VSS gf180mcu_fd_sc_mcu7t5v0__and2_1
XFILLER_82_529 VDD VDD VSS VSS gf180mcu_fd_sc_mcu7t5v0__fill_1
XFILLER_75_570 VDD VDD VSS VSS gf180mcu_fd_sc_mcu7t5v0__fill_2
XFILLER_23_629 VDD VDD VSS VSS gf180mcu_fd_sc_mcu7t5v0__fill_1
XFILLER_35_467 VDD VDD VSS VSS gf180mcu_fd_sc_mcu7t5v0__fillcap_8
XFILLER_94_2 VDD VDD VSS VSS gf180mcu_fd_sc_mcu7t5v0__fillcap_32
XFILLER_50_426 VDD VDD VSS VSS gf180mcu_fd_sc_mcu7t5v0__fillcap_4
X_2933_ _2933_/A1 _2939_/A2 _2933_/B _3704_/D VDD VDD VSS VSS gf180mcu_fd_sc_mcu7t5v0__oai21_1
X_2864_ _3678_/Q wire231/I _2867_/B _2865_/B2 VDD VDD VSS VSS gf180mcu_fd_sc_mcu7t5v0__oai21_1
X_2795_ _3736_/Q _2795_/A2 _2825_/B1 _2795_/B2 _2795_/C _2799_/B1 VDD VDD VSS VSS
+ gf180mcu_fd_sc_mcu7t5v0__aoi221_1
X_1815_ _2117_/B _1813_/Z _1815_/ZN VDD VDD VSS VSS gf180mcu_fd_sc_mcu7t5v0__xnor2_1
X_3416_ _3456_/A1 _3435_/B _3435_/A1 VDD VDD VSS VSS gf180mcu_fd_sc_mcu7t5v0__nor2_1
XTAP_TAPCELL_ROW_90_1063 VDD VSS gf180mcu_fd_sc_mcu7t5v0__filltie
X_3347_ _3773_/Q _3348_/A2 _2115_/B VDD VDD VSS VSS gf180mcu_fd_sc_mcu7t5v0__nand2_1
Xload_slew260 _2963_/A1 _2959_/A1 VDD VDD VSS VSS gf180mcu_fd_sc_mcu7t5v0__buf_2
Xload_slew271 _2827_/A1 _2831_/A2 VDD VDD VSS VSS gf180mcu_fd_sc_mcu7t5v0__buf_4
Xload_slew293 _2051_/A1 _2060_/B VDD VDD VSS VSS gf180mcu_fd_sc_mcu7t5v0__buf_1
X_3278_ _3314_/A1 _3278_/A2 _3767_/Q _3280_/A2 VDD VDD VSS VSS gf180mcu_fd_sc_mcu7t5v0__aoi21_1
XFILLER_45_209 VDD VDD VSS VSS gf180mcu_fd_sc_mcu7t5v0__fill_1
X_2229_ _2236_/C _2227_/Z _2228_/Z _2229_/Z VDD VDD VSS VSS gf180mcu_fd_sc_mcu7t5v0__or3_1
XTAP_TAPCELL_ROW_56_738 VDD VSS gf180mcu_fd_sc_mcu7t5v0__filltie
XFILLER_76_367 VDD VDD VSS VSS gf180mcu_fd_sc_mcu7t5v0__fillcap_4
XFILLER_29_250 VDD VDD VSS VSS gf180mcu_fd_sc_mcu7t5v0__fill_1
XFILLER_64_518 VDD VDD VSS VSS gf180mcu_fd_sc_mcu7t5v0__fill_1
XFILLER_17_456 VDD VDD VSS VSS gf180mcu_fd_sc_mcu7t5v0__fill_1
XTAP_TAPCELL_ROW_27_462 VDD VSS gf180mcu_fd_sc_mcu7t5v0__filltie
XFILLER_72_573 VDD VDD VSS VSS gf180mcu_fd_sc_mcu7t5v0__fill_2
XFILLER_9_622 VDD VDD VSS VSS gf180mcu_fd_sc_mcu7t5v0__fillcap_8
X_2580_ input14/Z _2565_/Z _2580_/B _2582_/B1 VDD VDD VSS VSS gf180mcu_fd_sc_mcu7t5v0__oai21_1
X_3201_ _2051_/B _3205_/A2 _3207_/A1 VDD VDD VSS VSS gf180mcu_fd_sc_mcu7t5v0__nand2_1
XFILLER_95_632 VDD VDD VSS VSS gf180mcu_fd_sc_mcu7t5v0__fillcap_32
X_3132_ input28/Z _2734_/C _2969_/I _2442_/B _3132_/C _3133_/A2 VDD VDD VSS VSS gf180mcu_fd_sc_mcu7t5v0__aoi221_1
XFILLER_95_676 VDD VDD VSS VSS gf180mcu_fd_sc_mcu7t5v0__fill_1
XFILLER_27_209 VDD VDD VSS VSS gf180mcu_fd_sc_mcu7t5v0__fill_1
X_3063_ _3063_/I _3520_/A2 VDD VDD VSS VSS gf180mcu_fd_sc_mcu7t5v0__clkinv_1
X_2014_ _2014_/A1 _2014_/A2 _2014_/B _2028_/A2 VDD VDD VSS VSS gf180mcu_fd_sc_mcu7t5v0__aoi21_1
XTAP_TAPCELL_ROW_53_708 VDD VSS gf180mcu_fd_sc_mcu7t5v0__filltie
XFILLER_63_562 VDD VDD VSS VSS gf180mcu_fd_sc_mcu7t5v0__fill_2
XFILLER_90_381 VDD VDD VSS VSS gf180mcu_fd_sc_mcu7t5v0__fillcap_4
XFILLER_31_470 VDD VDD VSS VSS gf180mcu_fd_sc_mcu7t5v0__fillcap_16
X_2916_ wire249/Z _2959_/A2 _2916_/B _3696_/D VDD VDD VSS VSS gf180mcu_fd_sc_mcu7t5v0__oai21_1
XTAP_TAPCELL_ROW_61_785 VDD VSS gf180mcu_fd_sc_mcu7t5v0__filltie
XFILLER_31_492 VDD VDD VSS VSS gf180mcu_fd_sc_mcu7t5v0__fill_2
X_2847_ _3385_/A2 _2850_/A2 _2847_/B1 _2847_/B2 _3672_/D VDD VDD VSS VSS gf180mcu_fd_sc_mcu7t5v0__oai22_1
X_2778_ _2798_/A1 _2778_/A2 _2779_/B2 VDD VDD VSS VSS gf180mcu_fd_sc_mcu7t5v0__nand2_1
Xfanout601 wire617/Z wire604/I VDD VDD VSS VSS gf180mcu_fd_sc_mcu7t5v0__dlyb_1
XFILLER_58_312 VDD VDD VSS VSS gf180mcu_fd_sc_mcu7t5v0__fill_2
XFILLER_85_142 VDD VDD VSS VSS gf180mcu_fd_sc_mcu7t5v0__fillcap_64
XTAP_TAPCELL_ROW_69_863 VDD VSS gf180mcu_fd_sc_mcu7t5v0__filltie
XFILLER_18_209 VDD VDD VSS VSS gf180mcu_fd_sc_mcu7t5v0__fillcap_16
XFILLER_73_348 VDD VDD VSS VSS gf180mcu_fd_sc_mcu7t5v0__fill_2
XFILLER_81_381 VDD VDD VSS VSS gf180mcu_fd_sc_mcu7t5v0__fill_2
XTAP_TAPCELL_ROW_24_432 VDD VSS gf180mcu_fd_sc_mcu7t5v0__filltie
XFILLER_1_352 VDD VDD VSS VSS gf180mcu_fd_sc_mcu7t5v0__fillcap_64
XFILLER_89_492 VDD VDD VSS VSS gf180mcu_fd_sc_mcu7t5v0__fillcap_4
XFILLER_64_326 VDD VDD VSS VSS gf180mcu_fd_sc_mcu7t5v0__fillcap_16
X_3750_ _3750_/D _3751_/RN clkload7/I _3750_/Q VDD VDD VSS VSS gf180mcu_fd_sc_mcu7t5v0__dffrnq_1
XFILLER_9_430 VDD VDD VSS VSS gf180mcu_fd_sc_mcu7t5v0__fillcap_4
X_2701_ _3437_/A1 _2700_/Z _2713_/B VDD VDD VSS VSS gf180mcu_fd_sc_mcu7t5v0__nor2_1
X_3681_ _3681_/D _3684_/RN clkload5/I _3681_/Q VDD VDD VSS VSS gf180mcu_fd_sc_mcu7t5v0__dffrnq_2
X_2632_ _3104_/B2 input54/Z _2633_/B VDD VDD VSS VSS gf180mcu_fd_sc_mcu7t5v0__xor2_1
X_2563_ _3107_/A2 input78/Z wire305/Z _2563_/Z VDD VDD VSS VSS gf180mcu_fd_sc_mcu7t5v0__xor3_1
Xoutput204 _3696_/Q raw_edge2[7] VDD VDD VSS VSS gf180mcu_fd_sc_mcu7t5v0__buf_2
XFILLER_57_2 VDD VDD VSS VSS gf180mcu_fd_sc_mcu7t5v0__fillcap_64
Xoutput226 _3169_/A2 raw_edge3[8] VDD VDD VSS VSS gf180mcu_fd_sc_mcu7t5v0__buf_2
Xoutput215 _3036_/I raw_edge3[17] VDD VDD VSS VSS gf180mcu_fd_sc_mcu7t5v0__buf_2
XFILLER_87_418 VDD VDD VSS VSS gf180mcu_fd_sc_mcu7t5v0__fill_2
X_2494_ _2494_/A1 _2576_/A1 _2494_/B _2573_/A2 VDD VDD VSS VSS gf180mcu_fd_sc_mcu7t5v0__aoi21_1
XFILLER_67_142 VDD VDD VSS VSS gf180mcu_fd_sc_mcu7t5v0__fillcap_64
XFILLER_82_101 VDD VDD VSS VSS gf180mcu_fd_sc_mcu7t5v0__fillcap_4
X_3115_ input25/Z _3117_/A2 input24/Z _3118_/A2 _3118_/B VDD VDD VSS VSS gf180mcu_fd_sc_mcu7t5v0__oai22_1
XFILLER_55_348 VDD VDD VSS VSS gf180mcu_fd_sc_mcu7t5v0__fill_2
XTAP_TAPCELL_ROW_66_833 VDD VSS gf180mcu_fd_sc_mcu7t5v0__filltie
X_3046_ _3046_/I _3386_/A1 VDD VDD VSS VSS gf180mcu_fd_sc_mcu7t5v0__clkinv_1
XTAP_TAPCELL_ROW_38_568 VDD VSS gf180mcu_fd_sc_mcu7t5v0__filltie
XFILLER_23_212 VDD VDD VSS VSS gf180mcu_fd_sc_mcu7t5v0__fillcap_16
XFILLER_11_418 VDD VDD VSS VSS gf180mcu_fd_sc_mcu7t5v0__fill_2
Xfanout420 _3759_/Q wire422/I VDD VDD VSS VSS gf180mcu_fd_sc_mcu7t5v0__dlyb_1
XFILLER_48_34 VDD VDD VSS VSS gf180mcu_fd_sc_mcu7t5v0__fill_1
XFILLER_59_632 VDD VDD VSS VSS gf180mcu_fd_sc_mcu7t5v0__fill_1
Xfanout442 _3754_/Q _3124_/A2 VDD VDD VSS VSS gf180mcu_fd_sc_mcu7t5v0__dlyb_1
XFILLER_86_473 VDD VDD VSS VSS gf180mcu_fd_sc_mcu7t5v0__fillcap_4
XFILLER_46_326 VDD VDD VSS VSS gf180mcu_fd_sc_mcu7t5v0__fillcap_8
XFILLER_27_562 VDD VDD VSS VSS gf180mcu_fd_sc_mcu7t5v0__fill_1
XFILLER_42_554 VDD VDD VSS VSS gf180mcu_fd_sc_mcu7t5v0__fillcap_8
XTAP_TAPCELL_ROW_9_293 VDD VSS gf180mcu_fd_sc_mcu7t5v0__filltie
XFILLER_2_661 VDD VDD VSS VSS gf180mcu_fd_sc_mcu7t5v0__fillcap_4
XFILLER_96_259 VDD VDD VSS VSS gf180mcu_fd_sc_mcu7t5v0__fillcap_8
XFILLER_96_248 VDD VDD VSS VSS gf180mcu_fd_sc_mcu7t5v0__fill_2
XFILLER_49_120 VDD VDD VSS VSS gf180mcu_fd_sc_mcu7t5v0__fillcap_8
XFILLER_49_142 VDD VDD VSS VSS gf180mcu_fd_sc_mcu7t5v0__fillcap_8
XFILLER_64_101 VDD VDD VSS VSS gf180mcu_fd_sc_mcu7t5v0__fillcap_4
XFILLER_65_657 VDD VDD VSS VSS gf180mcu_fd_sc_mcu7t5v0__fill_1
XTAP_TAPCELL_ROW_63_803 VDD VSS gf180mcu_fd_sc_mcu7t5v0__filltie
XFILLER_33_510 VDD VDD VSS VSS gf180mcu_fd_sc_mcu7t5v0__fill_1
XTAP_TAPCELL_ROW_35_538 VDD VSS gf180mcu_fd_sc_mcu7t5v0__filltie
XFILLER_45_370 VDD VDD VSS VSS gf180mcu_fd_sc_mcu7t5v0__fillcap_4
X_1994_ _1991_/Z _1994_/A2 _1995_/I VDD VDD VSS VSS gf180mcu_fd_sc_mcu7t5v0__xnor2_1
XFILLER_20_237 VDD VDD VSS VSS gf180mcu_fd_sc_mcu7t5v0__fill_1
XFILLER_60_384 VDD VDD VSS VSS gf180mcu_fd_sc_mcu7t5v0__fill_1
XTAP_TAPCELL_ROW_71_880 VDD VSS gf180mcu_fd_sc_mcu7t5v0__filltie
X_3733_ _3733_/D wire559/Z clkload2/I _3733_/Q VDD VDD VSS VSS gf180mcu_fd_sc_mcu7t5v0__dffrnq_1
XFILLER_9_282 VDD VDD VSS VSS gf180mcu_fd_sc_mcu7t5v0__fill_2
X_3664_ _3664_/D _3736_/RN clkload2/I _3664_/Q VDD VDD VSS VSS gf180mcu_fd_sc_mcu7t5v0__dffrnq_2
X_2615_ _2148_/C input43/Z _2663_/B VDD VDD VSS VSS gf180mcu_fd_sc_mcu7t5v0__and2_1
X_3595_ _3612_/A1 _3685_/Q _3595_/Z VDD VDD VSS VSS gf180mcu_fd_sc_mcu7t5v0__xor2_1
X_2546_ _2603_/A1 _2603_/A2 _2603_/B _2602_/A2 VDD VDD VSS VSS gf180mcu_fd_sc_mcu7t5v0__nand3_1
X_2477_ wire462/I _3024_/ZN _2512_/A1 VDD VDD VSS VSS gf180mcu_fd_sc_mcu7t5v0__nand2_1
XFILLER_68_473 VDD VDD VSS VSS gf180mcu_fd_sc_mcu7t5v0__fillcap_4
XFILLER_18_37 VDD VDD VSS VSS gf180mcu_fd_sc_mcu7t5v0__fillcap_64
XTAP_TAPCELL_ROW_87_1035 VDD VSS gf180mcu_fd_sc_mcu7t5v0__filltie
X_3029_ _3714_/Q _3148_/A2 VDD VDD VSS VSS gf180mcu_fd_sc_mcu7t5v0__clkinv_1
XFILLER_24_543 VDD VDD VSS VSS gf180mcu_fd_sc_mcu7t5v0__fillcap_4
XFILLER_51_384 VDD VDD VSS VSS gf180mcu_fd_sc_mcu7t5v0__fillcap_8
Xclkload2 clkload2/I clkload2/Z VDD VDD VSS VSS gf180mcu_fd_sc_mcu7t5v0__clkbuf_2
XFILLER_59_66 VDD VDD VSS VSS gf180mcu_fd_sc_mcu7t5v0__fillcap_4
Xfanout250 wire255/I _2743_/A2 VDD VDD VSS VSS gf180mcu_fd_sc_mcu7t5v0__dlyb_1
XTAP_TAPCELL_ROW_77_939 VDD VSS gf180mcu_fd_sc_mcu7t5v0__filltie
XTAP_TAPCELL_ROW_6_263 VDD VSS gf180mcu_fd_sc_mcu7t5v0__filltie
XFILLER_46_101 VDD VDD VSS VSS gf180mcu_fd_sc_mcu7t5v0__fillcap_4
XFILLER_46_145 VDD VDD VSS VSS gf180mcu_fd_sc_mcu7t5v0__fill_1
XFILLER_74_465 VDD VDD VSS VSS gf180mcu_fd_sc_mcu7t5v0__fillcap_4
XTAP_TAPCELL_ROW_32_508 VDD VSS gf180mcu_fd_sc_mcu7t5v0__filltie
XFILLER_30_524 VDD VDD VSS VSS gf180mcu_fd_sc_mcu7t5v0__fill_1
XTAP_TAPCELL_ROW_40_585 VDD VSS gf180mcu_fd_sc_mcu7t5v0__filltie
Xwire640 wire640/I wire640/Z VDD VDD VSS VSS gf180mcu_fd_sc_mcu7t5v0__buf_2
X_2400_ _3101_/B2 wire515/I _2574_/C _2400_/Z VDD VDD VSS VSS gf180mcu_fd_sc_mcu7t5v0__xor3_1
XFILLER_6_263 VDD VDD VSS VSS gf180mcu_fd_sc_mcu7t5v0__fillcap_8
X_3380_ _3382_/A1 _3379_/I _3381_/I VDD VDD VSS VSS gf180mcu_fd_sc_mcu7t5v0__nor2_2
Xload_slew623 _2029_/B _3195_/A1 VDD VDD VSS VSS gf180mcu_fd_sc_mcu7t5v0__clkbuf_1
X_2331_ _2331_/A1 _2412_/A2 _2331_/B _2414_/A3 VDD VDD VSS VSS gf180mcu_fd_sc_mcu7t5v0__aoi21_1
Xload_slew645 _3009_/I _2414_/A2 VDD VDD VSS VSS gf180mcu_fd_sc_mcu7t5v0__clkbuf_2
X_2262_ wire374/Z _2266_/A2 _2262_/Z VDD VDD VSS VSS gf180mcu_fd_sc_mcu7t5v0__and2_1
X_2193_ _2155_/Z _2193_/A2 _2198_/A2 wire448/Z _2193_/C _2199_/A1 VDD VDD VSS VSS
+ gf180mcu_fd_sc_mcu7t5v0__aoi221_1
XFILLER_37_134 VDD VDD VSS VSS gf180mcu_fd_sc_mcu7t5v0__fillcap_4
XFILLER_37_178 VDD VDD VSS VSS gf180mcu_fd_sc_mcu7t5v0__fillcap_8
XTAP_TAPCELL_ROW_48_663 VDD VSS gf180mcu_fd_sc_mcu7t5v0__filltie
XFILLER_18_392 VDD VDD VSS VSS gf180mcu_fd_sc_mcu7t5v0__fillcap_8
XFILLER_21_535 VDD VDD VSS VSS gf180mcu_fd_sc_mcu7t5v0__fillcap_8
X_3716_ _3716_/D _3716_/RN _3717_/CLK _3716_/Q VDD VDD VSS VSS gf180mcu_fd_sc_mcu7t5v0__dffrnq_2
X_1977_ _2004_/C _1977_/A2 _1977_/Z VDD VDD VSS VSS gf180mcu_fd_sc_mcu7t5v0__xor2_1
X_3647_ _3645_/Z _3650_/A2 _3647_/Z VDD VDD VSS VSS gf180mcu_fd_sc_mcu7t5v0__or2_1
X_3578_ _3578_/A1 _3608_/A1 _3592_/A2 VDD VDD VSS VSS gf180mcu_fd_sc_mcu7t5v0__nor2_1
XTAP_TAPCELL_ROW_93_1094 VDD VSS gf180mcu_fd_sc_mcu7t5v0__filltie
X_2529_ _2547_/A2 _2528_/Z _2550_/A2 VDD VDD VSS VSS gf180mcu_fd_sc_mcu7t5v0__nor2_1
XTAP_TAPCELL_ROW_3_233 VDD VSS gf180mcu_fd_sc_mcu7t5v0__filltie
XFILLER_28_101 VDD VDD VSS VSS gf180mcu_fd_sc_mcu7t5v0__fillcap_4
XTAP_TAPCELL_ROW_74_909 VDD VSS gf180mcu_fd_sc_mcu7t5v0__filltie
XFILLER_43_104 VDD VDD VSS VSS gf180mcu_fd_sc_mcu7t5v0__fillcap_8
XFILLER_71_413 VDD VDD VSS VSS gf180mcu_fd_sc_mcu7t5v0__fillcap_4
XTAP_TAPCELL_ROW_82_986 VDD VSS gf180mcu_fd_sc_mcu7t5v0__filltie
XFILLER_94_527 VDD VDD VSS VSS gf180mcu_fd_sc_mcu7t5v0__fillcap_64
XFILLER_62_413 VDD VDD VSS VSS gf180mcu_fd_sc_mcu7t5v0__fill_1
XTAP_TAPCELL_ROW_45_633 VDD VSS gf180mcu_fd_sc_mcu7t5v0__filltie
XFILLER_62_457 VDD VDD VSS VSS gf180mcu_fd_sc_mcu7t5v0__fillcap_4
XTAP_TAPCELL_ROW_17_368 VDD VSS gf180mcu_fd_sc_mcu7t5v0__filltie
XFILLER_42_181 VDD VDD VSS VSS gf180mcu_fd_sc_mcu7t5v0__fill_1
X_2880_ _3601_/A1 _2892_/A2 _2880_/B1 _2880_/B2 _3683_/D VDD VDD VSS VSS gf180mcu_fd_sc_mcu7t5v0__oai22_1
X_1900_ _3718_/Q _3450_/A1 _1915_/B VDD VDD VSS VSS gf180mcu_fd_sc_mcu7t5v0__nand2_1
XFILLER_70_490 VDD VDD VSS VSS gf180mcu_fd_sc_mcu7t5v0__fillcap_8
X_1831_ _1830_/B _1831_/A2 _1831_/B1 _1857_/B3 _1831_/ZN VDD VDD VSS VSS gf180mcu_fd_sc_mcu7t5v0__aoi22_1
XFILLER_30_387 VDD VDD VSS VSS gf180mcu_fd_sc_mcu7t5v0__fill_2
Xwire492 _3699_/Q _3058_/I VDD VDD VSS VSS gf180mcu_fd_sc_mcu7t5v0__buf_2
X_3501_ _3483_/Z _3501_/A2 _3501_/B _3504_/A3 VDD VDD VSS VSS gf180mcu_fd_sc_mcu7t5v0__aoi21_1
X_3432_ _3455_/C _3456_/C VDD VDD VSS VSS gf180mcu_fd_sc_mcu7t5v0__clkinv_1
X_3363_ _3420_/A1 _3363_/A2 _3365_/A2 VDD VDD VSS VSS gf180mcu_fd_sc_mcu7t5v0__nor2_1
Xload_slew431 _2468_/A1 _2195_/B VDD VDD VSS VSS gf180mcu_fd_sc_mcu7t5v0__buf_1
X_2314_ _3106_/B1 _3447_/A1 _2329_/B VDD VDD VSS VSS gf180mcu_fd_sc_mcu7t5v0__nor2_1
Xload_slew464 _2984_/I wire462/I VDD VDD VSS VSS gf180mcu_fd_sc_mcu7t5v0__buf_2
X_3294_ _3768_/Q _3295_/A2 _3298_/A1 VDD VDD VSS VSS gf180mcu_fd_sc_mcu7t5v0__nand2_1
Xload_slew453 _3113_/A2 _2422_/A1 VDD VDD VSS VSS gf180mcu_fd_sc_mcu7t5v0__buf_2
X_2245_ _2229_/Z _2245_/A2 _2245_/B _2245_/C _2246_/B VDD VDD VSS VSS gf180mcu_fd_sc_mcu7t5v0__aoi211_2
Xload_slew475 _3740_/Q _3097_/I VDD VDD VSS VSS gf180mcu_fd_sc_mcu7t5v0__clkbuf_1
Xload_slew486 _3708_/Q _2940_/A1 VDD VDD VSS VSS gf180mcu_fd_sc_mcu7t5v0__buf_4
XTAP_TAPCELL_ROW_0_203 VDD VSS gf180mcu_fd_sc_mcu7t5v0__filltie
X_2176_ _2620_/A1 _2176_/A2 _2177_/C VDD VDD VSS VSS gf180mcu_fd_sc_mcu7t5v0__nor2_1
XFILLER_38_465 VDD VDD VSS VSS gf180mcu_fd_sc_mcu7t5v0__fill_1
XTAP_TAPCELL_ROW_84_1005 VDD VSS gf180mcu_fd_sc_mcu7t5v0__filltie
XFILLER_38_476 VDD VDD VSS VSS gf180mcu_fd_sc_mcu7t5v0__fill_1
XFILLER_26_649 VDD VDD VSS VSS gf180mcu_fd_sc_mcu7t5v0__fillcap_4
XFILLER_65_295 VDD VDD VSS VSS gf180mcu_fd_sc_mcu7t5v0__fillcap_4
XFILLER_40_107 VDD VDD VSS VSS gf180mcu_fd_sc_mcu7t5v0__fill_2
XTAP_TAPCELL_ROW_95_1112 VDD VSS gf180mcu_fd_sc_mcu7t5v0__filltie
XPHY_EDGE_ROW_1_Right_1 VDD VSS gf180mcu_fd_sc_mcu7t5v0__endcap
XFILLER_0_203 VDD VDD VSS VSS gf180mcu_fd_sc_mcu7t5v0__fill_1
XFILLER_0_269 VDD VDD VSS VSS gf180mcu_fd_sc_mcu7t5v0__fill_2
XFILLER_76_527 VDD VDD VSS VSS gf180mcu_fd_sc_mcu7t5v0__fillcap_8
XFILLER_29_454 VDD VDD VSS VSS gf180mcu_fd_sc_mcu7t5v0__fill_2
XFILLER_56_34 VDD VDD VSS VSS gf180mcu_fd_sc_mcu7t5v0__fill_1
XTAP_TAPCELL_ROW_59_769 VDD VSS gf180mcu_fd_sc_mcu7t5v0__filltie
XTAP_TAPCELL_ROW_42_603 VDD VSS gf180mcu_fd_sc_mcu7t5v0__filltie
XTAP_TAPCELL_ROW_14_338 VDD VSS gf180mcu_fd_sc_mcu7t5v0__filltie
XFILLER_12_332 VDD VDD VSS VSS gf180mcu_fd_sc_mcu7t5v0__fillcap_16
XFILLER_8_314 VDD VDD VSS VSS gf180mcu_fd_sc_mcu7t5v0__fill_1
XTAP_TAPCELL_ROW_50_680 VDD VSS gf180mcu_fd_sc_mcu7t5v0__filltie
XFILLER_4_575 VDD VDD VSS VSS gf180mcu_fd_sc_mcu7t5v0__fillcap_8
XFILLER_4_597 VDD VDD VSS VSS gf180mcu_fd_sc_mcu7t5v0__fillcap_16
XFILLER_79_365 VDD VDD VSS VSS gf180mcu_fd_sc_mcu7t5v0__fill_1
XFILLER_67_527 VDD VDD VSS VSS gf180mcu_fd_sc_mcu7t5v0__fillcap_4
X_2030_ _2029_/B _2028_/B _2030_/A3 _2053_/A2 VDD VDD VSS VSS gf180mcu_fd_sc_mcu7t5v0__xnor3_1
XFILLER_22_107 VDD VDD VSS VSS gf180mcu_fd_sc_mcu7t5v0__fillcap_64
XFILLER_35_479 VDD VDD VSS VSS gf180mcu_fd_sc_mcu7t5v0__fill_2
XFILLER_50_438 VDD VDD VSS VSS gf180mcu_fd_sc_mcu7t5v0__fill_1
X_2932_ _3704_/Q wire243/I _2933_/B VDD VDD VSS VSS gf180mcu_fd_sc_mcu7t5v0__nand2_1
XFILLER_87_2 VDD VDD VSS VSS gf180mcu_fd_sc_mcu7t5v0__fillcap_64
X_2863_ _3751_/Q wire267/I _2865_/B1 VDD VDD VSS VSS gf180mcu_fd_sc_mcu7t5v0__nor2_1
X_2794_ _2796_/A1 _2797_/A2 _2795_/B2 VDD VDD VSS VSS gf180mcu_fd_sc_mcu7t5v0__nand2_1
X_1814_ _2117_/B _1813_/Z _1830_/B VDD VDD VSS VSS gf180mcu_fd_sc_mcu7t5v0__nor2_1
XFILLER_7_72 VDD VDD VSS VSS gf180mcu_fd_sc_mcu7t5v0__fillcap_64
X_3415_ _3415_/A1 _3674_/Q _3435_/B VDD VDD VSS VSS gf180mcu_fd_sc_mcu7t5v0__nor2_1
XTAP_TAPCELL_ROW_90_1064 VDD VSS gf180mcu_fd_sc_mcu7t5v0__filltie
X_3346_ _2995_/I _3339_/B _3348_/A2 VDD VDD VSS VSS gf180mcu_fd_sc_mcu7t5v0__nand2_1
Xload_slew261 _2965_/A1 _2963_/A1 VDD VDD VSS VSS gf180mcu_fd_sc_mcu7t5v0__clkbuf_1
XFILLER_58_527 VDD VDD VSS VSS gf180mcu_fd_sc_mcu7t5v0__fillcap_8
XFILLER_85_346 VDD VDD VSS VSS gf180mcu_fd_sc_mcu7t5v0__fillcap_4
X_3277_ _3767_/Q _3314_/A1 _3278_/A2 _3280_/B VDD VDD VSS VSS gf180mcu_fd_sc_mcu7t5v0__nand3_1
Xload_slew283 _3585_/A3 _3612_/B2 VDD VDD VSS VSS gf180mcu_fd_sc_mcu7t5v0__clkbuf_2
X_2228_ _3736_/Q _3664_/Q _2228_/Z VDD VDD VSS VSS gf180mcu_fd_sc_mcu7t5v0__xor2_1
XTAP_TAPCELL_ROW_56_739 VDD VSS gf180mcu_fd_sc_mcu7t5v0__filltie
XFILLER_26_37 VDD VDD VSS VSS gf180mcu_fd_sc_mcu7t5v0__fillcap_64
X_2159_ _3101_/B2 _2157_/Z _2159_/B _3100_/C _2164_/A1 VDD VDD VSS VSS gf180mcu_fd_sc_mcu7t5v0__oai211_1
XFILLER_81_574 VDD VDD VSS VSS gf180mcu_fd_sc_mcu7t5v0__fill_1
XFILLER_14_619 VDD VDD VSS VSS gf180mcu_fd_sc_mcu7t5v0__fillcap_4
XFILLER_26_457 VDD VDD VSS VSS gf180mcu_fd_sc_mcu7t5v0__fill_2
XFILLER_53_254 VDD VDD VSS VSS gf180mcu_fd_sc_mcu7t5v0__fillcap_4
XFILLER_41_416 VDD VDD VSS VSS gf180mcu_fd_sc_mcu7t5v0__fillcap_4
XFILLER_41_449 VDD VDD VSS VSS gf180mcu_fd_sc_mcu7t5v0__fill_1
XTAP_TAPCELL_ROW_11_308 VDD VSS gf180mcu_fd_sc_mcu7t5v0__filltie
XFILLER_1_556 VDD VDD VSS VSS gf180mcu_fd_sc_mcu7t5v0__fillcap_4
XFILLER_67_66 VDD VDD VSS VSS gf180mcu_fd_sc_mcu7t5v0__fillcap_4
XFILLER_64_508 VDD VDD VSS VSS gf180mcu_fd_sc_mcu7t5v0__fill_2
XFILLER_29_273 VDD VDD VSS VSS gf180mcu_fd_sc_mcu7t5v0__fillcap_4
XFILLER_17_479 VDD VDD VSS VSS gf180mcu_fd_sc_mcu7t5v0__fillcap_4
XPHY_EDGE_ROW_17_Left_114 VDD VSS gf180mcu_fd_sc_mcu7t5v0__endcap
XTAP_TAPCELL_ROW_27_463 VDD VSS gf180mcu_fd_sc_mcu7t5v0__filltie
XFILLER_8_177 VDD VDD VSS VSS gf180mcu_fd_sc_mcu7t5v0__fillcap_16
XPHY_EDGE_ROW_26_Left_123 VDD VSS gf180mcu_fd_sc_mcu7t5v0__endcap
X_3200_ _3205_/B1 _3205_/B2 _3205_/C _3202_/A3 VDD VDD VSS VSS gf180mcu_fd_sc_mcu7t5v0__oai21_1
X_3131_ _3131_/A1 _3131_/A2 _3132_/C _3131_/A4 _3134_/A1 VDD VDD VSS VSS gf180mcu_fd_sc_mcu7t5v0__nand4_1
X_3062_ _3701_/Q _2006_/B VDD VDD VSS VSS gf180mcu_fd_sc_mcu7t5v0__inv_2
XFILLER_82_349 VDD VDD VSS VSS gf180mcu_fd_sc_mcu7t5v0__fillcap_8
X_2013_ _2045_/B _2013_/A2 _2014_/B VDD VDD VSS VSS gf180mcu_fd_sc_mcu7t5v0__nand2_1
XFILLER_48_582 VDD VDD VSS VSS gf180mcu_fd_sc_mcu7t5v0__fillcap_8
XPHY_EDGE_ROW_35_Left_132 VDD VSS gf180mcu_fd_sc_mcu7t5v0__endcap
XTAP_TAPCELL_ROW_53_709 VDD VSS gf180mcu_fd_sc_mcu7t5v0__filltie
X_2915_ wire466/Z wire544/Z _2959_/A2 VDD VDD VSS VSS gf180mcu_fd_sc_mcu7t5v0__nand2_1
XTAP_TAPCELL_ROW_61_786 VDD VSS gf180mcu_fd_sc_mcu7t5v0__filltie
X_2846_ _3672_/Q wire231/Z _2861_/B _2847_/B2 VDD VDD VSS VSS gf180mcu_fd_sc_mcu7t5v0__oai21_1
X_2777_ _2831_/A2 _2777_/A2 _2777_/A3 _2778_/A2 VDD VDD VSS VSS gf180mcu_fd_sc_mcu7t5v0__nand3_1
XPHY_EDGE_ROW_44_Left_141 VDD VSS gf180mcu_fd_sc_mcu7t5v0__endcap
X_3329_ _3330_/A1 _3330_/A2 _3770_/D VDD VDD VSS VSS gf180mcu_fd_sc_mcu7t5v0__xor2_1
XTAP_TAPCELL_ROW_69_864 VDD VSS gf180mcu_fd_sc_mcu7t5v0__filltie
XFILLER_73_316 VDD VDD VSS VSS gf180mcu_fd_sc_mcu7t5v0__fill_1
XPHY_EDGE_ROW_53_Left_150 VDD VSS gf180mcu_fd_sc_mcu7t5v0__endcap
XFILLER_26_232 VDD VDD VSS VSS gf180mcu_fd_sc_mcu7t5v0__fillcap_4
XFILLER_54_563 VDD VDD VSS VSS gf180mcu_fd_sc_mcu7t5v0__fill_1
XFILLER_81_360 VDD VDD VSS VSS gf180mcu_fd_sc_mcu7t5v0__fill_1
XTAP_TAPCELL_ROW_24_433 VDD VSS gf180mcu_fd_sc_mcu7t5v0__filltie
XFILLER_5_136 VDD VDD VSS VSS gf180mcu_fd_sc_mcu7t5v0__fillcap_4
XFILLER_37_508 VDD VDD VSS VSS gf180mcu_fd_sc_mcu7t5v0__fillcap_4
XFILLER_45_585 VDD VDD VSS VSS gf180mcu_fd_sc_mcu7t5v0__fill_1
XFILLER_17_298 VDD VDD VSS VSS gf180mcu_fd_sc_mcu7t5v0__fillcap_8
XFILLER_60_588 VDD VDD VSS VSS gf180mcu_fd_sc_mcu7t5v0__fill_1
XFILLER_60_599 VDD VDD VSS VSS gf180mcu_fd_sc_mcu7t5v0__fill_1
X_2700_ _2700_/A1 _2636_/B _2700_/Z VDD VDD VSS VSS gf180mcu_fd_sc_mcu7t5v0__xor2_1
X_3680_ _3680_/D wire597/Z _3721_/CLK _3680_/Q VDD VDD VSS VSS gf180mcu_fd_sc_mcu7t5v0__dffrnq_2
X_2631_ _2631_/A1 _2706_/B _2631_/B _2702_/A2 VDD VDD VSS VSS gf180mcu_fd_sc_mcu7t5v0__aoi21_1
X_2562_ wire462/I _3024_/ZN _2562_/A3 _2562_/Z VDD VDD VSS VSS gf180mcu_fd_sc_mcu7t5v0__xor3_1
Xoutput205 _3697_/Q raw_edge2[8] VDD VDD VSS VSS gf180mcu_fd_sc_mcu7t5v0__buf_2
Xoutput216 _3728_/Q raw_edge3[18] VDD VDD VSS VSS gf180mcu_fd_sc_mcu7t5v0__buf_2
Xoutput227 wire483/Z raw_edge3[9] VDD VDD VSS VSS gf180mcu_fd_sc_mcu7t5v0__buf_2
X_2493_ _2493_/I _2494_/B VDD VDD VSS VSS gf180mcu_fd_sc_mcu7t5v0__clkinv_1
X_3114_ _3112_/B _3114_/I1 _3114_/S _3114_/Z VDD VDD VSS VSS gf180mcu_fd_sc_mcu7t5v0__mux2_2
XFILLER_55_316 VDD VDD VSS VSS gf180mcu_fd_sc_mcu7t5v0__fillcap_4
X_3045_ _3671_/Q _3406_/A1 VDD VDD VSS VSS gf180mcu_fd_sc_mcu7t5v0__clkinv_1
XTAP_TAPCELL_ROW_66_834 VDD VSS gf180mcu_fd_sc_mcu7t5v0__filltie
XTAP_TAPCELL_ROW_38_569 VDD VSS gf180mcu_fd_sc_mcu7t5v0__filltie
XTAP_TAPCELL_ROW_21_403 VDD VSS gf180mcu_fd_sc_mcu7t5v0__filltie
X_2829_ _3096_/ZN _2829_/A2 _2829_/B1 _2829_/B2 _3667_/D VDD VDD VSS VSS gf180mcu_fd_sc_mcu7t5v0__oai22_1
XFILLER_46_338 VDD VDD VSS VSS gf180mcu_fd_sc_mcu7t5v0__fill_1
XFILLER_39_390 VDD VDD VSS VSS gf180mcu_fd_sc_mcu7t5v0__fillcap_8
XFILLER_64_34 VDD VDD VSS VSS gf180mcu_fd_sc_mcu7t5v0__fill_1
XFILLER_10_452 VDD VDD VSS VSS gf180mcu_fd_sc_mcu7t5v0__fill_2
XFILLER_10_441 VDD VDD VSS VSS gf180mcu_fd_sc_mcu7t5v0__fill_1
XFILLER_6_467 VDD VDD VSS VSS gf180mcu_fd_sc_mcu7t5v0__fill_1
XTAP_TAPCELL_ROW_9_294 VDD VSS gf180mcu_fd_sc_mcu7t5v0__filltie
XFILLER_69_419 VDD VDD VSS VSS gf180mcu_fd_sc_mcu7t5v0__fill_1
XFILLER_77_430 VDD VDD VSS VSS gf180mcu_fd_sc_mcu7t5v0__fill_2
XFILLER_49_132 VDD VDD VSS VSS gf180mcu_fd_sc_mcu7t5v0__fill_1
XFILLER_49_154 VDD VDD VSS VSS gf180mcu_fd_sc_mcu7t5v0__fill_2
XFILLER_65_625 VDD VDD VSS VSS gf180mcu_fd_sc_mcu7t5v0__fill_1
XTAP_TAPCELL_ROW_63_804 VDD VSS gf180mcu_fd_sc_mcu7t5v0__filltie
XFILLER_64_179 VDD VDD VSS VSS gf180mcu_fd_sc_mcu7t5v0__fill_1
XTAP_TAPCELL_ROW_35_539 VDD VSS gf180mcu_fd_sc_mcu7t5v0__filltie
XFILLER_60_374 VDD VDD VSS VSS gf180mcu_fd_sc_mcu7t5v0__fillcap_8
X_1993_ _1991_/Z _1994_/A2 _2023_/B VDD VDD VSS VSS gf180mcu_fd_sc_mcu7t5v0__nor2_1
XTAP_TAPCELL_ROW_71_881 VDD VSS gf180mcu_fd_sc_mcu7t5v0__filltie
X_3732_ _3732_/D _3735_/RN _3739_/CLK _3732_/Q VDD VDD VSS VSS gf180mcu_fd_sc_mcu7t5v0__dffrnq_1
X_3663_ _3663_/D wire559/Z clkload2/I _3663_/Q VDD VDD VSS VSS gf180mcu_fd_sc_mcu7t5v0__dffrnq_2
X_2614_ _3119_/A2 input44/Z _2682_/A2 VDD VDD VSS VSS gf180mcu_fd_sc_mcu7t5v0__nor2_2
X_3594_ _3612_/A1 _3612_/A2 _3629_/A1 VDD VDD VSS VSS gf180mcu_fd_sc_mcu7t5v0__nor2_2
X_2545_ _2545_/A1 _2538_/Z _2545_/A3 _2545_/B _2602_/A1 VDD VDD VSS VSS gf180mcu_fd_sc_mcu7t5v0__oai31_1
X_2476_ wire358/Z _3023_/I _2560_/A1 VDD VDD VSS VSS gf180mcu_fd_sc_mcu7t5v0__nand2_1
XFILLER_28_305 VDD VDD VSS VSS gf180mcu_fd_sc_mcu7t5v0__fillcap_8
XFILLER_95_282 VDD VDD VSS VSS gf180mcu_fd_sc_mcu7t5v0__fillcap_64
XFILLER_83_411 VDD VDD VSS VSS gf180mcu_fd_sc_mcu7t5v0__fill_2
XTAP_TAPCELL_ROW_87_1036 VDD VSS gf180mcu_fd_sc_mcu7t5v0__filltie
XFILLER_28_349 VDD VDD VSS VSS gf180mcu_fd_sc_mcu7t5v0__fillcap_16
XFILLER_55_146 VDD VDD VSS VSS gf180mcu_fd_sc_mcu7t5v0__fill_2
X_3028_ _3713_/Q _3028_/ZN VDD VDD VSS VSS gf180mcu_fd_sc_mcu7t5v0__clkinv_1
XFILLER_24_522 VDD VDD VSS VSS gf180mcu_fd_sc_mcu7t5v0__fill_2
XFILLER_34_37 VDD VDD VSS VSS gf180mcu_fd_sc_mcu7t5v0__fillcap_64
XFILLER_36_393 VDD VDD VSS VSS gf180mcu_fd_sc_mcu7t5v0__fillcap_4
XFILLER_36_382 VDD VDD VSS VSS gf180mcu_fd_sc_mcu7t5v0__fill_2
XFILLER_51_352 VDD VDD VSS VSS gf180mcu_fd_sc_mcu7t5v0__fillcap_32
XFILLER_11_216 VDD VDD VSS VSS gf180mcu_fd_sc_mcu7t5v0__fill_2
Xclkload3 clkload3/I clkload3/Z VDD VDD VSS VSS gf180mcu_fd_sc_mcu7t5v0__clkbuf_2
XFILLER_19_305 VDD VDD VSS VSS gf180mcu_fd_sc_mcu7t5v0__fillcap_4
XTAP_TAPCELL_ROW_6_264 VDD VSS gf180mcu_fd_sc_mcu7t5v0__filltie
Xfanout273 _2262_/Z wire275/I VDD VDD VSS VSS gf180mcu_fd_sc_mcu7t5v0__dlyb_1
Xfanout262 _2271_/ZN wire264/I VDD VDD VSS VSS gf180mcu_fd_sc_mcu7t5v0__dlyb_1
XFILLER_75_66 VDD VDD VSS VSS gf180mcu_fd_sc_mcu7t5v0__fillcap_4
XFILLER_19_349 VDD VDD VSS VSS gf180mcu_fd_sc_mcu7t5v0__fill_1
XFILLER_27_360 VDD VDD VSS VSS gf180mcu_fd_sc_mcu7t5v0__fillcap_16
XFILLER_74_499 VDD VDD VSS VSS gf180mcu_fd_sc_mcu7t5v0__fill_1
XTAP_TAPCELL_ROW_32_509 VDD VSS gf180mcu_fd_sc_mcu7t5v0__filltie
XFILLER_10_260 VDD VDD VSS VSS gf180mcu_fd_sc_mcu7t5v0__fillcap_8
Xwire630 wire630/I wire630/Z VDD VDD VSS VSS gf180mcu_fd_sc_mcu7t5v0__clkbuf_2
XTAP_TAPCELL_ROW_40_586 VDD VSS gf180mcu_fd_sc_mcu7t5v0__filltie
XFILLER_6_242 VDD VDD VSS VSS gf180mcu_fd_sc_mcu7t5v0__fill_2
Xwire663 input1/Z _2992_/I VDD VDD VSS VSS gf180mcu_fd_sc_mcu7t5v0__buf_4
X_2330_ _2330_/A1 _2410_/A3 _2330_/B _2412_/A2 VDD VDD VSS VSS gf180mcu_fd_sc_mcu7t5v0__oai21_1
Xload_slew613 fanout610/Z wire612/I VDD VDD VSS VSS gf180mcu_fd_sc_mcu7t5v0__clkbuf_2
Xload_slew602 _3721_/RN _3722_/RN VDD VDD VSS VSS gf180mcu_fd_sc_mcu7t5v0__clkbuf_2
Xload_slew657 wire656/I _2578_/A1 VDD VDD VSS VSS gf180mcu_fd_sc_mcu7t5v0__clkbuf_2
X_2261_ _2261_/A1 wire374/Z _2263_/A1 _2266_/A2 _2261_/Z VDD VDD VSS VSS gf180mcu_fd_sc_mcu7t5v0__and4_1
XFILLER_77_282 VDD VDD VSS VSS gf180mcu_fd_sc_mcu7t5v0__fillcap_8
X_2192_ _3700_/Q _2192_/A2 _2192_/B _2198_/A2 VDD VDD VSS VSS gf180mcu_fd_sc_mcu7t5v0__oai21_1
XFILLER_65_422 VDD VDD VSS VSS gf180mcu_fd_sc_mcu7t5v0__fillcap_4
XFILLER_92_241 VDD VDD VSS VSS gf180mcu_fd_sc_mcu7t5v0__fillcap_4
XFILLER_37_146 VDD VDD VSS VSS gf180mcu_fd_sc_mcu7t5v0__fill_1
XPHY_EDGE_ROW_9_Left_106 VDD VSS gf180mcu_fd_sc_mcu7t5v0__endcap
XTAP_TAPCELL_ROW_48_664 VDD VSS gf180mcu_fd_sc_mcu7t5v0__filltie
XFILLER_18_382 VDD VDD VSS VSS gf180mcu_fd_sc_mcu7t5v0__fill_2
XFILLER_45_190 VDD VDD VSS VSS gf180mcu_fd_sc_mcu7t5v0__fill_1
XFILLER_52_127 VDD VDD VSS VSS gf180mcu_fd_sc_mcu7t5v0__fill_2
X_1976_ _2004_/A1 _2004_/A2 _2004_/C _1986_/B VDD VDD VSS VSS gf180mcu_fd_sc_mcu7t5v0__aoi21_1
X_3715_ _3715_/D _3715_/RN _3715_/CLK _3715_/Q VDD VDD VSS VSS gf180mcu_fd_sc_mcu7t5v0__dffrnq_2
X_3646_ _3643_/Z _3646_/A2 _3646_/B _3650_/A2 VDD VDD VSS VSS gf180mcu_fd_sc_mcu7t5v0__aoi21_1
X_3577_ _3563_/B _3577_/A2 _3577_/B _3608_/A1 VDD VDD VSS VSS gf180mcu_fd_sc_mcu7t5v0__oai21_1
X_2528_ _2528_/A1 _2528_/A2 _2555_/A1 _2528_/Z VDD VDD VSS VSS gf180mcu_fd_sc_mcu7t5v0__and3_1
XTAP_TAPCELL_ROW_93_1095 VDD VSS gf180mcu_fd_sc_mcu7t5v0__filltie
X_2459_ _2459_/A1 _2459_/A2 _2459_/Z VDD VDD VSS VSS gf180mcu_fd_sc_mcu7t5v0__or2_1
XFILLER_96_580 VDD VDD VSS VSS gf180mcu_fd_sc_mcu7t5v0__fillcap_16
XTAP_TAPCELL_ROW_3_234 VDD VSS gf180mcu_fd_sc_mcu7t5v0__filltie
XFILLER_68_282 VDD VDD VSS VSS gf180mcu_fd_sc_mcu7t5v0__fillcap_4
XFILLER_68_271 VDD VDD VSS VSS gf180mcu_fd_sc_mcu7t5v0__fillcap_4
XTAP_TAPCELL_ROW_82_987 VDD VSS gf180mcu_fd_sc_mcu7t5v0__filltie
XFILLER_51_182 VDD VDD VSS VSS gf180mcu_fd_sc_mcu7t5v0__fill_2
XFILLER_79_536 VDD VDD VSS VSS gf180mcu_fd_sc_mcu7t5v0__fill_1
XFILLER_47_422 VDD VDD VSS VSS gf180mcu_fd_sc_mcu7t5v0__fillcap_8
XFILLER_59_282 VDD VDD VSS VSS gf180mcu_fd_sc_mcu7t5v0__fillcap_4
XFILLER_74_241 VDD VDD VSS VSS gf180mcu_fd_sc_mcu7t5v0__fillcap_4
XFILLER_47_466 VDD VDD VSS VSS gf180mcu_fd_sc_mcu7t5v0__fill_1
XTAP_TAPCELL_ROW_45_634 VDD VSS gf180mcu_fd_sc_mcu7t5v0__filltie
XFILLER_62_436 VDD VDD VSS VSS gf180mcu_fd_sc_mcu7t5v0__fill_1
XTAP_TAPCELL_ROW_17_369 VDD VSS gf180mcu_fd_sc_mcu7t5v0__filltie
XFILLER_27_190 VDD VDD VSS VSS gf180mcu_fd_sc_mcu7t5v0__fillcap_4
XFILLER_50_609 VDD VDD VSS VSS gf180mcu_fd_sc_mcu7t5v0__fillcap_4
XFILLER_35_80 VDD VDD VSS VSS gf180mcu_fd_sc_mcu7t5v0__fillcap_4
XFILLER_42_160 VDD VDD VSS VSS gf180mcu_fd_sc_mcu7t5v0__fillcap_8
X_1830_ _1830_/A1 _1827_/I _1830_/B _1857_/B3 VDD VDD VSS VSS gf180mcu_fd_sc_mcu7t5v0__aoi21_2
X_3500_ _3516_/A1 _3679_/Q _3500_/Z VDD VDD VSS VSS gf180mcu_fd_sc_mcu7t5v0__xor2_1
XFILLER_7_562 VDD VDD VSS VSS gf180mcu_fd_sc_mcu7t5v0__fillcap_4
X_3431_ _3431_/A1 _3675_/Q _3455_/C VDD VDD VSS VSS gf180mcu_fd_sc_mcu7t5v0__nand2_1
X_3362_ _3362_/A1 _3362_/A2 _3361_/B _3363_/A2 VDD VDD VSS VSS gf180mcu_fd_sc_mcu7t5v0__nor3_1
X_2313_ _2986_/I input14/Z _2330_/A1 VDD VDD VSS VSS gf180mcu_fd_sc_mcu7t5v0__nor2_1
Xload_slew410 _3761_/Q fanout407/I VDD VDD VSS VSS gf180mcu_fd_sc_mcu7t5v0__clkbuf_1
XFILLER_32_2 VDD VDD VSS VSS gf180mcu_fd_sc_mcu7t5v0__fillcap_32
X_3293_ _3326_/A1 _3326_/A2 _3293_/B _3293_/C _3295_/A2 VDD VDD VSS VSS gf180mcu_fd_sc_mcu7t5v0__aoi211_2
Xload_slew454 _2517_/A1 _3113_/A2 VDD VDD VSS VSS gf180mcu_fd_sc_mcu7t5v0__clkbuf_2
Xload_slew443 _2354_/A1 _3260_/A2 VDD VDD VSS VSS gf180mcu_fd_sc_mcu7t5v0__clkbuf_2
Xload_slew432 _2468_/A1 _2358_/A1 VDD VDD VSS VSS gf180mcu_fd_sc_mcu7t5v0__clkbuf_1
Xload_slew465 wire466/Z _2640_/A1 VDD VDD VSS VSS gf180mcu_fd_sc_mcu7t5v0__clkbuf_1
XFILLER_78_580 VDD VDD VSS VSS gf180mcu_fd_sc_mcu7t5v0__fillcap_4
Xload_slew498 _3691_/Q _3039_/I VDD VDD VSS VSS gf180mcu_fd_sc_mcu7t5v0__buf_2
X_2244_ _2229_/Z _2244_/A2 _2244_/B _2245_/C VDD VDD VSS VSS gf180mcu_fd_sc_mcu7t5v0__aoi21_1
Xload_slew487 _3706_/Q _3612_/A1 VDD VDD VSS VSS gf180mcu_fd_sc_mcu7t5v0__buf_4
X_2175_ _3696_/Q _2167_/S _2175_/B _2185_/A2 VDD VDD VSS VSS gf180mcu_fd_sc_mcu7t5v0__oai21_1
XTAP_TAPCELL_ROW_84_1006 VDD VSS gf180mcu_fd_sc_mcu7t5v0__filltie
XTAP_TAPCELL_ROW_0_204 VDD VSS gf180mcu_fd_sc_mcu7t5v0__filltie
XFILLER_26_617 VDD VDD VSS VSS gf180mcu_fd_sc_mcu7t5v0__fill_1
XFILLER_53_403 VDD VDD VSS VSS gf180mcu_fd_sc_mcu7t5v0__fillcap_16
XFILLER_53_458 VDD VDD VSS VSS gf180mcu_fd_sc_mcu7t5v0__fillcap_8
XFILLER_21_300 VDD VDD VSS VSS gf180mcu_fd_sc_mcu7t5v0__fill_1
XFILLER_33_160 VDD VDD VSS VSS gf180mcu_fd_sc_mcu7t5v0__fill_1
XFILLER_21_333 VDD VDD VSS VSS gf180mcu_fd_sc_mcu7t5v0__fill_1
X_1959_ _1959_/A1 _1941_/Z _1960_/B VDD VDD VSS VSS gf180mcu_fd_sc_mcu7t5v0__nor2_1
XTAP_TAPCELL_ROW_95_1113 VDD VSS gf180mcu_fd_sc_mcu7t5v0__filltie
X_3629_ _3629_/A1 _3611_/Z _3629_/A3 _3075_/I _3629_/B2 wire281/I VDD VDD VSS VSS
+ gf180mcu_fd_sc_mcu7t5v0__oai32_4
XFILLER_88_311 VDD VDD VSS VSS gf180mcu_fd_sc_mcu7t5v0__fillcap_4
XFILLER_88_399 VDD VDD VSS VSS gf180mcu_fd_sc_mcu7t5v0__fill_2
XFILLER_84_594 VDD VDD VSS VSS gf180mcu_fd_sc_mcu7t5v0__fill_1
XTAP_TAPCELL_ROW_42_604 VDD VSS gf180mcu_fd_sc_mcu7t5v0__filltie
XFILLER_72_34 VDD VDD VSS VSS gf180mcu_fd_sc_mcu7t5v0__fill_1
XFILLER_71_244 VDD VDD VSS VSS gf180mcu_fd_sc_mcu7t5v0__fillcap_8
XFILLER_24_171 VDD VDD VSS VSS gf180mcu_fd_sc_mcu7t5v0__fillcap_4
XTAP_TAPCELL_ROW_14_339 VDD VSS gf180mcu_fd_sc_mcu7t5v0__filltie
XFILLER_8_337 VDD VDD VSS VSS gf180mcu_fd_sc_mcu7t5v0__fillcap_4
XFILLER_40_664 VDD VDD VSS VSS gf180mcu_fd_sc_mcu7t5v0__fill_1
XFILLER_40_675 VDD VDD VSS VSS gf180mcu_fd_sc_mcu7t5v0__fill_2
XTAP_TAPCELL_ROW_50_681 VDD VSS gf180mcu_fd_sc_mcu7t5v0__filltie
XFILLER_4_521 VDD VDD VSS VSS gf180mcu_fd_sc_mcu7t5v0__fillcap_4
XFILLER_4_587 VDD VDD VSS VSS gf180mcu_fd_sc_mcu7t5v0__fill_2
XFILLER_39_208 VDD VDD VSS VSS gf180mcu_fd_sc_mcu7t5v0__fill_2
XFILLER_82_509 VDD VDD VSS VSS gf180mcu_fd_sc_mcu7t5v0__fillcap_4
XFILLER_90_520 VDD VDD VSS VSS gf180mcu_fd_sc_mcu7t5v0__fillcap_4
XFILLER_90_597 VDD VDD VSS VSS gf180mcu_fd_sc_mcu7t5v0__fillcap_32
X_2931_ _2931_/A1 wire243/Z _2931_/B _3703_/D VDD VDD VSS VSS gf180mcu_fd_sc_mcu7t5v0__oai21_1
Xclkbuf_0_clk clk clkbuf_0_clk/Z VDD VDD VSS VSS gf180mcu_fd_sc_mcu7t5v0__clkbuf_16
XFILLER_30_152 VDD VDD VSS VSS gf180mcu_fd_sc_mcu7t5v0__fillcap_4
X_2862_ _3492_/A2 _2865_/A2 _2862_/B1 _2862_/B2 _3677_/D VDD VDD VSS VSS gf180mcu_fd_sc_mcu7t5v0__oai22_1
XFILLER_30_174 VDD VDD VSS VSS gf180mcu_fd_sc_mcu7t5v0__fill_1
X_2793_ _2813_/A1 _2796_/A2 _2793_/B _2797_/A2 VDD VDD VSS VSS gf180mcu_fd_sc_mcu7t5v0__aoi21_1
X_1813_ _3350_/A2 _1813_/A2 _1813_/Z VDD VDD VSS VSS gf180mcu_fd_sc_mcu7t5v0__xor2_1
Xwire290 wire291/Z wire290/Z VDD VDD VSS VSS gf180mcu_fd_sc_mcu7t5v0__dlyb_1
X_3414_ _3695_/Q _3439_/A1 _3456_/A1 VDD VDD VSS VSS gf180mcu_fd_sc_mcu7t5v0__nor2_1
XPHY_EDGE_ROW_15_Right_15 VDD VSS gf180mcu_fd_sc_mcu7t5v0__endcap
XTAP_TAPCELL_ROW_90_1065 VDD VSS gf180mcu_fd_sc_mcu7t5v0__filltie
X_3345_ _3772_/Q _3345_/A2 _3345_/B _3349_/A1 VDD VDD VSS VSS gf180mcu_fd_sc_mcu7t5v0__aoi21_1
Xload_slew240 _2935_/A2 _2927_/A2 VDD VDD VSS VSS gf180mcu_fd_sc_mcu7t5v0__buf_1
X_3276_ _3314_/A1 _3278_/A2 _3279_/A3 VDD VDD VSS VSS gf180mcu_fd_sc_mcu7t5v0__nand2_1
XFILLER_58_539 VDD VDD VSS VSS gf180mcu_fd_sc_mcu7t5v0__fill_1
Xload_slew251 _2743_/A2 _2290_/A2 VDD VDD VSS VSS gf180mcu_fd_sc_mcu7t5v0__buf_1
X_2227_ _3737_/Q _3665_/Q _2227_/Z VDD VDD VSS VSS gf180mcu_fd_sc_mcu7t5v0__xor2_1
XFILLER_85_369 VDD VDD VSS VSS gf180mcu_fd_sc_mcu7t5v0__fillcap_32
XFILLER_26_447 VDD VDD VSS VSS gf180mcu_fd_sc_mcu7t5v0__fillcap_8
X_2158_ _3689_/Q _3668_/Q _2158_/S _2159_/B VDD VDD VSS VSS gf180mcu_fd_sc_mcu7t5v0__mux2_2
X_2089_ _3072_/ZN _2082_/Z _2089_/B _2096_/A1 VDD VDD VSS VSS gf180mcu_fd_sc_mcu7t5v0__oai21_1
XPHY_EDGE_ROW_24_Right_24 VDD VSS gf180mcu_fd_sc_mcu7t5v0__endcap
XFILLER_26_469 VDD VDD VSS VSS gf180mcu_fd_sc_mcu7t5v0__fillcap_4
XTAP_TAPCELL_ROW_11_309 VDD VSS gf180mcu_fd_sc_mcu7t5v0__filltie
XFILLER_22_664 VDD VDD VSS VSS gf180mcu_fd_sc_mcu7t5v0__fill_1
XFILLER_42_37 VDD VDD VSS VSS gf180mcu_fd_sc_mcu7t5v0__fillcap_64
XPHY_EDGE_ROW_33_Right_33 VDD VSS gf180mcu_fd_sc_mcu7t5v0__endcap
XFILLER_89_675 VDD VDD VSS VSS gf180mcu_fd_sc_mcu7t5v0__fill_2
XFILLER_84_391 VDD VDD VSS VSS gf180mcu_fd_sc_mcu7t5v0__fill_2
XPHY_EDGE_ROW_42_Right_42 VDD VSS gf180mcu_fd_sc_mcu7t5v0__endcap
XFILLER_44_222 VDD VDD VSS VSS gf180mcu_fd_sc_mcu7t5v0__fill_1
XFILLER_72_520 VDD VDD VSS VSS gf180mcu_fd_sc_mcu7t5v0__fillcap_4
XFILLER_83_66 VDD VDD VSS VSS gf180mcu_fd_sc_mcu7t5v0__fillcap_4
XTAP_TAPCELL_ROW_27_464 VDD VSS gf180mcu_fd_sc_mcu7t5v0__filltie
XFILLER_44_266 VDD VDD VSS VSS gf180mcu_fd_sc_mcu7t5v0__fillcap_4
XFILLER_72_575 VDD VDD VSS VSS gf180mcu_fd_sc_mcu7t5v0__fill_1
XFILLER_8_101 VDD VDD VSS VSS gf180mcu_fd_sc_mcu7t5v0__fillcap_4
XFILLER_9_657 VDD VDD VSS VSS gf180mcu_fd_sc_mcu7t5v0__fill_2
XFILLER_9_646 VDD VDD VSS VSS gf180mcu_fd_sc_mcu7t5v0__fill_1
XPHY_EDGE_ROW_51_Right_51 VDD VSS gf180mcu_fd_sc_mcu7t5v0__endcap
X_3130_ input28/Z _2734_/C _2969_/I _2442_/B _3131_/A4 VDD VDD VSS VSS gf180mcu_fd_sc_mcu7t5v0__aoi22_1
XFILLER_94_177 VDD VDD VSS VSS gf180mcu_fd_sc_mcu7t5v0__fillcap_64
XFILLER_82_317 VDD VDD VSS VSS gf180mcu_fd_sc_mcu7t5v0__fillcap_32
X_3061_ _3679_/Q _3539_/A1 VDD VDD VSS VSS gf180mcu_fd_sc_mcu7t5v0__clkinv_1
XPHY_EDGE_ROW_60_Right_60 VDD VSS gf180mcu_fd_sc_mcu7t5v0__endcap
X_2012_ _3196_/A2 _3066_/I _2013_/A2 VDD VDD VSS VSS gf180mcu_fd_sc_mcu7t5v0__nand2_1
XFILLER_48_594 VDD VDD VSS VSS gf180mcu_fd_sc_mcu7t5v0__fill_1
XFILLER_35_233 VDD VDD VSS VSS gf180mcu_fd_sc_mcu7t5v0__fill_2
XFILLER_63_564 VDD VDD VSS VSS gf180mcu_fd_sc_mcu7t5v0__fill_1
XFILLER_63_553 VDD VDD VSS VSS gf180mcu_fd_sc_mcu7t5v0__fillcap_4
XFILLER_16_480 VDD VDD VSS VSS gf180mcu_fd_sc_mcu7t5v0__fillcap_4
XFILLER_50_247 VDD VDD VSS VSS gf180mcu_fd_sc_mcu7t5v0__fill_1
X_2914_ _3696_/Q wire249/Z _2916_/B VDD VDD VSS VSS gf180mcu_fd_sc_mcu7t5v0__nand2_1
XTAP_TAPCELL_ROW_61_787 VDD VSS gf180mcu_fd_sc_mcu7t5v0__filltie
XFILLER_31_494 VDD VDD VSS VSS gf180mcu_fd_sc_mcu7t5v0__fill_1
X_2845_ _3745_/Q wire267/Z _2847_/B1 VDD VDD VSS VSS gf180mcu_fd_sc_mcu7t5v0__nor2_1
X_2776_ wire275/Z _2776_/A2 _2796_/B _2777_/A3 VDD VDD VSS VSS gf180mcu_fd_sc_mcu7t5v0__oai21_1
Xfanout614 input85/Z wire617/I VDD VDD VSS VSS gf180mcu_fd_sc_mcu7t5v0__dlyb_1
Xfanout658 input10/Z wire660/I VDD VDD VSS VSS gf180mcu_fd_sc_mcu7t5v0__dlyb_1
X_3328_ _3770_/Q _3328_/A2 _3330_/A2 VDD VDD VSS VSS gf180mcu_fd_sc_mcu7t5v0__xnor2_1
XFILLER_58_314 VDD VDD VSS VSS gf180mcu_fd_sc_mcu7t5v0__fill_1
XFILLER_86_667 VDD VDD VSS VSS gf180mcu_fd_sc_mcu7t5v0__fill_2
X_3259_ _3766_/Q _3274_/A2 _3314_/A1 _3280_/A1 VDD VDD VSS VSS gf180mcu_fd_sc_mcu7t5v0__nand3_1
XTAP_TAPCELL_ROW_69_865 VDD VSS gf180mcu_fd_sc_mcu7t5v0__filltie
XFILLER_54_520 VDD VDD VSS VSS gf180mcu_fd_sc_mcu7t5v0__fillcap_4
XFILLER_81_383 VDD VDD VSS VSS gf180mcu_fd_sc_mcu7t5v0__fill_1
XFILLER_14_428 VDD VDD VSS VSS gf180mcu_fd_sc_mcu7t5v0__fill_1
XFILLER_54_597 VDD VDD VSS VSS gf180mcu_fd_sc_mcu7t5v0__fill_1
XTAP_TAPCELL_ROW_24_434 VDD VSS gf180mcu_fd_sc_mcu7t5v0__filltie
XFILLER_10_645 VDD VDD VSS VSS gf180mcu_fd_sc_mcu7t5v0__fill_2
XFILLER_10_667 VDD VDD VSS VSS gf180mcu_fd_sc_mcu7t5v0__fillcap_4
XFILLER_64_317 VDD VDD VSS VSS gf180mcu_fd_sc_mcu7t5v0__fill_2
XFILLER_91_136 VDD VDD VSS VSS gf180mcu_fd_sc_mcu7t5v0__fillcap_4
XFILLER_76_177 VDD VDD VSS VSS gf180mcu_fd_sc_mcu7t5v0__fillcap_64
XFILLER_45_542 VDD VDD VSS VSS gf180mcu_fd_sc_mcu7t5v0__fill_1
XFILLER_45_575 VDD VDD VSS VSS gf180mcu_fd_sc_mcu7t5v0__fillcap_8
XFILLER_32_225 VDD VDD VSS VSS gf180mcu_fd_sc_mcu7t5v0__fillcap_8
XFILLER_72_394 VDD VDD VSS VSS gf180mcu_fd_sc_mcu7t5v0__fillcap_8
XFILLER_20_409 VDD VDD VSS VSS gf180mcu_fd_sc_mcu7t5v0__fill_2
XFILLER_13_483 VDD VDD VSS VSS gf180mcu_fd_sc_mcu7t5v0__fillcap_4
XFILLER_40_280 VDD VDD VSS VSS gf180mcu_fd_sc_mcu7t5v0__fill_2
X_2630_ _3743_/Q input53/Z _2631_/B VDD VDD VSS VSS gf180mcu_fd_sc_mcu7t5v0__xor2_1
X_2561_ _2561_/A1 _2507_/I _2561_/Z VDD VDD VSS VSS gf180mcu_fd_sc_mcu7t5v0__xor2_1
Xoutput206 _3056_/I raw_edge2[9] VDD VDD VSS VSS gf180mcu_fd_sc_mcu7t5v0__buf_2
Xoutput217 _3218_/A1 raw_edge3[19] VDD VDD VSS VSS gf180mcu_fd_sc_mcu7t5v0__buf_2
X_2492_ _3743_/Q input74/Z _2493_/I VDD VDD VSS VSS gf180mcu_fd_sc_mcu7t5v0__xnor2_1
Xoutput228 _3765_/Q ref_wave VDD VDD VSS VSS gf180mcu_fd_sc_mcu7t5v0__buf_2
X_3113_ _3113_/A1 _3113_/A2 _3113_/B1 _3113_/B2 _3113_/C _3114_/I1 VDD VDD VSS VSS
+ gf180mcu_fd_sc_mcu7t5v0__oai221_1
XFILLER_68_667 VDD VDD VSS VSS gf180mcu_fd_sc_mcu7t5v0__fill_2
XFILLER_95_486 VDD VDD VSS VSS gf180mcu_fd_sc_mcu7t5v0__fillcap_4
XTAP_TAPCELL_ROW_66_835 VDD VSS gf180mcu_fd_sc_mcu7t5v0__filltie
X_3044_ _3692_/Q _3419_/A1 VDD VDD VSS VSS gf180mcu_fd_sc_mcu7t5v0__inv_2
XTAP_TAPCELL_ROW_21_404 VDD VSS gf180mcu_fd_sc_mcu7t5v0__filltie
X_2828_ _2828_/A1 _2828_/A2 _2829_/B2 VDD VDD VSS VSS gf180mcu_fd_sc_mcu7t5v0__nand2_1
X_2759_ _3089_/ZN _2779_/A2 _2759_/B1 _2759_/B2 _3660_/D VDD VDD VSS VSS gf180mcu_fd_sc_mcu7t5v0__oai22_1
XFILLER_2_107 VDD VDD VSS VSS gf180mcu_fd_sc_mcu7t5v0__fillcap_64
XFILLER_78_409 VDD VDD VSS VSS gf180mcu_fd_sc_mcu7t5v0__fill_2
Xfanout411 _3234_/A2 _2448_/B VDD VDD VSS VSS gf180mcu_fd_sc_mcu7t5v0__dlyb_1
XFILLER_86_442 VDD VDD VSS VSS gf180mcu_fd_sc_mcu7t5v0__fillcap_4
XFILLER_86_453 VDD VDD VSS VSS gf180mcu_fd_sc_mcu7t5v0__fill_2
XFILLER_46_306 VDD VDD VSS VSS gf180mcu_fd_sc_mcu7t5v0__fill_1
XFILLER_46_317 VDD VDD VSS VSS gf180mcu_fd_sc_mcu7t5v0__fill_1
XFILLER_58_177 VDD VDD VSS VSS gf180mcu_fd_sc_mcu7t5v0__fillcap_8
XFILLER_73_136 VDD VDD VSS VSS gf180mcu_fd_sc_mcu7t5v0__fillcap_4
XFILLER_42_501 VDD VDD VSS VSS gf180mcu_fd_sc_mcu7t5v0__fill_1
XFILLER_42_523 VDD VDD VSS VSS gf180mcu_fd_sc_mcu7t5v0__fill_2
XFILLER_80_34 VDD VDD VSS VSS gf180mcu_fd_sc_mcu7t5v0__fill_1
XFILLER_22_280 VDD VDD VSS VSS gf180mcu_fd_sc_mcu7t5v0__fill_2
XFILLER_22_291 VDD VDD VSS VSS gf180mcu_fd_sc_mcu7t5v0__fill_2
XFILLER_13_72 VDD VDD VSS VSS gf180mcu_fd_sc_mcu7t5v0__fillcap_64
XFILLER_6_424 VDD VDD VSS VSS gf180mcu_fd_sc_mcu7t5v0__fillcap_16
XFILLER_6_457 VDD VDD VSS VSS gf180mcu_fd_sc_mcu7t5v0__fillcap_8
XFILLER_96_206 VDD VDD VSS VSS gf180mcu_fd_sc_mcu7t5v0__fillcap_32
XTAP_TAPCELL_ROW_9_295 VDD VSS gf180mcu_fd_sc_mcu7t5v0__filltie
XFILLER_18_520 VDD VDD VSS VSS gf180mcu_fd_sc_mcu7t5v0__fillcap_4
XTAP_TAPCELL_ROW_63_805 VDD VSS gf180mcu_fd_sc_mcu7t5v0__filltie
XFILLER_18_597 VDD VDD VSS VSS gf180mcu_fd_sc_mcu7t5v0__fill_1
XFILLER_45_383 VDD VDD VSS VSS gf180mcu_fd_sc_mcu7t5v0__fillcap_8
XPHY_EDGE_ROW_72_Left_169 VDD VSS gf180mcu_fd_sc_mcu7t5v0__endcap
X_3731_ _3731_/D _3731_/RN clkload4/I _3731_/Q VDD VDD VSS VSS gf180mcu_fd_sc_mcu7t5v0__dffrnq_1
XTAP_TAPCELL_ROW_71_882 VDD VSS gf180mcu_fd_sc_mcu7t5v0__filltie
X_1992_ _3700_/Q _1992_/A2 _1992_/B _1994_/A2 VDD VDD VSS VSS gf180mcu_fd_sc_mcu7t5v0__aoi21_1
Xclkload10 _3774_/CLK clkload10/Z VDD VDD VSS VSS gf180mcu_fd_sc_mcu7t5v0__clkbuf_2
XFILLER_9_273 VDD VDD VSS VSS gf180mcu_fd_sc_mcu7t5v0__fillcap_4
X_3662_ _3662_/D wire559/I clkload2/I _3662_/Q VDD VDD VSS VSS gf180mcu_fd_sc_mcu7t5v0__dffrnq_2
X_2613_ _2613_/A1 _2998_/I _2613_/Z VDD VDD VSS VSS gf180mcu_fd_sc_mcu7t5v0__xor2_2
XFILLER_62_2 VDD VDD VSS VSS gf180mcu_fd_sc_mcu7t5v0__fillcap_32
X_3593_ _3593_/A1 _3593_/A2 _3593_/Z VDD VDD VSS VSS gf180mcu_fd_sc_mcu7t5v0__xor2_2
X_2544_ _2603_/B _2545_/B VDD VDD VSS VSS gf180mcu_fd_sc_mcu7t5v0__clkinv_1
XFILLER_87_206 VDD VDD VSS VSS gf180mcu_fd_sc_mcu7t5v0__fillcap_4
XPHY_EDGE_ROW_81_Left_178 VDD VSS gf180mcu_fd_sc_mcu7t5v0__endcap
X_2475_ _2982_/I _3022_/ZN _2522_/A1 VDD VDD VSS VSS gf180mcu_fd_sc_mcu7t5v0__nor2_1
XTAP_TAPCELL_ROW_79_960 VDD VSS gf180mcu_fd_sc_mcu7t5v0__filltie
XFILLER_28_317 VDD VDD VSS VSS gf180mcu_fd_sc_mcu7t5v0__fillcap_32
XTAP_TAPCELL_ROW_87_1037 VDD VSS gf180mcu_fd_sc_mcu7t5v0__filltie
XFILLER_55_136 VDD VDD VSS VSS gf180mcu_fd_sc_mcu7t5v0__fillcap_4
X_3027_ _3778_/Q _3138_/A2 VDD VDD VSS VSS gf180mcu_fd_sc_mcu7t5v0__clkinv_1
XPHY_EDGE_ROW_90_Left_187 VDD VSS gf180mcu_fd_sc_mcu7t5v0__endcap
XFILLER_24_578 VDD VDD VSS VSS gf180mcu_fd_sc_mcu7t5v0__fill_2
XFILLER_51_342 VDD VDD VSS VSS gf180mcu_fd_sc_mcu7t5v0__fillcap_8
XFILLER_11_206 VDD VDD VSS VSS gf180mcu_fd_sc_mcu7t5v0__fillcap_4
Xclkload4 clkload4/I clkload4/Z VDD VDD VSS VSS gf180mcu_fd_sc_mcu7t5v0__clkbuf_2
XFILLER_50_37 VDD VDD VSS VSS gf180mcu_fd_sc_mcu7t5v0__fillcap_64
XFILLER_3_438 VDD VDD VSS VSS gf180mcu_fd_sc_mcu7t5v0__fillcap_32
XTAP_TAPCELL_ROW_6_265 VDD VSS gf180mcu_fd_sc_mcu7t5v0__filltie
XFILLER_74_401 VDD VDD VSS VSS gf180mcu_fd_sc_mcu7t5v0__fill_1
XFILLER_34_309 VDD VDD VSS VSS gf180mcu_fd_sc_mcu7t5v0__fillcap_4
XFILLER_91_66 VDD VDD VSS VSS gf180mcu_fd_sc_mcu7t5v0__fillcap_4
XFILLER_30_504 VDD VDD VSS VSS gf180mcu_fd_sc_mcu7t5v0__fillcap_16
Xwire642 wire642/I wire642/Z VDD VDD VSS VSS gf180mcu_fd_sc_mcu7t5v0__buf_2
XTAP_TAPCELL_ROW_40_587 VDD VSS gf180mcu_fd_sc_mcu7t5v0__filltie
XFILLER_10_272 VDD VDD VSS VSS gf180mcu_fd_sc_mcu7t5v0__fill_2
Xload_slew603 wire604/Z _3721_/RN VDD VDD VSS VSS gf180mcu_fd_sc_mcu7t5v0__clkbuf_2
XFILLER_69_206 VDD VDD VSS VSS gf180mcu_fd_sc_mcu7t5v0__fillcap_4
Xload_slew625 wire622/I wire624/I VDD VDD VSS VSS gf180mcu_fd_sc_mcu7t5v0__clkbuf_2
X_2260_ _2260_/A1 _2256_/Z _2260_/B _2260_/C _2266_/A2 VDD VDD VSS VSS gf180mcu_fd_sc_mcu7t5v0__oai211_2
X_2191_ _3539_/A1 _2192_/A2 _2192_/B VDD VDD VSS VSS gf180mcu_fd_sc_mcu7t5v0__nand2_1
XFILLER_77_294 VDD VDD VSS VSS gf180mcu_fd_sc_mcu7t5v0__fill_2
XTAP_TAPCELL_ROW_76_930 VDD VSS gf180mcu_fd_sc_mcu7t5v0__filltie
XFILLER_18_350 VDD VDD VSS VSS gf180mcu_fd_sc_mcu7t5v0__fill_1
XTAP_TAPCELL_ROW_48_665 VDD VSS gf180mcu_fd_sc_mcu7t5v0__filltie
XFILLER_53_629 VDD VDD VSS VSS gf180mcu_fd_sc_mcu7t5v0__fill_1
XFILLER_33_331 VDD VDD VSS VSS gf180mcu_fd_sc_mcu7t5v0__fill_2
XFILLER_21_515 VDD VDD VSS VSS gf180mcu_fd_sc_mcu7t5v0__fill_2
XFILLER_33_375 VDD VDD VSS VSS gf180mcu_fd_sc_mcu7t5v0__fill_2
X_1975_ _2004_/A1 _2004_/A2 _1977_/A2 VDD VDD VSS VSS gf180mcu_fd_sc_mcu7t5v0__nand2_1
X_3714_ _3714_/D wire612/Z _3721_/CLK _3714_/Q VDD VDD VSS VSS gf180mcu_fd_sc_mcu7t5v0__dffrnq_2
X_3645_ _3646_/B _3643_/Z _3646_/A2 _3645_/Z VDD VDD VSS VSS gf180mcu_fd_sc_mcu7t5v0__and3_1
X_3576_ _3576_/A1 _3606_/A2 _3578_/A1 VDD VDD VSS VSS gf180mcu_fd_sc_mcu7t5v0__nor2_1
X_2527_ _2528_/A2 _2555_/A1 _2552_/A3 VDD VDD VSS VSS gf180mcu_fd_sc_mcu7t5v0__nand2_1
X_2458_ _3652_/Q _2458_/A2 _3651_/Q _2459_/A2 VDD VDD VSS VSS gf180mcu_fd_sc_mcu7t5v0__aoi21_1
XPHY_EDGE_ROW_89_Right_89 VDD VSS gf180mcu_fd_sc_mcu7t5v0__endcap
XTAP_TAPCELL_ROW_3_235 VDD VSS gf180mcu_fd_sc_mcu7t5v0__filltie
X_2389_ wire408/Z _2389_/A2 _2361_/Z _2386_/Z _2389_/Z VDD VDD VSS VSS gf180mcu_fd_sc_mcu7t5v0__and4_1
XFILLER_43_139 VDD VDD VSS VSS gf180mcu_fd_sc_mcu7t5v0__fill_1
XFILLER_71_448 VDD VDD VSS VSS gf180mcu_fd_sc_mcu7t5v0__fill_1
XTAP_TAPCELL_ROW_82_988 VDD VSS gf180mcu_fd_sc_mcu7t5v0__filltie
XFILLER_51_150 VDD VDD VSS VSS gf180mcu_fd_sc_mcu7t5v0__fillcap_4
XFILLER_12_548 VDD VDD VSS VSS gf180mcu_fd_sc_mcu7t5v0__fillcap_8
XFILLER_79_526 VDD VDD VSS VSS gf180mcu_fd_sc_mcu7t5v0__fillcap_8
XFILLER_3_279 VDD VDD VSS VSS gf180mcu_fd_sc_mcu7t5v0__fill_1
XFILLER_66_209 VDD VDD VSS VSS gf180mcu_fd_sc_mcu7t5v0__fillcap_8
XFILLER_19_136 VDD VDD VSS VSS gf180mcu_fd_sc_mcu7t5v0__fillcap_4
XFILLER_47_445 VDD VDD VSS VSS gf180mcu_fd_sc_mcu7t5v0__fill_2
XFILLER_47_434 VDD VDD VSS VSS gf180mcu_fd_sc_mcu7t5v0__fill_2
XTAP_TAPCELL_ROW_73_900 VDD VSS gf180mcu_fd_sc_mcu7t5v0__filltie
XTAP_TAPCELL_ROW_45_635 VDD VSS gf180mcu_fd_sc_mcu7t5v0__filltie
XFILLER_42_172 VDD VDD VSS VSS gf180mcu_fd_sc_mcu7t5v0__fill_2
XFILLER_30_367 VDD VDD VSS VSS gf180mcu_fd_sc_mcu7t5v0__fill_1
XFILLER_30_389 VDD VDD VSS VSS gf180mcu_fd_sc_mcu7t5v0__fill_1
XFILLER_7_541 VDD VDD VSS VSS gf180mcu_fd_sc_mcu7t5v0__fill_1
XFILLER_7_574 VDD VDD VSS VSS gf180mcu_fd_sc_mcu7t5v0__fill_2
Xwire483 _3719_/Q wire483/Z VDD VDD VSS VSS gf180mcu_fd_sc_mcu7t5v0__buf_2
X_3430_ wire516/Z _3424_/Z _3430_/B _3442_/A1 VDD VDD VSS VSS gf180mcu_fd_sc_mcu7t5v0__aoi21_1
X_3361_ _3362_/A1 _3362_/A2 _3361_/B _3368_/B VDD VDD VSS VSS gf180mcu_fd_sc_mcu7t5v0__oai21_2
X_2312_ _2986_/I input14/Z _2330_/B VDD VDD VSS VSS gf180mcu_fd_sc_mcu7t5v0__nand2_1
Xload_slew433 _3222_/A1 _2468_/A1 VDD VDD VSS VSS gf180mcu_fd_sc_mcu7t5v0__buf_2
Xload_slew455 _2517_/A1 _2981_/I VDD VDD VSS VSS gf180mcu_fd_sc_mcu7t5v0__clkbuf_1
X_3292_ _3292_/A1 _3292_/A2 _3293_/C VDD VDD VSS VSS gf180mcu_fd_sc_mcu7t5v0__and2_1
Xload_slew444 _3124_/A2 _2873_/A1 VDD VDD VSS VSS gf180mcu_fd_sc_mcu7t5v0__clkbuf_2
Xload_slew477 _3729_/Q _3218_/A1 VDD VDD VSS VSS gf180mcu_fd_sc_mcu7t5v0__buf_2
XFILLER_25_2 VDD VDD VSS VSS gf180mcu_fd_sc_mcu7t5v0__fillcap_64
Xload_slew499 _3690_/Q _3041_/I VDD VDD VSS VSS gf180mcu_fd_sc_mcu7t5v0__buf_2
X_2243_ _2238_/Z _2243_/A2 _2245_/B VDD VDD VSS VSS gf180mcu_fd_sc_mcu7t5v0__nand2_1
Xload_slew488 _3705_/Q _3070_/I VDD VDD VSS VSS gf180mcu_fd_sc_mcu7t5v0__buf_4
X_2174_ _3433_/A2 _2167_/S _2175_/B VDD VDD VSS VSS gf180mcu_fd_sc_mcu7t5v0__nand2_1
XFILLER_93_562 VDD VDD VSS VSS gf180mcu_fd_sc_mcu7t5v0__fillcap_64
XTAP_TAPCELL_ROW_84_1007 VDD VSS gf180mcu_fd_sc_mcu7t5v0__filltie
XTAP_TAPCELL_ROW_0_205 VDD VSS gf180mcu_fd_sc_mcu7t5v0__filltie
X_1958_ _1919_/Z _1958_/A2 _1958_/B1 _1958_/B2 _1961_/A2 VDD VDD VSS VSS gf180mcu_fd_sc_mcu7t5v0__oai22_1
XTAP_TAPCELL_ROW_95_1114 VDD VSS gf180mcu_fd_sc_mcu7t5v0__filltie
X_1889_ _1890_/A1 _1890_/A3 _1891_/A2 VDD VDD VSS VSS gf180mcu_fd_sc_mcu7t5v0__nand2_1
X_3628_ _3628_/A1 _3641_/A1 _3630_/A1 VDD VDD VSS VSS gf180mcu_fd_sc_mcu7t5v0__nand2_1
X_3559_ _3560_/A1 _3537_/Z _3559_/B _3577_/B VDD VDD VSS VSS gf180mcu_fd_sc_mcu7t5v0__oai21_1
XFILLER_29_412 VDD VDD VSS VSS gf180mcu_fd_sc_mcu7t5v0__fill_2
XFILLER_69_581 VDD VDD VSS VSS gf180mcu_fd_sc_mcu7t5v0__fill_1
XFILLER_29_456 VDD VDD VSS VSS gf180mcu_fd_sc_mcu7t5v0__fill_1
XFILLER_29_489 VDD VDD VSS VSS gf180mcu_fd_sc_mcu7t5v0__fill_1
XFILLER_56_242 VDD VDD VSS VSS gf180mcu_fd_sc_mcu7t5v0__fill_2
XFILLER_71_212 VDD VDD VSS VSS gf180mcu_fd_sc_mcu7t5v0__fillcap_32
XFILLER_71_256 VDD VDD VSS VSS gf180mcu_fd_sc_mcu7t5v0__fill_1
XTAP_TAPCELL_ROW_42_605 VDD VSS gf180mcu_fd_sc_mcu7t5v0__filltie
XTAP_TAPCELL_ROW_50_682 VDD VSS gf180mcu_fd_sc_mcu7t5v0__filltie
XFILLER_21_72 VDD VDD VSS VSS gf180mcu_fd_sc_mcu7t5v0__fillcap_64
XFILLER_75_562 VDD VDD VSS VSS gf180mcu_fd_sc_mcu7t5v0__fillcap_8
XTAP_TAPCELL_ROW_58_760 VDD VSS gf180mcu_fd_sc_mcu7t5v0__filltie
XFILLER_90_543 VDD VDD VSS VSS gf180mcu_fd_sc_mcu7t5v0__fill_2
XFILLER_50_407 VDD VDD VSS VSS gf180mcu_fd_sc_mcu7t5v0__fill_2
X_2930_ _3066_/I wire243/Z _2931_/B VDD VDD VSS VSS gf180mcu_fd_sc_mcu7t5v0__nand2_1
XFILLER_43_492 VDD VDD VSS VSS gf180mcu_fd_sc_mcu7t5v0__fill_1
X_2861_ _3677_/Q wire231/I _2861_/B _2862_/B2 VDD VDD VSS VSS gf180mcu_fd_sc_mcu7t5v0__oai21_1
X_1812_ _3041_/I _1813_/A2 _1830_/A1 VDD VDD VSS VSS gf180mcu_fd_sc_mcu7t5v0__nor2_1
XFILLER_30_197 VDD VDD VSS VSS gf180mcu_fd_sc_mcu7t5v0__fill_2
X_2792_ _3093_/ZN _2792_/A2 _2792_/B _2796_/A2 VDD VDD VSS VSS gf180mcu_fd_sc_mcu7t5v0__oai21_1
Xwire291 wire292/Z wire291/Z VDD VDD VSS VSS gf180mcu_fd_sc_mcu7t5v0__dlyb_1
Xwire280 wire280/I wire280/Z VDD VDD VSS VSS gf180mcu_fd_sc_mcu7t5v0__clkbuf_1
X_3413_ _3672_/Q _3404_/Z _3413_/B _3443_/B1 VDD VDD VSS VSS gf180mcu_fd_sc_mcu7t5v0__aoi21_1
XTAP_TAPCELL_ROW_90_1066 VDD VSS gf180mcu_fd_sc_mcu7t5v0__filltie
X_3344_ _3344_/A1 _3344_/A2 _3772_/D VDD VDD VSS VSS gf180mcu_fd_sc_mcu7t5v0__xor2_1
Xload_slew230 wire231/Z _2843_/A2 VDD VDD VSS VSS gf180mcu_fd_sc_mcu7t5v0__clkbuf_2
X_3275_ wire306/Z _3275_/A2 _3278_/A2 VDD VDD VSS VSS gf180mcu_fd_sc_mcu7t5v0__xnor2_1
Xload_slew241 _2937_/A2 _2935_/A2 VDD VDD VSS VSS gf180mcu_fd_sc_mcu7t5v0__buf_2
Xload_slew252 _2743_/A2 _2298_/A1 VDD VDD VSS VSS gf180mcu_fd_sc_mcu7t5v0__buf_2
Xload_slew274 wire275/Z _2796_/A1 VDD VDD VSS VSS gf180mcu_fd_sc_mcu7t5v0__clkbuf_2
X_2226_ _2223_/I _2226_/A2 _2236_/C VDD VDD VSS VSS gf180mcu_fd_sc_mcu7t5v0__nor2_1
XFILLER_66_551 VDD VDD VSS VSS gf180mcu_fd_sc_mcu7t5v0__fill_1
X_2157_ _3690_/Q _3669_/Q _2158_/S _2157_/Z VDD VDD VSS VSS gf180mcu_fd_sc_mcu7t5v0__mux2_2
X_2088_ _2097_/A2 _2088_/A2 _2088_/Z VDD VDD VSS VSS gf180mcu_fd_sc_mcu7t5v0__xor2_2
XFILLER_21_142 VDD VDD VSS VSS gf180mcu_fd_sc_mcu7t5v0__fillcap_64
XFILLER_89_621 VDD VDD VSS VSS gf180mcu_fd_sc_mcu7t5v0__fillcap_8
XFILLER_89_632 VDD VDD VSS VSS gf180mcu_fd_sc_mcu7t5v0__fill_2
XFILLER_57_540 VDD VDD VSS VSS gf180mcu_fd_sc_mcu7t5v0__fillcap_8
XTAP_TAPCELL_ROW_55_730 VDD VSS gf180mcu_fd_sc_mcu7t5v0__filltie
XFILLER_25_470 VDD VDD VSS VSS gf180mcu_fd_sc_mcu7t5v0__fillcap_16
XTAP_TAPCELL_ROW_27_465 VDD VSS gf180mcu_fd_sc_mcu7t5v0__filltie
XFILLER_25_492 VDD VDD VSS VSS gf180mcu_fd_sc_mcu7t5v0__fill_1
XFILLER_79_142 VDD VDD VSS VSS gf180mcu_fd_sc_mcu7t5v0__fillcap_64
XFILLER_94_101 VDD VDD VSS VSS gf180mcu_fd_sc_mcu7t5v0__fillcap_4
XFILLER_0_580 VDD VDD VSS VSS gf180mcu_fd_sc_mcu7t5v0__fillcap_32
XFILLER_67_337 VDD VDD VSS VSS gf180mcu_fd_sc_mcu7t5v0__fill_1
X_3060_ _3700_/Q _3516_/A1 VDD VDD VSS VSS gf180mcu_fd_sc_mcu7t5v0__clkinv_1
X_2011_ _3724_/Q _3553_/A1 _2045_/B VDD VDD VSS VSS gf180mcu_fd_sc_mcu7t5v0__nand2_1
XFILLER_75_381 VDD VDD VSS VSS gf180mcu_fd_sc_mcu7t5v0__fillcap_4
XFILLER_23_418 VDD VDD VSS VSS gf180mcu_fd_sc_mcu7t5v0__fill_2
XFILLER_35_278 VDD VDD VSS VSS gf180mcu_fd_sc_mcu7t5v0__fill_2
XFILLER_92_2 VDD VDD VSS VSS gf180mcu_fd_sc_mcu7t5v0__fillcap_32
X_2913_ wire249/Z _2957_/A2 _2913_/B _3695_/D VDD VDD VSS VSS gf180mcu_fd_sc_mcu7t5v0__oai21_1
XTAP_TAPCELL_ROW_61_788 VDD VSS gf180mcu_fd_sc_mcu7t5v0__filltie
X_2844_ _3406_/A1 _2844_/A2 _2844_/B1 _2844_/B2 _3671_/D VDD VDD VSS VSS gf180mcu_fd_sc_mcu7t5v0__oai22_1
X_2775_ _3734_/Q _2775_/A2 _2805_/B1 _2775_/B2 _2775_/C _2779_/B1 VDD VDD VSS VSS
+ gf180mcu_fd_sc_mcu7t5v0__aoi221_1
Xfanout637 wire642/Z _2586_/B VDD VDD VSS VSS gf180mcu_fd_sc_mcu7t5v0__dlyb_1
X_3327_ _3770_/Q _3328_/A2 _3330_/B VDD VDD VSS VSS gf180mcu_fd_sc_mcu7t5v0__nand2_1
X_3258_ _3274_/A2 _3314_/A1 _3258_/ZN VDD VDD VSS VSS gf180mcu_fd_sc_mcu7t5v0__nand2_1
XFILLER_39_562 VDD VDD VSS VSS gf180mcu_fd_sc_mcu7t5v0__fill_1
XTAP_TAPCELL_ROW_69_866 VDD VSS gf180mcu_fd_sc_mcu7t5v0__filltie
X_2209_ _2210_/A1 _2210_/A2 _2259_/A1 VDD VDD VSS VSS gf180mcu_fd_sc_mcu7t5v0__nor2_1
XFILLER_66_381 VDD VDD VSS VSS gf180mcu_fd_sc_mcu7t5v0__fillcap_4
X_3189_ _3189_/A1 _3189_/A2 _3189_/B _3190_/A2 VDD VDD VSS VSS gf180mcu_fd_sc_mcu7t5v0__aoi21_1
XFILLER_73_329 VDD VDD VSS VSS gf180mcu_fd_sc_mcu7t5v0__fillcap_4
XFILLER_66_392 VDD VDD VSS VSS gf180mcu_fd_sc_mcu7t5v0__fill_1
XTAP_TAPCELL_ROW_52_700 VDD VSS gf180mcu_fd_sc_mcu7t5v0__filltie
XTAP_TAPCELL_ROW_24_435 VDD VSS gf180mcu_fd_sc_mcu7t5v0__filltie
XFILLER_41_259 VDD VDD VSS VSS gf180mcu_fd_sc_mcu7t5v0__fillcap_4
XFILLER_78_34 VDD VDD VSS VSS gf180mcu_fd_sc_mcu7t5v0__fill_1
XFILLER_1_322 VDD VDD VSS VSS gf180mcu_fd_sc_mcu7t5v0__fill_1
XFILLER_76_101 VDD VDD VSS VSS gf180mcu_fd_sc_mcu7t5v0__fillcap_4
XFILLER_17_212 VDD VDD VSS VSS gf180mcu_fd_sc_mcu7t5v0__fillcap_16
XFILLER_57_392 VDD VDD VSS VSS gf180mcu_fd_sc_mcu7t5v0__fillcap_8
XFILLER_17_256 VDD VDD VSS VSS gf180mcu_fd_sc_mcu7t5v0__fillcap_8
XFILLER_32_237 VDD VDD VSS VSS gf180mcu_fd_sc_mcu7t5v0__fill_2
XFILLER_60_535 VDD VDD VSS VSS gf180mcu_fd_sc_mcu7t5v0__fillcap_16
XFILLER_60_568 VDD VDD VSS VSS gf180mcu_fd_sc_mcu7t5v0__fillcap_4
XFILLER_9_422 VDD VDD VSS VSS gf180mcu_fd_sc_mcu7t5v0__fillcap_8
X_2560_ _2560_/A1 _2560_/A2 _2560_/B _2586_/A2 VDD VDD VSS VSS gf180mcu_fd_sc_mcu7t5v0__aoi21_1
Xoutput207 _3780_/Z raw_edge3[0] VDD VDD VSS VSS gf180mcu_fd_sc_mcu7t5v0__buf_2
X_2491_ _3100_/C _3026_/I _2491_/B _2576_/A1 VDD VDD VSS VSS gf180mcu_fd_sc_mcu7t5v0__oai21_1
Xoutput218 _3781_/Z raw_edge3[1] VDD VDD VSS VSS gf180mcu_fd_sc_mcu7t5v0__buf_2
X_3112_ input39/Z _2186_/B _3112_/B _3113_/C VDD VDD VSS VSS gf180mcu_fd_sc_mcu7t5v0__aoi21_1
XTAP_TAPCELL_ROW_66_836 VDD VSS gf180mcu_fd_sc_mcu7t5v0__filltie
X_3043_ _3689_/Q _3357_/A1 VDD VDD VSS VSS gf180mcu_fd_sc_mcu7t5v0__clkinv_1
XFILLER_51_524 VDD VDD VSS VSS gf180mcu_fd_sc_mcu7t5v0__fillcap_4
XTAP_TAPCELL_ROW_21_405 VDD VSS gf180mcu_fd_sc_mcu7t5v0__filltie
X_2827_ _2827_/A1 _2827_/A2 _2827_/A3 _2828_/A2 VDD VDD VSS VSS gf180mcu_fd_sc_mcu7t5v0__nand3_1
X_2758_ _2768_/A1 _2758_/A2 _2759_/B2 VDD VDD VSS VSS gf180mcu_fd_sc_mcu7t5v0__nand2_1
X_2689_ _2689_/A1 _2657_/C _2689_/Z VDD VDD VSS VSS gf180mcu_fd_sc_mcu7t5v0__xor2_1
XFILLER_86_410 VDD VDD VSS VSS gf180mcu_fd_sc_mcu7t5v0__fillcap_32
Xfanout456 _3750_/Q wire459/I VDD VDD VSS VSS gf180mcu_fd_sc_mcu7t5v0__dlyb_1
XFILLER_48_37 VDD VDD VSS VSS gf180mcu_fd_sc_mcu7t5v0__fillcap_64
XFILLER_58_101 VDD VDD VSS VSS gf180mcu_fd_sc_mcu7t5v0__fillcap_4
Xfanout467 _3746_/Q wire468/I VDD VDD VSS VSS gf180mcu_fd_sc_mcu7t5v0__dlyb_1
XFILLER_58_189 VDD VDD VSS VSS gf180mcu_fd_sc_mcu7t5v0__fill_2
XTAP_TAPCELL_ROW_37_560 VDD VSS gf180mcu_fd_sc_mcu7t5v0__filltie
XFILLER_42_535 VDD VDD VSS VSS gf180mcu_fd_sc_mcu7t5v0__fill_1
XFILLER_10_465 VDD VDD VSS VSS gf180mcu_fd_sc_mcu7t5v0__fill_2
XFILLER_10_454 VDD VDD VSS VSS gf180mcu_fd_sc_mcu7t5v0__fill_1
XFILLER_89_66 VDD VDD VSS VSS gf180mcu_fd_sc_mcu7t5v0__fillcap_4
XFILLER_2_675 VDD VDD VSS VSS gf180mcu_fd_sc_mcu7t5v0__fill_2
XFILLER_77_432 VDD VDD VSS VSS gf180mcu_fd_sc_mcu7t5v0__fill_1
XTAP_TAPCELL_ROW_9_296 VDD VSS gf180mcu_fd_sc_mcu7t5v0__filltie
XFILLER_65_605 VDD VDD VSS VSS gf180mcu_fd_sc_mcu7t5v0__fill_2
XFILLER_92_457 VDD VDD VSS VSS gf180mcu_fd_sc_mcu7t5v0__fillcap_64
XFILLER_33_502 VDD VDD VSS VSS gf180mcu_fd_sc_mcu7t5v0__fillcap_8
XFILLER_45_362 VDD VDD VSS VSS gf180mcu_fd_sc_mcu7t5v0__fillcap_8
XTAP_TAPCELL_ROW_63_806 VDD VSS gf180mcu_fd_sc_mcu7t5v0__filltie
X_1991_ _2006_/B _1989_/Z _1991_/Z VDD VDD VSS VSS gf180mcu_fd_sc_mcu7t5v0__xor2_1
XFILLER_60_387 VDD VDD VSS VSS gf180mcu_fd_sc_mcu7t5v0__fillcap_4
X_3730_ _3730_/D _3731_/RN clkload3/I _3730_/Q VDD VDD VSS VSS gf180mcu_fd_sc_mcu7t5v0__dffrnq_2
XTAP_TAPCELL_ROW_71_883 VDD VSS gf180mcu_fd_sc_mcu7t5v0__filltie
X_3661_ _3661_/D wire586/I clkload2/I _3661_/Q VDD VDD VSS VSS gf180mcu_fd_sc_mcu7t5v0__dffrnq_1
X_2612_ _2195_/B _2997_/ZN _2674_/A1 VDD VDD VSS VSS gf180mcu_fd_sc_mcu7t5v0__nand2_1
Xclkload11 _3717_/CLK clkload11/Z VDD VDD VSS VSS gf180mcu_fd_sc_mcu7t5v0__clkbuf_2
X_3592_ _3606_/A1 _3592_/A2 _3592_/B _3593_/A2 VDD VDD VSS VSS gf180mcu_fd_sc_mcu7t5v0__oai21_1
X_2543_ wire421/I _2604_/B _2603_/B VDD VDD VSS VSS gf180mcu_fd_sc_mcu7t5v0__xor2_1
XFILLER_55_2 VDD VDD VSS VSS gf180mcu_fd_sc_mcu7t5v0__fillcap_64
X_2474_ _2474_/I _2526_/B VDD VDD VSS VSS gf180mcu_fd_sc_mcu7t5v0__clkinv_1
XTAP_TAPCELL_ROW_79_961 VDD VSS gf180mcu_fd_sc_mcu7t5v0__filltie
XFILLER_68_487 VDD VDD VSS VSS gf180mcu_fd_sc_mcu7t5v0__fillcap_16
XTAP_TAPCELL_ROW_87_1038 VDD VSS gf180mcu_fd_sc_mcu7t5v0__filltie
X_3026_ _3026_/I _3026_/ZN VDD VDD VSS VSS gf180mcu_fd_sc_mcu7t5v0__clkinv_1
XFILLER_70_107 VDD VDD VSS VSS gf180mcu_fd_sc_mcu7t5v0__fillcap_64
XFILLER_24_524 VDD VDD VSS VSS gf180mcu_fd_sc_mcu7t5v0__fill_1
XFILLER_36_384 VDD VDD VSS VSS gf180mcu_fd_sc_mcu7t5v0__fill_1
XFILLER_51_310 VDD VDD VSS VSS gf180mcu_fd_sc_mcu7t5v0__fillcap_4
XTAP_TAPCELL_ROW_34_530 VDD VSS gf180mcu_fd_sc_mcu7t5v0__filltie
XFILLER_11_218 VDD VDD VSS VSS gf180mcu_fd_sc_mcu7t5v0__fill_1
Xclkload5 clkload5/I clkload5/Z VDD VDD VSS VSS gf180mcu_fd_sc_mcu7t5v0__clkbuf_2
XTAP_TAPCELL_ROW_6_266 VDD VSS gf180mcu_fd_sc_mcu7t5v0__filltie
XFILLER_47_605 VDD VDD VSS VSS gf180mcu_fd_sc_mcu7t5v0__fill_2
Xfanout242 _2918_/A1 wire243/I VDD VDD VSS VSS gf180mcu_fd_sc_mcu7t5v0__dlyb_1
Xfanout253 wire264/I wire255/I VDD VDD VSS VSS gf180mcu_fd_sc_mcu7t5v0__dlyb_1
XFILLER_59_476 VDD VDD VSS VSS gf180mcu_fd_sc_mcu7t5v0__fillcap_4
XFILLER_86_295 VDD VDD VSS VSS gf180mcu_fd_sc_mcu7t5v0__fillcap_16
XFILLER_74_457 VDD VDD VSS VSS gf180mcu_fd_sc_mcu7t5v0__fillcap_8
XFILLER_74_446 VDD VDD VSS VSS gf180mcu_fd_sc_mcu7t5v0__fill_2
XFILLER_15_557 VDD VDD VSS VSS gf180mcu_fd_sc_mcu7t5v0__fill_2
XFILLER_30_527 VDD VDD VSS VSS gf180mcu_fd_sc_mcu7t5v0__fillcap_64
Xwire643 _3008_/I _2696_/B VDD VDD VSS VSS gf180mcu_fd_sc_mcu7t5v0__buf_3
XFILLER_10_251 VDD VDD VSS VSS gf180mcu_fd_sc_mcu7t5v0__fill_1
Xwire632 input5/Z wire632/Z VDD VDD VSS VSS gf180mcu_fd_sc_mcu7t5v0__buf_2
XFILLER_6_244 VDD VDD VSS VSS gf180mcu_fd_sc_mcu7t5v0__fill_1
XTAP_TAPCELL_ROW_40_588 VDD VSS gf180mcu_fd_sc_mcu7t5v0__filltie
XFILLER_6_288 VDD VDD VSS VSS gf180mcu_fd_sc_mcu7t5v0__fillcap_16
Xload_slew615 wire616/Z _3690_/RN VDD VDD VSS VSS gf180mcu_fd_sc_mcu7t5v0__clkbuf_2
Xload_slew648 _3009_/I wire647/I VDD VDD VSS VSS gf180mcu_fd_sc_mcu7t5v0__clkbuf_1
X_2190_ _2190_/I _2193_/C VDD VDD VSS VSS gf180mcu_fd_sc_mcu7t5v0__clkinv_1
Xload_slew659 wire660/Z _1842_/A1 VDD VDD VSS VSS gf180mcu_fd_sc_mcu7t5v0__buf_1
XFILLER_37_104 VDD VDD VSS VSS gf180mcu_fd_sc_mcu7t5v0__fillcap_8
XTAP_TAPCELL_ROW_76_931 VDD VSS gf180mcu_fd_sc_mcu7t5v0__filltie
XTAP_TAPCELL_ROW_48_666 VDD VSS gf180mcu_fd_sc_mcu7t5v0__filltie
XFILLER_52_107 VDD VDD VSS VSS gf180mcu_fd_sc_mcu7t5v0__fillcap_16
XFILLER_65_468 VDD VDD VSS VSS gf180mcu_fd_sc_mcu7t5v0__fill_2
XFILLER_80_438 VDD VDD VSS VSS gf180mcu_fd_sc_mcu7t5v0__fill_2
XFILLER_18_384 VDD VDD VSS VSS gf180mcu_fd_sc_mcu7t5v0__fill_1
XTAP_TAPCELL_ROW_31_500 VDD VSS gf180mcu_fd_sc_mcu7t5v0__filltie
XFILLER_60_173 VDD VDD VSS VSS gf180mcu_fd_sc_mcu7t5v0__fill_2
X_1974_ _2005_/A1 _2005_/A3 _2004_/A2 VDD VDD VSS VSS gf180mcu_fd_sc_mcu7t5v0__nor2_1
X_3713_ _3713_/D wire612/Z _3715_/CLK _3713_/Q VDD VDD VSS VSS gf180mcu_fd_sc_mcu7t5v0__dffrnq_1
X_3644_ _3077_/I _3642_/Z _3646_/A2 VDD VDD VSS VSS gf180mcu_fd_sc_mcu7t5v0__nand2_1
X_3575_ _3563_/B _3541_/Z _3577_/B _3561_/I _3606_/A2 VDD VDD VSS VSS gf180mcu_fd_sc_mcu7t5v0__nand4_1
X_2526_ _2526_/A1 _2526_/A2 _2526_/B _2555_/A1 VDD VDD VSS VSS gf180mcu_fd_sc_mcu7t5v0__oai21_1
XFILLER_88_527 VDD VDD VSS VSS gf180mcu_fd_sc_mcu7t5v0__fill_2
X_2457_ _3653_/Q _2994_/ZN _2458_/A2 VDD VDD VSS VSS gf180mcu_fd_sc_mcu7t5v0__nand2_1
XFILLER_29_638 VDD VDD VSS VSS gf180mcu_fd_sc_mcu7t5v0__fill_2
X_2388_ _2388_/A1 _2386_/Z _2388_/A3 _2388_/B1 _3086_/ZN _3738_/D VDD VDD VSS VSS
+ gf180mcu_fd_sc_mcu7t5v0__oai32_1
XFILLER_56_402 VDD VDD VSS VSS gf180mcu_fd_sc_mcu7t5v0__fillcap_8
XTAP_TAPCELL_ROW_3_236 VDD VSS gf180mcu_fd_sc_mcu7t5v0__filltie
XFILLER_56_435 VDD VDD VSS VSS gf180mcu_fd_sc_mcu7t5v0__fillcap_16
XFILLER_83_276 VDD VDD VSS VSS gf180mcu_fd_sc_mcu7t5v0__fillcap_4
XFILLER_71_405 VDD VDD VSS VSS gf180mcu_fd_sc_mcu7t5v0__fillcap_8
X_3009_ _3009_/I _3491_/A1 VDD VDD VSS VSS gf180mcu_fd_sc_mcu7t5v0__inv_2
XTAP_TAPCELL_ROW_19_390 VDD VSS gf180mcu_fd_sc_mcu7t5v0__filltie
XFILLER_24_343 VDD VDD VSS VSS gf180mcu_fd_sc_mcu7t5v0__fillcap_4
XTAP_TAPCELL_ROW_82_989 VDD VSS gf180mcu_fd_sc_mcu7t5v0__filltie
XFILLER_24_387 VDD VDD VSS VSS gf180mcu_fd_sc_mcu7t5v0__fill_2
XFILLER_20_593 VDD VDD VSS VSS gf180mcu_fd_sc_mcu7t5v0__fill_2
XFILLER_86_34 VDD VDD VSS VSS gf180mcu_fd_sc_mcu7t5v0__fill_1
XFILLER_87_582 VDD VDD VSS VSS gf180mcu_fd_sc_mcu7t5v0__fill_1
XFILLER_19_72 VDD VDD VSS VSS gf180mcu_fd_sc_mcu7t5v0__fillcap_64
XFILLER_62_405 VDD VDD VSS VSS gf180mcu_fd_sc_mcu7t5v0__fillcap_8
XTAP_TAPCELL_ROW_73_901 VDD VSS gf180mcu_fd_sc_mcu7t5v0__filltie
XFILLER_34_107 VDD VDD VSS VSS gf180mcu_fd_sc_mcu7t5v0__fillcap_8
XTAP_TAPCELL_ROW_45_636 VDD VSS gf180mcu_fd_sc_mcu7t5v0__filltie
XFILLER_15_343 VDD VDD VSS VSS gf180mcu_fd_sc_mcu7t5v0__fillcap_4
XFILLER_30_379 VDD VDD VSS VSS gf180mcu_fd_sc_mcu7t5v0__fill_1
XFILLER_7_531 VDD VDD VSS VSS gf180mcu_fd_sc_mcu7t5v0__fillcap_8
Xwire451 _3752_/Q wire451/Z VDD VDD VSS VSS gf180mcu_fd_sc_mcu7t5v0__clkbuf_2
Xwire462 wire462/I wire462/Z VDD VDD VSS VSS gf180mcu_fd_sc_mcu7t5v0__clkbuf_2
Xwire495 _3695_/Q _3050_/I VDD VDD VSS VSS gf180mcu_fd_sc_mcu7t5v0__buf_2
X_3360_ _3360_/A1 _3360_/A2 _3360_/B _3420_/A1 VDD VDD VSS VSS gf180mcu_fd_sc_mcu7t5v0__aoi21_1
Xload_slew412 _3226_/A2 _3225_/A2 VDD VDD VSS VSS gf180mcu_fd_sc_mcu7t5v0__clkbuf_2
X_2311_ _2309_/I _2331_/A1 _2412_/A1 VDD VDD VSS VSS gf180mcu_fd_sc_mcu7t5v0__nand2_1
Xload_slew401 wire400/I _3088_/I VDD VDD VSS VSS gf180mcu_fd_sc_mcu7t5v0__buf_1
Xload_slew434 _2973_/I _3222_/A1 VDD VDD VSS VSS gf180mcu_fd_sc_mcu7t5v0__buf_1
X_3291_ _3292_/A1 _3292_/A2 _3293_/B VDD VDD VSS VSS gf180mcu_fd_sc_mcu7t5v0__nor2_1
XFILLER_2_280 VDD VDD VSS VSS gf180mcu_fd_sc_mcu7t5v0__fill_1
Xload_slew445 _3124_/A2 _2354_/A1 VDD VDD VSS VSS gf180mcu_fd_sc_mcu7t5v0__buf_2
Xload_slew423 wire422/I wire421/I VDD VDD VSS VSS gf180mcu_fd_sc_mcu7t5v0__buf_2
X_2242_ _2242_/A1 _2242_/A2 _2242_/B _2243_/A2 VDD VDD VSS VSS gf180mcu_fd_sc_mcu7t5v0__aoi21_1
Xload_slew489 _3703_/Q _3066_/I VDD VDD VSS VSS gf180mcu_fd_sc_mcu7t5v0__buf_2
XFILLER_18_2 VDD VDD VSS VSS gf180mcu_fd_sc_mcu7t5v0__fillcap_32
X_2173_ _3107_/B2 _2168_/I _2176_/A2 _2620_/A1 _2177_/A2 VDD VDD VSS VSS gf180mcu_fd_sc_mcu7t5v0__aoi22_1
XTAP_TAPCELL_ROW_0_206 VDD VSS gf180mcu_fd_sc_mcu7t5v0__filltie
XTAP_TAPCELL_ROW_84_1008 VDD VSS gf180mcu_fd_sc_mcu7t5v0__filltie
XFILLER_65_287 VDD VDD VSS VSS gf180mcu_fd_sc_mcu7t5v0__fillcap_8
XTAP_TAPCELL_ROW_16_360 VDD VSS gf180mcu_fd_sc_mcu7t5v0__filltie
X_1957_ _1953_/Z _1957_/A2 _1998_/A1 VDD VDD VSS VSS gf180mcu_fd_sc_mcu7t5v0__xnor2_1
X_1888_ _1888_/A1 _1888_/A2 _1888_/B1 _1871_/Z _1888_/C _1890_/A3 VDD VDD VSS VSS
+ gf180mcu_fd_sc_mcu7t5v0__oai221_2
X_3627_ _3627_/A1 _3077_/I _3641_/A1 VDD VDD VSS VSS gf180mcu_fd_sc_mcu7t5v0__nand2_1
X_3558_ _3558_/A1 _3558_/A2 _3555_/Z _3559_/B VDD VDD VSS VSS gf180mcu_fd_sc_mcu7t5v0__xor3_1
X_2509_ _2645_/A1 _3022_/I _2560_/B VDD VDD VSS VSS gf180mcu_fd_sc_mcu7t5v0__xor2_1
XFILLER_0_206 VDD VDD VSS VSS gf180mcu_fd_sc_mcu7t5v0__fillcap_32
X_3489_ wire646/Z _3492_/A3 _3507_/B VDD VDD VSS VSS gf180mcu_fd_sc_mcu7t5v0__nor2_1
XFILLER_76_519 VDD VDD VSS VSS gf180mcu_fd_sc_mcu7t5v0__fillcap_4
XFILLER_56_37 VDD VDD VSS VSS gf180mcu_fd_sc_mcu7t5v0__fillcap_64
XFILLER_16_107 VDD VDD VSS VSS gf180mcu_fd_sc_mcu7t5v0__fillcap_64
XTAP_TAPCELL_ROW_42_606 VDD VSS gf180mcu_fd_sc_mcu7t5v0__filltie
XFILLER_52_493 VDD VDD VSS VSS gf180mcu_fd_sc_mcu7t5v0__fillcap_8
XTAP_TAPCELL_ROW_50_683 VDD VSS gf180mcu_fd_sc_mcu7t5v0__filltie
XFILLER_79_346 VDD VDD VSS VSS gf180mcu_fd_sc_mcu7t5v0__fillcap_4
XFILLER_79_357 VDD VDD VSS VSS gf180mcu_fd_sc_mcu7t5v0__fillcap_8
XFILLER_75_530 VDD VDD VSS VSS gf180mcu_fd_sc_mcu7t5v0__fill_2
XTAP_TAPCELL_ROW_58_761 VDD VSS gf180mcu_fd_sc_mcu7t5v0__filltie
XFILLER_35_438 VDD VDD VSS VSS gf180mcu_fd_sc_mcu7t5v0__fill_1
X_2860_ _2920_/A1 wire267/I _2862_/B1 VDD VDD VSS VSS gf180mcu_fd_sc_mcu7t5v0__nor2_1
XFILLER_43_482 VDD VDD VSS VSS gf180mcu_fd_sc_mcu7t5v0__fill_2
XTAP_TAPCELL_ROW_13_330 VDD VSS gf180mcu_fd_sc_mcu7t5v0__filltie
X_1811_ _1865_/A1 _1811_/A2 _1813_/A2 VDD VDD VSS VSS gf180mcu_fd_sc_mcu7t5v0__nor2_1
X_2791_ _3736_/Q _2792_/A2 _2792_/B VDD VDD VSS VSS gf180mcu_fd_sc_mcu7t5v0__nand2_1
Xwire281 wire281/I wire281/Z VDD VDD VSS VSS gf180mcu_fd_sc_mcu7t5v0__clkbuf_1
Xwire292 wire292/I wire292/Z VDD VDD VSS VSS gf180mcu_fd_sc_mcu7t5v0__dlyb_1
X_3412_ _3405_/Z _3412_/A2 _3412_/B _3429_/A1 VDD VDD VSS VSS gf180mcu_fd_sc_mcu7t5v0__aoi21_1
X_3343_ _3344_/A1 _3344_/A2 _3345_/B VDD VDD VSS VSS gf180mcu_fd_sc_mcu7t5v0__nor2_1
XTAP_TAPCELL_ROW_90_1067 VDD VSS gf180mcu_fd_sc_mcu7t5v0__filltie
X_3274_ _3281_/B _3274_/A2 _3275_/A2 VDD VDD VSS VSS gf180mcu_fd_sc_mcu7t5v0__nand2_1
X_2225_ _3083_/ZN _2225_/A2 _2225_/B _2226_/A2 VDD VDD VSS VSS gf180mcu_fd_sc_mcu7t5v0__oai21_1
XFILLER_38_243 VDD VDD VSS VSS gf180mcu_fd_sc_mcu7t5v0__fill_2
XFILLER_81_511 VDD VDD VSS VSS gf180mcu_fd_sc_mcu7t5v0__fillcap_8
X_2156_ _3691_/Q _3670_/Q _2161_/S _2156_/Z VDD VDD VSS VSS gf180mcu_fd_sc_mcu7t5v0__mux2_2
X_2087_ _2098_/A1 _2087_/A2 _2088_/A2 VDD VDD VSS VSS gf180mcu_fd_sc_mcu7t5v0__nor2_1
XFILLER_81_544 VDD VDD VSS VSS gf180mcu_fd_sc_mcu7t5v0__fillcap_4
XPHY_EDGE_ROW_5_Right_5 VDD VSS gf180mcu_fd_sc_mcu7t5v0__endcap
X_2989_ _3743_/Q _3103_/B2 VDD VDD VSS VSS gf180mcu_fd_sc_mcu7t5v0__clkinv_1
XFILLER_49_508 VDD VDD VSS VSS gf180mcu_fd_sc_mcu7t5v0__fillcap_8
XFILLER_17_405 VDD VDD VSS VSS gf180mcu_fd_sc_mcu7t5v0__fill_2
XFILLER_84_393 VDD VDD VSS VSS gf180mcu_fd_sc_mcu7t5v0__fill_1
XFILLER_29_298 VDD VDD VSS VSS gf180mcu_fd_sc_mcu7t5v0__fill_2
XTAP_TAPCELL_ROW_55_731 VDD VSS gf180mcu_fd_sc_mcu7t5v0__filltie
XTAP_TAPCELL_ROW_27_466 VDD VSS gf180mcu_fd_sc_mcu7t5v0__filltie
XFILLER_40_452 VDD VDD VSS VSS gf180mcu_fd_sc_mcu7t5v0__fill_2
XTAP_TAPCELL_ROW_10_300 VDD VSS gf180mcu_fd_sc_mcu7t5v0__filltie
XFILLER_9_659 VDD VDD VSS VSS gf180mcu_fd_sc_mcu7t5v0__fill_1
X_2010_ _3196_/A2 _3066_/I _2028_/A1 VDD VDD VSS VSS gf180mcu_fd_sc_mcu7t5v0__nor2_1
X_2912_ _3747_/Q _2912_/A2 _2957_/A2 VDD VDD VSS VSS gf180mcu_fd_sc_mcu7t5v0__nand2_1
XFILLER_31_430 VDD VDD VSS VSS gf180mcu_fd_sc_mcu7t5v0__fillcap_4
XFILLER_85_2 VDD VDD VSS VSS gf180mcu_fd_sc_mcu7t5v0__fillcap_64
X_2843_ _3671_/Q _2843_/A2 _2843_/B _2844_/B2 VDD VDD VSS VSS gf180mcu_fd_sc_mcu7t5v0__oai21_1
XTAP_TAPCELL_ROW_61_789 VDD VSS gf180mcu_fd_sc_mcu7t5v0__filltie
X_2774_ wire275/Z _2777_/A2 _2775_/B2 VDD VDD VSS VSS gf180mcu_fd_sc_mcu7t5v0__nand2_1
Xfanout605 fanout610/Z _3673_/RN VDD VDD VSS VSS gf180mcu_fd_sc_mcu7t5v0__dlyb_1
Xfanout627 wire632/Z wire630/I VDD VDD VSS VSS gf180mcu_fd_sc_mcu7t5v0__dlyb_1
XPHY_EDGE_ROW_13_Left_110 VDD VSS gf180mcu_fd_sc_mcu7t5v0__endcap
X_3326_ _3326_/A1 _3326_/A2 _3326_/B _3328_/A2 VDD VDD VSS VSS gf180mcu_fd_sc_mcu7t5v0__aoi21_1
XFILLER_58_305 VDD VDD VSS VSS gf180mcu_fd_sc_mcu7t5v0__fill_2
X_3257_ _3326_/A1 _3326_/A2 _3339_/B VDD VDD VSS VSS gf180mcu_fd_sc_mcu7t5v0__nand2_2
XTAP_TAPCELL_ROW_69_867 VDD VSS gf180mcu_fd_sc_mcu7t5v0__filltie
XFILLER_26_213 VDD VDD VSS VSS gf180mcu_fd_sc_mcu7t5v0__fill_2
X_2208_ _2208_/A1 _2205_/Z _2208_/B _2208_/C _2210_/A2 VDD VDD VSS VSS gf180mcu_fd_sc_mcu7t5v0__aoi211_2
XFILLER_54_500 VDD VDD VSS VSS gf180mcu_fd_sc_mcu7t5v0__fill_2
X_3188_ _3189_/A1 _3189_/B _3189_/A2 _3188_/Z VDD VDD VSS VSS gf180mcu_fd_sc_mcu7t5v0__and3_1
XFILLER_81_330 VDD VDD VSS VSS gf180mcu_fd_sc_mcu7t5v0__fillcap_16
XFILLER_26_224 VDD VDD VSS VSS gf180mcu_fd_sc_mcu7t5v0__fillcap_8
X_2139_ _3581_/A1 wire388/Z _2139_/B _2206_/B VDD VDD VSS VSS gf180mcu_fd_sc_mcu7t5v0__oai21_1
XFILLER_81_352 VDD VDD VSS VSS gf180mcu_fd_sc_mcu7t5v0__fillcap_8
XTAP_TAPCELL_ROW_52_701 VDD VSS gf180mcu_fd_sc_mcu7t5v0__filltie
XTAP_TAPCELL_ROW_24_436 VDD VSS gf180mcu_fd_sc_mcu7t5v0__filltie
XFILLER_22_452 VDD VDD VSS VSS gf180mcu_fd_sc_mcu7t5v0__fill_2
XFILLER_6_607 VDD VDD VSS VSS gf180mcu_fd_sc_mcu7t5v0__fill_2
XFILLER_22_496 VDD VDD VSS VSS gf180mcu_fd_sc_mcu7t5v0__fillcap_8
XFILLER_94_34 VDD VDD VSS VSS gf180mcu_fd_sc_mcu7t5v0__fill_1
XFILLER_45_500 VDD VDD VSS VSS gf180mcu_fd_sc_mcu7t5v0__fillcap_4
XFILLER_64_319 VDD VDD VSS VSS gf180mcu_fd_sc_mcu7t5v0__fill_1
XFILLER_27_72 VDD VDD VSS VSS gf180mcu_fd_sc_mcu7t5v0__fillcap_64
XFILLER_45_599 VDD VDD VSS VSS gf180mcu_fd_sc_mcu7t5v0__fill_1
XFILLER_40_271 VDD VDD VSS VSS gf180mcu_fd_sc_mcu7t5v0__fill_1
Xoutput208 _3720_/Q raw_edge3[10] VDD VDD VSS VSS gf180mcu_fd_sc_mcu7t5v0__buf_2
X_2490_ _3741_/Q _3026_/ZN _2490_/B _2571_/A2 VDD VDD VSS VSS gf180mcu_fd_sc_mcu7t5v0__aoi21_1
Xoutput219 wire476/Z raw_edge3[20] VDD VDD VSS VSS gf180mcu_fd_sc_mcu7t5v0__buf_2
XFILLER_95_422 VDD VDD VSS VSS gf180mcu_fd_sc_mcu7t5v0__fillcap_64
X_3111_ input39/Z _2186_/B _3111_/B1 input38/Z _3113_/B2 VDD VDD VSS VSS gf180mcu_fd_sc_mcu7t5v0__oai22_1
X_3042_ _3668_/Q _3355_/A1 VDD VDD VSS VSS gf180mcu_fd_sc_mcu7t5v0__clkinv_1
XTAP_TAPCELL_ROW_66_837 VDD VSS gf180mcu_fd_sc_mcu7t5v0__filltie
XFILLER_36_588 VDD VDD VSS VSS gf180mcu_fd_sc_mcu7t5v0__fill_2
XFILLER_63_352 VDD VDD VSS VSS gf180mcu_fd_sc_mcu7t5v0__fillcap_4
XFILLER_90_171 VDD VDD VSS VSS gf180mcu_fd_sc_mcu7t5v0__fillcap_4
XFILLER_23_249 VDD VDD VSS VSS gf180mcu_fd_sc_mcu7t5v0__fill_2
XFILLER_51_558 VDD VDD VSS VSS gf180mcu_fd_sc_mcu7t5v0__fill_2
XTAP_TAPCELL_ROW_21_406 VDD VSS gf180mcu_fd_sc_mcu7t5v0__filltie
XFILLER_31_282 VDD VDD VSS VSS gf180mcu_fd_sc_mcu7t5v0__fillcap_4
X_2826_ _2826_/A1 _2826_/A2 _3763_/Q _2827_/A3 VDD VDD VSS VSS gf180mcu_fd_sc_mcu7t5v0__oai21_1
X_2757_ _2757_/A1 _2757_/A2 _2831_/A2 _2758_/A2 VDD VDD VSS VSS gf180mcu_fd_sc_mcu7t5v0__nand3_1
X_2688_ wire624/I _2687_/Z _2723_/C VDD VDD VSS VSS gf180mcu_fd_sc_mcu7t5v0__nor2_1
Xfanout402 _3761_/Q _3281_/B VDD VDD VSS VSS gf180mcu_fd_sc_mcu7t5v0__dlyb_1
X_3309_ _3332_/A1 _3309_/A2 _3271_/B _3285_/B _3310_/A3 VDD VDD VSS VSS gf180mcu_fd_sc_mcu7t5v0__nand4_1
XFILLER_64_37 VDD VDD VSS VSS gf180mcu_fd_sc_mcu7t5v0__fillcap_64
XTAP_TAPCELL_ROW_37_561 VDD VSS gf180mcu_fd_sc_mcu7t5v0__filltie
XFILLER_22_271 VDD VDD VSS VSS gf180mcu_fd_sc_mcu7t5v0__fillcap_4
XFILLER_22_282 VDD VDD VSS VSS gf180mcu_fd_sc_mcu7t5v0__fill_1
XFILLER_6_448 VDD VDD VSS VSS gf180mcu_fd_sc_mcu7t5v0__fillcap_4
XFILLER_1_142 VDD VDD VSS VSS gf180mcu_fd_sc_mcu7t5v0__fillcap_64
XFILLER_89_282 VDD VDD VSS VSS gf180mcu_fd_sc_mcu7t5v0__fillcap_64
XFILLER_77_422 VDD VDD VSS VSS gf180mcu_fd_sc_mcu7t5v0__fillcap_8
XTAP_TAPCELL_ROW_9_297 VDD VSS gf180mcu_fd_sc_mcu7t5v0__filltie
XFILLER_77_455 VDD VDD VSS VSS gf180mcu_fd_sc_mcu7t5v0__fill_2
XTAP_TAPCELL_ROW_63_807 VDD VSS gf180mcu_fd_sc_mcu7t5v0__filltie
XFILLER_45_374 VDD VDD VSS VSS gf180mcu_fd_sc_mcu7t5v0__fill_2
XFILLER_60_311 VDD VDD VSS VSS gf180mcu_fd_sc_mcu7t5v0__fillcap_4
XFILLER_72_171 VDD VDD VSS VSS gf180mcu_fd_sc_mcu7t5v0__fillcap_4
X_1990_ _3701_/Q _1989_/Z _2021_/A2 VDD VDD VSS VSS gf180mcu_fd_sc_mcu7t5v0__nand2_1
XFILLER_33_547 VDD VDD VSS VSS gf180mcu_fd_sc_mcu7t5v0__fill_2
XTAP_TAPCELL_ROW_71_884 VDD VSS gf180mcu_fd_sc_mcu7t5v0__filltie
X_3660_ _3660_/D wire554/I clkload8/I _3660_/Q VDD VDD VSS VSS gf180mcu_fd_sc_mcu7t5v0__dffrnq_2
X_2611_ _3656_/Q _3081_/ZN _2740_/A1 VDD VDD VSS VSS gf180mcu_fd_sc_mcu7t5v0__nand2_1
Xclkload12 _3721_/CLK clkload12/Z VDD VDD VSS VSS gf180mcu_fd_sc_mcu7t5v0__clkbuf_2
X_3591_ _3608_/C _3590_/Z _3593_/A1 VDD VDD VSS VSS gf180mcu_fd_sc_mcu7t5v0__nor2_1
X_2542_ _2734_/C _2604_/B _2599_/A1 VDD VDD VSS VSS gf180mcu_fd_sc_mcu7t5v0__nor2_1
XFILLER_5_492 VDD VDD VSS VSS gf180mcu_fd_sc_mcu7t5v0__fillcap_16
XFILLER_5_470 VDD VDD VSS VSS gf180mcu_fd_sc_mcu7t5v0__fillcap_8
X_2473_ _2977_/I input64/Z _2474_/I VDD VDD VSS VSS gf180mcu_fd_sc_mcu7t5v0__xor2_1
XFILLER_48_2 VDD VDD VSS VSS gf180mcu_fd_sc_mcu7t5v0__fillcap_32
XTAP_TAPCELL_ROW_79_962 VDD VSS gf180mcu_fd_sc_mcu7t5v0__filltie
XFILLER_68_477 VDD VDD VSS VSS gf180mcu_fd_sc_mcu7t5v0__fill_1
X_3025_ _3025_/I _3025_/ZN VDD VDD VSS VSS gf180mcu_fd_sc_mcu7t5v0__clkinv_1
XFILLER_24_547 VDD VDD VSS VSS gf180mcu_fd_sc_mcu7t5v0__fill_2
XTAP_TAPCELL_ROW_34_531 VDD VSS gf180mcu_fd_sc_mcu7t5v0__filltie
Xclkload6 clkload6/I clkload6/Z VDD VDD VSS VSS gf180mcu_fd_sc_mcu7t5v0__clkbuf_2
X_2809_ _3094_/ZN _2809_/A2 _2809_/B1 _2809_/B2 _3665_/D VDD VDD VSS VSS gf180mcu_fd_sc_mcu7t5v0__oai22_1
Xfanout232 wire235/I wire233/I VDD VDD VSS VSS gf180mcu_fd_sc_mcu7t5v0__dlyb_1
XFILLER_59_422 VDD VDD VSS VSS gf180mcu_fd_sc_mcu7t5v0__fillcap_4
XFILLER_86_241 VDD VDD VSS VSS gf180mcu_fd_sc_mcu7t5v0__fillcap_4
XTAP_TAPCELL_ROW_6_267 VDD VSS gf180mcu_fd_sc_mcu7t5v0__filltie
Xfanout265 _2848_/A2 wire267/I VDD VDD VSS VSS gf180mcu_fd_sc_mcu7t5v0__dlyb_1
Xfanout276 _2262_/Z _2265_/B2 VDD VDD VSS VSS gf180mcu_fd_sc_mcu7t5v0__dlyb_1
XFILLER_74_425 VDD VDD VSS VSS gf180mcu_fd_sc_mcu7t5v0__fillcap_4
XFILLER_42_377 VDD VDD VSS VSS gf180mcu_fd_sc_mcu7t5v0__fillcap_8
XFILLER_10_230 VDD VDD VSS VSS gf180mcu_fd_sc_mcu7t5v0__fill_2
Xwire622 wire622/I wire622/Z VDD VDD VSS VSS gf180mcu_fd_sc_mcu7t5v0__buf_1
XTAP_TAPCELL_ROW_40_589 VDD VSS gf180mcu_fd_sc_mcu7t5v0__filltie
Xwire655 wire656/Z wire655/Z VDD VDD VSS VSS gf180mcu_fd_sc_mcu7t5v0__buf_2
XTAP_TAPCELL_ROW_76_932 VDD VSS gf180mcu_fd_sc_mcu7t5v0__filltie
XFILLER_37_138 VDD VDD VSS VSS gf180mcu_fd_sc_mcu7t5v0__fill_2
XFILLER_1_66 VDD VDD VSS VSS gf180mcu_fd_sc_mcu7t5v0__fillcap_4
XTAP_TAPCELL_ROW_48_667 VDD VSS gf180mcu_fd_sc_mcu7t5v0__filltie
XFILLER_80_417 VDD VDD VSS VSS gf180mcu_fd_sc_mcu7t5v0__fillcap_4
XFILLER_33_333 VDD VDD VSS VSS gf180mcu_fd_sc_mcu7t5v0__fill_1
XTAP_TAPCELL_ROW_31_501 VDD VSS gf180mcu_fd_sc_mcu7t5v0__filltie
XFILLER_60_185 VDD VDD VSS VSS gf180mcu_fd_sc_mcu7t5v0__fillcap_4
X_1973_ _1932_/I _1973_/A2 _2005_/A3 VDD VDD VSS VSS gf180mcu_fd_sc_mcu7t5v0__nor2_1
X_3712_ _3712_/D _3712_/RN _3715_/CLK _3712_/Q VDD VDD VSS VSS gf180mcu_fd_sc_mcu7t5v0__dffrnq_2
X_3643_ _3077_/I _3642_/Z _3643_/Z VDD VDD VSS VSS gf180mcu_fd_sc_mcu7t5v0__or2_1
X_3574_ _3571_/Z _3574_/A2 _3606_/A1 VDD VDD VSS VSS gf180mcu_fd_sc_mcu7t5v0__xnor2_2
X_2525_ _2525_/I _2526_/A2 VDD VDD VSS VSS gf180mcu_fd_sc_mcu7t5v0__clkinv_1
XTAP_TAPCELL_ROW_93_1087 VDD VSS gf180mcu_fd_sc_mcu7t5v0__filltie
X_2456_ _3652_/Q _2459_/A1 _2460_/A1 VDD VDD VSS VSS gf180mcu_fd_sc_mcu7t5v0__nand2_1
X_2387_ _3737_/Q _2387_/A2 _3738_/Q _2388_/A3 VDD VDD VSS VSS gf180mcu_fd_sc_mcu7t5v0__aoi21_1
XFILLER_68_241 VDD VDD VSS VSS gf180mcu_fd_sc_mcu7t5v0__fillcap_4
XFILLER_68_263 VDD VDD VSS VSS gf180mcu_fd_sc_mcu7t5v0__fillcap_8
XTAP_TAPCELL_ROW_3_237 VDD VSS gf180mcu_fd_sc_mcu7t5v0__filltie
X_3008_ _3008_/I _3178_/A1 VDD VDD VSS VSS gf180mcu_fd_sc_mcu7t5v0__inv_2
XFILLER_71_417 VDD VDD VSS VSS gf180mcu_fd_sc_mcu7t5v0__fill_2
XTAP_TAPCELL_ROW_19_391 VDD VSS gf180mcu_fd_sc_mcu7t5v0__filltie
XFILLER_24_333 VDD VDD VSS VSS gf180mcu_fd_sc_mcu7t5v0__fillcap_4
XFILLER_36_193 VDD VDD VSS VSS gf180mcu_fd_sc_mcu7t5v0__fillcap_4
XFILLER_24_355 VDD VDD VSS VSS gf180mcu_fd_sc_mcu7t5v0__fillcap_16
XFILLER_51_174 VDD VDD VSS VSS gf180mcu_fd_sc_mcu7t5v0__fillcap_8
XPHY_EDGE_ROW_5_Left_102 VDD VSS gf180mcu_fd_sc_mcu7t5v0__endcap
XFILLER_47_436 VDD VDD VSS VSS gf180mcu_fd_sc_mcu7t5v0__fill_1
XFILLER_47_447 VDD VDD VSS VSS gf180mcu_fd_sc_mcu7t5v0__fill_1
XFILLER_28_650 VDD VDD VSS VSS gf180mcu_fd_sc_mcu7t5v0__fill_1
XTAP_TAPCELL_ROW_73_902 VDD VSS gf180mcu_fd_sc_mcu7t5v0__filltie
XTAP_TAPCELL_ROW_45_637 VDD VSS gf180mcu_fd_sc_mcu7t5v0__filltie
XFILLER_35_72 VDD VDD VSS VSS gf180mcu_fd_sc_mcu7t5v0__fillcap_8
XFILLER_43_675 VDD VDD VSS VSS gf180mcu_fd_sc_mcu7t5v0__fill_2
XFILLER_42_174 VDD VDD VSS VSS gf180mcu_fd_sc_mcu7t5v0__fill_1
Xwire496 _3694_/Q _3048_/I VDD VDD VSS VSS gf180mcu_fd_sc_mcu7t5v0__buf_2
X_2310_ _2413_/A1 _3168_/A1 _2331_/A1 VDD VDD VSS VSS gf180mcu_fd_sc_mcu7t5v0__nand2_1
X_3290_ _3288_/Z _3290_/A2 _3290_/B _3292_/A2 VDD VDD VSS VSS gf180mcu_fd_sc_mcu7t5v0__oai21_1
Xload_slew413 _3244_/A2 _3226_/A2 VDD VDD VSS VSS gf180mcu_fd_sc_mcu7t5v0__clkbuf_2
X_2241_ _2241_/A1 _2241_/A2 _2241_/A3 _2242_/A2 VDD VDD VSS VSS gf180mcu_fd_sc_mcu7t5v0__nand3_1
XFILLER_78_550 VDD VDD VSS VSS gf180mcu_fd_sc_mcu7t5v0__fill_1
Xload_slew457 _2982_/I _2645_/A1 VDD VDD VSS VSS gf180mcu_fd_sc_mcu7t5v0__clkbuf_1
Xload_slew479 _3725_/Q _2282_/A1 VDD VDD VSS VSS gf180mcu_fd_sc_mcu7t5v0__buf_2
X_2172_ _3415_/A1 wire397/I _2172_/B _2176_/A2 VDD VDD VSS VSS gf180mcu_fd_sc_mcu7t5v0__oai21_1
XTAP_TAPCELL_ROW_0_207 VDD VSS gf180mcu_fd_sc_mcu7t5v0__filltie
XFILLER_26_609 VDD VDD VSS VSS gf180mcu_fd_sc_mcu7t5v0__fill_2
XPHY_EDGE_ROW_69_Left_166 VDD VSS gf180mcu_fd_sc_mcu7t5v0__endcap
XTAP_TAPCELL_ROW_84_1009 VDD VSS gf180mcu_fd_sc_mcu7t5v0__filltie
XFILLER_65_277 VDD VDD VSS VSS gf180mcu_fd_sc_mcu7t5v0__fill_2
XFILLER_80_247 VDD VDD VSS VSS gf180mcu_fd_sc_mcu7t5v0__fillcap_64
XFILLER_18_171 VDD VDD VSS VSS gf180mcu_fd_sc_mcu7t5v0__fillcap_4
XTAP_TAPCELL_ROW_16_361 VDD VSS gf180mcu_fd_sc_mcu7t5v0__filltie
X_1956_ _1953_/Z _1957_/A2 _1983_/A1 VDD VDD VSS VSS gf180mcu_fd_sc_mcu7t5v0__nand2_1
X_1887_ _1876_/I _1885_/Z _1891_/A1 VDD VDD VSS VSS gf180mcu_fd_sc_mcu7t5v0__xnor2_1
XPHY_EDGE_ROW_78_Left_175 VDD VSS gf180mcu_fd_sc_mcu7t5v0__endcap
X_3626_ _3708_/Q _3626_/A2 _3628_/A1 VDD VDD VSS VSS gf180mcu_fd_sc_mcu7t5v0__nand2_1
X_3557_ wire632/Z _3555_/Z _3572_/A2 VDD VDD VSS VSS gf180mcu_fd_sc_mcu7t5v0__nand2_1
X_2508_ _2512_/A1 _2512_/A2 _2507_/I _2560_/A2 VDD VDD VSS VSS gf180mcu_fd_sc_mcu7t5v0__nand3_1
X_3488_ _3483_/Z _3501_/A2 _3492_/A3 VDD VDD VSS VSS gf180mcu_fd_sc_mcu7t5v0__xnor2_2
X_2439_ _2443_/A2 _2443_/A3 _2441_/B VDD VDD VSS VSS gf180mcu_fd_sc_mcu7t5v0__nor2_1
XPHY_EDGE_ROW_87_Left_184 VDD VSS gf180mcu_fd_sc_mcu7t5v0__endcap
XFILLER_29_414 VDD VDD VSS VSS gf180mcu_fd_sc_mcu7t5v0__fill_1
XFILLER_56_244 VDD VDD VSS VSS gf180mcu_fd_sc_mcu7t5v0__fill_1
XFILLER_84_597 VDD VDD VSS VSS gf180mcu_fd_sc_mcu7t5v0__fill_2
XTAP_TAPCELL_ROW_42_607 VDD VSS gf180mcu_fd_sc_mcu7t5v0__filltie
XFILLER_72_37 VDD VDD VSS VSS gf180mcu_fd_sc_mcu7t5v0__fillcap_64
XFILLER_12_314 VDD VDD VSS VSS gf180mcu_fd_sc_mcu7t5v0__fill_1
XPHY_EDGE_ROW_96_Left_193 VDD VSS gf180mcu_fd_sc_mcu7t5v0__endcap
XTAP_TAPCELL_ROW_50_684 VDD VSS gf180mcu_fd_sc_mcu7t5v0__filltie
XFILLER_94_317 VDD VDD VSS VSS gf180mcu_fd_sc_mcu7t5v0__fillcap_64
XFILLER_35_417 VDD VDD VSS VSS gf180mcu_fd_sc_mcu7t5v0__fill_2
XTAP_TAPCELL_ROW_58_762 VDD VSS gf180mcu_fd_sc_mcu7t5v0__filltie
XFILLER_28_491 VDD VDD VSS VSS gf180mcu_fd_sc_mcu7t5v0__fill_1
XFILLER_50_409 VDD VDD VSS VSS gf180mcu_fd_sc_mcu7t5v0__fill_1
XTAP_TAPCELL_ROW_13_331 VDD VSS gf180mcu_fd_sc_mcu7t5v0__filltie
X_1810_ _1797_/Z _1810_/A2 _1809_/B _1811_/A2 VDD VDD VSS VSS gf180mcu_fd_sc_mcu7t5v0__nor3_1
XFILLER_30_177 VDD VDD VSS VSS gf180mcu_fd_sc_mcu7t5v0__fillcap_16
X_2790_ _3093_/ZN _2795_/A2 _2795_/C VDD VDD VSS VSS gf180mcu_fd_sc_mcu7t5v0__nor2_1
XFILLER_30_199 VDD VDD VSS VSS gf180mcu_fd_sc_mcu7t5v0__fill_1
Xwire282 wire282/I wire282/Z VDD VDD VSS VSS gf180mcu_fd_sc_mcu7t5v0__dlyb_1
XFILLER_7_362 VDD VDD VSS VSS gf180mcu_fd_sc_mcu7t5v0__fillcap_4
XFILLER_7_373 VDD VDD VSS VSS gf180mcu_fd_sc_mcu7t5v0__fill_1
X_3411_ _3443_/A1 wire287/Z _3411_/Z VDD VDD VSS VSS gf180mcu_fd_sc_mcu7t5v0__xor2_1
X_3342_ _3342_/A1 _3342_/A2 _3342_/B _3344_/A2 VDD VDD VSS VSS gf180mcu_fd_sc_mcu7t5v0__aoi21_1
XFILLER_30_2 VDD VDD VSS VSS gf180mcu_fd_sc_mcu7t5v0__fillcap_32
X_3273_ _3289_/B _3273_/A2 _3273_/A3 _3273_/B wire306/I VDD VDD VSS VSS gf180mcu_fd_sc_mcu7t5v0__oai31_2
Xload_slew254 wire255/Z _2280_/A1 VDD VDD VSS VSS gf180mcu_fd_sc_mcu7t5v0__buf_1
X_2224_ _3084_/ZN _3662_/Q _2222_/B _2225_/B VDD VDD VSS VSS gf180mcu_fd_sc_mcu7t5v0__or3_1
X_2155_ _2422_/A1 _2189_/A2 _2155_/Z VDD VDD VSS VSS gf180mcu_fd_sc_mcu7t5v0__or2_1
XFILLER_81_523 VDD VDD VSS VSS gf180mcu_fd_sc_mcu7t5v0__fill_1
XFILLER_66_575 VDD VDD VSS VSS gf180mcu_fd_sc_mcu7t5v0__fillcap_16
X_2086_ _2099_/C _2085_/Z _2097_/A2 VDD VDD VSS VSS gf180mcu_fd_sc_mcu7t5v0__nand2_1
X_2988_ _3744_/Q _3104_/B2 VDD VDD VSS VSS gf180mcu_fd_sc_mcu7t5v0__clkinv_1
X_1939_ _1939_/I _1958_/B2 VDD VDD VSS VSS gf180mcu_fd_sc_mcu7t5v0__clkinv_1
X_3609_ _3636_/A1 _3636_/A2 _3609_/Z VDD VDD VSS VSS gf180mcu_fd_sc_mcu7t5v0__and2_1
XFILLER_88_177 VDD VDD VSS VSS gf180mcu_fd_sc_mcu7t5v0__fillcap_64
XFILLER_29_277 VDD VDD VSS VSS gf180mcu_fd_sc_mcu7t5v0__fill_2
XFILLER_72_512 VDD VDD VSS VSS gf180mcu_fd_sc_mcu7t5v0__fillcap_8
XFILLER_44_247 VDD VDD VSS VSS gf180mcu_fd_sc_mcu7t5v0__fill_2
XTAP_TAPCELL_ROW_55_732 VDD VSS gf180mcu_fd_sc_mcu7t5v0__filltie
XTAP_TAPCELL_ROW_27_467 VDD VSS gf180mcu_fd_sc_mcu7t5v0__filltie
XFILLER_44_258 VDD VDD VSS VSS gf180mcu_fd_sc_mcu7t5v0__fillcap_8
XFILLER_72_567 VDD VDD VSS VSS gf180mcu_fd_sc_mcu7t5v0__fill_1
XPHY_EDGE_ROW_11_Right_11 VDD VSS gf180mcu_fd_sc_mcu7t5v0__endcap
XFILLER_12_177 VDD VDD VSS VSS gf180mcu_fd_sc_mcu7t5v0__fillcap_32
XTAP_TAPCELL_ROW_10_301 VDD VSS gf180mcu_fd_sc_mcu7t5v0__filltie
XFILLER_4_365 VDD VDD VSS VSS gf180mcu_fd_sc_mcu7t5v0__fillcap_4
XFILLER_4_387 VDD VDD VSS VSS gf180mcu_fd_sc_mcu7t5v0__fillcap_32
XPHY_EDGE_ROW_20_Right_20 VDD VSS gf180mcu_fd_sc_mcu7t5v0__endcap
XFILLER_95_626 VDD VDD VSS VSS gf180mcu_fd_sc_mcu7t5v0__fillcap_4
XFILLER_63_512 VDD VDD VSS VSS gf180mcu_fd_sc_mcu7t5v0__fill_2
XFILLER_63_523 VDD VDD VSS VSS gf180mcu_fd_sc_mcu7t5v0__fillcap_4
X_2911_ _3695_/Q _2911_/A2 _2913_/B VDD VDD VSS VSS gf180mcu_fd_sc_mcu7t5v0__nand2_1
XFILLER_31_486 VDD VDD VSS VSS gf180mcu_fd_sc_mcu7t5v0__fillcap_4
X_2842_ _2905_/A1 _2842_/A2 _2844_/B1 VDD VDD VSS VSS gf180mcu_fd_sc_mcu7t5v0__nor2_1
XFILLER_78_2 VDD VDD VSS VSS gf180mcu_fd_sc_mcu7t5v0__fillcap_32
X_2773_ _2773_/A1 _2776_/A2 _2793_/B _2777_/A2 VDD VDD VSS VSS gf180mcu_fd_sc_mcu7t5v0__aoi21_1
X_3325_ _3340_/A1 _3325_/A2 _3326_/B VDD VDD VSS VSS gf180mcu_fd_sc_mcu7t5v0__xor2_1
X_3256_ wire636/Z _3652_/Q _3326_/A2 VDD VDD VSS VSS gf180mcu_fd_sc_mcu7t5v0__nand2_1
XFILLER_58_317 VDD VDD VSS VSS gf180mcu_fd_sc_mcu7t5v0__fill_1
XFILLER_85_136 VDD VDD VSS VSS gf180mcu_fd_sc_mcu7t5v0__fillcap_4
XFILLER_39_553 VDD VDD VSS VSS gf180mcu_fd_sc_mcu7t5v0__fillcap_4
X_2207_ _2442_/B _2207_/A2 _2207_/B _2208_/C VDD VDD VSS VSS gf180mcu_fd_sc_mcu7t5v0__oai21_1
X_3187_ wire642/Z _3187_/A2 _3179_/Z _3187_/B2 _3187_/C _3189_/A2 VDD VDD VSS VSS
+ gf180mcu_fd_sc_mcu7t5v0__oai221_1
XFILLER_26_236 VDD VDD VSS VSS gf180mcu_fd_sc_mcu7t5v0__fill_2
X_2138_ _3071_/I wire388/Z _2139_/B VDD VDD VSS VSS gf180mcu_fd_sc_mcu7t5v0__nand2_1
X_2069_ _2052_/Z _2054_/Z _2069_/B _2072_/A2 VDD VDD VSS VSS gf180mcu_fd_sc_mcu7t5v0__oai21_1
XFILLER_26_247 VDD VDD VSS VSS gf180mcu_fd_sc_mcu7t5v0__fillcap_4
XTAP_TAPCELL_ROW_52_702 VDD VSS gf180mcu_fd_sc_mcu7t5v0__filltie
XFILLER_54_589 VDD VDD VSS VSS gf180mcu_fd_sc_mcu7t5v0__fillcap_4
XFILLER_22_420 VDD VDD VSS VSS gf180mcu_fd_sc_mcu7t5v0__fillcap_16
XTAP_TAPCELL_ROW_24_437 VDD VSS gf180mcu_fd_sc_mcu7t5v0__filltie
XFILLER_49_306 VDD VDD VSS VSS gf180mcu_fd_sc_mcu7t5v0__fill_1
XFILLER_77_637 VDD VDD VSS VSS gf180mcu_fd_sc_mcu7t5v0__fill_2
XFILLER_17_247 VDD VDD VSS VSS gf180mcu_fd_sc_mcu7t5v0__fill_1
XFILLER_72_364 VDD VDD VSS VSS gf180mcu_fd_sc_mcu7t5v0__fill_2
XFILLER_32_239 VDD VDD VSS VSS gf180mcu_fd_sc_mcu7t5v0__fill_1
XFILLER_43_72 VDD VDD VSS VSS gf180mcu_fd_sc_mcu7t5v0__fillcap_32
XFILLER_9_468 VDD VDD VSS VSS gf180mcu_fd_sc_mcu7t5v0__fill_2
Xoutput209 _3721_/Q raw_edge3[11] VDD VDD VSS VSS gf180mcu_fd_sc_mcu7t5v0__buf_2
X_3110_ _3111_/B1 input38/Z input37/Z _3110_/B2 _3110_/C _3113_/B1 VDD VDD VSS VSS
+ gf180mcu_fd_sc_mcu7t5v0__aoi221_1
XFILLER_67_136 VDD VDD VSS VSS gf180mcu_fd_sc_mcu7t5v0__fillcap_4
X_3041_ _3041_/I _3350_/A2 VDD VDD VSS VSS gf180mcu_fd_sc_mcu7t5v0__clkinv_1
XFILLER_63_331 VDD VDD VSS VSS gf180mcu_fd_sc_mcu7t5v0__fillcap_8
XTAP_TAPCELL_ROW_66_838 VDD VSS gf180mcu_fd_sc_mcu7t5v0__filltie
XFILLER_23_206 VDD VDD VSS VSS gf180mcu_fd_sc_mcu7t5v0__fillcap_4
XFILLER_23_228 VDD VDD VSS VSS gf180mcu_fd_sc_mcu7t5v0__fill_2
XFILLER_51_537 VDD VDD VSS VSS gf180mcu_fd_sc_mcu7t5v0__fill_1
XFILLER_16_291 VDD VDD VSS VSS gf180mcu_fd_sc_mcu7t5v0__fillcap_8
XTAP_TAPCELL_ROW_21_407 VDD VSS gf180mcu_fd_sc_mcu7t5v0__filltie
XFILLER_31_272 VDD VDD VSS VSS gf180mcu_fd_sc_mcu7t5v0__fillcap_8
X_2825_ _3739_/Q wire312/Z _2825_/B1 _2825_/B2 _2825_/C _2829_/B1 VDD VDD VSS VSS
+ gf180mcu_fd_sc_mcu7t5v0__aoi221_1
X_2756_ _2756_/A1 _2756_/A2 _2827_/A1 VDD VDD VSS VSS gf180mcu_fd_sc_mcu7t5v0__nor2_4
X_2687_ _2661_/B _2687_/A2 _2687_/Z VDD VDD VSS VSS gf180mcu_fd_sc_mcu7t5v0__xor2_1
Xfanout436 _3755_/Q _2469_/A1 VDD VDD VSS VSS gf180mcu_fd_sc_mcu7t5v0__dlyb_1
Xfanout447 _3752_/Q _2518_/A1 VDD VDD VSS VSS gf180mcu_fd_sc_mcu7t5v0__dlyb_1
Xfanout425 _3758_/Q wire428/I VDD VDD VSS VSS gf180mcu_fd_sc_mcu7t5v0__dlyb_1
X_3308_ _3308_/A1 _3308_/A2 _3324_/A1 _3308_/B _3310_/A2 VDD VDD VSS VSS gf180mcu_fd_sc_mcu7t5v0__oai31_1
X_3239_ _3271_/B _3308_/A1 _3301_/A2 VDD VDD VSS VSS gf180mcu_fd_sc_mcu7t5v0__nand2_1
XTAP_TAPCELL_ROW_37_562 VDD VSS gf180mcu_fd_sc_mcu7t5v0__filltie
XFILLER_80_37 VDD VDD VSS VSS gf180mcu_fd_sc_mcu7t5v0__fillcap_64
XFILLER_10_467 VDD VDD VSS VSS gf180mcu_fd_sc_mcu7t5v0__fill_1
XFILLER_8_2 VDD VDD VSS VSS gf180mcu_fd_sc_mcu7t5v0__fillcap_32
XFILLER_77_489 VDD VDD VSS VSS gf180mcu_fd_sc_mcu7t5v0__fill_1
XPHY_EDGE_ROW_32_Left_129 VDD VSS gf180mcu_fd_sc_mcu7t5v0__endcap
XFILLER_64_139 VDD VDD VSS VSS gf180mcu_fd_sc_mcu7t5v0__fill_2
XFILLER_57_191 VDD VDD VSS VSS gf180mcu_fd_sc_mcu7t5v0__fillcap_4
XTAP_TAPCELL_ROW_63_808 VDD VSS gf180mcu_fd_sc_mcu7t5v0__filltie
XFILLER_33_537 VDD VDD VSS VSS gf180mcu_fd_sc_mcu7t5v0__fillcap_4
XFILLER_20_209 VDD VDD VSS VSS gf180mcu_fd_sc_mcu7t5v0__fillcap_16
XTAP_TAPCELL_ROW_71_885 VDD VSS gf180mcu_fd_sc_mcu7t5v0__filltie
XFILLER_9_232 VDD VDD VSS VSS gf180mcu_fd_sc_mcu7t5v0__fillcap_4
XFILLER_9_265 VDD VDD VSS VSS gf180mcu_fd_sc_mcu7t5v0__fillcap_8
X_2610_ _2610_/A1 _2610_/A2 _2740_/B _3655_/D VDD VDD VSS VSS gf180mcu_fd_sc_mcu7t5v0__aoi21_1
Xclkload13 _3694_/CLK clkload13/Z VDD VDD VSS VSS gf180mcu_fd_sc_mcu7t5v0__clkbuf_2
XPHY_EDGE_ROW_41_Left_138 VDD VSS gf180mcu_fd_sc_mcu7t5v0__endcap
X_3590_ _3568_/Z _3590_/A2 _3589_/B _3590_/Z VDD VDD VSS VSS gf180mcu_fd_sc_mcu7t5v0__and3_1
X_2541_ _2545_/A1 _2545_/A3 _2603_/A2 VDD VDD VSS VSS gf180mcu_fd_sc_mcu7t5v0__nor2_1
XFILLER_5_482 VDD VDD VSS VSS gf180mcu_fd_sc_mcu7t5v0__fill_1
X_2472_ _2148_/C input64/Z _2528_/A2 VDD VDD VSS VSS gf180mcu_fd_sc_mcu7t5v0__nand2_1
XPHY_EDGE_ROW_50_Left_147 VDD VSS gf180mcu_fd_sc_mcu7t5v0__endcap
X_3024_ _3024_/I _3024_/ZN VDD VDD VSS VSS gf180mcu_fd_sc_mcu7t5v0__clkinv_1
XFILLER_36_353 VDD VDD VSS VSS gf180mcu_fd_sc_mcu7t5v0__fillcap_4
XFILLER_36_364 VDD VDD VSS VSS gf180mcu_fd_sc_mcu7t5v0__fillcap_4
XFILLER_63_150 VDD VDD VSS VSS gf180mcu_fd_sc_mcu7t5v0__fillcap_4
XFILLER_91_492 VDD VDD VSS VSS gf180mcu_fd_sc_mcu7t5v0__fillcap_64
XTAP_TAPCELL_ROW_34_532 VDD VSS gf180mcu_fd_sc_mcu7t5v0__filltie
XFILLER_36_397 VDD VDD VSS VSS gf180mcu_fd_sc_mcu7t5v0__fill_2
XFILLER_51_323 VDD VDD VSS VSS gf180mcu_fd_sc_mcu7t5v0__fillcap_4
Xclkload7 clkload7/I clkload7/Z VDD VDD VSS VSS gf180mcu_fd_sc_mcu7t5v0__clkbuf_2
X_2808_ _2808_/A1 _2808_/A2 _2809_/B2 VDD VDD VSS VSS gf180mcu_fd_sc_mcu7t5v0__nand2_1
X_2739_ _2681_/Z _2739_/A2 _2737_/Z _2739_/A4 _2740_/A2 VDD VDD VSS VSS gf180mcu_fd_sc_mcu7t5v0__nand4_1
XTAP_TAPCELL_ROW_6_268 VDD VSS gf180mcu_fd_sc_mcu7t5v0__filltie
Xfanout244 _2911_/A2 _2903_/A1 VDD VDD VSS VSS gf180mcu_fd_sc_mcu7t5v0__dlyb_1
XFILLER_59_434 VDD VDD VSS VSS gf180mcu_fd_sc_mcu7t5v0__fillcap_16
XFILLER_47_607 VDD VDD VSS VSS gf180mcu_fd_sc_mcu7t5v0__fill_1
XFILLER_74_448 VDD VDD VSS VSS gf180mcu_fd_sc_mcu7t5v0__fill_1
XFILLER_15_559 VDD VDD VSS VSS gf180mcu_fd_sc_mcu7t5v0__fill_1
XFILLER_15_548 VDD VDD VSS VSS gf180mcu_fd_sc_mcu7t5v0__fill_1
XFILLER_27_397 VDD VDD VSS VSS gf180mcu_fd_sc_mcu7t5v0__fillcap_8
XFILLER_23_570 VDD VDD VSS VSS gf180mcu_fd_sc_mcu7t5v0__fillcap_8
Xwire634 input4/Z _2691_/B VDD VDD VSS VSS gf180mcu_fd_sc_mcu7t5v0__buf_2
Xwire612 wire612/I wire612/Z VDD VDD VSS VSS gf180mcu_fd_sc_mcu7t5v0__buf_1
Xwire656 wire656/I wire656/Z VDD VDD VSS VSS gf180mcu_fd_sc_mcu7t5v0__buf_1
Xload_slew628 _2588_/A1 _3005_/I VDD VDD VSS VSS gf180mcu_fd_sc_mcu7t5v0__buf_2
XFILLER_2_452 VDD VDD VSS VSS gf180mcu_fd_sc_mcu7t5v0__fill_2
Xload_slew606 _3692_/RN _3670_/RN VDD VDD VSS VSS gf180mcu_fd_sc_mcu7t5v0__clkbuf_1
Xload_slew639 _2586_/B wire638/I VDD VDD VSS VSS gf180mcu_fd_sc_mcu7t5v0__clkbuf_2
XTAP_TAPCELL_ROW_76_933 VDD VSS gf180mcu_fd_sc_mcu7t5v0__filltie
XFILLER_65_426 VDD VDD VSS VSS gf180mcu_fd_sc_mcu7t5v0__fill_1
XFILLER_65_448 VDD VDD VSS VSS gf180mcu_fd_sc_mcu7t5v0__fillcap_16
XFILLER_46_651 VDD VDD VSS VSS gf180mcu_fd_sc_mcu7t5v0__fill_1
XTAP_TAPCELL_ROW_48_668 VDD VSS gf180mcu_fd_sc_mcu7t5v0__filltie
XFILLER_61_632 VDD VDD VSS VSS gf180mcu_fd_sc_mcu7t5v0__fill_1
XFILLER_73_492 VDD VDD VSS VSS gf180mcu_fd_sc_mcu7t5v0__fillcap_8
XFILLER_14_592 VDD VDD VSS VSS gf180mcu_fd_sc_mcu7t5v0__fill_2
XTAP_TAPCELL_ROW_31_502 VDD VSS gf180mcu_fd_sc_mcu7t5v0__filltie
X_1972_ _1972_/A1 _1895_/Z _1972_/B _1972_/C _2004_/A1 VDD VDD VSS VSS gf180mcu_fd_sc_mcu7t5v0__oai211_2
X_3711_ _3711_/D _3712_/RN _3715_/CLK _3781_/I VDD VDD VSS VSS gf180mcu_fd_sc_mcu7t5v0__dffrnq_1
X_3642_ _3688_/Q _3709_/Q _3642_/A3 _3642_/Z VDD VDD VSS VSS gf180mcu_fd_sc_mcu7t5v0__xor3_1
XFILLER_60_2 VDD VDD VSS VSS gf180mcu_fd_sc_mcu7t5v0__fillcap_32
XPHY_EDGE_ROW_49_Right_49 VDD VSS gf180mcu_fd_sc_mcu7t5v0__endcap
X_3573_ _3571_/Z _3574_/A2 _3592_/B VDD VDD VSS VSS gf180mcu_fd_sc_mcu7t5v0__or2_1
X_2524_ _2979_/ZN _3020_/I _2524_/B1 _2981_/ZN _2525_/I VDD VDD VSS VSS gf180mcu_fd_sc_mcu7t5v0__aoi22_1
XTAP_TAPCELL_ROW_93_1088 VDD VSS gf180mcu_fd_sc_mcu7t5v0__filltie
XFILLER_88_529 VDD VDD VSS VSS gf180mcu_fd_sc_mcu7t5v0__fill_1
X_2455_ _2992_/I input2/Z _2455_/A3 _3651_/D VDD VDD VSS VSS gf180mcu_fd_sc_mcu7t5v0__nand3_1
X_2386_ _3737_/Q _3738_/Q _2387_/A2 _2386_/Z VDD VDD VSS VSS gf180mcu_fd_sc_mcu7t5v0__and3_1
XFILLER_29_629 VDD VDD VSS VSS gf180mcu_fd_sc_mcu7t5v0__fill_1
XFILLER_83_212 VDD VDD VSS VSS gf180mcu_fd_sc_mcu7t5v0__fillcap_64
XTAP_TAPCELL_ROW_3_238 VDD VSS gf180mcu_fd_sc_mcu7t5v0__filltie
XFILLER_56_426 VDD VDD VSS VSS gf180mcu_fd_sc_mcu7t5v0__fill_1
XFILLER_68_286 VDD VDD VSS VSS gf180mcu_fd_sc_mcu7t5v0__fill_1
XFILLER_68_275 VDD VDD VSS VSS gf180mcu_fd_sc_mcu7t5v0__fill_2
XPHY_EDGE_ROW_58_Right_58 VDD VSS gf180mcu_fd_sc_mcu7t5v0__endcap
X_3007_ _3007_/I _3526_/A1 VDD VDD VSS VSS gf180mcu_fd_sc_mcu7t5v0__inv_2
XTAP_TAPCELL_ROW_19_392 VDD VSS gf180mcu_fd_sc_mcu7t5v0__filltie
XFILLER_36_172 VDD VDD VSS VSS gf180mcu_fd_sc_mcu7t5v0__fill_2
XFILLER_64_492 VDD VDD VSS VSS gf180mcu_fd_sc_mcu7t5v0__fillcap_16
XFILLER_12_518 VDD VDD VSS VSS gf180mcu_fd_sc_mcu7t5v0__fill_2
XFILLER_51_142 VDD VDD VSS VSS gf180mcu_fd_sc_mcu7t5v0__fillcap_8
XFILLER_24_389 VDD VDD VSS VSS gf180mcu_fd_sc_mcu7t5v0__fill_1
XPHY_EDGE_ROW_67_Right_67 VDD VSS gf180mcu_fd_sc_mcu7t5v0__endcap
XPHY_EDGE_ROW_76_Right_76 VDD VSS gf180mcu_fd_sc_mcu7t5v0__endcap
XFILLER_59_286 VDD VDD VSS VSS gf180mcu_fd_sc_mcu7t5v0__fill_2
XTAP_TAPCELL_ROW_73_903 VDD VSS gf180mcu_fd_sc_mcu7t5v0__filltie
XFILLER_28_673 VDD VDD VSS VSS gf180mcu_fd_sc_mcu7t5v0__fillcap_4
XFILLER_27_194 VDD VDD VSS VSS gf180mcu_fd_sc_mcu7t5v0__fill_1
XFILLER_43_632 VDD VDD VSS VSS gf180mcu_fd_sc_mcu7t5v0__fill_2
XTAP_TAPCELL_ROW_45_638 VDD VSS gf180mcu_fd_sc_mcu7t5v0__filltie
XFILLER_35_84 VDD VDD VSS VSS gf180mcu_fd_sc_mcu7t5v0__fill_2
XFILLER_70_451 VDD VDD VSS VSS gf180mcu_fd_sc_mcu7t5v0__fillcap_4
XTAP_TAPCELL_ROW_81_980 VDD VSS gf180mcu_fd_sc_mcu7t5v0__filltie
XFILLER_70_473 VDD VDD VSS VSS gf180mcu_fd_sc_mcu7t5v0__fillcap_4
XFILLER_7_500 VDD VDD VSS VSS gf180mcu_fd_sc_mcu7t5v0__fill_2
XPHY_EDGE_ROW_85_Right_85 VDD VSS gf180mcu_fd_sc_mcu7t5v0__endcap
XFILLER_11_562 VDD VDD VSS VSS gf180mcu_fd_sc_mcu7t5v0__fill_2
XFILLER_51_72 VDD VDD VSS VSS gf180mcu_fd_sc_mcu7t5v0__fillcap_64
Xwire497 _3693_/Q _3046_/I VDD VDD VSS VSS gf180mcu_fd_sc_mcu7t5v0__buf_2
Xload_slew403 _2214_/A1 _2297_/A1 VDD VDD VSS VSS gf180mcu_fd_sc_mcu7t5v0__buf_2
Xload_slew414 _2448_/B _3244_/A2 VDD VDD VSS VSS gf180mcu_fd_sc_mcu7t5v0__clkbuf_1
X_2240_ _2225_/B _2240_/A2 _2241_/A3 VDD VDD VSS VSS gf180mcu_fd_sc_mcu7t5v0__nand2_1
XPHY_EDGE_ROW_94_Right_94 VDD VSS gf180mcu_fd_sc_mcu7t5v0__endcap
Xload_slew458 wire459/Z _2982_/I VDD VDD VSS VSS gf180mcu_fd_sc_mcu7t5v0__buf_2
Xload_slew469 wire468/I _2986_/I VDD VDD VSS VSS gf180mcu_fd_sc_mcu7t5v0__buf_2
XFILLER_78_584 VDD VDD VSS VSS gf180mcu_fd_sc_mcu7t5v0__fill_2
X_2171_ _3674_/Q wire397/I _2172_/B VDD VDD VSS VSS gf180mcu_fd_sc_mcu7t5v0__nand2_1
XFILLER_65_212 VDD VDD VSS VSS gf180mcu_fd_sc_mcu7t5v0__fill_2
XTAP_TAPCELL_ROW_0_208 VDD VSS gf180mcu_fd_sc_mcu7t5v0__filltie
XFILLER_38_448 VDD VDD VSS VSS gf180mcu_fd_sc_mcu7t5v0__fill_2
XFILLER_46_481 VDD VDD VSS VSS gf180mcu_fd_sc_mcu7t5v0__fill_1
XTAP_TAPCELL_ROW_16_362 VDD VSS gf180mcu_fd_sc_mcu7t5v0__filltie
X_1955_ _1953_/Z _1957_/A2 _1996_/B VDD VDD VSS VSS gf180mcu_fd_sc_mcu7t5v0__nor2_1
XTAP_TAPCELL_ROW_95_1106 VDD VSS gf180mcu_fd_sc_mcu7t5v0__filltie
X_1886_ _1886_/A1 _1885_/Z _1911_/A1 VDD VDD VSS VSS gf180mcu_fd_sc_mcu7t5v0__nand2_1
X_3625_ _3627_/A1 _3077_/I _3641_/B VDD VDD VSS VSS gf180mcu_fd_sc_mcu7t5v0__nor2_1
X_3556_ wire632/Z _3555_/Z _3572_/B VDD VDD VSS VSS gf180mcu_fd_sc_mcu7t5v0__nor2_1
X_2507_ _2507_/I _2510_/A1 VDD VDD VSS VSS gf180mcu_fd_sc_mcu7t5v0__clkinv_1
X_3487_ _3518_/A1 _3518_/A2 _3487_/B _3501_/A2 VDD VDD VSS VSS gf180mcu_fd_sc_mcu7t5v0__oai21_1
X_2438_ _3117_/A2 wire361/Z _2437_/Z wire366/Z _3756_/D VDD VDD VSS VSS gf180mcu_fd_sc_mcu7t5v0__oai22_1
XFILLER_69_562 VDD VDD VSS VSS gf180mcu_fd_sc_mcu7t5v0__fill_1
X_2369_ _3733_/Q _3732_/Q _2373_/A2 VDD VDD VSS VSS gf180mcu_fd_sc_mcu7t5v0__nand2_1
XFILLER_69_573 VDD VDD VSS VSS gf180mcu_fd_sc_mcu7t5v0__fillcap_8
XFILLER_84_543 VDD VDD VSS VSS gf180mcu_fd_sc_mcu7t5v0__fill_1
XTAP_TAPCELL_ROW_42_608 VDD VSS gf180mcu_fd_sc_mcu7t5v0__filltie
XTAP_TAPCELL_ROW_50_685 VDD VSS gf180mcu_fd_sc_mcu7t5v0__filltie
XFILLER_47_201 VDD VDD VSS VSS gf180mcu_fd_sc_mcu7t5v0__fill_2
XFILLER_75_554 VDD VDD VSS VSS gf180mcu_fd_sc_mcu7t5v0__fillcap_4
XFILLER_75_532 VDD VDD VSS VSS gf180mcu_fd_sc_mcu7t5v0__fill_1
XFILLER_90_524 VDD VDD VSS VSS gf180mcu_fd_sc_mcu7t5v0__fill_1
XTAP_TAPCELL_ROW_58_763 VDD VSS gf180mcu_fd_sc_mcu7t5v0__filltie
XFILLER_15_142 VDD VDD VSS VSS gf180mcu_fd_sc_mcu7t5v0__fillcap_64
XFILLER_30_101 VDD VDD VSS VSS gf180mcu_fd_sc_mcu7t5v0__fillcap_4
XTAP_TAPCELL_ROW_13_332 VDD VSS gf180mcu_fd_sc_mcu7t5v0__filltie
XFILLER_11_392 VDD VDD VSS VSS gf180mcu_fd_sc_mcu7t5v0__fillcap_8
XFILLER_7_352 VDD VDD VSS VSS gf180mcu_fd_sc_mcu7t5v0__fill_2
XFILLER_7_66 VDD VDD VSS VSS gf180mcu_fd_sc_mcu7t5v0__fillcap_4
Xwire294 wire296/Z wire294/Z VDD VDD VSS VSS gf180mcu_fd_sc_mcu7t5v0__dlyb_1
X_3410_ _3443_/A1 _3410_/A2 _3412_/B VDD VDD VSS VSS gf180mcu_fd_sc_mcu7t5v0__nor2_1
X_3341_ _3772_/Q _3345_/A2 _3344_/A1 VDD VDD VSS VSS gf180mcu_fd_sc_mcu7t5v0__xnor2_1
XTAP_TAPCELL_ROW_90_1058 VDD VSS gf180mcu_fd_sc_mcu7t5v0__filltie
X_3272_ _3282_/A2 _3309_/A2 _3272_/B _3273_/A3 VDD VDD VSS VSS gf180mcu_fd_sc_mcu7t5v0__aoi21_1
XFILLER_23_2 VDD VDD VSS VSS gf180mcu_fd_sc_mcu7t5v0__fillcap_64
X_2223_ _2223_/I _2242_/A1 VDD VDD VSS VSS gf180mcu_fd_sc_mcu7t5v0__clkinv_1
XFILLER_38_201 VDD VDD VSS VSS gf180mcu_fd_sc_mcu7t5v0__fill_2
Xload_slew266 wire267/Z _2842_/A2 VDD VDD VSS VSS gf180mcu_fd_sc_mcu7t5v0__clkbuf_2
Xload_slew277 _2806_/A1 _2826_/A1 VDD VDD VSS VSS gf180mcu_fd_sc_mcu7t5v0__clkbuf_2
X_2154_ _3699_/Q _2154_/A2 _2154_/B _2189_/A2 VDD VDD VSS VSS gf180mcu_fd_sc_mcu7t5v0__oai21_1
XFILLER_38_267 VDD VDD VSS VSS gf180mcu_fd_sc_mcu7t5v0__fillcap_32
X_2085_ _2062_/Z _2064_/Z _2084_/B _2085_/Z VDD VDD VSS VSS gf180mcu_fd_sc_mcu7t5v0__or3_1
XFILLER_19_492 VDD VDD VSS VSS gf180mcu_fd_sc_mcu7t5v0__fill_2
XFILLER_81_568 VDD VDD VSS VSS gf180mcu_fd_sc_mcu7t5v0__fillcap_4
X_2987_ _3745_/Q _3106_/B1 VDD VDD VSS VSS gf180mcu_fd_sc_mcu7t5v0__clkinv_1
X_1938_ _1954_/A1 _1937_/Z _1939_/I VDD VDD VSS VSS gf180mcu_fd_sc_mcu7t5v0__xor2_1
X_1869_ _3425_/A1 _1868_/Z _1875_/B VDD VDD VSS VSS gf180mcu_fd_sc_mcu7t5v0__nor2_1
Xinput80 cfg_phase90_offset[8] _3023_/I VDD VDD VSS VSS gf180mcu_fd_sc_mcu7t5v0__buf_1
X_3608_ _3608_/A1 _3608_/A2 _3608_/B _3608_/C _3636_/A2 VDD VDD VSS VSS gf180mcu_fd_sc_mcu7t5v0__aoi211_2
XFILLER_88_101 VDD VDD VSS VSS gf180mcu_fd_sc_mcu7t5v0__fillcap_4
X_3539_ _3539_/A1 _3525_/Z _3539_/B _3541_/A2 VDD VDD VSS VSS gf180mcu_fd_sc_mcu7t5v0__oai21_1
XFILLER_76_307 VDD VDD VSS VSS gf180mcu_fd_sc_mcu7t5v0__fill_2
XFILLER_17_407 VDD VDD VSS VSS gf180mcu_fd_sc_mcu7t5v0__fill_1
XFILLER_84_384 VDD VDD VSS VSS gf180mcu_fd_sc_mcu7t5v0__fill_1
XTAP_TAPCELL_ROW_55_733 VDD VSS gf180mcu_fd_sc_mcu7t5v0__filltie
XFILLER_72_524 VDD VDD VSS VSS gf180mcu_fd_sc_mcu7t5v0__fill_1
XTAP_TAPCELL_ROW_27_468 VDD VSS gf180mcu_fd_sc_mcu7t5v0__filltie
XFILLER_12_101 VDD VDD VSS VSS gf180mcu_fd_sc_mcu7t5v0__fillcap_4
XFILLER_25_462 VDD VDD VSS VSS gf180mcu_fd_sc_mcu7t5v0__fill_2
XFILLER_40_443 VDD VDD VSS VSS gf180mcu_fd_sc_mcu7t5v0__fill_1
XFILLER_40_454 VDD VDD VSS VSS gf180mcu_fd_sc_mcu7t5v0__fill_1
XFILLER_40_465 VDD VDD VSS VSS gf180mcu_fd_sc_mcu7t5v0__fillcap_4
XTAP_TAPCELL_ROW_10_302 VDD VSS gf180mcu_fd_sc_mcu7t5v0__filltie
XFILLER_4_377 VDD VDD VSS VSS gf180mcu_fd_sc_mcu7t5v0__fillcap_8
XFILLER_75_340 VDD VDD VSS VSS gf180mcu_fd_sc_mcu7t5v0__fillcap_4
XFILLER_63_546 VDD VDD VSS VSS gf180mcu_fd_sc_mcu7t5v0__fill_2
XFILLER_35_259 VDD VDD VSS VSS gf180mcu_fd_sc_mcu7t5v0__fill_1
XFILLER_63_557 VDD VDD VSS VSS gf180mcu_fd_sc_mcu7t5v0__fill_2
XFILLER_90_387 VDD VDD VSS VSS gf180mcu_fd_sc_mcu7t5v0__fillcap_16
XFILLER_16_484 VDD VDD VSS VSS gf180mcu_fd_sc_mcu7t5v0__fill_2
X_2910_ _2910_/A1 _2955_/A2 _2910_/B _3694_/D VDD VDD VSS VSS gf180mcu_fd_sc_mcu7t5v0__oai21_1
XFILLER_31_443 VDD VDD VSS VSS gf180mcu_fd_sc_mcu7t5v0__fillcap_4
XFILLER_31_454 VDD VDD VSS VSS gf180mcu_fd_sc_mcu7t5v0__fillcap_4
X_2841_ _3378_/A1 _2844_/A2 _2841_/B1 _2841_/B2 _3670_/D VDD VDD VSS VSS gf180mcu_fd_sc_mcu7t5v0__oai22_1
X_2772_ _3091_/ZN _2772_/A2 _2772_/B _2776_/A2 VDD VDD VSS VSS gf180mcu_fd_sc_mcu7t5v0__oai21_1
X_3324_ _3324_/A1 _3324_/A2 _3324_/B _3325_/A2 VDD VDD VSS VSS gf180mcu_fd_sc_mcu7t5v0__oai21_1
X_3255_ _3289_/B _3255_/A2 _3255_/A3 _3255_/B1 _3255_/B2 _3281_/A1 VDD VDD VSS VSS
+ gf180mcu_fd_sc_mcu7t5v0__oai32_4
X_2206_ _2442_/B _2207_/A2 _2206_/B _2675_/C _2208_/B VDD VDD VSS VSS gf180mcu_fd_sc_mcu7t5v0__aoi211_1
XFILLER_39_587 VDD VDD VSS VSS gf180mcu_fd_sc_mcu7t5v0__fill_2
X_3186_ wire517/Z _2006_/C _3189_/B VDD VDD VSS VSS gf180mcu_fd_sc_mcu7t5v0__xor2_1
XFILLER_26_215 VDD VDD VSS VSS gf180mcu_fd_sc_mcu7t5v0__fill_1
X_2137_ _3072_/ZN wire388/Z _2137_/B _2207_/A2 VDD VDD VSS VSS gf180mcu_fd_sc_mcu7t5v0__oai21_1
XFILLER_54_524 VDD VDD VSS VSS gf180mcu_fd_sc_mcu7t5v0__fill_1
XFILLER_54_535 VDD VDD VSS VSS gf180mcu_fd_sc_mcu7t5v0__fillcap_8
X_2068_ _2065_/Z _2068_/A2 _2097_/A1 VDD VDD VSS VSS gf180mcu_fd_sc_mcu7t5v0__xnor2_1
XFILLER_41_229 VDD VDD VSS VSS gf180mcu_fd_sc_mcu7t5v0__fillcap_4
XTAP_TAPCELL_ROW_52_703 VDD VSS gf180mcu_fd_sc_mcu7t5v0__filltie
XTAP_TAPCELL_ROW_24_438 VDD VSS gf180mcu_fd_sc_mcu7t5v0__filltie
XFILLER_22_454 VDD VDD VSS VSS gf180mcu_fd_sc_mcu7t5v0__fill_1
XFILLER_6_609 VDD VDD VSS VSS gf180mcu_fd_sc_mcu7t5v0__fill_1
XTAP_TAPCELL_ROW_60_780 VDD VSS gf180mcu_fd_sc_mcu7t5v0__filltie
XFILLER_78_37 VDD VDD VSS VSS gf180mcu_fd_sc_mcu7t5v0__fillcap_64
XFILLER_45_557 VDD VDD VSS VSS gf180mcu_fd_sc_mcu7t5v0__fill_2
XFILLER_72_387 VDD VDD VSS VSS gf180mcu_fd_sc_mcu7t5v0__fill_2
XFILLER_13_487 VDD VDD VSS VSS gf180mcu_fd_sc_mcu7t5v0__fill_2
XFILLER_5_620 VDD VDD VSS VSS gf180mcu_fd_sc_mcu7t5v0__fill_1
XFILLER_4_34 VDD VDD VSS VSS gf180mcu_fd_sc_mcu7t5v0__fill_1
XFILLER_4_174 VDD VDD VSS VSS gf180mcu_fd_sc_mcu7t5v0__fill_1
XFILLER_68_649 VDD VDD VSS VSS gf180mcu_fd_sc_mcu7t5v0__fill_2
XFILLER_82_107 VDD VDD VSS VSS gf180mcu_fd_sc_mcu7t5v0__fillcap_64
X_3040_ _3670_/Q _3378_/A1 VDD VDD VSS VSS gf180mcu_fd_sc_mcu7t5v0__clkinv_1
XFILLER_48_384 VDD VDD VSS VSS gf180mcu_fd_sc_mcu7t5v0__fill_1
XFILLER_48_395 VDD VDD VSS VSS gf180mcu_fd_sc_mcu7t5v0__fillcap_4
XTAP_TAPCELL_ROW_66_839 VDD VSS gf180mcu_fd_sc_mcu7t5v0__filltie
XFILLER_36_579 VDD VDD VSS VSS gf180mcu_fd_sc_mcu7t5v0__fill_1
XFILLER_90_2 VDD VDD VSS VSS gf180mcu_fd_sc_mcu7t5v0__fillcap_32
XTAP_TAPCELL_ROW_21_408 VDD VSS gf180mcu_fd_sc_mcu7t5v0__filltie
X_2824_ _2826_/A1 _2827_/A2 _2825_/B2 VDD VDD VSS VSS gf180mcu_fd_sc_mcu7t5v0__nand2_1
X_2755_ wire275/Z _2755_/A2 _2806_/B _2757_/A2 VDD VDD VSS VSS gf180mcu_fd_sc_mcu7t5v0__oai21_1
X_2686_ _3004_/ZN _2685_/Z _2724_/B1 VDD VDD VSS VSS gf180mcu_fd_sc_mcu7t5v0__nor2_1
X_3307_ _3237_/B _3309_/A2 _3324_/A1 VDD VDD VSS VSS gf180mcu_fd_sc_mcu7t5v0__nor2_1
Xfanout415 _3760_/Q _2598_/A1 VDD VDD VSS VSS gf180mcu_fd_sc_mcu7t5v0__dlyb_1
XFILLER_86_457 VDD VDD VSS VSS gf180mcu_fd_sc_mcu7t5v0__fillcap_16
XFILLER_86_446 VDD VDD VSS VSS gf180mcu_fd_sc_mcu7t5v0__fill_2
X_3238_ _3299_/B _3319_/A3 _3283_/B2 VDD VDD VSS VSS gf180mcu_fd_sc_mcu7t5v0__nand2_1
XFILLER_67_660 VDD VDD VSS VSS gf180mcu_fd_sc_mcu7t5v0__fill_1
XFILLER_27_524 VDD VDD VSS VSS gf180mcu_fd_sc_mcu7t5v0__fillcap_4
X_3169_ _3472_/A1 _3169_/A2 _3169_/Z VDD VDD VSS VSS gf180mcu_fd_sc_mcu7t5v0__xor2_1
XTAP_TAPCELL_ROW_37_563 VDD VSS gf180mcu_fd_sc_mcu7t5v0__filltie
XFILLER_42_527 VDD VDD VSS VSS gf180mcu_fd_sc_mcu7t5v0__fillcap_8
XFILLER_54_376 VDD VDD VSS VSS gf180mcu_fd_sc_mcu7t5v0__fill_1
XFILLER_10_413 VDD VDD VSS VSS gf180mcu_fd_sc_mcu7t5v0__fillcap_16
XFILLER_10_457 VDD VDD VSS VSS gf180mcu_fd_sc_mcu7t5v0__fillcap_8
XFILLER_2_667 VDD VDD VSS VSS gf180mcu_fd_sc_mcu7t5v0__fillcap_8
XFILLER_49_104 VDD VDD VSS VSS gf180mcu_fd_sc_mcu7t5v0__fillcap_16
XFILLER_64_107 VDD VDD VSS VSS gf180mcu_fd_sc_mcu7t5v0__fillcap_32
XFILLER_18_524 VDD VDD VSS VSS gf180mcu_fd_sc_mcu7t5v0__fill_1
XTAP_TAPCELL_ROW_63_809 VDD VSS gf180mcu_fd_sc_mcu7t5v0__filltie
XTAP_TAPCELL_ROW_71_886 VDD VSS gf180mcu_fd_sc_mcu7t5v0__filltie
XFILLER_13_295 VDD VDD VSS VSS gf180mcu_fd_sc_mcu7t5v0__fillcap_4
XFILLER_9_277 VDD VDD VSS VSS gf180mcu_fd_sc_mcu7t5v0__fill_2
XFILLER_9_244 VDD VDD VSS VSS gf180mcu_fd_sc_mcu7t5v0__fillcap_4
Xclkload14 _3715_/CLK clkload14/Z VDD VDD VSS VSS gf180mcu_fd_sc_mcu7t5v0__clkbuf_2
X_2540_ wire428/Z _3017_/ZN _2540_/B _2545_/A3 VDD VDD VSS VSS gf180mcu_fd_sc_mcu7t5v0__aoi21_1
X_2471_ _3119_/A2 input65/Z _2528_/A1 VDD VDD VSS VSS gf180mcu_fd_sc_mcu7t5v0__nand2_1
XFILLER_68_457 VDD VDD VSS VSS gf180mcu_fd_sc_mcu7t5v0__fillcap_16
XFILLER_95_276 VDD VDD VSS VSS gf180mcu_fd_sc_mcu7t5v0__fillcap_4
X_3023_ _3023_/I _2513_/B VDD VDD VSS VSS gf180mcu_fd_sc_mcu7t5v0__clkinv_1
XFILLER_48_181 VDD VDD VSS VSS gf180mcu_fd_sc_mcu7t5v0__fill_2
XFILLER_24_527 VDD VDD VSS VSS gf180mcu_fd_sc_mcu7t5v0__fillcap_16
XFILLER_36_387 VDD VDD VSS VSS gf180mcu_fd_sc_mcu7t5v0__fill_2
XFILLER_24_549 VDD VDD VSS VSS gf180mcu_fd_sc_mcu7t5v0__fill_1
XTAP_TAPCELL_ROW_34_533 VDD VSS gf180mcu_fd_sc_mcu7t5v0__filltie
Xclkload8 clkload8/I clkload8/Z VDD VDD VSS VSS gf180mcu_fd_sc_mcu7t5v0__clkbuf_2
X_2807_ _2831_/A2 _2807_/A2 _2807_/A3 _2808_/A2 VDD VDD VSS VSS gf180mcu_fd_sc_mcu7t5v0__nand3_1
X_2738_ _2738_/A1 _2738_/A2 _2738_/B _2739_/A4 VDD VDD VSS VSS gf180mcu_fd_sc_mcu7t5v0__oai21_1
X_2669_ _2442_/B input48/Z _2676_/A1 VDD VDD VSS VSS gf180mcu_fd_sc_mcu7t5v0__nand2_1
Xfanout256 wire263/Z wire258/I VDD VDD VSS VSS gf180mcu_fd_sc_mcu7t5v0__dlyb_1
XTAP_TAPCELL_ROW_6_269 VDD VSS gf180mcu_fd_sc_mcu7t5v0__filltie
XFILLER_86_287 VDD VDD VSS VSS gf180mcu_fd_sc_mcu7t5v0__fill_2
XFILLER_46_107 VDD VDD VSS VSS gf180mcu_fd_sc_mcu7t5v0__fill_2
XFILLER_27_332 VDD VDD VSS VSS gf180mcu_fd_sc_mcu7t5v0__fill_2
XFILLER_39_192 VDD VDD VSS VSS gf180mcu_fd_sc_mcu7t5v0__fillcap_16
XFILLER_27_376 VDD VDD VSS VSS gf180mcu_fd_sc_mcu7t5v0__fill_2
XFILLER_42_313 VDD VDD VSS VSS gf180mcu_fd_sc_mcu7t5v0__fill_2
XFILLER_10_210 VDD VDD VSS VSS gf180mcu_fd_sc_mcu7t5v0__fillcap_16
XFILLER_23_582 VDD VDD VSS VSS gf180mcu_fd_sc_mcu7t5v0__fill_2
XFILLER_10_232 VDD VDD VSS VSS gf180mcu_fd_sc_mcu7t5v0__fill_1
Xwire624 wire624/I _2029_/B VDD VDD VSS VSS gf180mcu_fd_sc_mcu7t5v0__buf_2
XFILLER_6_225 VDD VDD VSS VSS gf180mcu_fd_sc_mcu7t5v0__fill_2
Xwire635 input3/Z _3015_/I VDD VDD VSS VSS gf180mcu_fd_sc_mcu7t5v0__buf_2
Xwire646 wire647/Z wire646/Z VDD VDD VSS VSS gf180mcu_fd_sc_mcu7t5v0__buf_1
XFILLER_6_247 VDD VDD VSS VSS gf180mcu_fd_sc_mcu7t5v0__fillcap_16
Xload_slew618 input85/Z fanout583/I VDD VDD VSS VSS gf180mcu_fd_sc_mcu7t5v0__buf_2
Xload_slew607 _3715_/RN _3692_/RN VDD VDD VSS VSS gf180mcu_fd_sc_mcu7t5v0__buf_2
XFILLER_49_72 VDD VDD VSS VSS gf180mcu_fd_sc_mcu7t5v0__fillcap_32
XFILLER_77_276 VDD VDD VSS VSS gf180mcu_fd_sc_mcu7t5v0__fillcap_4
XTAP_TAPCELL_ROW_76_934 VDD VSS gf180mcu_fd_sc_mcu7t5v0__filltie
XFILLER_18_343 VDD VDD VSS VSS gf180mcu_fd_sc_mcu7t5v0__fill_1
XFILLER_33_346 VDD VDD VSS VSS gf180mcu_fd_sc_mcu7t5v0__fillcap_4
XFILLER_33_357 VDD VDD VSS VSS gf180mcu_fd_sc_mcu7t5v0__fill_2
X_1971_ _1971_/A1 _1971_/A2 _1971_/B _1971_/C _2005_/A2 VDD VDD VSS VSS gf180mcu_fd_sc_mcu7t5v0__aoi211_2
XTAP_TAPCELL_ROW_31_503 VDD VSS gf180mcu_fd_sc_mcu7t5v0__filltie
X_3710_ _3710_/D _3712_/RN _3715_/CLK _3780_/I VDD VDD VSS VSS gf180mcu_fd_sc_mcu7t5v0__dffrnq_1
X_3641_ _3641_/A1 wire281/Z _3641_/B _3642_/A3 VDD VDD VSS VSS gf180mcu_fd_sc_mcu7t5v0__aoi21_1
X_3572_ _3065_/I _3572_/A2 _3572_/B _3574_/A2 VDD VDD VSS VSS gf180mcu_fd_sc_mcu7t5v0__aoi21_1
X_2523_ wire448/I _3020_/ZN _2523_/B _2524_/B1 VDD VDD VSS VSS gf180mcu_fd_sc_mcu7t5v0__aoi21_1
XFILLER_53_2 VDD VDD VSS VSS gf180mcu_fd_sc_mcu7t5v0__fillcap_64
XTAP_TAPCELL_ROW_93_1089 VDD VSS gf180mcu_fd_sc_mcu7t5v0__filltie
X_2454_ _3651_/Q _2459_/A1 _2455_/A3 VDD VDD VSS VSS gf180mcu_fd_sc_mcu7t5v0__nand2_1
X_2385_ _3737_/Q _2388_/A1 _2385_/A3 _2385_/B _3737_/D VDD VDD VSS VSS gf180mcu_fd_sc_mcu7t5v0__oai31_1
XFILLER_96_596 VDD VDD VSS VSS gf180mcu_fd_sc_mcu7t5v0__fillcap_4
Xinput1 cal_start input1/Z VDD VDD VSS VSS gf180mcu_fd_sc_mcu7t5v0__buf_3
XTAP_TAPCELL_ROW_3_239 VDD VSS gf180mcu_fd_sc_mcu7t5v0__filltie
XFILLER_28_107 VDD VDD VSS VSS gf180mcu_fd_sc_mcu7t5v0__fillcap_64
X_3006_ _3006_/I wire517/I VDD VDD VSS VSS gf180mcu_fd_sc_mcu7t5v0__inv_2
XFILLER_36_151 VDD VDD VSS VSS gf180mcu_fd_sc_mcu7t5v0__fill_2
XFILLER_71_419 VDD VDD VSS VSS gf180mcu_fd_sc_mcu7t5v0__fill_1
XFILLER_51_154 VDD VDD VSS VSS gf180mcu_fd_sc_mcu7t5v0__fill_1
XFILLER_3_206 VDD VDD VSS VSS gf180mcu_fd_sc_mcu7t5v0__fillcap_4
XFILLER_86_37 VDD VDD VSS VSS gf180mcu_fd_sc_mcu7t5v0__fillcap_64
XFILLER_59_232 VDD VDD VSS VSS gf180mcu_fd_sc_mcu7t5v0__fill_2
XFILLER_87_574 VDD VDD VSS VSS gf180mcu_fd_sc_mcu7t5v0__fillcap_8
XFILLER_28_663 VDD VDD VSS VSS gf180mcu_fd_sc_mcu7t5v0__fill_2
XTAP_TAPCELL_ROW_73_904 VDD VSS gf180mcu_fd_sc_mcu7t5v0__filltie
XTAP_TAPCELL_ROW_45_639 VDD VSS gf180mcu_fd_sc_mcu7t5v0__filltie
XTAP_TAPCELL_ROW_81_981 VDD VSS gf180mcu_fd_sc_mcu7t5v0__filltie
Xwire421 wire421/I wire421/Z VDD VDD VSS VSS gf180mcu_fd_sc_mcu7t5v0__clkbuf_2
Xwire476 _3730_/Q wire476/Z VDD VDD VSS VSS gf180mcu_fd_sc_mcu7t5v0__buf_2
Xload_slew404 wire405/Z _2214_/A1 VDD VDD VSS VSS gf180mcu_fd_sc_mcu7t5v0__clkbuf_2
Xload_slew437 _2547_/B2 _2613_/A1 VDD VDD VSS VSS gf180mcu_fd_sc_mcu7t5v0__buf_2
Xload_slew426 wire428/Z _2970_/I VDD VDD VSS VSS gf180mcu_fd_sc_mcu7t5v0__clkbuf_2
X_2170_ _2170_/A1 _2170_/A2 _2170_/B _2177_/A1 VDD VDD VSS VSS gf180mcu_fd_sc_mcu7t5v0__oai21_1
XFILLER_38_427 VDD VDD VSS VSS gf180mcu_fd_sc_mcu7t5v0__fillcap_4
XTAP_TAPCELL_ROW_0_209 VDD VSS gf180mcu_fd_sc_mcu7t5v0__filltie
XFILLER_53_419 VDD VDD VSS VSS gf180mcu_fd_sc_mcu7t5v0__fill_1
XFILLER_65_279 VDD VDD VSS VSS gf180mcu_fd_sc_mcu7t5v0__fill_1
XFILLER_33_154 VDD VDD VSS VSS gf180mcu_fd_sc_mcu7t5v0__fillcap_4
XFILLER_61_452 VDD VDD VSS VSS gf180mcu_fd_sc_mcu7t5v0__fill_2
XTAP_TAPCELL_ROW_16_363 VDD VSS gf180mcu_fd_sc_mcu7t5v0__filltie
XFILLER_61_485 VDD VDD VSS VSS gf180mcu_fd_sc_mcu7t5v0__fillcap_4
X_1954_ _1954_/A1 _1937_/Z _1954_/B _1957_/A2 VDD VDD VSS VSS gf180mcu_fd_sc_mcu7t5v0__aoi21_1
XFILLER_33_198 VDD VDD VSS VSS gf180mcu_fd_sc_mcu7t5v0__fillcap_4
XTAP_TAPCELL_ROW_95_1107 VDD VSS gf180mcu_fd_sc_mcu7t5v0__filltie
X_1885_ _3050_/I _1884_/Z _1885_/Z VDD VDD VSS VSS gf180mcu_fd_sc_mcu7t5v0__xor2_1
X_3624_ _3685_/Q _3624_/A2 _3624_/B _3648_/A1 VDD VDD VSS VSS gf180mcu_fd_sc_mcu7t5v0__aoi21_1
X_3555_ _3555_/A1 _3554_/I _3555_/Z VDD VDD VSS VSS gf180mcu_fd_sc_mcu7t5v0__xor2_1
X_2506_ wire358/Z _3023_/I _2507_/I VDD VDD VSS VSS gf180mcu_fd_sc_mcu7t5v0__xor2_1
X_3486_ _3056_/I _3492_/A2 _3485_/Z _3697_/Q _3487_/B VDD VDD VSS VSS gf180mcu_fd_sc_mcu7t5v0__aoi22_1
XFILLER_88_349 VDD VDD VSS VSS gf180mcu_fd_sc_mcu7t5v0__fillcap_8
X_2437_ _2349_/Z _2437_/A2 _2437_/Z VDD VDD VSS VSS gf180mcu_fd_sc_mcu7t5v0__xor2_1
XFILLER_84_511 VDD VDD VSS VSS gf180mcu_fd_sc_mcu7t5v0__fillcap_8
X_2368_ _3732_/Q _2388_/B1 _3733_/Q _2371_/B VDD VDD VSS VSS gf180mcu_fd_sc_mcu7t5v0__aoi21_1
X_2299_ _2299_/A1 _2261_/Z _2743_/B _2918_/A1 VDD VDD VSS VSS gf180mcu_fd_sc_mcu7t5v0__aoi21_4
XFILLER_25_644 VDD VDD VSS VSS gf180mcu_fd_sc_mcu7t5v0__fill_2
XTAP_TAPCELL_ROW_42_609 VDD VSS gf180mcu_fd_sc_mcu7t5v0__filltie
XFILLER_52_441 VDD VDD VSS VSS gf180mcu_fd_sc_mcu7t5v0__fill_2
XFILLER_40_647 VDD VDD VSS VSS gf180mcu_fd_sc_mcu7t5v0__fill_2
XFILLER_40_658 VDD VDD VSS VSS gf180mcu_fd_sc_mcu7t5v0__fillcap_4
XFILLER_20_360 VDD VDD VSS VSS gf180mcu_fd_sc_mcu7t5v0__fill_1
XTAP_TAPCELL_ROW_50_686 VDD VSS gf180mcu_fd_sc_mcu7t5v0__filltie
XFILLER_4_559 VDD VDD VSS VSS gf180mcu_fd_sc_mcu7t5v0__fillcap_16
Xoutput190 _3702_/Q raw_edge2[13] VDD VDD VSS VSS gf180mcu_fd_sc_mcu7t5v0__buf_2
XFILLER_87_360 VDD VDD VSS VSS gf180mcu_fd_sc_mcu7t5v0__fillcap_4
XFILLER_75_500 VDD VDD VSS VSS gf180mcu_fd_sc_mcu7t5v0__fillcap_4
XFILLER_35_419 VDD VDD VSS VSS gf180mcu_fd_sc_mcu7t5v0__fill_1
XTAP_TAPCELL_ROW_83_1000 VDD VSS gf180mcu_fd_sc_mcu7t5v0__filltie
XFILLER_90_558 VDD VDD VSS VSS gf180mcu_fd_sc_mcu7t5v0__fillcap_32
XTAP_TAPCELL_ROW_13_333 VDD VSS gf180mcu_fd_sc_mcu7t5v0__filltie
Xwire284 wire286/Z wire284/Z VDD VDD VSS VSS gf180mcu_fd_sc_mcu7t5v0__dlyb_1
X_3340_ _3340_/A1 _3340_/A2 _3340_/B _3345_/A2 VDD VDD VSS VSS gf180mcu_fd_sc_mcu7t5v0__aoi21_1
XTAP_TAPCELL_ROW_90_1059 VDD VSS gf180mcu_fd_sc_mcu7t5v0__filltie
X_3271_ _3271_/A1 _3287_/A2 _3271_/B _3273_/A2 VDD VDD VSS VSS gf180mcu_fd_sc_mcu7t5v0__aoi21_1
Xload_slew245 _2903_/A1 _2900_/A1 VDD VDD VSS VSS gf180mcu_fd_sc_mcu7t5v0__buf_1
Xload_slew234 wire233/I _2894_/A2 VDD VDD VSS VSS gf180mcu_fd_sc_mcu7t5v0__buf_2
X_2222_ _2241_/A1 _2241_/A2 _2222_/B _2222_/C _2223_/I VDD VDD VSS VSS gf180mcu_fd_sc_mcu7t5v0__aoi211_1
Xload_slew278 _2265_/B2 _2806_/A1 VDD VDD VSS VSS gf180mcu_fd_sc_mcu7t5v0__buf_1
XFILLER_78_393 VDD VDD VSS VSS gf180mcu_fd_sc_mcu7t5v0__fillcap_16
XFILLER_16_2 VDD VDD VSS VSS gf180mcu_fd_sc_mcu7t5v0__fillcap_32
XFILLER_38_213 VDD VDD VSS VSS gf180mcu_fd_sc_mcu7t5v0__fill_2
X_2153_ _3506_/A1 _2154_/A2 _2154_/B VDD VDD VSS VSS gf180mcu_fd_sc_mcu7t5v0__nand2_1
XFILLER_66_522 VDD VDD VSS VSS gf180mcu_fd_sc_mcu7t5v0__fill_2
XFILLER_93_352 VDD VDD VSS VSS gf180mcu_fd_sc_mcu7t5v0__fillcap_64
XFILLER_26_408 VDD VDD VSS VSS gf180mcu_fd_sc_mcu7t5v0__fillcap_32
X_2084_ _2062_/Z _2064_/Z _2084_/B _2099_/C VDD VDD VSS VSS gf180mcu_fd_sc_mcu7t5v0__oai21_1
XFILLER_81_536 VDD VDD VSS VSS gf180mcu_fd_sc_mcu7t5v0__fillcap_8
XFILLER_34_441 VDD VDD VSS VSS gf180mcu_fd_sc_mcu7t5v0__fill_1
X_2986_ _2986_/I _3107_/B2 VDD VDD VSS VSS gf180mcu_fd_sc_mcu7t5v0__clkinv_1
X_1937_ wire646/Z _1927_/Z _1933_/Z _1937_/Z VDD VDD VSS VSS gf180mcu_fd_sc_mcu7t5v0__xor3_1
X_1868_ _3159_/A2 _3050_/I _1877_/A2 _1868_/Z VDD VDD VSS VSS gf180mcu_fd_sc_mcu7t5v0__xor3_1
Xinput81 cfg_phase90_offset[9] _3022_/I VDD VDD VSS VSS gf180mcu_fd_sc_mcu7t5v0__buf_1
Xinput70 cfg_phase90_offset[18] _2604_/B VDD VDD VSS VSS gf180mcu_fd_sc_mcu7t5v0__buf_1
X_3607_ wire280/Z _3607_/A2 _3607_/B _3636_/A1 VDD VDD VSS VSS gf180mcu_fd_sc_mcu7t5v0__oai21_1
X_3538_ _3063_/I _3536_/Z _3538_/Z VDD VDD VSS VSS gf180mcu_fd_sc_mcu7t5v0__xor2_1
X_1799_ _3041_/I _3781_/I _1802_/B VDD VDD VSS VSS gf180mcu_fd_sc_mcu7t5v0__xnor2_1
X_3469_ _3485_/A2 _3472_/A3 _3469_/Z VDD VDD VSS VSS gf180mcu_fd_sc_mcu7t5v0__xor2_1
XFILLER_69_393 VDD VDD VSS VSS gf180mcu_fd_sc_mcu7t5v0__fill_1
XFILLER_29_257 VDD VDD VSS VSS gf180mcu_fd_sc_mcu7t5v0__fillcap_16
XFILLER_29_279 VDD VDD VSS VSS gf180mcu_fd_sc_mcu7t5v0__fill_1
XTAP_TAPCELL_ROW_55_734 VDD VSS gf180mcu_fd_sc_mcu7t5v0__filltie
XFILLER_57_599 VDD VDD VSS VSS gf180mcu_fd_sc_mcu7t5v0__fill_1
XFILLER_25_430 VDD VDD VSS VSS gf180mcu_fd_sc_mcu7t5v0__fill_1
XFILLER_37_290 VDD VDD VSS VSS gf180mcu_fd_sc_mcu7t5v0__fill_2
XFILLER_44_249 VDD VDD VSS VSS gf180mcu_fd_sc_mcu7t5v0__fill_1
XTAP_TAPCELL_ROW_10_303 VDD VSS gf180mcu_fd_sc_mcu7t5v0__filltie
XFILLER_0_562 VDD VDD VSS VSS gf180mcu_fd_sc_mcu7t5v0__fillcap_8
XFILLER_48_544 VDD VDD VSS VSS gf180mcu_fd_sc_mcu7t5v0__fill_1
XFILLER_57_72 VDD VDD VSS VSS gf180mcu_fd_sc_mcu7t5v0__fillcap_64
XFILLER_90_311 VDD VDD VSS VSS gf180mcu_fd_sc_mcu7t5v0__fillcap_4
XFILLER_75_385 VDD VDD VSS VSS gf180mcu_fd_sc_mcu7t5v0__fill_2
XFILLER_63_514 VDD VDD VSS VSS gf180mcu_fd_sc_mcu7t5v0__fill_1
XFILLER_28_290 VDD VDD VSS VSS gf180mcu_fd_sc_mcu7t5v0__fill_1
X_2840_ _3743_/Q _2842_/A2 _2843_/B _2841_/B2 VDD VDD VSS VSS gf180mcu_fd_sc_mcu7t5v0__oai21_1
X_2771_ _3734_/Q _2772_/A2 _2772_/B VDD VDD VSS VSS gf180mcu_fd_sc_mcu7t5v0__nand2_1
XPHY_EDGE_ROW_9_Right_9 VDD VSS gf180mcu_fd_sc_mcu7t5v0__endcap
X_3323_ _3251_/C _3332_/B1 _3323_/B _3338_/B _3324_/B VDD VDD VSS VSS gf180mcu_fd_sc_mcu7t5v0__oai211_1
X_3254_ _3254_/A1 _3254_/A2 _3254_/B _3255_/A3 VDD VDD VSS VSS gf180mcu_fd_sc_mcu7t5v0__aoi21_1
X_2205_ _2205_/A1 _2203_/Z _2204_/Z _2205_/Z VDD VDD VSS VSS gf180mcu_fd_sc_mcu7t5v0__and3_1
XTAP_TAPCELL_ROW_69_859 VDD VSS gf180mcu_fd_sc_mcu7t5v0__filltie
XFILLER_94_661 VDD VDD VSS VSS gf180mcu_fd_sc_mcu7t5v0__fillcap_4
X_3185_ wire517/Z _2006_/C _3185_/Z VDD VDD VSS VSS gf180mcu_fd_sc_mcu7t5v0__and2_1
XFILLER_81_322 VDD VDD VSS VSS gf180mcu_fd_sc_mcu7t5v0__fill_2
X_2136_ _2885_/A1 wire388/Z _2137_/B VDD VDD VSS VSS gf180mcu_fd_sc_mcu7t5v0__nand2_1
X_2067_ _2065_/Z _2068_/A2 _2098_/A1 VDD VDD VSS VSS gf180mcu_fd_sc_mcu7t5v0__nor2_1
XFILLER_26_238 VDD VDD VSS VSS gf180mcu_fd_sc_mcu7t5v0__fill_1
XFILLER_81_377 VDD VDD VSS VSS gf180mcu_fd_sc_mcu7t5v0__fillcap_4
XTAP_TAPCELL_ROW_52_704 VDD VSS gf180mcu_fd_sc_mcu7t5v0__filltie
XTAP_TAPCELL_ROW_24_439 VDD VSS gf180mcu_fd_sc_mcu7t5v0__filltie
XFILLER_22_477 VDD VDD VSS VSS gf180mcu_fd_sc_mcu7t5v0__fill_1
XFILLER_22_466 VDD VDD VSS VSS gf180mcu_fd_sc_mcu7t5v0__fill_2
X_2969_ _2969_/I _3129_/A1 VDD VDD VSS VSS gf180mcu_fd_sc_mcu7t5v0__clkinv_1
XTAP_TAPCELL_ROW_60_781 VDD VSS gf180mcu_fd_sc_mcu7t5v0__filltie
XFILLER_94_37 VDD VDD VSS VSS gf180mcu_fd_sc_mcu7t5v0__fillcap_64
XFILLER_57_352 VDD VDD VSS VSS gf180mcu_fd_sc_mcu7t5v0__fillcap_4
XFILLER_84_171 VDD VDD VSS VSS gf180mcu_fd_sc_mcu7t5v0__fillcap_4
XFILLER_72_366 VDD VDD VSS VSS gf180mcu_fd_sc_mcu7t5v0__fill_1
XFILLER_13_422 VDD VDD VSS VSS gf180mcu_fd_sc_mcu7t5v0__fillcap_4
XFILLER_40_263 VDD VDD VSS VSS gf180mcu_fd_sc_mcu7t5v0__fillcap_8
XFILLER_5_676 VDD VDD VSS VSS gf180mcu_fd_sc_mcu7t5v0__fill_1
XTAP_TAPCELL_ROW_89_1050 VDD VSS gf180mcu_fd_sc_mcu7t5v0__filltie
XFILLER_91_664 VDD VDD VSS VSS gf180mcu_fd_sc_mcu7t5v0__fillcap_4
XFILLER_16_271 VDD VDD VSS VSS gf180mcu_fd_sc_mcu7t5v0__fill_2
XFILLER_63_399 VDD VDD VSS VSS gf180mcu_fd_sc_mcu7t5v0__fillcap_16
XTAP_TAPCELL_ROW_21_409 VDD VSS gf180mcu_fd_sc_mcu7t5v0__filltie
XFILLER_83_2 VDD VDD VSS VSS gf180mcu_fd_sc_mcu7t5v0__fillcap_64
X_2823_ _2823_/A1 _2826_/A2 _3740_/Q _2827_/A2 VDD VDD VSS VSS gf180mcu_fd_sc_mcu7t5v0__aoi21_1
X_2754_ _3732_/Q _2775_/A2 _2805_/B1 _2754_/B2 _2754_/C _2759_/B1 VDD VDD VSS VSS
+ gf180mcu_fd_sc_mcu7t5v0__aoi221_1
X_2685_ _2873_/A1 input44/Z _2685_/A3 _2685_/Z VDD VDD VSS VSS gf180mcu_fd_sc_mcu7t5v0__xor3_1
X_3306_ _3299_/B _3306_/A2 _3319_/A3 _3308_/A2 VDD VDD VSS VSS gf180mcu_fd_sc_mcu7t5v0__nor3_1
X_3237_ _3223_/Z _3225_/Z _3237_/B _3308_/A1 VDD VDD VSS VSS gf180mcu_fd_sc_mcu7t5v0__aoi21_1
XFILLER_39_330 VDD VDD VSS VSS gf180mcu_fd_sc_mcu7t5v0__fill_1
XFILLER_39_374 VDD VDD VSS VSS gf180mcu_fd_sc_mcu7t5v0__fillcap_16
X_3168_ _3168_/A1 _3169_/A2 _3176_/B VDD VDD VSS VSS gf180mcu_fd_sc_mcu7t5v0__nand2_1
XFILLER_82_664 VDD VDD VSS VSS gf180mcu_fd_sc_mcu7t5v0__fill_1
X_2119_ _2992_/I wire636/Z _2119_/Z VDD VDD VSS VSS gf180mcu_fd_sc_mcu7t5v0__or2_1
X_3099_ _3099_/A1 wire448/I _3112_/B VDD VDD VSS VSS gf180mcu_fd_sc_mcu7t5v0__nor2_1
XFILLER_22_241 VDD VDD VSS VSS gf180mcu_fd_sc_mcu7t5v0__fillcap_4
XFILLER_10_403 VDD VDD VSS VSS gf180mcu_fd_sc_mcu7t5v0__fill_2
XFILLER_22_263 VDD VDD VSS VSS gf180mcu_fd_sc_mcu7t5v0__fillcap_8
XFILLER_50_594 VDD VDD VSS VSS gf180mcu_fd_sc_mcu7t5v0__fill_1
XFILLER_13_66 VDD VDD VSS VSS gf180mcu_fd_sc_mcu7t5v0__fillcap_4
XTAP_TAPCELL_ROW_9_289 VDD VSS gf180mcu_fd_sc_mcu7t5v0__filltie
XFILLER_45_311 VDD VDD VSS VSS gf180mcu_fd_sc_mcu7t5v0__fill_2
XFILLER_45_322 VDD VDD VSS VSS gf180mcu_fd_sc_mcu7t5v0__fillcap_16
XFILLER_45_399 VDD VDD VSS VSS gf180mcu_fd_sc_mcu7t5v0__fillcap_8
XFILLER_60_358 VDD VDD VSS VSS gf180mcu_fd_sc_mcu7t5v0__fillcap_16
XFILLER_9_212 VDD VDD VSS VSS gf180mcu_fd_sc_mcu7t5v0__fillcap_4
XFILLER_9_289 VDD VDD VSS VSS gf180mcu_fd_sc_mcu7t5v0__fillcap_32
X_2470_ _3119_/A2 input65/Z _2547_/A2 VDD VDD VSS VSS gf180mcu_fd_sc_mcu7t5v0__nor2_2
XFILLER_68_436 VDD VDD VSS VSS gf180mcu_fd_sc_mcu7t5v0__fill_2
XTAP_TAPCELL_ROW_79_954 VDD VSS gf180mcu_fd_sc_mcu7t5v0__filltie
X_3022_ _3022_/I _3022_/ZN VDD VDD VSS VSS gf180mcu_fd_sc_mcu7t5v0__clkinv_1
XFILLER_36_300 VDD VDD VSS VSS gf180mcu_fd_sc_mcu7t5v0__fill_2
XFILLER_48_171 VDD VDD VSS VSS gf180mcu_fd_sc_mcu7t5v0__fillcap_4
XFILLER_24_506 VDD VDD VSS VSS gf180mcu_fd_sc_mcu7t5v0__fillcap_16
XTAP_TAPCELL_ROW_34_534 VDD VSS gf180mcu_fd_sc_mcu7t5v0__filltie
XFILLER_51_314 VDD VDD VSS VSS gf180mcu_fd_sc_mcu7t5v0__fill_1
Xclkload9 clkload9/I clkload9/Z VDD VDD VSS VSS gf180mcu_fd_sc_mcu7t5v0__clkbuf_2
X_2806_ _2806_/A1 _2806_/A2 _2806_/B _2807_/A3 VDD VDD VSS VSS gf180mcu_fd_sc_mcu7t5v0__oai21_1
X_2737_ _2738_/A1 _2738_/A2 _2738_/B _2737_/Z VDD VDD VSS VSS gf180mcu_fd_sc_mcu7t5v0__or3_1
X_2668_ _2675_/C _2675_/B _2727_/A1 VDD VDD VSS VSS gf180mcu_fd_sc_mcu7t5v0__nor2_1
X_2599_ _2599_/A1 _2603_/C _2599_/Z VDD VDD VSS VSS gf180mcu_fd_sc_mcu7t5v0__xor2_1
Xfanout268 _2848_/A2 wire269/I VDD VDD VSS VSS gf180mcu_fd_sc_mcu7t5v0__dlyb_1
XFILLER_70_667 VDD VDD VSS VSS gf180mcu_fd_sc_mcu7t5v0__fill_2
Xwire647 wire647/I wire647/Z VDD VDD VSS VSS gf180mcu_fd_sc_mcu7t5v0__clkbuf_2
Xwire636 input2/Z wire636/Z VDD VDD VSS VSS gf180mcu_fd_sc_mcu7t5v0__buf_3
XFILLER_2_454 VDD VDD VSS VSS gf180mcu_fd_sc_mcu7t5v0__fill_1
Xload_slew608 _3673_/RN _3715_/RN VDD VDD VSS VSS gf180mcu_fd_sc_mcu7t5v0__clkbuf_2
XFILLER_92_247 VDD VDD VSS VSS gf180mcu_fd_sc_mcu7t5v0__fillcap_64
XTAP_TAPCELL_ROW_86_1020 VDD VSS gf180mcu_fd_sc_mcu7t5v0__filltie
XTAP_TAPCELL_ROW_48_659 VDD VSS gf180mcu_fd_sc_mcu7t5v0__filltie
XFILLER_58_491 VDD VDD VSS VSS gf180mcu_fd_sc_mcu7t5v0__fill_1
XFILLER_18_366 VDD VDD VSS VSS gf180mcu_fd_sc_mcu7t5v0__fill_2
XFILLER_65_72 VDD VDD VSS VSS gf180mcu_fd_sc_mcu7t5v0__fillcap_64
X_1970_ _1929_/C _1973_/A2 _1971_/C VDD VDD VSS VSS gf180mcu_fd_sc_mcu7t5v0__or2_1
XTAP_TAPCELL_ROW_31_504 VDD VSS gf180mcu_fd_sc_mcu7t5v0__filltie
XFILLER_60_177 VDD VDD VSS VSS gf180mcu_fd_sc_mcu7t5v0__fillcap_8
XFILLER_14_594 VDD VDD VSS VSS gf180mcu_fd_sc_mcu7t5v0__fill_1
XFILLER_60_199 VDD VDD VSS VSS gf180mcu_fd_sc_mcu7t5v0__fill_1
X_3640_ _3648_/B _3639_/Z _3640_/Z VDD VDD VSS VSS gf180mcu_fd_sc_mcu7t5v0__and2_1
X_3571_ _3571_/A1 _3569_/Z _3571_/Z VDD VDD VSS VSS gf180mcu_fd_sc_mcu7t5v0__xor2_1
X_2522_ _2522_/A1 _2511_/Z _2522_/A3 _2522_/B _2554_/A2 VDD VDD VSS VSS gf180mcu_fd_sc_mcu7t5v0__oai31_1
XFILLER_5_292 VDD VDD VSS VSS gf180mcu_fd_sc_mcu7t5v0__fillcap_32
XFILLER_46_2 VDD VDD VSS VSS gf180mcu_fd_sc_mcu7t5v0__fillcap_32
X_2453_ _2992_/I input2/Z _2460_/B VDD VDD VSS VSS gf180mcu_fd_sc_mcu7t5v0__nand2_1
X_2384_ _2384_/A1 _2385_/A3 _2384_/B _3737_/Q _2385_/B VDD VDD VSS VSS gf180mcu_fd_sc_mcu7t5v0__oai211_1
Xinput2 cfg_done input2/Z VDD VDD VSS VSS gf180mcu_fd_sc_mcu7t5v0__buf_3
X_3005_ _3005_/I _3558_/A1 VDD VDD VSS VSS gf180mcu_fd_sc_mcu7t5v0__inv_2
XFILLER_36_174 VDD VDD VSS VSS gf180mcu_fd_sc_mcu7t5v0__fill_1
XFILLER_24_347 VDD VDD VSS VSS gf180mcu_fd_sc_mcu7t5v0__fill_2
XFILLER_52_667 VDD VDD VSS VSS gf180mcu_fd_sc_mcu7t5v0__fill_2
XFILLER_32_391 VDD VDD VSS VSS gf180mcu_fd_sc_mcu7t5v0__fillcap_4
XFILLER_20_597 VDD VDD VSS VSS gf180mcu_fd_sc_mcu7t5v0__fillcap_4
X_3769_ _3769_/D wire554/Z clkload1/I _3769_/Q VDD VDD VSS VSS gf180mcu_fd_sc_mcu7t5v0__dffrnq_1
XFILLER_10_34 VDD VDD VSS VSS gf180mcu_fd_sc_mcu7t5v0__fill_1
XFILLER_59_200 VDD VDD VSS VSS gf180mcu_fd_sc_mcu7t5v0__fillcap_4
XFILLER_47_417 VDD VDD VSS VSS gf180mcu_fd_sc_mcu7t5v0__fill_2
XFILLER_59_277 VDD VDD VSS VSS gf180mcu_fd_sc_mcu7t5v0__fill_2
XFILLER_59_288 VDD VDD VSS VSS gf180mcu_fd_sc_mcu7t5v0__fill_1
XFILLER_28_631 VDD VDD VSS VSS gf180mcu_fd_sc_mcu7t5v0__fill_2
XFILLER_74_247 VDD VDD VSS VSS gf180mcu_fd_sc_mcu7t5v0__fillcap_64
XTAP_TAPCELL_ROW_73_905 VDD VSS gf180mcu_fd_sc_mcu7t5v0__filltie
XFILLER_27_174 VDD VDD VSS VSS gf180mcu_fd_sc_mcu7t5v0__fillcap_16
XFILLER_43_634 VDD VDD VSS VSS gf180mcu_fd_sc_mcu7t5v0__fill_1
XFILLER_55_483 VDD VDD VSS VSS gf180mcu_fd_sc_mcu7t5v0__fillcap_4
XFILLER_15_347 VDD VDD VSS VSS gf180mcu_fd_sc_mcu7t5v0__fill_2
XFILLER_30_328 VDD VDD VSS VSS gf180mcu_fd_sc_mcu7t5v0__fillcap_4
XFILLER_35_86 VDD VDD VSS VSS gf180mcu_fd_sc_mcu7t5v0__fill_1
XFILLER_42_177 VDD VDD VSS VSS gf180mcu_fd_sc_mcu7t5v0__fillcap_4
XFILLER_7_502 VDD VDD VSS VSS gf180mcu_fd_sc_mcu7t5v0__fill_1
Xwire422 wire422/I _2968_/I VDD VDD VSS VSS gf180mcu_fd_sc_mcu7t5v0__buf_1
Xwire400 wire400/I wire400/Z VDD VDD VSS VSS gf180mcu_fd_sc_mcu7t5v0__clkbuf_2
Xwire466 _3748_/Q wire466/Z VDD VDD VSS VSS gf180mcu_fd_sc_mcu7t5v0__buf_1
Xload_slew427 wire428/Z _3235_/A1 VDD VDD VSS VSS gf180mcu_fd_sc_mcu7t5v0__buf_2
XPHY_EDGE_ROW_29_Left_126 VDD VSS gf180mcu_fd_sc_mcu7t5v0__endcap
Xload_slew416 _2598_/A1 _2996_/I VDD VDD VSS VSS gf180mcu_fd_sc_mcu7t5v0__clkbuf_2
Xload_slew438 _2469_/A1 _2547_/B2 VDD VDD VSS VSS gf180mcu_fd_sc_mcu7t5v0__clkbuf_2
Xload_slew449 _2518_/A1 wire448/I VDD VDD VSS VSS gf180mcu_fd_sc_mcu7t5v0__clkbuf_1
XFILLER_78_597 VDD VDD VSS VSS gf180mcu_fd_sc_mcu7t5v0__fill_2
XFILLER_78_586 VDD VDD VSS VSS gf180mcu_fd_sc_mcu7t5v0__fill_1
XFILLER_65_203 VDD VDD VSS VSS gf180mcu_fd_sc_mcu7t5v0__fillcap_4
XFILLER_93_556 VDD VDD VSS VSS gf180mcu_fd_sc_mcu7t5v0__fillcap_4
XFILLER_34_667 VDD VDD VSS VSS gf180mcu_fd_sc_mcu7t5v0__fill_2
XPHY_EDGE_ROW_38_Left_135 VDD VSS gf180mcu_fd_sc_mcu7t5v0__endcap
XTAP_TAPCELL_ROW_16_364 VDD VSS gf180mcu_fd_sc_mcu7t5v0__filltie
XFILLER_33_166 VDD VDD VSS VSS gf180mcu_fd_sc_mcu7t5v0__fillcap_32
X_1953_ _3483_/A1 _1952_/Z _1953_/Z VDD VDD VSS VSS gf180mcu_fd_sc_mcu7t5v0__xor2_1
XFILLER_14_391 VDD VDD VSS VSS gf180mcu_fd_sc_mcu7t5v0__fill_2
X_1884_ _3437_/A1 _1884_/A2 _1884_/A3 _1884_/Z VDD VDD VSS VSS gf180mcu_fd_sc_mcu7t5v0__xor3_1
XTAP_TAPCELL_ROW_95_1108 VDD VSS gf180mcu_fd_sc_mcu7t5v0__filltie
X_3623_ _3636_/B _3623_/A2 _3623_/ZN VDD VDD VSS VSS gf180mcu_fd_sc_mcu7t5v0__xnor2_2
X_3554_ _3554_/I _3584_/A2 VDD VDD VSS VSS gf180mcu_fd_sc_mcu7t5v0__clkinv_1
X_2505_ _2512_/A1 _2512_/A2 _2561_/A1 VDD VDD VSS VSS gf180mcu_fd_sc_mcu7t5v0__nand2_1
XPHY_EDGE_ROW_47_Left_144 VDD VSS gf180mcu_fd_sc_mcu7t5v0__endcap
X_3485_ _3485_/A1 _3485_/A2 _3485_/Z VDD VDD VSS VSS gf180mcu_fd_sc_mcu7t5v0__and2_1
XFILLER_88_317 VDD VDD VSS VSS gf180mcu_fd_sc_mcu7t5v0__fillcap_32
X_2436_ _2356_/C _3003_/I _2436_/B _2437_/A2 VDD VDD VSS VSS gf180mcu_fd_sc_mcu7t5v0__aoi21_1
X_2367_ _2367_/I _3732_/D VDD VDD VSS VSS gf180mcu_fd_sc_mcu7t5v0__clkinv_1
XFILLER_84_523 VDD VDD VSS VSS gf180mcu_fd_sc_mcu7t5v0__fill_2
X_2298_ _2298_/A1 _2943_/A1 _2298_/B _3730_/D VDD VDD VSS VSS gf180mcu_fd_sc_mcu7t5v0__oai21_1
XFILLER_71_206 VDD VDD VSS VSS gf180mcu_fd_sc_mcu7t5v0__fillcap_4
XPHY_EDGE_ROW_56_Left_153 VDD VSS gf180mcu_fd_sc_mcu7t5v0__endcap
XFILLER_24_177 VDD VDD VSS VSS gf180mcu_fd_sc_mcu7t5v0__fillcap_32
XTAP_TAPCELL_ROW_50_687 VDD VSS gf180mcu_fd_sc_mcu7t5v0__filltie
XFILLER_4_527 VDD VDD VSS VSS gf180mcu_fd_sc_mcu7t5v0__fillcap_32
XFILLER_21_66 VDD VDD VSS VSS gf180mcu_fd_sc_mcu7t5v0__fillcap_4
XPHY_EDGE_ROW_65_Left_162 VDD VSS gf180mcu_fd_sc_mcu7t5v0__endcap
Xoutput180 _3672_/Q raw_edge1[4] VDD VDD VSS VSS gf180mcu_fd_sc_mcu7t5v0__buf_2
Xoutput191 _3703_/Q raw_edge2[14] VDD VDD VSS VSS gf180mcu_fd_sc_mcu7t5v0__buf_2
XFILLER_47_203 VDD VDD VSS VSS gf180mcu_fd_sc_mcu7t5v0__fill_1
XFILLER_87_394 VDD VDD VSS VSS gf180mcu_fd_sc_mcu7t5v0__fillcap_16
XTAP_TAPCELL_ROW_58_754 VDD VSS gf180mcu_fd_sc_mcu7t5v0__filltie
XPHY_EDGE_ROW_74_Left_171 VDD VSS gf180mcu_fd_sc_mcu7t5v0__endcap
XFILLER_16_601 VDD VDD VSS VSS gf180mcu_fd_sc_mcu7t5v0__fill_1
XFILLER_16_667 VDD VDD VSS VSS gf180mcu_fd_sc_mcu7t5v0__fill_2
XFILLER_16_656 VDD VDD VSS VSS gf180mcu_fd_sc_mcu7t5v0__fill_1
XTAP_TAPCELL_ROW_13_334 VDD VSS gf180mcu_fd_sc_mcu7t5v0__filltie
XPHY_EDGE_ROW_83_Left_180 VDD VSS gf180mcu_fd_sc_mcu7t5v0__endcap
XFILLER_7_343 VDD VDD VSS VSS gf180mcu_fd_sc_mcu7t5v0__fill_2
Xwire263 wire264/Z wire263/Z VDD VDD VSS VSS gf180mcu_fd_sc_mcu7t5v0__clkbuf_2
Xwire296 wire297/Z wire296/Z VDD VDD VSS VSS gf180mcu_fd_sc_mcu7t5v0__dlyb_1
X_3270_ _3286_/A1 _3269_/Z _3270_/B _3287_/A2 VDD VDD VSS VSS gf180mcu_fd_sc_mcu7t5v0__oai21_1
X_2221_ _3734_/Q _3662_/Q _2222_/C VDD VDD VSS VSS gf180mcu_fd_sc_mcu7t5v0__xor2_1
Xload_slew246 _2903_/A1 _2910_/A1 VDD VDD VSS VSS gf180mcu_fd_sc_mcu7t5v0__buf_2
Xload_slew279 _2073_/A1 _2038_/A1 VDD VDD VSS VSS gf180mcu_fd_sc_mcu7t5v0__clkbuf_1
Xload_slew257 wire258/Z _2948_/A2 VDD VDD VSS VSS gf180mcu_fd_sc_mcu7t5v0__clkbuf_2
X_2152_ _2201_/A1 _2201_/A2 _2201_/A3 _2199_/B VDD VDD VSS VSS gf180mcu_fd_sc_mcu7t5v0__nor3_1
X_2083_ wire523/Z _3612_/A1 _2083_/A3 _2084_/B VDD VDD VSS VSS gf180mcu_fd_sc_mcu7t5v0__xor3_1
XFILLER_46_291 VDD VDD VSS VSS gf180mcu_fd_sc_mcu7t5v0__fill_1
XFILLER_21_136 VDD VDD VSS VSS gf180mcu_fd_sc_mcu7t5v0__fillcap_4
X_2985_ _3747_/Q _3108_/B2 VDD VDD VSS VSS gf180mcu_fd_sc_mcu7t5v0__clkinv_1
X_1936_ wire646/Z _1935_/Z _1954_/B VDD VDD VSS VSS gf180mcu_fd_sc_mcu7t5v0__nor2_1
X_1867_ _1972_/A1 _1895_/A1 _1877_/A2 VDD VDD VSS VSS gf180mcu_fd_sc_mcu7t5v0__nor2_1
Xinput82 comp input82/Z VDD VDD VSS VSS gf180mcu_fd_sc_mcu7t5v0__buf_2
Xinput60 cfg_phase270_offset[9] input60/Z VDD VDD VSS VSS gf180mcu_fd_sc_mcu7t5v0__buf_1
Xinput71 cfg_phase90_offset[19] input71/Z VDD VDD VSS VSS gf180mcu_fd_sc_mcu7t5v0__buf_1
X_3606_ _3606_/A1 _3606_/A2 _3608_/C _3590_/Z _3607_/B VDD VDD VSS VSS gf180mcu_fd_sc_mcu7t5v0__nor4_1
X_1798_ _3350_/A2 _3781_/I _1808_/A1 VDD VDD VSS VSS gf180mcu_fd_sc_mcu7t5v0__nand2_1
X_3537_ _3063_/I _3536_/Z _3537_/Z VDD VDD VSS VSS gf180mcu_fd_sc_mcu7t5v0__and2_1
X_3468_ _3450_/Z _3468_/A2 _3468_/B _3472_/A3 VDD VDD VSS VSS gf180mcu_fd_sc_mcu7t5v0__aoi21_1
X_2419_ wire459/Z _3526_/A1 _2339_/B _2419_/Z VDD VDD VSS VSS gf180mcu_fd_sc_mcu7t5v0__xor3_1
XFILLER_29_203 VDD VDD VSS VSS gf180mcu_fd_sc_mcu7t5v0__fill_1
X_3399_ _3399_/A1 _3673_/Q _3399_/Z VDD VDD VSS VSS gf180mcu_fd_sc_mcu7t5v0__xor2_1
XFILLER_25_442 VDD VDD VSS VSS gf180mcu_fd_sc_mcu7t5v0__fillcap_4
XFILLER_72_559 VDD VDD VSS VSS gf180mcu_fd_sc_mcu7t5v0__fillcap_8
XFILLER_25_486 VDD VDD VSS VSS gf180mcu_fd_sc_mcu7t5v0__fillcap_4
XFILLER_80_581 VDD VDD VSS VSS gf180mcu_fd_sc_mcu7t5v0__fillcap_8
XFILLER_8_107 VDD VDD VSS VSS gf180mcu_fd_sc_mcu7t5v0__fillcap_64
XTAP_TAPCELL_ROW_10_304 VDD VSS gf180mcu_fd_sc_mcu7t5v0__filltie
XFILLER_79_136 VDD VDD VSS VSS gf180mcu_fd_sc_mcu7t5v0__fillcap_4
XFILLER_63_559 VDD VDD VSS VSS gf180mcu_fd_sc_mcu7t5v0__fill_1
XFILLER_16_464 VDD VDD VSS VSS gf180mcu_fd_sc_mcu7t5v0__fillcap_16
XFILLER_16_453 VDD VDD VSS VSS gf180mcu_fd_sc_mcu7t5v0__fill_2
XFILLER_73_72 VDD VDD VSS VSS gf180mcu_fd_sc_mcu7t5v0__fillcap_64
XFILLER_16_486 VDD VDD VSS VSS gf180mcu_fd_sc_mcu7t5v0__fill_1
XFILLER_31_434 VDD VDD VSS VSS gf180mcu_fd_sc_mcu7t5v0__fill_2
XFILLER_43_294 VDD VDD VSS VSS gf180mcu_fd_sc_mcu7t5v0__fill_1
X_2770_ _3091_/ZN _2775_/A2 _2775_/C VDD VDD VSS VSS gf180mcu_fd_sc_mcu7t5v0__nor2_1
XFILLER_8_652 VDD VDD VSS VSS gf180mcu_fd_sc_mcu7t5v0__fill_1
X_3322_ _3251_/C _3322_/A2 _3332_/B1 _3323_/B VDD VDD VSS VSS gf180mcu_fd_sc_mcu7t5v0__nand3_1
X_3253_ _3237_/B _3282_/A1 _3254_/A2 VDD VDD VSS VSS gf180mcu_fd_sc_mcu7t5v0__nand2_1
X_2204_ _2442_/B _2207_/A2 _2204_/Z VDD VDD VSS VSS gf180mcu_fd_sc_mcu7t5v0__xor2_1
X_3184_ wire642/Z _3187_/A2 _3184_/A3 _3184_/Z VDD VDD VSS VSS gf180mcu_fd_sc_mcu7t5v0__xor3_1
XFILLER_39_545 VDD VDD VSS VSS gf180mcu_fd_sc_mcu7t5v0__fillcap_8
X_2135_ wire421/Z _2202_/A2 _2207_/B VDD VDD VSS VSS gf180mcu_fd_sc_mcu7t5v0__nand2_1
X_2066_ _3704_/Q _2066_/A2 _2066_/B _2068_/A2 VDD VDD VSS VSS gf180mcu_fd_sc_mcu7t5v0__aoi21_1
XFILLER_41_209 VDD VDD VSS VSS gf180mcu_fd_sc_mcu7t5v0__fill_1
XTAP_TAPCELL_ROW_52_705 VDD VSS gf180mcu_fd_sc_mcu7t5v0__filltie
XFILLER_10_629 VDD VDD VSS VSS gf180mcu_fd_sc_mcu7t5v0__fillcap_16
X_2968_ _2968_/I _2734_/C VDD VDD VSS VSS gf180mcu_fd_sc_mcu7t5v0__inv_2
XTAP_TAPCELL_ROW_60_782 VDD VSS gf180mcu_fd_sc_mcu7t5v0__filltie
X_1919_ _3450_/A1 _1918_/Z _1919_/Z VDD VDD VSS VSS gf180mcu_fd_sc_mcu7t5v0__xor2_2
X_2899_ _3742_/Q wire543/Z _2947_/A2 VDD VDD VSS VSS gf180mcu_fd_sc_mcu7t5v0__nand2_1
XFILLER_89_434 VDD VDD VSS VSS gf180mcu_fd_sc_mcu7t5v0__fillcap_4
XFILLER_1_349 VDD VDD VSS VSS gf180mcu_fd_sc_mcu7t5v0__fill_1
XFILLER_17_228 VDD VDD VSS VSS gf180mcu_fd_sc_mcu7t5v0__fill_2
XFILLER_17_206 VDD VDD VSS VSS gf180mcu_fd_sc_mcu7t5v0__fillcap_4
XFILLER_45_504 VDD VDD VSS VSS gf180mcu_fd_sc_mcu7t5v0__fill_2
XFILLER_45_559 VDD VDD VSS VSS gf180mcu_fd_sc_mcu7t5v0__fill_1
XFILLER_72_334 VDD VDD VSS VSS gf180mcu_fd_sc_mcu7t5v0__fill_2
XFILLER_72_389 VDD VDD VSS VSS gf180mcu_fd_sc_mcu7t5v0__fill_1
XFILLER_13_489 VDD VDD VSS VSS gf180mcu_fd_sc_mcu7t5v0__fill_1
XTAP_TAPCELL_ROW_89_1051 VDD VSS gf180mcu_fd_sc_mcu7t5v0__filltie
XFILLER_91_632 VDD VDD VSS VSS gf180mcu_fd_sc_mcu7t5v0__fillcap_32
XFILLER_63_345 VDD VDD VSS VSS gf180mcu_fd_sc_mcu7t5v0__fillcap_4
XFILLER_63_356 VDD VDD VSS VSS gf180mcu_fd_sc_mcu7t5v0__fill_1
XFILLER_31_231 VDD VDD VSS VSS gf180mcu_fd_sc_mcu7t5v0__fill_2
XFILLER_31_286 VDD VDD VSS VSS gf180mcu_fd_sc_mcu7t5v0__fill_2
X_2822_ _3096_/ZN _2822_/A2 _2822_/B _2826_/A2 VDD VDD VSS VSS gf180mcu_fd_sc_mcu7t5v0__oai21_1
XFILLER_76_2 VDD VDD VSS VSS gf180mcu_fd_sc_mcu7t5v0__fillcap_32
X_2753_ wire275/Z _2757_/A1 _2754_/B2 VDD VDD VSS VSS gf180mcu_fd_sc_mcu7t5v0__nand2_1
X_2684_ _2613_/Z _2684_/A2 _2684_/Z VDD VDD VSS VSS gf180mcu_fd_sc_mcu7t5v0__xor2_1
X_3305_ _3271_/B _3338_/B _3308_/B VDD VDD VSS VSS gf180mcu_fd_sc_mcu7t5v0__nor2_1
XFILLER_58_139 VDD VDD VSS VSS gf180mcu_fd_sc_mcu7t5v0__fillcap_8
X_3236_ _3223_/Z _3225_/Z _3319_/A3 VDD VDD VSS VSS gf180mcu_fd_sc_mcu7t5v0__nand2_1
XFILLER_67_640 VDD VDD VSS VSS gf180mcu_fd_sc_mcu7t5v0__fill_2
X_3167_ _3011_/I _3170_/A2 _3167_/A3 _3167_/Z VDD VDD VSS VSS gf180mcu_fd_sc_mcu7t5v0__xor3_1
XFILLER_82_632 VDD VDD VSS VSS gf180mcu_fd_sc_mcu7t5v0__fill_1
X_2118_ _2992_/I wire636/Z _2443_/A2 VDD VDD VSS VSS gf180mcu_fd_sc_mcu7t5v0__nor2_4
X_3098_ _3099_/A1 wire448/I _3113_/A1 _3113_/A2 _3114_/S VDD VDD VSS VSS gf180mcu_fd_sc_mcu7t5v0__aoi22_1
X_2049_ _2060_/B _2048_/Z _2052_/A3 VDD VDD VSS VSS gf180mcu_fd_sc_mcu7t5v0__nor2_1
XFILLER_81_142 VDD VDD VSS VSS gf180mcu_fd_sc_mcu7t5v0__fillcap_64
XFILLER_14_209 VDD VDD VSS VSS gf180mcu_fd_sc_mcu7t5v0__fillcap_16
XFILLER_35_592 VDD VDD VSS VSS gf180mcu_fd_sc_mcu7t5v0__fill_2
XFILLER_10_437 VDD VDD VSS VSS gf180mcu_fd_sc_mcu7t5v0__fillcap_4
XFILLER_49_128 VDD VDD VSS VSS gf180mcu_fd_sc_mcu7t5v0__fillcap_4
XFILLER_85_492 VDD VDD VSS VSS gf180mcu_fd_sc_mcu7t5v0__fillcap_64
XFILLER_85_481 VDD VDD VSS VSS gf180mcu_fd_sc_mcu7t5v0__fillcap_8
XFILLER_73_632 VDD VDD VSS VSS gf180mcu_fd_sc_mcu7t5v0__fill_2
XFILLER_33_529 VDD VDD VSS VSS gf180mcu_fd_sc_mcu7t5v0__fillcap_8
XFILLER_13_220 VDD VDD VSS VSS gf180mcu_fd_sc_mcu7t5v0__fill_2
XFILLER_41_562 VDD VDD VSS VSS gf180mcu_fd_sc_mcu7t5v0__fillcap_16
XFILLER_9_279 VDD VDD VSS VSS gf180mcu_fd_sc_mcu7t5v0__fill_1
XPHY_EDGE_ROW_10_Left_107 VDD VSS gf180mcu_fd_sc_mcu7t5v0__endcap
XFILLER_95_212 VDD VDD VSS VSS gf180mcu_fd_sc_mcu7t5v0__fillcap_64
XFILLER_83_407 VDD VDD VSS VSS gf180mcu_fd_sc_mcu7t5v0__fillcap_4
XTAP_TAPCELL_ROW_79_955 VDD VSS gf180mcu_fd_sc_mcu7t5v0__filltie
X_3021_ _3021_/I _2523_/B VDD VDD VSS VSS gf180mcu_fd_sc_mcu7t5v0__clkinv_1
XFILLER_48_183 VDD VDD VSS VSS gf180mcu_fd_sc_mcu7t5v0__fill_1
XFILLER_36_378 VDD VDD VSS VSS gf180mcu_fd_sc_mcu7t5v0__fillcap_4
XTAP_TAPCELL_ROW_62_800 VDD VSS gf180mcu_fd_sc_mcu7t5v0__filltie
XFILLER_63_142 VDD VDD VSS VSS gf180mcu_fd_sc_mcu7t5v0__fillcap_8
XTAP_TAPCELL_ROW_34_535 VDD VSS gf180mcu_fd_sc_mcu7t5v0__filltie
X_2805_ _3737_/Q _2831_/B _2805_/B1 _2805_/B2 _2805_/C _2809_/B1 VDD VDD VSS VSS gf180mcu_fd_sc_mcu7t5v0__aoi221_1
X_2736_ input52/Z _2736_/A2 _2738_/B VDD VDD VSS VSS gf180mcu_fd_sc_mcu7t5v0__xor2_1
X_2667_ _2674_/A1 _2674_/A2 _2726_/A1 VDD VDD VSS VSS gf180mcu_fd_sc_mcu7t5v0__nand2_1
X_2598_ _2598_/A1 input71/Z _2603_/C VDD VDD VSS VSS gf180mcu_fd_sc_mcu7t5v0__xor2_1
Xfanout247 _2918_/A1 wire249/I VDD VDD VSS VSS gf180mcu_fd_sc_mcu7t5v0__dlyb_1
Xfanout236 _2937_/A2 _2301_/A3 VDD VDD VSS VSS gf180mcu_fd_sc_mcu7t5v0__dlyb_1
X_3219_ wire476/Z _3219_/A2 _3219_/Z VDD VDD VSS VSS gf180mcu_fd_sc_mcu7t5v0__xor2_1
XFILLER_39_150 VDD VDD VSS VSS gf180mcu_fd_sc_mcu7t5v0__fillcap_4
XFILLER_27_334 VDD VDD VSS VSS gf180mcu_fd_sc_mcu7t5v0__fill_1
XFILLER_55_632 VDD VDD VSS VSS gf180mcu_fd_sc_mcu7t5v0__fill_2
XFILLER_67_492 VDD VDD VSS VSS gf180mcu_fd_sc_mcu7t5v0__fill_1
XFILLER_54_131 VDD VDD VSS VSS gf180mcu_fd_sc_mcu7t5v0__fillcap_4
XFILLER_10_201 VDD VDD VSS VSS gf180mcu_fd_sc_mcu7t5v0__fillcap_4
XFILLER_23_584 VDD VDD VSS VSS gf180mcu_fd_sc_mcu7t5v0__fill_1
Xwire604 wire604/I wire604/Z VDD VDD VSS VSS gf180mcu_fd_sc_mcu7t5v0__buf_1
Xwire626 input6/Z wire626/Z VDD VDD VSS VSS gf180mcu_fd_sc_mcu7t5v0__buf_2
XFILLER_6_227 VDD VDD VSS VSS gf180mcu_fd_sc_mcu7t5v0__fill_1
XFILLER_6_238 VDD VDD VSS VSS gf180mcu_fd_sc_mcu7t5v0__fillcap_4
XFILLER_6_2 VDD VDD VSS VSS gf180mcu_fd_sc_mcu7t5v0__fillcap_32
Xload_slew609 _3673_/RN _3717_/RN VDD VDD VSS VSS gf180mcu_fd_sc_mcu7t5v0__buf_2
XFILLER_77_212 VDD VDD VSS VSS gf180mcu_fd_sc_mcu7t5v0__fillcap_64
XTAP_TAPCELL_ROW_76_925 VDD VSS gf180mcu_fd_sc_mcu7t5v0__filltie
XTAP_TAPCELL_ROW_86_1021 VDD VSS gf180mcu_fd_sc_mcu7t5v0__filltie
XFILLER_45_186 VDD VDD VSS VSS gf180mcu_fd_sc_mcu7t5v0__fillcap_4
XFILLER_60_101 VDD VDD VSS VSS gf180mcu_fd_sc_mcu7t5v0__fillcap_4
XFILLER_81_72 VDD VDD VSS VSS gf180mcu_fd_sc_mcu7t5v0__fillcap_64
XTAP_TAPCELL_ROW_31_505 VDD VSS gf180mcu_fd_sc_mcu7t5v0__filltie
XFILLER_60_189 VDD VDD VSS VSS gf180mcu_fd_sc_mcu7t5v0__fill_2
X_3570_ _3682_/Q _3569_/Z _3590_/A2 VDD VDD VSS VSS gf180mcu_fd_sc_mcu7t5v0__nand2_1
X_2521_ _2521_/A1 _2521_/A2 _2521_/B _2526_/A1 VDD VDD VSS VSS gf180mcu_fd_sc_mcu7t5v0__aoi21_1
X_2452_ wire514/I _2451_/Z _3761_/D VDD VDD VSS VSS gf180mcu_fd_sc_mcu7t5v0__nor2_1
XPHY_EDGE_ROW_18_Right_18 VDD VSS gf180mcu_fd_sc_mcu7t5v0__endcap
XFILLER_39_2 VDD VDD VSS VSS gf180mcu_fd_sc_mcu7t5v0__fillcap_64
X_2383_ _3085_/ZN _2383_/A2 _2383_/B1 _2388_/B1 _3736_/D VDD VDD VSS VSS gf180mcu_fd_sc_mcu7t5v0__aoi22_1
Xinput3 cfg_f_MEMS_fcw[0] input3/Z VDD VDD VSS VSS gf180mcu_fd_sc_mcu7t5v0__buf_2
X_3004_ input7/Z _3004_/ZN VDD VDD VSS VSS gf180mcu_fd_sc_mcu7t5v0__inv_2
XFILLER_37_632 VDD VDD VSS VSS gf180mcu_fd_sc_mcu7t5v0__fill_1
XFILLER_52_613 VDD VDD VSS VSS gf180mcu_fd_sc_mcu7t5v0__fillcap_4
XTAP_TAPCELL_ROW_19_384 VDD VSS gf180mcu_fd_sc_mcu7t5v0__filltie
XPHY_EDGE_ROW_27_Right_27 VDD VSS gf180mcu_fd_sc_mcu7t5v0__endcap
XFILLER_36_197 VDD VDD VSS VSS gf180mcu_fd_sc_mcu7t5v0__fill_2
X_3768_ _3768_/D _3768_/RN clkload1/I _3768_/Q VDD VDD VSS VSS gf180mcu_fd_sc_mcu7t5v0__dffrnq_1
X_2719_ _3526_/A1 _2693_/Z _2719_/B1 _3178_/A1 _2719_/C _2721_/B1 VDD VDD VSS VSS
+ gf180mcu_fd_sc_mcu7t5v0__aoi221_1
X_3699_ _3699_/D wire597/Z _3721_/CLK _3699_/Q VDD VDD VSS VSS gf180mcu_fd_sc_mcu7t5v0__dffrnq_2
XPHY_EDGE_ROW_36_Right_36 VDD VSS gf180mcu_fd_sc_mcu7t5v0__endcap
XFILLER_87_510 VDD VDD VSS VSS gf180mcu_fd_sc_mcu7t5v0__fill_2
XFILLER_59_212 VDD VDD VSS VSS gf180mcu_fd_sc_mcu7t5v0__fill_2
XFILLER_19_66 VDD VDD VSS VSS gf180mcu_fd_sc_mcu7t5v0__fillcap_4
XTAP_TAPCELL_ROW_2_230 VDD VSS gf180mcu_fd_sc_mcu7t5v0__filltie
XFILLER_27_142 VDD VDD VSS VSS gf180mcu_fd_sc_mcu7t5v0__fillcap_32
XFILLER_55_462 VDD VDD VSS VSS gf180mcu_fd_sc_mcu7t5v0__fill_2
XFILLER_42_101 VDD VDD VSS VSS gf180mcu_fd_sc_mcu7t5v0__fillcap_4
XPHY_EDGE_ROW_45_Right_45 VDD VSS gf180mcu_fd_sc_mcu7t5v0__endcap
XFILLER_70_421 VDD VDD VSS VSS gf180mcu_fd_sc_mcu7t5v0__fillcap_16
Xwire478 _3727_/Q _3036_/I VDD VDD VSS VSS gf180mcu_fd_sc_mcu7t5v0__buf_2
XPHY_EDGE_ROW_54_Right_54 VDD VSS gf180mcu_fd_sc_mcu7t5v0__endcap
XTAP_TAPCELL_ROW_92_1080 VDD VSS gf180mcu_fd_sc_mcu7t5v0__filltie
Xload_slew406 _3281_/B _2995_/I VDD VDD VSS VSS gf180mcu_fd_sc_mcu7t5v0__buf_2
Xload_slew417 _3234_/A2 _3245_/A2 VDD VDD VSS VSS gf180mcu_fd_sc_mcu7t5v0__clkbuf_2
XFILLER_19_632 VDD VDD VSS VSS gf180mcu_fd_sc_mcu7t5v0__fill_1
XPHY_EDGE_ROW_63_Right_63 VDD VSS gf180mcu_fd_sc_mcu7t5v0__endcap
XFILLER_33_112 VDD VDD VSS VSS gf180mcu_fd_sc_mcu7t5v0__fill_1
XTAP_TAPCELL_ROW_44_630 VDD VSS gf180mcu_fd_sc_mcu7t5v0__filltie
X_1952_ _2696_/B _1949_/B _1952_/A3 _1952_/Z VDD VDD VSS VSS gf180mcu_fd_sc_mcu7t5v0__xor3_1
X_1883_ _3437_/A1 _1882_/Z _1892_/B VDD VDD VSS VSS gf180mcu_fd_sc_mcu7t5v0__nor2_1
XTAP_TAPCELL_ROW_95_1109 VDD VSS gf180mcu_fd_sc_mcu7t5v0__filltie
X_3622_ _3636_/C _3609_/Z _3622_/B _3623_/A2 VDD VDD VSS VSS gf180mcu_fd_sc_mcu7t5v0__oai21_1
XPHY_EDGE_ROW_72_Right_72 VDD VSS gf180mcu_fd_sc_mcu7t5v0__endcap
X_3553_ _3553_/A1 _3682_/Q _3554_/I VDD VDD VSS VSS gf180mcu_fd_sc_mcu7t5v0__xor2_1
X_2504_ _2504_/A1 _3024_/ZN _2504_/B1 wire305/Z _2504_/C _2512_/A2 VDD VDD VSS VSS
+ gf180mcu_fd_sc_mcu7t5v0__oai221_4
X_3484_ _3450_/Z _3485_/A2 _3518_/A2 VDD VDD VSS VSS gf180mcu_fd_sc_mcu7t5v0__nand2_1
X_2435_ wire366/Z _2436_/B _2435_/A3 wire361/Z _3118_/A2 _3755_/D VDD VDD VSS VSS
+ gf180mcu_fd_sc_mcu7t5v0__oai32_1
XFILLER_69_510 VDD VDD VSS VSS gf180mcu_fd_sc_mcu7t5v0__fill_2
XFILLER_69_543 VDD VDD VSS VSS gf180mcu_fd_sc_mcu7t5v0__fillcap_4
X_2366_ _2388_/B1 _2388_/A1 _2366_/S _2367_/I VDD VDD VSS VSS gf180mcu_fd_sc_mcu7t5v0__mux2_2
XPHY_EDGE_ROW_81_Right_81 VDD VSS gf180mcu_fd_sc_mcu7t5v0__endcap
X_2297_ _2297_/A1 wire536/Z _2943_/A1 VDD VDD VSS VSS gf180mcu_fd_sc_mcu7t5v0__nand2_1
XFILLER_24_101 VDD VDD VSS VSS gf180mcu_fd_sc_mcu7t5v0__fillcap_4
XFILLER_25_668 VDD VDD VSS VSS gf180mcu_fd_sc_mcu7t5v0__fill_1
XFILLER_40_649 VDD VDD VSS VSS gf180mcu_fd_sc_mcu7t5v0__fill_1
XPHY_EDGE_ROW_90_Right_90 VDD VSS gf180mcu_fd_sc_mcu7t5v0__endcap
XFILLER_79_318 VDD VDD VSS VSS gf180mcu_fd_sc_mcu7t5v0__fill_2
Xoutput170 _2143_/A1 raw_edge1[14] VDD VDD VSS VSS gf180mcu_fd_sc_mcu7t5v0__buf_2
Xoutput181 _3673_/Q raw_edge1[5] VDD VDD VSS VSS gf180mcu_fd_sc_mcu7t5v0__buf_2
Xoutput192 _3704_/Q raw_edge2[15] VDD VDD VSS VSS gf180mcu_fd_sc_mcu7t5v0__buf_2
XTAP_TAPCELL_ROW_58_755 VDD VSS gf180mcu_fd_sc_mcu7t5v0__filltie
XFILLER_90_527 VDD VDD VSS VSS gf180mcu_fd_sc_mcu7t5v0__fillcap_16
XFILLER_43_410 VDD VDD VSS VSS gf180mcu_fd_sc_mcu7t5v0__fillcap_8
XTAP_TAPCELL_ROW_41_600 VDD VSS gf180mcu_fd_sc_mcu7t5v0__filltie
XFILLER_30_115 VDD VDD VSS VSS gf180mcu_fd_sc_mcu7t5v0__fill_2
XTAP_TAPCELL_ROW_13_335 VDD VSS gf180mcu_fd_sc_mcu7t5v0__filltie
Xwire231 wire231/I wire231/Z VDD VDD VSS VSS gf180mcu_fd_sc_mcu7t5v0__buf_1
XFILLER_7_366 VDD VDD VSS VSS gf180mcu_fd_sc_mcu7t5v0__fill_2
Xwire275 wire275/I wire275/Z VDD VDD VSS VSS gf180mcu_fd_sc_mcu7t5v0__buf_1
Xwire264 wire264/I wire264/Z VDD VDD VSS VSS gf180mcu_fd_sc_mcu7t5v0__buf_2
Xwire297 wire299/Z wire297/Z VDD VDD VSS VSS gf180mcu_fd_sc_mcu7t5v0__dlyb_1
Xwire286 wire286/I wire286/Z VDD VDD VSS VSS gf180mcu_fd_sc_mcu7t5v0__dlyb_1
X_2220_ _3735_/Q _3663_/Q _2222_/B VDD VDD VSS VSS gf180mcu_fd_sc_mcu7t5v0__xor2_1
XFILLER_66_502 VDD VDD VSS VSS gf180mcu_fd_sc_mcu7t5v0__fillcap_16
X_2151_ _3119_/A2 _2194_/B1 _2201_/A3 VDD VDD VSS VSS gf180mcu_fd_sc_mcu7t5v0__nor2_2
XFILLER_66_524 VDD VDD VSS VSS gf180mcu_fd_sc_mcu7t5v0__fill_1
X_2082_ wire523/Z _2083_/A3 _2082_/Z VDD VDD VSS VSS gf180mcu_fd_sc_mcu7t5v0__and2_1
XFILLER_19_473 VDD VDD VSS VSS gf180mcu_fd_sc_mcu7t5v0__fill_2
XFILLER_34_465 VDD VDD VSS VSS gf180mcu_fd_sc_mcu7t5v0__fillcap_16
X_2984_ _2984_/I _3110_/B2 VDD VDD VSS VSS gf180mcu_fd_sc_mcu7t5v0__clkinv_1
XFILLER_22_627 VDD VDD VSS VSS gf180mcu_fd_sc_mcu7t5v0__fill_2
X_1935_ _1927_/Z _1933_/Z _1935_/Z VDD VDD VSS VSS gf180mcu_fd_sc_mcu7t5v0__xor2_1
X_1866_ _3148_/A2 _3046_/I _1848_/Z _1866_/B _1895_/A1 VDD VDD VSS VSS gf180mcu_fd_sc_mcu7t5v0__oai31_4
Xinput61 cfg_phase90_offset[0] _3026_/I VDD VDD VSS VSS gf180mcu_fd_sc_mcu7t5v0__buf_1
Xinput72 cfg_phase90_offset[1] input72/Z VDD VDD VSS VSS gf180mcu_fd_sc_mcu7t5v0__buf_1
Xinput50 cfg_phase270_offset[19] input50/Z VDD VDD VSS VSS gf180mcu_fd_sc_mcu7t5v0__buf_1
X_1797_ _3350_/A2 _3781_/I _1797_/Z VDD VDD VSS VSS gf180mcu_fd_sc_mcu7t5v0__and2_1
X_3605_ _3606_/A1 _3608_/C _3590_/Z _3608_/A2 VDD VDD VSS VSS gf180mcu_fd_sc_mcu7t5v0__nor3_1
Xinput83 latch_phase270_ack _3081_/I VDD VDD VSS VSS gf180mcu_fd_sc_mcu7t5v0__buf_1
X_3536_ wire517/Z _3532_/Z _3536_/A3 _3536_/Z VDD VDD VSS VSS gf180mcu_fd_sc_mcu7t5v0__xor3_1
X_3467_ _3056_/I _3677_/Q _3485_/A2 VDD VDD VSS VSS gf180mcu_fd_sc_mcu7t5v0__xnor2_2
X_2418_ _2423_/A1 _2418_/A2 _2418_/A3 wire362/Z wire358/I _3749_/D VDD VDD VSS VSS
+ gf180mcu_fd_sc_mcu7t5v0__oai32_1
X_3398_ _3398_/A1 _3397_/B _3398_/A3 _3398_/Z VDD VDD VSS VSS gf180mcu_fd_sc_mcu7t5v0__xor3_1
X_2349_ _2973_/I wire525/I _2349_/Z VDD VDD VSS VSS gf180mcu_fd_sc_mcu7t5v0__xor2_1
XFILLER_57_524 VDD VDD VSS VSS gf180mcu_fd_sc_mcu7t5v0__fillcap_16
XFILLER_29_248 VDD VDD VSS VSS gf180mcu_fd_sc_mcu7t5v0__fill_2
XFILLER_57_557 VDD VDD VSS VSS gf180mcu_fd_sc_mcu7t5v0__fill_2
XFILLER_57_568 VDD VDD VSS VSS gf180mcu_fd_sc_mcu7t5v0__fillcap_16
XFILLER_84_387 VDD VDD VSS VSS gf180mcu_fd_sc_mcu7t5v0__fillcap_4
XFILLER_84_376 VDD VDD VSS VSS gf180mcu_fd_sc_mcu7t5v0__fillcap_8
XFILLER_72_527 VDD VDD VSS VSS gf180mcu_fd_sc_mcu7t5v0__fillcap_32
XFILLER_16_34 VDD VDD VSS VSS gf180mcu_fd_sc_mcu7t5v0__fill_1
XFILLER_37_292 VDD VDD VSS VSS gf180mcu_fd_sc_mcu7t5v0__fill_1
XPHY_EDGE_ROW_0_Right_0 VDD VSS gf180mcu_fd_sc_mcu7t5v0__endcap
XFILLER_25_454 VDD VDD VSS VSS gf180mcu_fd_sc_mcu7t5v0__fillcap_8
XFILLER_13_627 VDD VDD VSS VSS gf180mcu_fd_sc_mcu7t5v0__fill_2
XTAP_TAPCELL_ROW_10_305 VDD VSS gf180mcu_fd_sc_mcu7t5v0__filltie
XFILLER_4_314 VDD VDD VSS VSS gf180mcu_fd_sc_mcu7t5v0__fill_1
XFILLER_94_107 VDD VDD VSS VSS gf180mcu_fd_sc_mcu7t5v0__fillcap_64
XFILLER_75_310 VDD VDD VSS VSS gf180mcu_fd_sc_mcu7t5v0__fill_1
XFILLER_48_524 VDD VDD VSS VSS gf180mcu_fd_sc_mcu7t5v0__fill_1
XFILLER_75_387 VDD VDD VSS VSS gf180mcu_fd_sc_mcu7t5v0__fill_1
XFILLER_75_365 VDD VDD VSS VSS gf180mcu_fd_sc_mcu7t5v0__fillcap_16
XFILLER_35_229 VDD VDD VSS VSS gf180mcu_fd_sc_mcu7t5v0__fillcap_4
XFILLER_63_538 VDD VDD VSS VSS gf180mcu_fd_sc_mcu7t5v0__fillcap_8
XFILLER_63_527 VDD VDD VSS VSS gf180mcu_fd_sc_mcu7t5v0__fill_2
XFILLER_71_593 VDD VDD VSS VSS gf180mcu_fd_sc_mcu7t5v0__fillcap_4
XFILLER_8_675 VDD VDD VSS VSS gf180mcu_fd_sc_mcu7t5v0__fill_2
X_3321_ _3302_/Z _3324_/A1 _3332_/B1 VDD VDD VSS VSS gf180mcu_fd_sc_mcu7t5v0__nor2_1
X_3252_ _3306_/A2 _3251_/C _3254_/B VDD VDD VSS VSS gf180mcu_fd_sc_mcu7t5v0__nand2_1
XFILLER_39_502 VDD VDD VSS VSS gf180mcu_fd_sc_mcu7t5v0__fillcap_4
XFILLER_21_2 VDD VDD VSS VSS gf180mcu_fd_sc_mcu7t5v0__fillcap_64
X_2203_ _2675_/C _2206_/B _2203_/Z VDD VDD VSS VSS gf180mcu_fd_sc_mcu7t5v0__xor2_1
X_3183_ wire640/Z _3187_/A2 _3189_/A1 VDD VDD VSS VSS gf180mcu_fd_sc_mcu7t5v0__nand2_1
XFILLER_39_557 VDD VDD VSS VSS gf180mcu_fd_sc_mcu7t5v0__fill_2
X_2134_ _3707_/Q wire388/I _2134_/B _2202_/A2 VDD VDD VSS VSS gf180mcu_fd_sc_mcu7t5v0__oai21_1
X_2065_ _3581_/A1 _2063_/Z _2065_/Z VDD VDD VSS VSS gf180mcu_fd_sc_mcu7t5v0__xor2_1
XFILLER_81_346 VDD VDD VSS VSS gf180mcu_fd_sc_mcu7t5v0__fillcap_4
XTAP_TAPCELL_ROW_52_706 VDD VSS gf180mcu_fd_sc_mcu7t5v0__filltie
XFILLER_22_468 VDD VDD VSS VSS gf180mcu_fd_sc_mcu7t5v0__fill_1
X_2967_ wire264/Z _2967_/A2 _2967_/B _3721_/D VDD VDD VSS VSS gf180mcu_fd_sc_mcu7t5v0__oai21_1
X_2898_ _3690_/Q _2900_/A1 _2900_/B VDD VDD VSS VSS gf180mcu_fd_sc_mcu7t5v0__nand2_1
X_1918_ _3472_/A1 _1916_/Z _1918_/Z VDD VDD VSS VSS gf180mcu_fd_sc_mcu7t5v0__xor2_1
X_1849_ _1834_/Z _1849_/A2 _1849_/B _1850_/A2 VDD VDD VSS VSS gf180mcu_fd_sc_mcu7t5v0__oai21_1
X_3519_ _2006_/B _3063_/I _3533_/B VDD VDD VSS VSS gf180mcu_fd_sc_mcu7t5v0__nor2_1
XFILLER_76_107 VDD VDD VSS VSS gf180mcu_fd_sc_mcu7t5v0__fillcap_64
XTAP_TAPCELL_ROW_68_850 VDD VSS gf180mcu_fd_sc_mcu7t5v0__filltie
XFILLER_27_66 VDD VDD VSS VSS gf180mcu_fd_sc_mcu7t5v0__fillcap_4
XFILLER_45_549 VDD VDD VSS VSS gf180mcu_fd_sc_mcu7t5v0__fillcap_8
XFILLER_9_417 VDD VDD VSS VSS gf180mcu_fd_sc_mcu7t5v0__fill_2
XTAP_TAPCELL_ROW_23_430 VDD VSS gf180mcu_fd_sc_mcu7t5v0__filltie
XFILLER_40_243 VDD VDD VSS VSS gf180mcu_fd_sc_mcu7t5v0__fill_2
XFILLER_40_298 VDD VDD VSS VSS gf180mcu_fd_sc_mcu7t5v0__fillcap_16
XFILLER_4_37 VDD VDD VSS VSS gf180mcu_fd_sc_mcu7t5v0__fillcap_64
XFILLER_4_177 VDD VDD VSS VSS gf180mcu_fd_sc_mcu7t5v0__fillcap_32
XFILLER_95_416 VDD VDD VSS VSS gf180mcu_fd_sc_mcu7t5v0__fillcap_4
XFILLER_0_372 VDD VDD VSS VSS gf180mcu_fd_sc_mcu7t5v0__fill_2
XTAP_TAPCELL_ROW_89_1052 VDD VSS gf180mcu_fd_sc_mcu7t5v0__filltie
XFILLER_63_302 VDD VDD VSS VSS gf180mcu_fd_sc_mcu7t5v0__fill_1
XFILLER_16_273 VDD VDD VSS VSS gf180mcu_fd_sc_mcu7t5v0__fill_1
X_2821_ _3739_/Q _2822_/A2 _2822_/B VDD VDD VSS VSS gf180mcu_fd_sc_mcu7t5v0__nand2_1
X_2752_ _2773_/A1 _2755_/A2 _2793_/B _2757_/A1 VDD VDD VSS VSS gf180mcu_fd_sc_mcu7t5v0__aoi21_1
X_2683_ _3117_/A2 _2997_/ZN _2683_/A3 _2683_/Z VDD VDD VSS VSS gf180mcu_fd_sc_mcu7t5v0__xor3_1
XFILLER_69_2 VDD VDD VSS VSS gf180mcu_fd_sc_mcu7t5v0__fillcap_64
X_3304_ _3338_/B _3304_/A2 _3304_/A3 _3310_/A1 VDD VDD VSS VSS gf180mcu_fd_sc_mcu7t5v0__nand3_1
Xfanout407 fanout407/I wire408/I VDD VDD VSS VSS gf180mcu_fd_sc_mcu7t5v0__dlyb_1
X_3235_ _3235_/A1 _3245_/A2 _3263_/C VDD VDD VSS VSS gf180mcu_fd_sc_mcu7t5v0__xnor2_2
XFILLER_58_107 VDD VDD VSS VSS gf180mcu_fd_sc_mcu7t5v0__fillcap_32
X_3166_ _3170_/A1 _3170_/A2 _3176_/A1 VDD VDD VSS VSS gf180mcu_fd_sc_mcu7t5v0__nor2_1
XFILLER_66_162 VDD VDD VSS VSS gf180mcu_fd_sc_mcu7t5v0__fillcap_4
XFILLER_66_151 VDD VDD VSS VSS gf180mcu_fd_sc_mcu7t5v0__fill_2
XFILLER_39_398 VDD VDD VSS VSS gf180mcu_fd_sc_mcu7t5v0__fillcap_4
X_3097_ _3097_/I _3097_/ZN VDD VDD VSS VSS gf180mcu_fd_sc_mcu7t5v0__clkinv_1
XFILLER_54_313 VDD VDD VSS VSS gf180mcu_fd_sc_mcu7t5v0__fill_2
XFILLER_54_335 VDD VDD VSS VSS gf180mcu_fd_sc_mcu7t5v0__fillcap_4
X_2117_ _3357_/A1 _1802_/B _2117_/B _2117_/ZN VDD VDD VSS VSS gf180mcu_fd_sc_mcu7t5v0__aoi21_1
X_2048_ _2047_/B _2048_/A2 _2048_/A3 _2048_/Z VDD VDD VSS VSS gf180mcu_fd_sc_mcu7t5v0__and3_1
XTAP_TAPCELL_ROW_37_555 VDD VSS gf180mcu_fd_sc_mcu7t5v0__filltie
XFILLER_50_574 VDD VDD VSS VSS gf180mcu_fd_sc_mcu7t5v0__fill_2
XTAP_TAPCELL_ROW_20_400 VDD VSS gf180mcu_fd_sc_mcu7t5v0__filltie
XFILLER_1_136 VDD VDD VSS VSS gf180mcu_fd_sc_mcu7t5v0__fillcap_4
XFILLER_89_276 VDD VDD VSS VSS gf180mcu_fd_sc_mcu7t5v0__fillcap_4
XFILLER_77_416 VDD VDD VSS VSS gf180mcu_fd_sc_mcu7t5v0__fillcap_4
XFILLER_45_313 VDD VDD VSS VSS gf180mcu_fd_sc_mcu7t5v0__fill_1
XFILLER_45_346 VDD VDD VSS VSS gf180mcu_fd_sc_mcu7t5v0__fillcap_4
XFILLER_41_530 VDD VDD VSS VSS gf180mcu_fd_sc_mcu7t5v0__fill_2
XFILLER_41_552 VDD VDD VSS VSS gf180mcu_fd_sc_mcu7t5v0__fillcap_8
XTAP_TAPCELL_ROW_71_878 VDD VSS gf180mcu_fd_sc_mcu7t5v0__filltie
XFILLER_13_287 VDD VDD VSS VSS gf180mcu_fd_sc_mcu7t5v0__fillcap_8
XFILLER_79_72 VDD VDD VSS VSS gf180mcu_fd_sc_mcu7t5v0__fillcap_64
XTAP_TAPCELL_ROW_8_280 VDD VSS gf180mcu_fd_sc_mcu7t5v0__filltie
XTAP_TAPCELL_ROW_79_956 VDD VSS gf180mcu_fd_sc_mcu7t5v0__filltie
XFILLER_0_180 VDD VDD VSS VSS gf180mcu_fd_sc_mcu7t5v0__fill_2
X_3020_ _3020_/I _3020_/ZN VDD VDD VSS VSS gf180mcu_fd_sc_mcu7t5v0__clkinv_1
XFILLER_36_302 VDD VDD VSS VSS gf180mcu_fd_sc_mcu7t5v0__fill_1
XFILLER_36_313 VDD VDD VSS VSS gf180mcu_fd_sc_mcu7t5v0__fill_2
XFILLER_36_357 VDD VDD VSS VSS gf180mcu_fd_sc_mcu7t5v0__fill_2
XFILLER_63_154 VDD VDD VSS VSS gf180mcu_fd_sc_mcu7t5v0__fill_1
XFILLER_51_327 VDD VDD VSS VSS gf180mcu_fd_sc_mcu7t5v0__fill_1
XTAP_TAPCELL_ROW_62_801 VDD VSS gf180mcu_fd_sc_mcu7t5v0__filltie
X_2804_ _2806_/A1 _2807_/A2 _2805_/B2 VDD VDD VSS VSS gf180mcu_fd_sc_mcu7t5v0__nand2_1
X_2735_ _2735_/A1 _2735_/A2 _2738_/A2 VDD VDD VSS VSS gf180mcu_fd_sc_mcu7t5v0__nand2_1
X_2666_ _2613_/Z _2682_/A2 _2682_/A3 _2666_/B _2674_/A2 VDD VDD VSS VSS gf180mcu_fd_sc_mcu7t5v0__oai31_2
X_2597_ _2211_/C input71/Z _2605_/A1 VDD VDD VSS VSS gf180mcu_fd_sc_mcu7t5v0__nand2_1
Xfanout259 wire264/Z _2965_/A1 VDD VDD VSS VSS gf180mcu_fd_sc_mcu7t5v0__dlyb_1
X_3218_ _3218_/A1 _3218_/A2 _3218_/Z VDD VDD VSS VSS gf180mcu_fd_sc_mcu7t5v0__xor2_1
XFILLER_86_279 VDD VDD VSS VSS gf180mcu_fd_sc_mcu7t5v0__fillcap_8
XFILLER_27_324 VDD VDD VSS VSS gf180mcu_fd_sc_mcu7t5v0__fillcap_8
X_3149_ input11/Z _3714_/Q _3150_/I VDD VDD VSS VSS gf180mcu_fd_sc_mcu7t5v0__xnor2_1
XFILLER_54_165 VDD VDD VSS VSS gf180mcu_fd_sc_mcu7t5v0__fill_2
XFILLER_24_34 VDD VDD VSS VSS gf180mcu_fd_sc_mcu7t5v0__fill_1
Xwire616 wire617/Z wire616/Z VDD VDD VSS VSS gf180mcu_fd_sc_mcu7t5v0__clkbuf_2
Xwire638 wire638/I _3007_/I VDD VDD VSS VSS gf180mcu_fd_sc_mcu7t5v0__buf_1
XFILLER_10_268 VDD VDD VSS VSS gf180mcu_fd_sc_mcu7t5v0__fillcap_4
Xwire649 wire649/I wire649/Z VDD VDD VSS VSS gf180mcu_fd_sc_mcu7t5v0__clkbuf_2
XFILLER_2_489 VDD VDD VSS VSS gf180mcu_fd_sc_mcu7t5v0__fill_2
XTAP_TAPCELL_ROW_76_926 VDD VSS gf180mcu_fd_sc_mcu7t5v0__filltie
XFILLER_65_419 VDD VDD VSS VSS gf180mcu_fd_sc_mcu7t5v0__fill_1
XTAP_TAPCELL_ROW_86_1022 VDD VSS gf180mcu_fd_sc_mcu7t5v0__filltie
XFILLER_73_430 VDD VDD VSS VSS gf180mcu_fd_sc_mcu7t5v0__fill_1
XFILLER_33_327 VDD VDD VSS VSS gf180mcu_fd_sc_mcu7t5v0__fillcap_4
XFILLER_73_485 VDD VDD VSS VSS gf180mcu_fd_sc_mcu7t5v0__fillcap_4
XTAP_TAPCELL_ROW_31_506 VDD VSS gf180mcu_fd_sc_mcu7t5v0__filltie
X_2520_ _2521_/B _2522_/B VDD VDD VSS VSS gf180mcu_fd_sc_mcu7t5v0__clkinv_1
X_2451_ _3318_/B _2451_/A2 _2451_/Z VDD VDD VSS VSS gf180mcu_fd_sc_mcu7t5v0__xor2_1
X_2382_ _2384_/B _2385_/A3 _2383_/B1 VDD VDD VSS VSS gf180mcu_fd_sc_mcu7t5v0__nand2_1
X_3003_ _3003_/I _3598_/A1 VDD VDD VSS VSS gf180mcu_fd_sc_mcu7t5v0__inv_2
Xinput4 cfg_f_MEMS_fcw[10] input4/Z VDD VDD VSS VSS gf180mcu_fd_sc_mcu7t5v0__buf_2
XFILLER_64_452 VDD VDD VSS VSS gf180mcu_fd_sc_mcu7t5v0__fill_2
XTAP_TAPCELL_ROW_47_650 VDD VSS gf180mcu_fd_sc_mcu7t5v0__filltie
XFILLER_91_282 VDD VDD VSS VSS gf180mcu_fd_sc_mcu7t5v0__fillcap_64
XTAP_TAPCELL_ROW_19_385 VDD VSS gf180mcu_fd_sc_mcu7t5v0__filltie
XFILLER_24_349 VDD VDD VSS VSS gf180mcu_fd_sc_mcu7t5v0__fill_1
XFILLER_20_577 VDD VDD VSS VSS gf180mcu_fd_sc_mcu7t5v0__fillcap_16
X_3767_ _3767_/D _3767_/RN clkload1/I _3767_/Q VDD VDD VSS VSS gf180mcu_fd_sc_mcu7t5v0__dffrnq_1
X_2718_ _2718_/A1 _2718_/A2 _2718_/A3 _2719_/C VDD VDD VSS VSS gf180mcu_fd_sc_mcu7t5v0__and3_1
X_3698_ _3698_/D _3719_/RN _3774_/CLK _3698_/Q VDD VDD VSS VSS gf180mcu_fd_sc_mcu7t5v0__dffrnq_2
X_2649_ _2186_/B input60/Z _2649_/B _2649_/C _2650_/A2 VDD VDD VSS VSS gf180mcu_fd_sc_mcu7t5v0__oai211_1
XFILLER_87_544 VDD VDD VSS VSS gf180mcu_fd_sc_mcu7t5v0__fillcap_4
XFILLER_47_419 VDD VDD VSS VSS gf180mcu_fd_sc_mcu7t5v0__fill_1
XFILLER_59_279 VDD VDD VSS VSS gf180mcu_fd_sc_mcu7t5v0__fill_1
XTAP_TAPCELL_ROW_2_231 VDD VSS gf180mcu_fd_sc_mcu7t5v0__filltie
XFILLER_28_633 VDD VDD VSS VSS gf180mcu_fd_sc_mcu7t5v0__fill_1
XFILLER_15_327 VDD VDD VSS VSS gf180mcu_fd_sc_mcu7t5v0__fillcap_16
XFILLER_15_349 VDD VDD VSS VSS gf180mcu_fd_sc_mcu7t5v0__fill_1
XFILLER_35_66 VDD VDD VSS VSS gf180mcu_fd_sc_mcu7t5v0__fillcap_4
XTAP_TAPCELL_ROW_81_973 VDD VSS gf180mcu_fd_sc_mcu7t5v0__filltie
XFILLER_42_168 VDD VDD VSS VSS gf180mcu_fd_sc_mcu7t5v0__fillcap_4
XFILLER_70_477 VDD VDD VSS VSS gf180mcu_fd_sc_mcu7t5v0__fill_2
XFILLER_23_393 VDD VDD VSS VSS gf180mcu_fd_sc_mcu7t5v0__fillcap_8
Xwire424 _3759_/Q wire424/Z VDD VDD VSS VSS gf180mcu_fd_sc_mcu7t5v0__clkbuf_2
Xwire446 _3753_/Q _2977_/I VDD VDD VSS VSS gf180mcu_fd_sc_mcu7t5v0__buf_2
Xwire435 _3756_/Q wire435/Z VDD VDD VSS VSS gf180mcu_fd_sc_mcu7t5v0__clkbuf_2
Xwire468 wire468/I wire468/Z VDD VDD VSS VSS gf180mcu_fd_sc_mcu7t5v0__buf_1
Xload_slew418 _2598_/A1 _3234_/A2 VDD VDD VSS VSS gf180mcu_fd_sc_mcu7t5v0__buf_2
XTAP_TAPCELL_ROW_92_1081 VDD VSS gf180mcu_fd_sc_mcu7t5v0__filltie
XFILLER_19_655 VDD VDD VSS VSS gf180mcu_fd_sc_mcu7t5v0__fill_2
XFILLER_46_441 VDD VDD VSS VSS gf180mcu_fd_sc_mcu7t5v0__fill_2
XFILLER_46_452 VDD VDD VSS VSS gf180mcu_fd_sc_mcu7t5v0__fill_2
XFILLER_73_260 VDD VDD VSS VSS gf180mcu_fd_sc_mcu7t5v0__fillcap_8
XFILLER_61_444 VDD VDD VSS VSS gf180mcu_fd_sc_mcu7t5v0__fillcap_8
XTAP_TAPCELL_ROW_16_355 VDD VSS gf180mcu_fd_sc_mcu7t5v0__filltie
XFILLER_33_146 VDD VDD VSS VSS gf180mcu_fd_sc_mcu7t5v0__fillcap_8
X_1951_ _2696_/B _1951_/A2 _1950_/Z _1964_/B VDD VDD VSS VSS gf180mcu_fd_sc_mcu7t5v0__nor3_1
X_1882_ _1884_/A2 _1884_/A3 _1882_/Z VDD VDD VSS VSS gf180mcu_fd_sc_mcu7t5v0__xor2_1
XFILLER_41_190 VDD VDD VSS VSS gf180mcu_fd_sc_mcu7t5v0__fill_1
X_3621_ _3617_/Z _3621_/A2 _3636_/B VDD VDD VSS VSS gf180mcu_fd_sc_mcu7t5v0__xnor2_1
X_3552_ _3066_/I _3571_/A1 _3582_/B VDD VDD VSS VSS gf180mcu_fd_sc_mcu7t5v0__nand2_1
X_2503_ _2504_/B1 wire305/Z _2504_/C _2562_/A3 VDD VDD VSS VSS gf180mcu_fd_sc_mcu7t5v0__oai21_1
XFILLER_51_2 VDD VDD VSS VSS gf180mcu_fd_sc_mcu7t5v0__fillcap_64
X_3483_ _3483_/A1 _3678_/Q _3483_/Z VDD VDD VSS VSS gf180mcu_fd_sc_mcu7t5v0__xor2_1
X_2434_ _2350_/Z _2434_/A2 _2435_/A3 VDD VDD VSS VSS gf180mcu_fd_sc_mcu7t5v0__nor2_1
X_2365_ wire408/Z wire319/Z _2361_/Z _2388_/A1 VDD VDD VSS VSS gf180mcu_fd_sc_mcu7t5v0__nand3_1
X_2296_ _3730_/Q _2298_/A1 _2298_/B VDD VDD VSS VSS gf180mcu_fd_sc_mcu7t5v0__nand2_1
XFILLER_84_558 VDD VDD VSS VSS gf180mcu_fd_sc_mcu7t5v0__fillcap_32
XFILLER_37_474 VDD VDD VSS VSS gf180mcu_fd_sc_mcu7t5v0__fill_2
XFILLER_52_400 VDD VDD VSS VSS gf180mcu_fd_sc_mcu7t5v0__fill_1
XFILLER_92_591 VDD VDD VSS VSS gf180mcu_fd_sc_mcu7t5v0__fillcap_4
XTAP_TAPCELL_ROW_50_678 VDD VSS gf180mcu_fd_sc_mcu7t5v0__filltie
XFILLER_20_396 VDD VDD VSS VSS gf180mcu_fd_sc_mcu7t5v0__fill_1
Xoutput160 _3667_/Q delay_wave_cycle[7] VDD VDD VSS VSS gf180mcu_fd_sc_mcu7t5v0__buf_2
Xoutput171 _2140_/A1 raw_edge1[15] VDD VDD VSS VSS gf180mcu_fd_sc_mcu7t5v0__buf_2
Xoutput182 _3674_/Q raw_edge1[6] VDD VDD VSS VSS gf180mcu_fd_sc_mcu7t5v0__buf_2
Xoutput193 _3705_/Q raw_edge2[16] VDD VDD VSS VSS gf180mcu_fd_sc_mcu7t5v0__buf_2
XFILLER_87_352 VDD VDD VSS VSS gf180mcu_fd_sc_mcu7t5v0__fillcap_8
XFILLER_75_558 VDD VDD VSS VSS gf180mcu_fd_sc_mcu7t5v0__fill_2
XTAP_TAPCELL_ROW_58_756 VDD VSS gf180mcu_fd_sc_mcu7t5v0__filltie
XFILLER_28_452 VDD VDD VSS VSS gf180mcu_fd_sc_mcu7t5v0__fill_2
XFILLER_70_241 VDD VDD VSS VSS gf180mcu_fd_sc_mcu7t5v0__fillcap_4
XFILLER_70_263 VDD VDD VSS VSS gf180mcu_fd_sc_mcu7t5v0__fillcap_4
XFILLER_31_628 VDD VDD VSS VSS gf180mcu_fd_sc_mcu7t5v0__fill_2
XTAP_TAPCELL_ROW_41_601 VDD VSS gf180mcu_fd_sc_mcu7t5v0__filltie
XFILLER_11_352 VDD VDD VSS VSS gf180mcu_fd_sc_mcu7t5v0__fillcap_4
XFILLER_7_312 VDD VDD VSS VSS gf180mcu_fd_sc_mcu7t5v0__fill_1
Xwire243 wire243/I wire243/Z VDD VDD VSS VSS gf180mcu_fd_sc_mcu7t5v0__clkbuf_2
Xwire287 wire289/Z wire287/Z VDD VDD VSS VSS gf180mcu_fd_sc_mcu7t5v0__dlyb_1
XFILLER_3_562 VDD VDD VSS VSS gf180mcu_fd_sc_mcu7t5v0__fillcap_64
Xload_slew237 _2301_/A3 _2939_/A2 VDD VDD VSS VSS gf180mcu_fd_sc_mcu7t5v0__clkbuf_2
XFILLER_87_72 VDD VDD VSS VSS gf180mcu_fd_sc_mcu7t5v0__fillcap_64
Xload_slew248 wire249/Z _2911_/A2 VDD VDD VSS VSS gf180mcu_fd_sc_mcu7t5v0__buf_2
XFILLER_38_227 VDD VDD VSS VSS gf180mcu_fd_sc_mcu7t5v0__fillcap_16
X_2150_ _3550_/A1 _2196_/A2 _2150_/B _2194_/B1 VDD VDD VSS VSS gf180mcu_fd_sc_mcu7t5v0__oai21_1
X_2081_ wire523/Z _2083_/A3 _2089_/B VDD VDD VSS VSS gf180mcu_fd_sc_mcu7t5v0__or2_1
XFILLER_19_430 VDD VDD VSS VSS gf180mcu_fd_sc_mcu7t5v0__fill_2
XTAP_TAPCELL_ROW_29_480 VDD VSS gf180mcu_fd_sc_mcu7t5v0__filltie
X_2983_ _3749_/Q _3111_/B1 VDD VDD VSS VSS gf180mcu_fd_sc_mcu7t5v0__clkinv_1
X_1934_ _1934_/A1 _1934_/A2 _1934_/B _1950_/A2 VDD VDD VSS VSS gf180mcu_fd_sc_mcu7t5v0__oai21_1
X_1865_ _1865_/A1 _1865_/A2 _1865_/B _1865_/C _1971_/A1 VDD VDD VSS VSS gf180mcu_fd_sc_mcu7t5v0__oai211_2
Xinput40 cfg_phase270_offset[0] input40/Z VDD VDD VSS VSS gf180mcu_fd_sc_mcu7t5v0__buf_1
Xinput73 cfg_phase90_offset[20] input73/Z VDD VDD VSS VSS gf180mcu_fd_sc_mcu7t5v0__buf_1
Xinput62 cfg_phase90_offset[10] _3021_/I VDD VDD VSS VSS gf180mcu_fd_sc_mcu7t5v0__buf_1
Xinput51 cfg_phase270_offset[1] input51/Z VDD VDD VSS VSS gf180mcu_fd_sc_mcu7t5v0__buf_1
X_3604_ _3592_/B _3590_/Z _3608_/B VDD VDD VSS VSS gf180mcu_fd_sc_mcu7t5v0__nor2_1
X_1796_ _3078_/ZN _3643_/Z _1796_/A3 _1796_/Z VDD VDD VSS VSS gf180mcu_fd_sc_mcu7t5v0__xor3_2
Xinput84 latch_phase90_ack _3080_/I VDD VDD VSS VSS gf180mcu_fd_sc_mcu7t5v0__buf_1
X_3535_ _2691_/B _3535_/A2 _3560_/A1 VDD VDD VSS VSS gf180mcu_fd_sc_mcu7t5v0__nor2_1
X_3466_ _3545_/A1 _3545_/A2 _3481_/A1 VDD VDD VSS VSS gf180mcu_fd_sc_mcu7t5v0__nand2_1
X_2417_ _2417_/A1 _2334_/Z _2418_/A3 VDD VDD VSS VSS gf180mcu_fd_sc_mcu7t5v0__nor2_1
X_3397_ _3374_/Z _3397_/A2 _3397_/B _3409_/B1 VDD VDD VSS VSS gf180mcu_fd_sc_mcu7t5v0__aoi21_1
XFILLER_69_341 VDD VDD VSS VSS gf180mcu_fd_sc_mcu7t5v0__fill_1
XFILLER_84_311 VDD VDD VSS VSS gf180mcu_fd_sc_mcu7t5v0__fillcap_4
X_2348_ _2427_/A1 wire282/Z _2427_/B _2432_/A1 VDD VDD VSS VSS gf180mcu_fd_sc_mcu7t5v0__nand3_1
XFILLER_69_374 VDD VDD VSS VSS gf180mcu_fd_sc_mcu7t5v0__fillcap_4
X_2279_ _3724_/Q _2280_/A1 _2280_/B VDD VDD VSS VSS gf180mcu_fd_sc_mcu7t5v0__nand2_1
XTAP_TAPCELL_ROW_55_726 VDD VSS gf180mcu_fd_sc_mcu7t5v0__filltie
XFILLER_25_422 VDD VDD VSS VSS gf180mcu_fd_sc_mcu7t5v0__fillcap_8
XFILLER_80_561 VDD VDD VSS VSS gf180mcu_fd_sc_mcu7t5v0__fillcap_8
XFILLER_52_296 VDD VDD VSS VSS gf180mcu_fd_sc_mcu7t5v0__fillcap_8
XTAP_TAPCELL_ROW_10_306 VDD VSS gf180mcu_fd_sc_mcu7t5v0__filltie
XFILLER_32_34 VDD VDD VSS VSS gf180mcu_fd_sc_mcu7t5v0__fill_1
XFILLER_20_171 VDD VDD VSS VSS gf180mcu_fd_sc_mcu7t5v0__fillcap_4
XFILLER_88_650 VDD VDD VSS VSS gf180mcu_fd_sc_mcu7t5v0__fill_2
XFILLER_48_514 VDD VDD VSS VSS gf180mcu_fd_sc_mcu7t5v0__fill_2
XTAP_TAPCELL_ROW_26_450 VDD VSS gf180mcu_fd_sc_mcu7t5v0__filltie
XFILLER_43_263 VDD VDD VSS VSS gf180mcu_fd_sc_mcu7t5v0__fillcap_4
XFILLER_31_447 VDD VDD VSS VSS gf180mcu_fd_sc_mcu7t5v0__fill_2
XFILLER_31_436 VDD VDD VSS VSS gf180mcu_fd_sc_mcu7t5v0__fill_1
XFILLER_31_458 VDD VDD VSS VSS gf180mcu_fd_sc_mcu7t5v0__fill_2
XFILLER_7_142 VDD VDD VSS VSS gf180mcu_fd_sc_mcu7t5v0__fillcap_64
X_3320_ _3308_/B _3331_/A2 _3324_/A2 VDD VDD VSS VSS gf180mcu_fd_sc_mcu7t5v0__nand2_1
X_3251_ _3306_/A2 _3322_/A2 _3251_/B1 _3284_/A4 _3251_/C _3255_/A2 VDD VDD VSS VSS
+ gf180mcu_fd_sc_mcu7t5v0__aoi221_4
XFILLER_78_171 VDD VDD VSS VSS gf180mcu_fd_sc_mcu7t5v0__fillcap_4
X_2202_ wire421/Z _2202_/A2 _2210_/A1 VDD VDD VSS VSS gf180mcu_fd_sc_mcu7t5v0__nor2_1
X_3182_ _3179_/Z _3187_/B2 _3187_/C _3184_/A3 VDD VDD VSS VSS gf180mcu_fd_sc_mcu7t5v0__oai21_1
XFILLER_14_2 VDD VDD VSS VSS gf180mcu_fd_sc_mcu7t5v0__fillcap_32
X_2133_ _3631_/A1 wire388/I _2134_/B VDD VDD VSS VSS gf180mcu_fd_sc_mcu7t5v0__nand2_1
XFILLER_94_675 VDD VDD VSS VSS gf180mcu_fd_sc_mcu7t5v0__fill_2
XFILLER_81_314 VDD VDD VSS VSS gf180mcu_fd_sc_mcu7t5v0__fillcap_8
X_2064_ _3070_/I _2063_/Z _2064_/Z VDD VDD VSS VSS gf180mcu_fd_sc_mcu7t5v0__and2_1
XFILLER_19_282 VDD VDD VSS VSS gf180mcu_fd_sc_mcu7t5v0__fillcap_4
XFILLER_19_271 VDD VDD VSS VSS gf180mcu_fd_sc_mcu7t5v0__fill_1
XFILLER_81_369 VDD VDD VSS VSS gf180mcu_fd_sc_mcu7t5v0__fillcap_8
XFILLER_34_296 VDD VDD VSS VSS gf180mcu_fd_sc_mcu7t5v0__fillcap_4
X_2966_ _3721_/Q wire264/Z _2967_/B VDD VDD VSS VSS gf180mcu_fd_sc_mcu7t5v0__nand2_1
XTAP_TAPCELL_ROW_60_773 VDD VSS gf180mcu_fd_sc_mcu7t5v0__filltie
X_2897_ _2900_/A1 _2945_/A2 _2897_/B _3689_/D VDD VDD VSS VSS gf180mcu_fd_sc_mcu7t5v0__oai21_1
XFILLER_30_491 VDD VDD VSS VSS gf180mcu_fd_sc_mcu7t5v0__fill_1
X_1917_ _3472_/A1 _1916_/Z _1924_/B VDD VDD VSS VSS gf180mcu_fd_sc_mcu7t5v0__nor2_1
X_1848_ _3715_/Q _3048_/I _1848_/Z VDD VDD VSS VSS gf180mcu_fd_sc_mcu7t5v0__xor2_2
XFILLER_1_329 VDD VDD VSS VSS gf180mcu_fd_sc_mcu7t5v0__fillcap_4
X_3518_ _3518_/A1 _3518_/A2 _3518_/A3 _3518_/B _3523_/A1 VDD VDD VSS VSS gf180mcu_fd_sc_mcu7t5v0__oai31_4
X_3449_ _3450_/A1 _3055_/I _3468_/B VDD VDD VSS VSS gf180mcu_fd_sc_mcu7t5v0__nor2_1
XFILLER_57_300 VDD VDD VSS VSS gf180mcu_fd_sc_mcu7t5v0__fillcap_8
Xload_slew590 _3764_/RN wire589/I VDD VDD VSS VSS gf180mcu_fd_sc_mcu7t5v0__buf_1
XTAP_TAPCELL_ROW_68_851 VDD VSS gf180mcu_fd_sc_mcu7t5v0__filltie
XFILLER_72_347 VDD VDD VSS VSS gf180mcu_fd_sc_mcu7t5v0__fillcap_4
XFILLER_72_336 VDD VDD VSS VSS gf180mcu_fd_sc_mcu7t5v0__fill_1
XFILLER_40_222 VDD VDD VSS VSS gf180mcu_fd_sc_mcu7t5v0__fillcap_16
XFILLER_43_66 VDD VDD VSS VSS gf180mcu_fd_sc_mcu7t5v0__fillcap_4
XFILLER_4_101 VDD VDD VSS VSS gf180mcu_fd_sc_mcu7t5v0__fillcap_4
XFILLER_5_668 VDD VDD VSS VSS gf180mcu_fd_sc_mcu7t5v0__fillcap_8
XFILLER_48_311 VDD VDD VSS VSS gf180mcu_fd_sc_mcu7t5v0__fillcap_4
XTAP_TAPCELL_ROW_89_1053 VDD VSS gf180mcu_fd_sc_mcu7t5v0__filltie
XFILLER_16_241 VDD VDD VSS VSS gf180mcu_fd_sc_mcu7t5v0__fillcap_4
XFILLER_90_177 VDD VDD VSS VSS gf180mcu_fd_sc_mcu7t5v0__fillcap_64
XFILLER_16_263 VDD VDD VSS VSS gf180mcu_fd_sc_mcu7t5v0__fillcap_8
XFILLER_44_594 VDD VDD VSS VSS gf180mcu_fd_sc_mcu7t5v0__fill_1
X_2820_ _3096_/ZN wire312/Z _2825_/C VDD VDD VSS VSS gf180mcu_fd_sc_mcu7t5v0__nor2_1
X_2751_ _3089_/ZN _2772_/A2 _2751_/B _2755_/A2 VDD VDD VSS VSS gf180mcu_fd_sc_mcu7t5v0__oai21_1
XFILLER_31_288 VDD VDD VSS VSS gf180mcu_fd_sc_mcu7t5v0__fill_1
XFILLER_8_451 VDD VDD VSS VSS gf180mcu_fd_sc_mcu7t5v0__fillcap_4
X_2682_ _2613_/Z _2682_/A2 _2682_/A3 _2998_/ZN _2974_/I _2683_/A3 VDD VDD VSS VSS
+ gf180mcu_fd_sc_mcu7t5v0__oai32_4
X_3303_ _3303_/A1 _3302_/Z _3304_/A3 VDD VDD VSS VSS gf180mcu_fd_sc_mcu7t5v0__nand2_1
X_3234_ _3235_/A1 _3234_/A2 _3265_/C VDD VDD VSS VSS gf180mcu_fd_sc_mcu7t5v0__xor2_2
X_3165_ _3170_/B _3170_/C _3167_/A3 VDD VDD VSS VSS gf180mcu_fd_sc_mcu7t5v0__nor2_1
XFILLER_27_528 VDD VDD VSS VSS gf180mcu_fd_sc_mcu7t5v0__fill_1
X_2116_ _3355_/A1 _3355_/B _2116_/B _2116_/ZN VDD VDD VSS VSS gf180mcu_fd_sc_mcu7t5v0__aoi21_2
X_3096_ _3667_/Q _3096_/ZN VDD VDD VSS VSS gf180mcu_fd_sc_mcu7t5v0__clkinv_1
XTAP_TAPCELL_ROW_65_821 VDD VSS gf180mcu_fd_sc_mcu7t5v0__filltie
X_2047_ _2048_/A2 _2048_/A3 _2047_/B _2051_/A1 VDD VDD VSS VSS gf180mcu_fd_sc_mcu7t5v0__aoi21_2
XFILLER_82_667 VDD VDD VSS VSS gf180mcu_fd_sc_mcu7t5v0__fill_2
XTAP_TAPCELL_ROW_37_556 VDD VSS gf180mcu_fd_sc_mcu7t5v0__filltie
XTAP_TAPCELL_ROW_20_401 VDD VSS gf180mcu_fd_sc_mcu7t5v0__filltie
X_2949_ wire258/Z _2949_/A2 _2949_/B _3712_/D VDD VDD VSS VSS gf180mcu_fd_sc_mcu7t5v0__oai21_1
XFILLER_77_439 VDD VDD VSS VSS gf180mcu_fd_sc_mcu7t5v0__fillcap_16
XFILLER_73_634 VDD VDD VSS VSS gf180mcu_fd_sc_mcu7t5v0__fill_1
XFILLER_60_317 VDD VDD VSS VSS gf180mcu_fd_sc_mcu7t5v0__fill_1
XFILLER_72_177 VDD VDD VSS VSS gf180mcu_fd_sc_mcu7t5v0__fillcap_64
XFILLER_26_594 VDD VDD VSS VSS gf180mcu_fd_sc_mcu7t5v0__fill_1
XTAP_TAPCELL_ROW_71_879 VDD VSS gf180mcu_fd_sc_mcu7t5v0__filltie
XFILLER_13_299 VDD VDD VSS VSS gf180mcu_fd_sc_mcu7t5v0__fill_2
XFILLER_9_248 VDD VDD VSS VSS gf180mcu_fd_sc_mcu7t5v0__fill_1
XFILLER_5_454 VDD VDD VSS VSS gf180mcu_fd_sc_mcu7t5v0__fillcap_16
XFILLER_5_487 VDD VDD VSS VSS gf180mcu_fd_sc_mcu7t5v0__fill_2
XTAP_TAPCELL_ROW_8_281 VDD VSS gf180mcu_fd_sc_mcu7t5v0__filltie
XTAP_TAPCELL_ROW_79_957 VDD VSS gf180mcu_fd_sc_mcu7t5v0__filltie
XFILLER_95_72 VDD VDD VSS VSS gf180mcu_fd_sc_mcu7t5v0__fillcap_64
XFILLER_76_461 VDD VDD VSS VSS gf180mcu_fd_sc_mcu7t5v0__fill_2
XFILLER_64_667 VDD VDD VSS VSS gf180mcu_fd_sc_mcu7t5v0__fill_2
XFILLER_91_486 VDD VDD VSS VSS gf180mcu_fd_sc_mcu7t5v0__fillcap_4
XTAP_TAPCELL_ROW_34_526 VDD VSS gf180mcu_fd_sc_mcu7t5v0__filltie
XFILLER_81_2 VDD VDD VSS VSS gf180mcu_fd_sc_mcu7t5v0__fillcap_64
X_2803_ _2803_/A1 _2806_/A2 _3097_/I _2807_/A2 VDD VDD VSS VSS gf180mcu_fd_sc_mcu7t5v0__aoi21_1
X_2734_ _2211_/C input50/Z _2734_/B _2734_/C _2735_/A2 VDD VDD VSS VSS gf180mcu_fd_sc_mcu7t5v0__oai211_1
X_2665_ _3117_/A2 _2997_/I _2998_/I _3118_/A2 _2666_/B VDD VDD VSS VSS gf180mcu_fd_sc_mcu7t5v0__aoi22_1
X_2596_ wire525/Z _2548_/Z _2602_/B VDD VDD VSS VSS gf180mcu_fd_sc_mcu7t5v0__nor2_1
XFILLER_86_247 VDD VDD VSS VSS gf180mcu_fd_sc_mcu7t5v0__fillcap_32
X_3217_ _3728_/Q _3218_/A1 _3217_/A3 _3219_/A2 VDD VDD VSS VSS gf180mcu_fd_sc_mcu7t5v0__nor3_1
XFILLER_55_634 VDD VDD VSS VSS gf180mcu_fd_sc_mcu7t5v0__fill_1
X_3148_ wire655/Z _3148_/A2 _3157_/A1 VDD VDD VSS VSS gf180mcu_fd_sc_mcu7t5v0__nor2_1
XFILLER_82_453 VDD VDD VSS VSS gf180mcu_fd_sc_mcu7t5v0__fill_2
X_3079_ _3780_/I _3079_/ZN VDD VDD VSS VSS gf180mcu_fd_sc_mcu7t5v0__clkinv_1
XFILLER_70_615 VDD VDD VSS VSS gf180mcu_fd_sc_mcu7t5v0__fill_1
XFILLER_54_199 VDD VDD VSS VSS gf180mcu_fd_sc_mcu7t5v0__fill_2
Xwire617 wire617/I wire617/Z VDD VDD VSS VSS gf180mcu_fd_sc_mcu7t5v0__clkbuf_2
XFILLER_10_247 VDD VDD VSS VSS gf180mcu_fd_sc_mcu7t5v0__fillcap_4
XFILLER_40_34 VDD VDD VSS VSS gf180mcu_fd_sc_mcu7t5v0__fill_1
XFILLER_2_457 VDD VDD VSS VSS gf180mcu_fd_sc_mcu7t5v0__fillcap_32
XTAP_TAPCELL_ROW_5_251 VDD VSS gf180mcu_fd_sc_mcu7t5v0__filltie
XTAP_TAPCELL_ROW_76_927 VDD VSS gf180mcu_fd_sc_mcu7t5v0__filltie
XTAP_TAPCELL_ROW_86_1023 VDD VSS gf180mcu_fd_sc_mcu7t5v0__filltie
XFILLER_46_667 VDD VDD VSS VSS gf180mcu_fd_sc_mcu7t5v0__fill_2
XFILLER_45_199 VDD VDD VSS VSS gf180mcu_fd_sc_mcu7t5v0__fillcap_8
XFILLER_60_169 VDD VDD VSS VSS gf180mcu_fd_sc_mcu7t5v0__fillcap_4
XFILLER_14_597 VDD VDD VSS VSS gf180mcu_fd_sc_mcu7t5v0__fill_2
XFILLER_41_383 VDD VDD VSS VSS gf180mcu_fd_sc_mcu7t5v0__fillcap_4
X_2450_ wire514/I _2450_/A2 _2451_/A2 _3760_/D VDD VDD VSS VSS gf180mcu_fd_sc_mcu7t5v0__nor3_1
XFILLER_96_512 VDD VDD VSS VSS gf180mcu_fd_sc_mcu7t5v0__fillcap_32
X_2381_ _3735_/Q _3736_/Q _2381_/A3 _2385_/A3 VDD VDD VSS VSS gf180mcu_fd_sc_mcu7t5v0__nand3_1
XFILLER_68_247 VDD VDD VSS VSS gf180mcu_fd_sc_mcu7t5v0__fillcap_16
XFILLER_83_206 VDD VDD VSS VSS gf180mcu_fd_sc_mcu7t5v0__fillcap_4
Xinput5 cfg_f_MEMS_fcw[11] input5/Z VDD VDD VSS VSS gf180mcu_fd_sc_mcu7t5v0__buf_2
X_3002_ _3002_/I _3002_/ZN VDD VDD VSS VSS gf180mcu_fd_sc_mcu7t5v0__clkinv_1
XFILLER_24_317 VDD VDD VSS VSS gf180mcu_fd_sc_mcu7t5v0__fillcap_16
XFILLER_36_177 VDD VDD VSS VSS gf180mcu_fd_sc_mcu7t5v0__fillcap_16
XTAP_TAPCELL_ROW_47_651 VDD VSS gf180mcu_fd_sc_mcu7t5v0__filltie
XTAP_TAPCELL_ROW_19_386 VDD VSS gf180mcu_fd_sc_mcu7t5v0__filltie
XFILLER_36_199 VDD VDD VSS VSS gf180mcu_fd_sc_mcu7t5v0__fill_1
XFILLER_51_136 VDD VDD VSS VSS gf180mcu_fd_sc_mcu7t5v0__fillcap_4
XFILLER_20_545 VDD VDD VSS VSS gf180mcu_fd_sc_mcu7t5v0__fillcap_4
X_3766_ _3766_/D _3767_/RN clkload1/I _3766_/Q VDD VDD VSS VSS gf180mcu_fd_sc_mcu7t5v0__dffrnq_1
XFILLER_9_590 VDD VDD VSS VSS gf180mcu_fd_sc_mcu7t5v0__fillcap_32
X_2717_ wire647/I _2697_/Z _2718_/A3 VDD VDD VSS VSS gf180mcu_fd_sc_mcu7t5v0__nand2_1
XFILLER_10_37 VDD VDD VSS VSS gf180mcu_fd_sc_mcu7t5v0__fillcap_64
X_3697_ _3697_/D wire604/Z _3721_/CLK _3697_/Q VDD VDD VSS VSS gf180mcu_fd_sc_mcu7t5v0__dffrnq_2
X_2648_ _2694_/A1 _2694_/A2 _2648_/A3 _2654_/A1 VDD VDD VSS VSS gf180mcu_fd_sc_mcu7t5v0__nand3_1
XFILLER_87_512 VDD VDD VSS VSS gf180mcu_fd_sc_mcu7t5v0__fill_1
X_2579_ _2579_/A1 _2570_/Z _2579_/A3 _2579_/B _2580_/B VDD VDD VSS VSS gf180mcu_fd_sc_mcu7t5v0__oai31_1
XFILLER_47_409 VDD VDD VSS VSS gf180mcu_fd_sc_mcu7t5v0__fillcap_8
XFILLER_55_475 VDD VDD VSS VSS gf180mcu_fd_sc_mcu7t5v0__fillcap_8
XFILLER_55_464 VDD VDD VSS VSS gf180mcu_fd_sc_mcu7t5v0__fill_1
XTAP_TAPCELL_ROW_81_974 VDD VSS gf180mcu_fd_sc_mcu7t5v0__filltie
XFILLER_51_66 VDD VDD VSS VSS gf180mcu_fd_sc_mcu7t5v0__fillcap_4
XPHY_EDGE_ROW_2_Left_99 VDD VSS gf180mcu_fd_sc_mcu7t5v0__endcap
XFILLER_78_501 VDD VDD VSS VSS gf180mcu_fd_sc_mcu7t5v0__fill_2
XTAP_TAPCELL_ROW_92_1082 VDD VSS gf180mcu_fd_sc_mcu7t5v0__filltie
XFILLER_78_523 VDD VDD VSS VSS gf180mcu_fd_sc_mcu7t5v0__fill_2
XFILLER_18_177 VDD VDD VSS VSS gf180mcu_fd_sc_mcu7t5v0__fillcap_32
XFILLER_46_464 VDD VDD VSS VSS gf180mcu_fd_sc_mcu7t5v0__fill_1
XTAP_TAPCELL_ROW_44_621 VDD VSS gf180mcu_fd_sc_mcu7t5v0__filltie
XFILLER_73_272 VDD VDD VSS VSS gf180mcu_fd_sc_mcu7t5v0__fill_2
XTAP_TAPCELL_ROW_16_356 VDD VSS gf180mcu_fd_sc_mcu7t5v0__filltie
XFILLER_14_350 VDD VDD VSS VSS gf180mcu_fd_sc_mcu7t5v0__fill_1
XFILLER_33_158 VDD VDD VSS VSS gf180mcu_fd_sc_mcu7t5v0__fill_2
X_1950_ _1967_/A1 _1950_/A2 _1949_/B _1950_/Z VDD VDD VSS VSS gf180mcu_fd_sc_mcu7t5v0__and3_1
XFILLER_61_489 VDD VDD VSS VSS gf180mcu_fd_sc_mcu7t5v0__fill_1
X_1881_ _1879_/Z _1893_/B _1884_/A3 VDD VDD VSS VSS gf180mcu_fd_sc_mcu7t5v0__nand2_1
XFILLER_41_180 VDD VDD VSS VSS gf180mcu_fd_sc_mcu7t5v0__fillcap_8
X_3620_ _3617_/Z _3621_/A2 _3637_/A2 VDD VDD VSS VSS gf180mcu_fd_sc_mcu7t5v0__nor2_1
X_3551_ _3064_/I _3558_/A2 _3551_/B1 _3551_/B2 _3551_/C _3555_/A1 VDD VDD VSS VSS
+ gf180mcu_fd_sc_mcu7t5v0__aoi221_4
X_2502_ _2502_/A1 _2482_/Z _2568_/A2 _2502_/B wire305/I VDD VDD VSS VSS gf180mcu_fd_sc_mcu7t5v0__oai31_4
XFILLER_6_593 VDD VDD VSS VSS gf180mcu_fd_sc_mcu7t5v0__fill_2
X_3482_ _3483_/A1 _3678_/Q _3501_/B VDD VDD VSS VSS gf180mcu_fd_sc_mcu7t5v0__nor2_1
X_2433_ _2350_/Z _2434_/A2 _2436_/B VDD VDD VSS VSS gf180mcu_fd_sc_mcu7t5v0__and2_1
XFILLER_44_2 VDD VDD VSS VSS gf180mcu_fd_sc_mcu7t5v0__fillcap_32
X_2364_ _2384_/B _2384_/A1 _2388_/B1 VDD VDD VSS VSS gf180mcu_fd_sc_mcu7t5v0__nand2_2
XFILLER_96_342 VDD VDD VSS VSS gf180mcu_fd_sc_mcu7t5v0__fillcap_32
XPHY_EDGE_ROW_16_Left_113 VDD VSS gf180mcu_fd_sc_mcu7t5v0__endcap
X_2295_ _2298_/A1 _2941_/A1 _2295_/B _3729_/D VDD VDD VSS VSS gf180mcu_fd_sc_mcu7t5v0__oai21_1
XFILLER_52_423 VDD VDD VSS VSS gf180mcu_fd_sc_mcu7t5v0__fill_1
XPHY_EDGE_ROW_25_Left_122 VDD VSS gf180mcu_fd_sc_mcu7t5v0__endcap
XTAP_TAPCELL_ROW_50_679 VDD VSS gf180mcu_fd_sc_mcu7t5v0__filltie
X_3749_ _3749_/D _3774_/RN _3774_/CLK _3749_/Q VDD VDD VSS VSS gf180mcu_fd_sc_mcu7t5v0__dffrnq_1
Xoutput161 wire513/Z latch_error VDD VDD VSS VSS gf180mcu_fd_sc_mcu7t5v0__buf_2
Xoutput150 _3481_/Z cal_phase90_offset[8] VDD VDD VSS VSS gf180mcu_fd_sc_mcu7t5v0__buf_2
XFILLER_87_320 VDD VDD VSS VSS gf180mcu_fd_sc_mcu7t5v0__fillcap_8
XPHY_EDGE_ROW_34_Left_131 VDD VSS gf180mcu_fd_sc_mcu7t5v0__endcap
Xoutput183 _3675_/Q raw_edge1[7] VDD VDD VSS VSS gf180mcu_fd_sc_mcu7t5v0__buf_2
Xoutput172 _3684_/Q raw_edge1[16] VDD VDD VSS VSS gf180mcu_fd_sc_mcu7t5v0__buf_2
Xoutput194 _3706_/Q raw_edge2[17] VDD VDD VSS VSS gf180mcu_fd_sc_mcu7t5v0__buf_2
XFILLER_87_364 VDD VDD VSS VSS gf180mcu_fd_sc_mcu7t5v0__fill_1
XFILLER_75_504 VDD VDD VSS VSS gf180mcu_fd_sc_mcu7t5v0__fill_2
XTAP_TAPCELL_ROW_58_757 VDD VSS gf180mcu_fd_sc_mcu7t5v0__filltie
XFILLER_83_570 VDD VDD VSS VSS gf180mcu_fd_sc_mcu7t5v0__fillcap_4
XFILLER_28_475 VDD VDD VSS VSS gf180mcu_fd_sc_mcu7t5v0__fillcap_16
XFILLER_15_136 VDD VDD VSS VSS gf180mcu_fd_sc_mcu7t5v0__fillcap_4
XPHY_EDGE_ROW_43_Left_140 VDD VSS gf180mcu_fd_sc_mcu7t5v0__endcap
XFILLER_30_117 VDD VDD VSS VSS gf180mcu_fd_sc_mcu7t5v0__fill_1
XFILLER_7_335 VDD VDD VSS VSS gf180mcu_fd_sc_mcu7t5v0__fillcap_8
Xwire233 wire233/I wire233/Z VDD VDD VSS VSS gf180mcu_fd_sc_mcu7t5v0__buf_1
Xwire255 wire255/I wire255/Z VDD VDD VSS VSS gf180mcu_fd_sc_mcu7t5v0__buf_1
XTAP_TAPCELL_ROW_94_1100 VDD VSS gf180mcu_fd_sc_mcu7t5v0__filltie
Xwire299 wire300/Z wire299/Z VDD VDD VSS VSS gf180mcu_fd_sc_mcu7t5v0__dlyb_1
Xclkbuf_4_9_0_clk clkbuf_0_clk/Z clkload8/I VDD VDD VSS VSS gf180mcu_fd_sc_mcu7t5v0__clkbuf_8
Xload_slew238 _2301_/A3 _2943_/A2 VDD VDD VSS VSS gf180mcu_fd_sc_mcu7t5v0__buf_2
X_2080_ _2077_/Z _2101_/A2 _2083_/A3 VDD VDD VSS VSS gf180mcu_fd_sc_mcu7t5v0__xnor2_1
XFILLER_34_401 VDD VDD VSS VSS gf180mcu_fd_sc_mcu7t5v0__fill_1
XFILLER_74_581 VDD VDD VSS VSS gf180mcu_fd_sc_mcu7t5v0__fill_1
XTAP_TAPCELL_ROW_29_481 VDD VSS gf180mcu_fd_sc_mcu7t5v0__filltie
X_2982_ _2982_/I _2186_/B VDD VDD VSS VSS gf180mcu_fd_sc_mcu7t5v0__inv_2
XFILLER_22_629 VDD VDD VSS VSS gf180mcu_fd_sc_mcu7t5v0__fill_1
X_1933_ _1934_/A1 _1934_/A2 _1933_/Z VDD VDD VSS VSS gf180mcu_fd_sc_mcu7t5v0__or2_1
X_1864_ _3028_/ZN _3692_/Q _1864_/B1 _1835_/Z _1864_/C _1972_/A1 VDD VDD VSS VSS gf180mcu_fd_sc_mcu7t5v0__aoi221_4
Xinput30 cfg_phase0_offset[1] input30/Z VDD VDD VSS VSS gf180mcu_fd_sc_mcu7t5v0__buf_1
X_3603_ _3600_/Z _3603_/A2 _3636_/C VDD VDD VSS VSS gf180mcu_fd_sc_mcu7t5v0__xnor2_1
Xinput63 cfg_phase90_offset[11] _3020_/I VDD VDD VSS VSS gf180mcu_fd_sc_mcu7t5v0__buf_1
Xinput41 cfg_phase270_offset[10] _3000_/I VDD VDD VSS VSS gf180mcu_fd_sc_mcu7t5v0__buf_1
Xinput52 cfg_phase270_offset[20] input52/Z VDD VDD VSS VSS gf180mcu_fd_sc_mcu7t5v0__buf_1
X_1795_ _3648_/B _3650_/ZN _3645_/Z _1796_/A3 VDD VDD VSS VSS gf180mcu_fd_sc_mcu7t5v0__aoi21_1
Xinput85 rst_n input85/Z VDD VDD VSS VSS gf180mcu_fd_sc_mcu7t5v0__buf_2
Xinput74 cfg_phase90_offset[2] input74/Z VDD VDD VSS VSS gf180mcu_fd_sc_mcu7t5v0__buf_1
X_3534_ _3532_/Z _3536_/A3 _3535_/A2 VDD VDD VSS VSS gf180mcu_fd_sc_mcu7t5v0__xnor2_1
XFILLER_89_629 VDD VDD VSS VSS gf180mcu_fd_sc_mcu7t5v0__fill_1
X_3465_ _3545_/A2 _3464_/Z _3465_/Z VDD VDD VSS VSS gf180mcu_fd_sc_mcu7t5v0__and2_1
X_2416_ _3749_/Q wire544/I _2961_/A2 VDD VDD VSS VSS gf180mcu_fd_sc_mcu7t5v0__nand2_1
X_3396_ _3374_/Z _3397_/A2 _3398_/A3 VDD VDD VSS VSS gf180mcu_fd_sc_mcu7t5v0__nand2_1
XFILLER_69_331 VDD VDD VSS VSS gf180mcu_fd_sc_mcu7t5v0__fill_2
XFILLER_96_172 VDD VDD VSS VSS gf180mcu_fd_sc_mcu7t5v0__fillcap_32
X_2347_ _2427_/A1 wire282/Z _2427_/B _2347_/Z VDD VDD VSS VSS gf180mcu_fd_sc_mcu7t5v0__and3_1
X_2278_ _2613_/A1 _2288_/A2 _2931_/A1 VDD VDD VSS VSS gf180mcu_fd_sc_mcu7t5v0__nand2_1
XFILLER_57_548 VDD VDD VSS VSS gf180mcu_fd_sc_mcu7t5v0__fill_1
XFILLER_57_559 VDD VDD VSS VSS gf180mcu_fd_sc_mcu7t5v0__fill_1
XTAP_TAPCELL_ROW_55_727 VDD VSS gf180mcu_fd_sc_mcu7t5v0__filltie
XFILLER_80_551 VDD VDD VSS VSS gf180mcu_fd_sc_mcu7t5v0__fillcap_4
XFILLER_13_629 VDD VDD VSS VSS gf180mcu_fd_sc_mcu7t5v0__fill_1
XTAP_TAPCELL_ROW_10_307 VDD VSS gf180mcu_fd_sc_mcu7t5v0__filltie
XFILLER_48_537 VDD VDD VSS VSS gf180mcu_fd_sc_mcu7t5v0__fill_1
XFILLER_16_423 VDD VDD VSS VSS gf180mcu_fd_sc_mcu7t5v0__fillcap_16
XFILLER_28_272 VDD VDD VSS VSS gf180mcu_fd_sc_mcu7t5v0__fillcap_4
XFILLER_43_220 VDD VDD VSS VSS gf180mcu_fd_sc_mcu7t5v0__fill_2
XTAP_TAPCELL_ROW_26_451 VDD VSS gf180mcu_fd_sc_mcu7t5v0__filltie
XFILLER_71_562 VDD VDD VSS VSS gf180mcu_fd_sc_mcu7t5v0__fillcap_8
X_3250_ _3299_/B _3225_/Z _3284_/A4 VDD VDD VSS VSS gf180mcu_fd_sc_mcu7t5v0__nand2_1
X_2201_ _2201_/A1 _2201_/A2 _2201_/A3 _2201_/B1 _2201_/B2 _2205_/A1 VDD VDD VSS VSS
+ gf180mcu_fd_sc_mcu7t5v0__oai32_4
X_3181_ _3179_/Z _3187_/B2 _3181_/Z VDD VDD VSS VSS gf180mcu_fd_sc_mcu7t5v0__xor2_1
XFILLER_39_559 VDD VDD VSS VSS gf180mcu_fd_sc_mcu7t5v0__fill_1
X_2132_ wire419/Z _2132_/A2 _2210_/B VDD VDD VSS VSS gf180mcu_fd_sc_mcu7t5v0__nand2_1
XFILLER_93_142 VDD VDD VSS VSS gf180mcu_fd_sc_mcu7t5v0__fillcap_64
XFILLER_26_209 VDD VDD VSS VSS gf180mcu_fd_sc_mcu7t5v0__fillcap_4
X_2063_ _3598_/A1 _2059_/Z _2063_/A3 _2063_/Z VDD VDD VSS VSS gf180mcu_fd_sc_mcu7t5v0__xor3_1
XFILLER_47_592 VDD VDD VSS VSS gf180mcu_fd_sc_mcu7t5v0__fill_1
XFILLER_34_242 VDD VDD VSS VSS gf180mcu_fd_sc_mcu7t5v0__fill_2
XFILLER_34_264 VDD VDD VSS VSS gf180mcu_fd_sc_mcu7t5v0__fillcap_32
X_2965_ _2965_/A1 _2965_/A2 _2965_/B _3720_/D VDD VDD VSS VSS gf180mcu_fd_sc_mcu7t5v0__oai21_1
XTAP_TAPCELL_ROW_60_774 VDD VSS gf180mcu_fd_sc_mcu7t5v0__filltie
X_2896_ _3689_/Q _2900_/A1 _2897_/B VDD VDD VSS VSS gf180mcu_fd_sc_mcu7t5v0__nand2_1
X_1916_ _1914_/Z _1916_/A2 _1916_/Z VDD VDD VSS VSS gf180mcu_fd_sc_mcu7t5v0__xor2_1
X_1847_ _3715_/Q _3399_/A1 _1866_/B VDD VDD VSS VSS gf180mcu_fd_sc_mcu7t5v0__nand2_1
X_3517_ _3501_/B _3517_/A2 _3517_/B _3518_/B VDD VDD VSS VSS gf180mcu_fd_sc_mcu7t5v0__aoi21_1
X_3448_ _3448_/I _3461_/A1 VDD VDD VSS VSS gf180mcu_fd_sc_mcu7t5v0__clkinv_1
X_3379_ _3379_/I _3383_/A2 VDD VDD VSS VSS gf180mcu_fd_sc_mcu7t5v0__clkinv_1
Xload_slew591 _3764_/RN _3748_/RN VDD VDD VSS VSS gf180mcu_fd_sc_mcu7t5v0__clkbuf_1
XFILLER_57_312 VDD VDD VSS VSS gf180mcu_fd_sc_mcu7t5v0__fill_2
Xload_slew580 _3725_/RN _3727_/RN VDD VDD VSS VSS gf180mcu_fd_sc_mcu7t5v0__clkbuf_2
XFILLER_85_676 VDD VDD VSS VSS gf180mcu_fd_sc_mcu7t5v0__fill_1
XTAP_TAPCELL_ROW_68_852 VDD VSS gf180mcu_fd_sc_mcu7t5v0__filltie
XFILLER_25_220 VDD VDD VSS VSS gf180mcu_fd_sc_mcu7t5v0__fill_2
XFILLER_13_415 VDD VDD VSS VSS gf180mcu_fd_sc_mcu7t5v0__fillcap_4
XFILLER_53_562 VDD VDD VSS VSS gf180mcu_fd_sc_mcu7t5v0__fillcap_16
XFILLER_13_426 VDD VDD VSS VSS gf180mcu_fd_sc_mcu7t5v0__fill_2
XFILLER_9_419 VDD VDD VSS VSS gf180mcu_fd_sc_mcu7t5v0__fill_1
XFILLER_21_492 VDD VDD VSS VSS gf180mcu_fd_sc_mcu7t5v0__fillcap_8
XTAP_TAPCELL_ROW_89_1054 VDD VSS gf180mcu_fd_sc_mcu7t5v0__filltie
XFILLER_75_142 VDD VDD VSS VSS gf180mcu_fd_sc_mcu7t5v0__fillcap_64
XFILLER_90_101 VDD VDD VSS VSS gf180mcu_fd_sc_mcu7t5v0__fillcap_4
XFILLER_63_315 VDD VDD VSS VSS gf180mcu_fd_sc_mcu7t5v0__fillcap_16
XFILLER_91_668 VDD VDD VSS VSS gf180mcu_fd_sc_mcu7t5v0__fill_1
XFILLER_44_540 VDD VDD VSS VSS gf180mcu_fd_sc_mcu7t5v0__fillcap_4
XFILLER_44_551 VDD VDD VSS VSS gf180mcu_fd_sc_mcu7t5v0__fill_2
X_2750_ _3732_/Q _2772_/A2 _2751_/B VDD VDD VSS VSS gf180mcu_fd_sc_mcu7t5v0__nand2_1
X_2681_ _2681_/A1 _2733_/B _2681_/Z VDD VDD VSS VSS gf180mcu_fd_sc_mcu7t5v0__xor2_1
X_3302_ _3309_/A2 _3302_/A2 _3302_/Z VDD VDD VSS VSS gf180mcu_fd_sc_mcu7t5v0__and2_1
XFILLER_79_470 VDD VDD VSS VSS gf180mcu_fd_sc_mcu7t5v0__fill_2
X_3233_ wire359/I _3245_/A2 _3282_/B VDD VDD VSS VSS gf180mcu_fd_sc_mcu7t5v0__xor2_2
XFILLER_79_492 VDD VDD VSS VSS gf180mcu_fd_sc_mcu7t5v0__fillcap_4
XFILLER_39_312 VDD VDD VSS VSS gf180mcu_fd_sc_mcu7t5v0__fill_2
XFILLER_94_451 VDD VDD VSS VSS gf180mcu_fd_sc_mcu7t5v0__fillcap_4
X_3164_ _3170_/C _3163_/Z _3164_/ZN VDD VDD VSS VSS gf180mcu_fd_sc_mcu7t5v0__nor2_1
XFILLER_66_153 VDD VDD VSS VSS gf180mcu_fd_sc_mcu7t5v0__fill_1
X_2115_ _3349_/A1 _3349_/A2 _2115_/B _3774_/D VDD VDD VSS VSS gf180mcu_fd_sc_mcu7t5v0__oai21_1
X_3095_ _3666_/Q _3095_/ZN VDD VDD VSS VSS gf180mcu_fd_sc_mcu7t5v0__clkinv_1
XTAP_TAPCELL_ROW_65_822 VDD VSS gf180mcu_fd_sc_mcu7t5v0__filltie
X_2046_ _3725_/Q _3582_/A1 _2046_/B _2048_/A3 VDD VDD VSS VSS gf180mcu_fd_sc_mcu7t5v0__aoi21_1
XFILLER_35_540 VDD VDD VSS VSS gf180mcu_fd_sc_mcu7t5v0__fillcap_8
XTAP_TAPCELL_ROW_37_557 VDD VSS gf180mcu_fd_sc_mcu7t5v0__filltie
XFILLER_35_562 VDD VDD VSS VSS gf180mcu_fd_sc_mcu7t5v0__fillcap_4
XFILLER_50_565 VDD VDD VSS VSS gf180mcu_fd_sc_mcu7t5v0__fill_1
XFILLER_10_429 VDD VDD VSS VSS gf180mcu_fd_sc_mcu7t5v0__fillcap_8
XTAP_TAPCELL_ROW_20_402 VDD VSS gf180mcu_fd_sc_mcu7t5v0__filltie
X_2948_ _3712_/Q _2948_/A2 _2949_/B VDD VDD VSS VSS gf180mcu_fd_sc_mcu7t5v0__nand2_1
X_2879_ _3683_/Q _2894_/A2 _2885_/B _2880_/B2 VDD VDD VSS VSS gf180mcu_fd_sc_mcu7t5v0__oai21_1
XFILLER_89_212 VDD VDD VSS VSS gf180mcu_fd_sc_mcu7t5v0__fillcap_64
XPHY_EDGE_ROW_8_Left_105 VDD VSS gf180mcu_fd_sc_mcu7t5v0__endcap
XFILLER_38_34 VDD VDD VSS VSS gf180mcu_fd_sc_mcu7t5v0__fill_1
XFILLER_85_440 VDD VDD VSS VSS gf180mcu_fd_sc_mcu7t5v0__fill_1
XFILLER_57_142 VDD VDD VSS VSS gf180mcu_fd_sc_mcu7t5v0__fill_2
XFILLER_72_101 VDD VDD VSS VSS gf180mcu_fd_sc_mcu7t5v0__fillcap_4
XFILLER_73_668 VDD VDD VSS VSS gf180mcu_fd_sc_mcu7t5v0__fill_1
XFILLER_13_212 VDD VDD VSS VSS gf180mcu_fd_sc_mcu7t5v0__fillcap_8
XFILLER_9_216 VDD VDD VSS VSS gf180mcu_fd_sc_mcu7t5v0__fill_2
XFILLER_5_422 VDD VDD VSS VSS gf180mcu_fd_sc_mcu7t5v0__fillcap_32
XTAP_TAPCELL_ROW_79_958 VDD VSS gf180mcu_fd_sc_mcu7t5v0__filltie
XTAP_TAPCELL_ROW_8_282 VDD VSS gf180mcu_fd_sc_mcu7t5v0__filltie
XFILLER_1_672 VDD VDD VSS VSS gf180mcu_fd_sc_mcu7t5v0__fillcap_4
XFILLER_49_632 VDD VDD VSS VSS gf180mcu_fd_sc_mcu7t5v0__fill_1
XFILLER_0_182 VDD VDD VSS VSS gf180mcu_fd_sc_mcu7t5v0__fill_1
XFILLER_36_337 VDD VDD VSS VSS gf180mcu_fd_sc_mcu7t5v0__fillcap_16
XFILLER_63_167 VDD VDD VSS VSS gf180mcu_fd_sc_mcu7t5v0__fillcap_4
XTAP_TAPCELL_ROW_34_527 VDD VSS gf180mcu_fd_sc_mcu7t5v0__filltie
XFILLER_44_370 VDD VDD VSS VSS gf180mcu_fd_sc_mcu7t5v0__fill_2
X_2802_ _3094_/ZN wire374/Z _2802_/B _2806_/A2 VDD VDD VSS VSS gf180mcu_fd_sc_mcu7t5v0__oai21_1
X_2733_ _2733_/A1 _2733_/A2 _2733_/B _2733_/C _2738_/A1 VDD VDD VSS VSS gf180mcu_fd_sc_mcu7t5v0__aoi211_1
XFILLER_74_2 VDD VDD VSS VSS gf180mcu_fd_sc_mcu7t5v0__fillcap_32
X_2664_ _2682_/A2 _2682_/A3 _2684_/A2 VDD VDD VSS VSS gf180mcu_fd_sc_mcu7t5v0__nor2_1
X_2595_ _2595_/A1 _2595_/A2 _2594_/B _2595_/Z VDD VDD VSS VSS gf180mcu_fd_sc_mcu7t5v0__and3_1
Xfanout239 wire243/I _2937_/A2 VDD VDD VSS VSS gf180mcu_fd_sc_mcu7t5v0__dlyb_1
X_3216_ _3728_/Q _3214_/I _3216_/Z VDD VDD VSS VSS gf180mcu_fd_sc_mcu7t5v0__xor2_1
XFILLER_39_120 VDD VDD VSS VSS gf180mcu_fd_sc_mcu7t5v0__fill_2
XFILLER_67_440 VDD VDD VSS VSS gf180mcu_fd_sc_mcu7t5v0__fillcap_4
XFILLER_82_410 VDD VDD VSS VSS gf180mcu_fd_sc_mcu7t5v0__fillcap_8
XFILLER_54_101 VDD VDD VSS VSS gf180mcu_fd_sc_mcu7t5v0__fillcap_4
X_3147_ _3146_/B _3147_/A2 _3147_/ZN VDD VDD VSS VSS gf180mcu_fd_sc_mcu7t5v0__xnor2_1
XFILLER_67_462 VDD VDD VSS VSS gf180mcu_fd_sc_mcu7t5v0__fillcap_16
XFILLER_54_123 VDD VDD VSS VSS gf180mcu_fd_sc_mcu7t5v0__fillcap_8
XFILLER_82_465 VDD VDD VSS VSS gf180mcu_fd_sc_mcu7t5v0__fill_1
XFILLER_42_307 VDD VDD VSS VSS gf180mcu_fd_sc_mcu7t5v0__fill_1
X_3078_ _3688_/Q _3078_/ZN VDD VDD VSS VSS gf180mcu_fd_sc_mcu7t5v0__clkinv_1
X_2029_ _2027_/Z _2029_/A2 _2029_/B _2053_/B VDD VDD VSS VSS gf180mcu_fd_sc_mcu7t5v0__aoi21_1
XFILLER_42_329 VDD VDD VSS VSS gf180mcu_fd_sc_mcu7t5v0__fillcap_32
XFILLER_10_226 VDD VDD VSS VSS gf180mcu_fd_sc_mcu7t5v0__fillcap_4
Xwire629 wire630/Z wire629/Z VDD VDD VSS VSS gf180mcu_fd_sc_mcu7t5v0__buf_2
XFILLER_2_436 VDD VDD VSS VSS gf180mcu_fd_sc_mcu7t5v0__fillcap_16
XFILLER_49_66 VDD VDD VSS VSS gf180mcu_fd_sc_mcu7t5v0__fillcap_4
XTAP_TAPCELL_ROW_5_252 VDD VSS gf180mcu_fd_sc_mcu7t5v0__filltie
XTAP_TAPCELL_ROW_76_928 VDD VSS gf180mcu_fd_sc_mcu7t5v0__filltie
XTAP_TAPCELL_ROW_86_1024 VDD VSS gf180mcu_fd_sc_mcu7t5v0__filltie
XFILLER_73_476 VDD VDD VSS VSS gf180mcu_fd_sc_mcu7t5v0__fill_2
XFILLER_14_543 VDD VDD VSS VSS gf180mcu_fd_sc_mcu7t5v0__fill_2
XFILLER_14_576 VDD VDD VSS VSS gf180mcu_fd_sc_mcu7t5v0__fillcap_16
X_2380_ _3083_/ZN _3085_/ZN _2380_/A3 _2387_/A2 VDD VDD VSS VSS gf180mcu_fd_sc_mcu7t5v0__nor3_1
XFILLER_96_546 VDD VDD VSS VSS gf180mcu_fd_sc_mcu7t5v0__fillcap_32
Xinput6 cfg_f_MEMS_fcw[12] input6/Z VDD VDD VSS VSS gf180mcu_fd_sc_mcu7t5v0__buf_2
X_3001_ _3001_/I _3001_/ZN VDD VDD VSS VSS gf180mcu_fd_sc_mcu7t5v0__clkinv_1
XTAP_TAPCELL_ROW_47_652 VDD VSS gf180mcu_fd_sc_mcu7t5v0__filltie
XFILLER_64_454 VDD VDD VSS VSS gf180mcu_fd_sc_mcu7t5v0__fill_1
XFILLER_64_465 VDD VDD VSS VSS gf180mcu_fd_sc_mcu7t5v0__fill_2
XTAP_TAPCELL_ROW_19_387 VDD VSS gf180mcu_fd_sc_mcu7t5v0__filltie
XFILLER_32_384 VDD VDD VSS VSS gf180mcu_fd_sc_mcu7t5v0__fill_1
XFILLER_20_535 VDD VDD VSS VSS gf180mcu_fd_sc_mcu7t5v0__fillcap_4
XFILLER_32_395 VDD VDD VSS VSS gf180mcu_fd_sc_mcu7t5v0__fill_1
X_3765_ _3765_/D wire594/I clkload7/I _3765_/Q VDD VDD VSS VSS gf180mcu_fd_sc_mcu7t5v0__dffrnq_1
X_2716_ wire647/I _2697_/Z _2716_/B1 _2716_/B2 _2716_/C _2718_/A2 VDD VDD VSS VSS
+ gf180mcu_fd_sc_mcu7t5v0__oai221_1
X_3696_ _3696_/D wire616/Z _3774_/CLK _3696_/Q VDD VDD VSS VSS gf180mcu_fd_sc_mcu7t5v0__dffrnq_1
X_2647_ _2694_/A1 _2694_/A2 _2648_/A3 _2647_/Z VDD VDD VSS VSS gf180mcu_fd_sc_mcu7t5v0__and3_1
X_2578_ _2578_/A1 _2572_/Z _2578_/B1 _2578_/B2 _2578_/C _2579_/A3 VDD VDD VSS VSS
+ gf180mcu_fd_sc_mcu7t5v0__aoi221_1
XTAP_TAPCELL_ROW_2_222 VDD VSS gf180mcu_fd_sc_mcu7t5v0__filltie
XFILLER_70_402 VDD VDD VSS VSS gf180mcu_fd_sc_mcu7t5v0__fill_1
XFILLER_42_115 VDD VDD VSS VSS gf180mcu_fd_sc_mcu7t5v0__fillcap_4
XFILLER_55_487 VDD VDD VSS VSS gf180mcu_fd_sc_mcu7t5v0__fill_2
XTAP_TAPCELL_ROW_81_975 VDD VSS gf180mcu_fd_sc_mcu7t5v0__filltie
XFILLER_70_457 VDD VDD VSS VSS gf180mcu_fd_sc_mcu7t5v0__fill_1
XPHY_EDGE_ROW_14_Right_14 VDD VSS gf180mcu_fd_sc_mcu7t5v0__endcap
XFILLER_50_181 VDD VDD VSS VSS gf180mcu_fd_sc_mcu7t5v0__fill_1
XFILLER_7_539 VDD VDD VSS VSS gf180mcu_fd_sc_mcu7t5v0__fill_2
XFILLER_7_517 VDD VDD VSS VSS gf180mcu_fd_sc_mcu7t5v0__fillcap_4
Xwire448 wire448/I wire448/Z VDD VDD VSS VSS gf180mcu_fd_sc_mcu7t5v0__buf_1
Xwire459 wire459/I wire459/Z VDD VDD VSS VSS gf180mcu_fd_sc_mcu7t5v0__buf_1
XFILLER_4_2 VDD VDD VSS VSS gf180mcu_fd_sc_mcu7t5v0__fillcap_32
Xload_slew409 wire408/I _2736_/A2 VDD VDD VSS VSS gf180mcu_fd_sc_mcu7t5v0__clkbuf_1
XTAP_TAPCELL_ROW_92_1083 VDD VSS gf180mcu_fd_sc_mcu7t5v0__filltie
XFILLER_78_546 VDD VDD VSS VSS gf180mcu_fd_sc_mcu7t5v0__fillcap_4
XFILLER_78_535 VDD VDD VSS VSS gf180mcu_fd_sc_mcu7t5v0__fillcap_4
XPHY_EDGE_ROW_23_Right_23 VDD VSS gf180mcu_fd_sc_mcu7t5v0__endcap
Xfanout592 wire617/I wire594/I VDD VDD VSS VSS gf180mcu_fd_sc_mcu7t5v0__dlyb_1
Xfanout570 fanout583/I _3735_/RN VDD VDD VSS VSS gf180mcu_fd_sc_mcu7t5v0__dlyb_1
XFILLER_65_207 VDD VDD VSS VSS gf180mcu_fd_sc_mcu7t5v0__fill_2
XFILLER_18_101 VDD VDD VSS VSS gf180mcu_fd_sc_mcu7t5v0__fillcap_4
XFILLER_46_443 VDD VDD VSS VSS gf180mcu_fd_sc_mcu7t5v0__fill_1
XFILLER_46_454 VDD VDD VSS VSS gf180mcu_fd_sc_mcu7t5v0__fill_1
XFILLER_61_402 VDD VDD VSS VSS gf180mcu_fd_sc_mcu7t5v0__fillcap_4
XFILLER_33_104 VDD VDD VSS VSS gf180mcu_fd_sc_mcu7t5v0__fillcap_8
XTAP_TAPCELL_ROW_44_622 VDD VSS gf180mcu_fd_sc_mcu7t5v0__filltie
XFILLER_73_295 VDD VDD VSS VSS gf180mcu_fd_sc_mcu7t5v0__fill_2
XTAP_TAPCELL_ROW_16_357 VDD VSS gf180mcu_fd_sc_mcu7t5v0__filltie
XPHY_EDGE_ROW_32_Right_32 VDD VSS gf180mcu_fd_sc_mcu7t5v0__endcap
XFILLER_33_137 VDD VDD VSS VSS gf180mcu_fd_sc_mcu7t5v0__fill_2
X_1880_ _3717_/Q _3431_/A1 _1893_/B VDD VDD VSS VSS gf180mcu_fd_sc_mcu7t5v0__nand2_1
X_3550_ _3550_/A1 _3065_/I _3550_/B _3551_/C VDD VDD VSS VSS gf180mcu_fd_sc_mcu7t5v0__aoi21_1
X_2501_ _2482_/Z _2568_/A2 _2565_/A3 VDD VDD VSS VSS gf180mcu_fd_sc_mcu7t5v0__nor2_1
X_3481_ _3481_/A1 _3510_/A1 _3481_/Z VDD VDD VSS VSS gf180mcu_fd_sc_mcu7t5v0__xor2_1
X_2432_ _2432_/A1 _2432_/A2 _2432_/B _2434_/A2 VDD VDD VSS VSS gf180mcu_fd_sc_mcu7t5v0__aoi21_1
XPHY_EDGE_ROW_41_Right_41 VDD VSS gf180mcu_fd_sc_mcu7t5v0__endcap
XFILLER_37_2 VDD VDD VSS VSS gf180mcu_fd_sc_mcu7t5v0__fillcap_64
X_2363_ wire408/Z _2389_/A2 _2361_/Z _2384_/A1 VDD VDD VSS VSS gf180mcu_fd_sc_mcu7t5v0__nand3_1
XFILLER_69_535 VDD VDD VSS VSS gf180mcu_fd_sc_mcu7t5v0__fillcap_8
XFILLER_96_376 VDD VDD VSS VSS gf180mcu_fd_sc_mcu7t5v0__fillcap_32
XFILLER_84_527 VDD VDD VSS VSS gf180mcu_fd_sc_mcu7t5v0__fillcap_16
X_2294_ _3729_/Q _2298_/A1 _2295_/B VDD VDD VSS VSS gf180mcu_fd_sc_mcu7t5v0__nand2_1
XFILLER_37_476 VDD VDD VSS VSS gf180mcu_fd_sc_mcu7t5v0__fill_1
XFILLER_25_627 VDD VDD VSS VSS gf180mcu_fd_sc_mcu7t5v0__fill_2
XPHY_EDGE_ROW_50_Right_50 VDD VSS gf180mcu_fd_sc_mcu7t5v0__endcap
XFILLER_64_295 VDD VDD VSS VSS gf180mcu_fd_sc_mcu7t5v0__fillcap_4
X_3748_ _3748_/D _3748_/RN clkload9/I _3748_/Q VDD VDD VSS VSS gf180mcu_fd_sc_mcu7t5v0__dffrnq_1
X_3679_ _3679_/D wire597/Z _3721_/CLK _3679_/Q VDD VDD VSS VSS gf180mcu_fd_sc_mcu7t5v0__dffrnq_2
Xoutput140 _3640_/Z cal_phase90_offset[18] VDD VDD VSS VSS gf180mcu_fd_sc_mcu7t5v0__buf_2
Xoutput151 _3498_/Z cal_phase90_offset[9] VDD VDD VSS VSS gf180mcu_fd_sc_mcu7t5v0__buf_2
Xoutput162 _3656_/Q latch_phase270 VDD VDD VSS VSS gf180mcu_fd_sc_mcu7t5v0__buf_2
Xoutput173 _2885_/A1 raw_edge1[17] VDD VDD VSS VSS gf180mcu_fd_sc_mcu7t5v0__buf_2
Xoutput184 _3676_/Q raw_edge1[8] VDD VDD VSS VSS gf180mcu_fd_sc_mcu7t5v0__buf_2
Xoutput195 _3707_/Q raw_edge2[18] VDD VDD VSS VSS gf180mcu_fd_sc_mcu7t5v0__buf_2
XFILLER_28_410 VDD VDD VSS VSS gf180mcu_fd_sc_mcu7t5v0__fillcap_4
XFILLER_46_34 VDD VDD VSS VSS gf180mcu_fd_sc_mcu7t5v0__fill_1
XTAP_TAPCELL_ROW_58_758 VDD VSS gf180mcu_fd_sc_mcu7t5v0__filltie
XFILLER_28_454 VDD VDD VSS VSS gf180mcu_fd_sc_mcu7t5v0__fill_1
XFILLER_31_608 VDD VDD VSS VSS gf180mcu_fd_sc_mcu7t5v0__fill_2
XFILLER_30_107 VDD VDD VSS VSS gf180mcu_fd_sc_mcu7t5v0__fillcap_8
XTAP_TAPCELL_ROW_13_327 VDD VSS gf180mcu_fd_sc_mcu7t5v0__filltie
XFILLER_7_325 VDD VDD VSS VSS gf180mcu_fd_sc_mcu7t5v0__fill_2
XTAP_TAPCELL_ROW_94_1101 VDD VSS gf180mcu_fd_sc_mcu7t5v0__filltie
Xwire267 wire267/I wire267/Z VDD VDD VSS VSS gf180mcu_fd_sc_mcu7t5v0__clkbuf_2
Xwire289 wire290/Z wire289/Z VDD VDD VSS VSS gf180mcu_fd_sc_mcu7t5v0__dlyb_1
XFILLER_78_387 VDD VDD VSS VSS gf180mcu_fd_sc_mcu7t5v0__fill_1
XFILLER_93_346 VDD VDD VSS VSS gf180mcu_fd_sc_mcu7t5v0__fillcap_4
XFILLER_81_519 VDD VDD VSS VSS gf180mcu_fd_sc_mcu7t5v0__fillcap_4
XFILLER_74_560 VDD VDD VSS VSS gf180mcu_fd_sc_mcu7t5v0__fillcap_4
XFILLER_19_487 VDD VDD VSS VSS gf180mcu_fd_sc_mcu7t5v0__fill_2
XTAP_TAPCELL_ROW_29_482 VDD VSS gf180mcu_fd_sc_mcu7t5v0__filltie
XFILLER_34_457 VDD VDD VSS VSS gf180mcu_fd_sc_mcu7t5v0__fillcap_4
X_2981_ _2981_/I _2981_/ZN VDD VDD VSS VSS gf180mcu_fd_sc_mcu7t5v0__inv_2
XFILLER_42_490 VDD VDD VSS VSS gf180mcu_fd_sc_mcu7t5v0__fill_2
X_1932_ _1932_/I _1934_/A2 VDD VDD VSS VSS gf180mcu_fd_sc_mcu7t5v0__clkinv_1
X_1863_ _1834_/Z _1848_/Z _1864_/C VDD VDD VSS VSS gf180mcu_fd_sc_mcu7t5v0__or2_1
Xinput20 cfg_phase0_offset[10] _2980_/I VDD VDD VSS VSS gf180mcu_fd_sc_mcu7t5v0__buf_1
Xinput31 cfg_phase0_offset[20] input31/Z VDD VDD VSS VSS gf180mcu_fd_sc_mcu7t5v0__buf_1
X_3602_ _3600_/Z _3603_/A2 _3622_/B VDD VDD VSS VSS gf180mcu_fd_sc_mcu7t5v0__nand2_1
Xinput42 cfg_phase270_offset[11] _2999_/I VDD VDD VSS VSS gf180mcu_fd_sc_mcu7t5v0__buf_1
Xinput53 cfg_phase270_offset[2] input53/Z VDD VDD VSS VSS gf180mcu_fd_sc_mcu7t5v0__buf_1
Xinput64 cfg_phase90_offset[12] input64/Z VDD VDD VSS VSS gf180mcu_fd_sc_mcu7t5v0__buf_1
Xinput86 soft_rst_n input86/Z VDD VDD VSS VSS gf180mcu_fd_sc_mcu7t5v0__buf_1
Xinput75 cfg_phase90_offset[3] input75/Z VDD VDD VSS VSS gf180mcu_fd_sc_mcu7t5v0__buf_1
X_3533_ _3551_/B1 _3533_/A2 _3533_/B _3536_/A3 VDD VDD VSS VSS gf180mcu_fd_sc_mcu7t5v0__aoi21_1
X_3464_ _3464_/A1 _3444_/Z _3463_/B _3464_/Z VDD VDD VSS VSS gf180mcu_fd_sc_mcu7t5v0__or3_1
XFILLER_88_107 VDD VDD VSS VSS gf180mcu_fd_sc_mcu7t5v0__fillcap_64
X_2415_ _3110_/B2 _2415_/A2 _2414_/Z wire368/I _3748_/D VDD VDD VSS VSS gf180mcu_fd_sc_mcu7t5v0__oai22_1
X_3395_ _3395_/A1 _3406_/A1 _3391_/Z _3397_/B VDD VDD VSS VSS gf180mcu_fd_sc_mcu7t5v0__xor3_1
X_2346_ _2346_/I _2427_/B VDD VDD VSS VSS gf180mcu_fd_sc_mcu7t5v0__clkinv_1
X_2277_ wire255/Z _2929_/A1 _2277_/B _3723_/D VDD VDD VSS VSS gf180mcu_fd_sc_mcu7t5v0__oai21_1
XFILLER_25_402 VDD VDD VSS VSS gf180mcu_fd_sc_mcu7t5v0__fillcap_4
XFILLER_52_210 VDD VDD VSS VSS gf180mcu_fd_sc_mcu7t5v0__fillcap_4
XTAP_TAPCELL_ROW_55_728 VDD VSS gf180mcu_fd_sc_mcu7t5v0__filltie
XFILLER_65_582 VDD VDD VSS VSS gf180mcu_fd_sc_mcu7t5v0__fillcap_4
XFILLER_16_37 VDD VDD VSS VSS gf180mcu_fd_sc_mcu7t5v0__fillcap_64
XFILLER_12_107 VDD VDD VSS VSS gf180mcu_fd_sc_mcu7t5v0__fillcap_64
XFILLER_4_317 VDD VDD VSS VSS gf180mcu_fd_sc_mcu7t5v0__fillcap_4
XFILLER_0_501 VDD VDD VSS VSS gf180mcu_fd_sc_mcu7t5v0__fillcap_8
XFILLER_0_512 VDD VDD VSS VSS gf180mcu_fd_sc_mcu7t5v0__fillcap_32
XFILLER_88_652 VDD VDD VSS VSS gf180mcu_fd_sc_mcu7t5v0__fill_1
XFILLER_75_302 VDD VDD VSS VSS gf180mcu_fd_sc_mcu7t5v0__fill_2
XFILLER_75_324 VDD VDD VSS VSS gf180mcu_fd_sc_mcu7t5v0__fillcap_16
XFILLER_57_66 VDD VDD VSS VSS gf180mcu_fd_sc_mcu7t5v0__fillcap_4
XFILLER_63_508 VDD VDD VSS VSS gf180mcu_fd_sc_mcu7t5v0__fillcap_4
XFILLER_56_593 VDD VDD VSS VSS gf180mcu_fd_sc_mcu7t5v0__fill_2
XFILLER_16_457 VDD VDD VSS VSS gf180mcu_fd_sc_mcu7t5v0__fill_2
XTAP_TAPCELL_ROW_26_452 VDD VSS gf180mcu_fd_sc_mcu7t5v0__filltie
XFILLER_8_667 VDD VDD VSS VSS gf180mcu_fd_sc_mcu7t5v0__fillcap_8
X_2200_ _2201_/A1 _2198_/B _2201_/B2 VDD VDD VSS VSS gf180mcu_fd_sc_mcu7t5v0__nor2_1
X_3180_ _3180_/A1 _3180_/A2 _3180_/B _3187_/B2 VDD VDD VSS VSS gf180mcu_fd_sc_mcu7t5v0__aoi21_2
X_2131_ _2940_/A1 _2211_/A2 _2211_/B _2132_/A2 VDD VDD VSS VSS gf180mcu_fd_sc_mcu7t5v0__oai21_1
XFILLER_66_313 VDD VDD VSS VSS gf180mcu_fd_sc_mcu7t5v0__fill_2
X_2062_ _3598_/A1 _2061_/Z _2062_/Z VDD VDD VSS VSS gf180mcu_fd_sc_mcu7t5v0__and2_1
XFILLER_47_582 VDD VDD VSS VSS gf180mcu_fd_sc_mcu7t5v0__fill_2
X_2964_ _3720_/Q _2965_/A1 _2965_/B VDD VDD VSS VSS gf180mcu_fd_sc_mcu7t5v0__nand2_1
XTAP_TAPCELL_ROW_60_775 VDD VSS gf180mcu_fd_sc_mcu7t5v0__filltie
X_1915_ _1915_/A1 _1901_/Z _1915_/B _1916_/A2 VDD VDD VSS VSS gf180mcu_fd_sc_mcu7t5v0__oai21_1
X_2895_ _3078_/ZN _2895_/A2 _2895_/B1 _2895_/B2 _3688_/D VDD VDD VSS VSS gf180mcu_fd_sc_mcu7t5v0__oai22_1
X_1846_ _1846_/A1 _1846_/A2 _1846_/ZN VDD VDD VSS VSS gf180mcu_fd_sc_mcu7t5v0__xnor2_1
XPHY_EDGE_ROW_62_Left_159 VDD VSS gf180mcu_fd_sc_mcu7t5v0__endcap
X_3516_ _3516_/A1 _3679_/Q _3487_/B _3518_/A3 _3517_/B VDD VDD VSS VSS gf180mcu_fd_sc_mcu7t5v0__oai22_1
XFILLER_89_438 VDD VDD VSS VSS gf180mcu_fd_sc_mcu7t5v0__fill_2
XPHY_EDGE_ROW_4_Right_4 VDD VSS gf180mcu_fd_sc_mcu7t5v0__endcap
X_3447_ _3447_/A1 _3436_/Z _3447_/B _3448_/I VDD VDD VSS VSS gf180mcu_fd_sc_mcu7t5v0__aoi21_1
X_3378_ _3378_/A1 _3375_/Z _3379_/I VDD VDD VSS VSS gf180mcu_fd_sc_mcu7t5v0__xor2_2
X_2329_ _2315_/Z _2407_/A2 _2329_/B _2410_/A3 VDD VDD VSS VSS gf180mcu_fd_sc_mcu7t5v0__aoi21_1
Xload_slew581 _3723_/RN _3725_/RN VDD VDD VSS VSS gf180mcu_fd_sc_mcu7t5v0__buf_1
XPHY_EDGE_ROW_71_Left_168 VDD VSS gf180mcu_fd_sc_mcu7t5v0__endcap
XTAP_TAPCELL_ROW_68_853 VDD VSS gf180mcu_fd_sc_mcu7t5v0__filltie
XFILLER_38_593 VDD VDD VSS VSS gf180mcu_fd_sc_mcu7t5v0__fill_2
XFILLER_80_382 VDD VDD VSS VSS gf180mcu_fd_sc_mcu7t5v0__fill_2
Xclkbuf_4_8_0_clk clkbuf_0_clk/Z clkload7/I VDD VDD VSS VSS gf180mcu_fd_sc_mcu7t5v0__clkbuf_8
XTAP_TAPCELL_ROW_23_422 VDD VSS gf180mcu_fd_sc_mcu7t5v0__filltie
XPHY_EDGE_ROW_80_Left_177 VDD VSS gf180mcu_fd_sc_mcu7t5v0__endcap
XFILLER_5_626 VDD VDD VSS VSS gf180mcu_fd_sc_mcu7t5v0__fillcap_4
XFILLER_4_158 VDD VDD VSS VSS gf180mcu_fd_sc_mcu7t5v0__fillcap_16
XFILLER_0_364 VDD VDD VSS VSS gf180mcu_fd_sc_mcu7t5v0__fillcap_8
XTAP_TAPCELL_ROW_89_1055 VDD VSS gf180mcu_fd_sc_mcu7t5v0__filltie
XFILLER_63_349 VDD VDD VSS VSS gf180mcu_fd_sc_mcu7t5v0__fill_1
XFILLER_71_393 VDD VDD VSS VSS gf180mcu_fd_sc_mcu7t5v0__fillcap_4
X_2680_ wire424/Z _2734_/B _2733_/B VDD VDD VSS VSS gf180mcu_fd_sc_mcu7t5v0__xor2_1
X_3301_ _3306_/A2 _3301_/A2 _3301_/A3 _3304_/A2 VDD VDD VSS VSS gf180mcu_fd_sc_mcu7t5v0__nand3_1
X_3232_ _3757_/Q _3244_/A2 _3270_/B VDD VDD VSS VSS gf180mcu_fd_sc_mcu7t5v0__xor2_2
XFILLER_39_324 VDD VDD VSS VSS gf180mcu_fd_sc_mcu7t5v0__fillcap_4
X_3163_ _3163_/A1 _3163_/A2 _3162_/B _3163_/Z VDD VDD VSS VSS gf180mcu_fd_sc_mcu7t5v0__and3_1
X_2114_ _3766_/Q _3258_/ZN _3766_/D VDD VDD VSS VSS gf180mcu_fd_sc_mcu7t5v0__xnor2_1
X_3094_ _3665_/Q _3094_/ZN VDD VDD VSS VSS gf180mcu_fd_sc_mcu7t5v0__clkinv_1
XTAP_TAPCELL_ROW_65_823 VDD VSS gf180mcu_fd_sc_mcu7t5v0__filltie
X_2045_ _3205_/A2 _3704_/Q _2045_/B _2046_/B VDD VDD VSS VSS gf180mcu_fd_sc_mcu7t5v0__aoi21_1
XTAP_TAPCELL_ROW_37_558 VDD VSS gf180mcu_fd_sc_mcu7t5v0__filltie
XFILLER_50_544 VDD VDD VSS VSS gf180mcu_fd_sc_mcu7t5v0__fill_1
X_2947_ _2948_/A2 _2947_/A2 _2947_/B _3711_/D VDD VDD VSS VSS gf180mcu_fd_sc_mcu7t5v0__oai21_1
X_2878_ wire435/Z _2893_/A2 _2880_/B1 VDD VDD VSS VSS gf180mcu_fd_sc_mcu7t5v0__nor2_1
X_1829_ _1829_/I _1831_/B1 VDD VDD VSS VSS gf180mcu_fd_sc_mcu7t5v0__clkinv_1
XFILLER_77_408 VDD VDD VSS VSS gf180mcu_fd_sc_mcu7t5v0__fillcap_8
XFILLER_85_430 VDD VDD VSS VSS gf180mcu_fd_sc_mcu7t5v0__fill_1
XPHY_EDGE_ROW_79_Right_79 VDD VSS gf180mcu_fd_sc_mcu7t5v0__endcap
XFILLER_45_338 VDD VDD VSS VSS gf180mcu_fd_sc_mcu7t5v0__fillcap_8
XFILLER_54_34 VDD VDD VSS VSS gf180mcu_fd_sc_mcu7t5v0__fill_1
XTAP_TAPCELL_ROW_0_194 VDD VSS gf180mcu_fd_sc_mcu7t5v0__filltie
XFILLER_41_522 VDD VDD VSS VSS gf180mcu_fd_sc_mcu7t5v0__fillcap_8
XFILLER_9_206 VDD VDD VSS VSS gf180mcu_fd_sc_mcu7t5v0__fillcap_4
XPHY_EDGE_ROW_88_Right_88 VDD VSS gf180mcu_fd_sc_mcu7t5v0__endcap
XFILLER_5_489 VDD VDD VSS VSS gf180mcu_fd_sc_mcu7t5v0__fill_1
XFILLER_5_478 VDD VDD VSS VSS gf180mcu_fd_sc_mcu7t5v0__fillcap_4
XTAP_TAPCELL_ROW_79_959 VDD VSS gf180mcu_fd_sc_mcu7t5v0__filltie
XTAP_TAPCELL_ROW_8_283 VDD VSS gf180mcu_fd_sc_mcu7t5v0__filltie
XFILLER_0_172 VDD VDD VSS VSS gf180mcu_fd_sc_mcu7t5v0__fillcap_8
XFILLER_76_452 VDD VDD VSS VSS gf180mcu_fd_sc_mcu7t5v0__fill_2
XFILLER_76_463 VDD VDD VSS VSS gf180mcu_fd_sc_mcu7t5v0__fill_1
XFILLER_91_422 VDD VDD VSS VSS gf180mcu_fd_sc_mcu7t5v0__fillcap_64
XTAP_TAPCELL_ROW_34_528 VDD VSS gf180mcu_fd_sc_mcu7t5v0__filltie
X_2801_ _3737_/Q wire374/Z _2802_/B VDD VDD VSS VSS gf180mcu_fd_sc_mcu7t5v0__nand2_1
X_3781_ _3781_/I _3781_/Z VDD VDD VSS VSS gf180mcu_fd_sc_mcu7t5v0__buf_1
XTAP_TAPCELL_ROW_70_870 VDD VSS gf180mcu_fd_sc_mcu7t5v0__filltie
X_2732_ _2732_/A1 _2732_/A2 _2732_/B _2732_/C _2739_/A2 VDD VDD VSS VSS gf180mcu_fd_sc_mcu7t5v0__aoi211_1
X_2663_ _3119_/A2 input44/Z _2663_/B _2663_/C _2682_/A3 VDD VDD VSS VSS gf180mcu_fd_sc_mcu7t5v0__aoi211_4
XFILLER_67_2 VDD VDD VSS VSS gf180mcu_fd_sc_mcu7t5v0__fillcap_64
X_2594_ _2595_/A1 _2595_/A2 _2594_/B _2601_/A1 VDD VDD VSS VSS gf180mcu_fd_sc_mcu7t5v0__aoi21_1
XFILLER_5_72 VDD VDD VSS VSS gf180mcu_fd_sc_mcu7t5v0__fillcap_64
Xfanout229 wire235/Z wire231/I VDD VDD VSS VSS gf180mcu_fd_sc_mcu7t5v0__dlyb_1
X_3215_ _3728_/Q _3217_/A3 _3218_/A2 VDD VDD VSS VSS gf180mcu_fd_sc_mcu7t5v0__nor2_1
XFILLER_39_154 VDD VDD VSS VSS gf180mcu_fd_sc_mcu7t5v0__fill_2
X_3146_ _3146_/A1 _3712_/Q _3146_/B _3152_/A2 VDD VDD VSS VSS gf180mcu_fd_sc_mcu7t5v0__oai21_1
XFILLER_67_485 VDD VDD VSS VSS gf180mcu_fd_sc_mcu7t5v0__fillcap_4
XFILLER_82_422 VDD VDD VSS VSS gf180mcu_fd_sc_mcu7t5v0__fill_2
XFILLER_54_135 VDD VDD VSS VSS gf180mcu_fd_sc_mcu7t5v0__fill_1
X_3077_ _3077_/I _3626_/A2 VDD VDD VSS VSS gf180mcu_fd_sc_mcu7t5v0__clkinv_1
X_2028_ _2028_/A1 _2028_/A2 _2028_/B _2029_/A2 VDD VDD VSS VSS gf180mcu_fd_sc_mcu7t5v0__oai21_1
XFILLER_54_157 VDD VDD VSS VSS gf180mcu_fd_sc_mcu7t5v0__fillcap_8
XFILLER_35_360 VDD VDD VSS VSS gf180mcu_fd_sc_mcu7t5v0__fillcap_4
XFILLER_23_544 VDD VDD VSS VSS gf180mcu_fd_sc_mcu7t5v0__fillcap_16
XFILLER_24_37 VDD VDD VSS VSS gf180mcu_fd_sc_mcu7t5v0__fillcap_64
XFILLER_50_330 VDD VDD VSS VSS gf180mcu_fd_sc_mcu7t5v0__fillcap_16
Xwire619 input8/Z _3003_/I VDD VDD VSS VSS gf180mcu_fd_sc_mcu7t5v0__buf_4
XFILLER_6_209 VDD VDD VSS VSS gf180mcu_fd_sc_mcu7t5v0__fillcap_16
XTAP_TAPCELL_ROW_5_253 VDD VSS gf180mcu_fd_sc_mcu7t5v0__filltie
XTAP_TAPCELL_ROW_76_929 VDD VSS gf180mcu_fd_sc_mcu7t5v0__filltie
XTAP_TAPCELL_ROW_86_1025 VDD VSS gf180mcu_fd_sc_mcu7t5v0__filltie
XFILLER_85_282 VDD VDD VSS VSS gf180mcu_fd_sc_mcu7t5v0__fillcap_64
XFILLER_65_66 VDD VDD VSS VSS gf180mcu_fd_sc_mcu7t5v0__fillcap_4
XFILLER_14_511 VDD VDD VSS VSS gf180mcu_fd_sc_mcu7t5v0__fill_1
XFILLER_33_319 VDD VDD VSS VSS gf180mcu_fd_sc_mcu7t5v0__fillcap_8
XFILLER_14_599 VDD VDD VSS VSS gf180mcu_fd_sc_mcu7t5v0__fill_1
XFILLER_5_220 VDD VDD VSS VSS gf180mcu_fd_sc_mcu7t5v0__fillcap_4
XFILLER_1_492 VDD VDD VSS VSS gf180mcu_fd_sc_mcu7t5v0__fillcap_64
Xinput7 cfg_f_MEMS_fcw[13] input7/Z VDD VDD VSS VSS gf180mcu_fd_sc_mcu7t5v0__buf_3
X_3000_ _3000_/I _2658_/B VDD VDD VSS VSS gf180mcu_fd_sc_mcu7t5v0__clkinv_1
XFILLER_64_444 VDD VDD VSS VSS gf180mcu_fd_sc_mcu7t5v0__fillcap_8
XFILLER_36_168 VDD VDD VSS VSS gf180mcu_fd_sc_mcu7t5v0__fillcap_4
XTAP_TAPCELL_ROW_47_653 VDD VSS gf180mcu_fd_sc_mcu7t5v0__filltie
XFILLER_52_617 VDD VDD VSS VSS gf180mcu_fd_sc_mcu7t5v0__fill_1
XTAP_TAPCELL_ROW_19_388 VDD VSS gf180mcu_fd_sc_mcu7t5v0__filltie
XFILLER_44_190 VDD VDD VSS VSS gf180mcu_fd_sc_mcu7t5v0__fill_1
X_3764_ _3774_/Q _3764_/RN clkload9/I _3764_/Q VDD VDD VSS VSS gf180mcu_fd_sc_mcu7t5v0__dffrnq_1
X_2715_ _3168_/A1 _2698_/Z _2716_/C VDD VDD VSS VSS gf180mcu_fd_sc_mcu7t5v0__nand2_1
X_3695_ _3695_/D _3716_/RN _3717_/CLK _3695_/Q VDD VDD VSS VSS gf180mcu_fd_sc_mcu7t5v0__dffrnq_2
X_2646_ _2646_/A1 _2645_/Z _2648_/A3 VDD VDD VSS VSS gf180mcu_fd_sc_mcu7t5v0__nor2_1
X_2577_ _2577_/A1 _2569_/Z _2577_/B _2578_/C VDD VDD VSS VSS gf180mcu_fd_sc_mcu7t5v0__aoi21_1
XTAP_TAPCELL_ROW_2_223 VDD VSS gf180mcu_fd_sc_mcu7t5v0__filltie
XFILLER_82_241 VDD VDD VSS VSS gf180mcu_fd_sc_mcu7t5v0__fillcap_4
X_3129_ _3129_/A1 wire428/Z _3757_/Q _3129_/B2 _3132_/C VDD VDD VSS VSS gf180mcu_fd_sc_mcu7t5v0__aoi22_1
XTAP_TAPCELL_ROW_81_976 VDD VSS gf180mcu_fd_sc_mcu7t5v0__filltie
XFILLER_23_352 VDD VDD VSS VSS gf180mcu_fd_sc_mcu7t5v0__fillcap_16
Xwire405 _2995_/I wire405/Z VDD VDD VSS VSS gf180mcu_fd_sc_mcu7t5v0__buf_1
XTAP_TAPCELL_ROW_92_1084 VDD VSS gf180mcu_fd_sc_mcu7t5v0__filltie
XTAP_TAPCELL_ROW_44_623 VDD VSS gf180mcu_fd_sc_mcu7t5v0__filltie
XTAP_TAPCELL_ROW_16_358 VDD VSS gf180mcu_fd_sc_mcu7t5v0__filltie
X_2500_ _2566_/A1 _2577_/A1 _2500_/B _2568_/A2 VDD VDD VSS VSS gf180mcu_fd_sc_mcu7t5v0__aoi21_2
X_3480_ _3481_/A1 _3510_/A1 _3513_/A1 VDD VDD VSS VSS gf180mcu_fd_sc_mcu7t5v0__nand2_1
X_2431_ _2119_/Z _2929_/A1 _2430_/Z wire366/I _3754_/D VDD VDD VSS VSS gf180mcu_fd_sc_mcu7t5v0__oai22_1
X_2362_ wire408/Z _2361_/Z _2459_/A1 VDD VDD VSS VSS gf180mcu_fd_sc_mcu7t5v0__nand2_1
X_2293_ wire419/Z _3139_/A1 _2941_/A1 VDD VDD VSS VSS gf180mcu_fd_sc_mcu7t5v0__nand2_1
XFILLER_69_547 VDD VDD VSS VSS gf180mcu_fd_sc_mcu7t5v0__fill_1
XFILLER_49_271 VDD VDD VSS VSS gf180mcu_fd_sc_mcu7t5v0__fill_1
XFILLER_52_447 VDD VDD VSS VSS gf180mcu_fd_sc_mcu7t5v0__fillcap_8
XFILLER_32_193 VDD VDD VSS VSS gf180mcu_fd_sc_mcu7t5v0__fill_2
XFILLER_60_491 VDD VDD VSS VSS gf180mcu_fd_sc_mcu7t5v0__fill_2
X_3747_ _3747_/D _3748_/RN _3774_/CLK _3747_/Q VDD VDD VSS VSS gf180mcu_fd_sc_mcu7t5v0__dffrnq_1
X_3678_ _3678_/D wire597/I _3717_/CLK _3678_/Q VDD VDD VSS VSS gf180mcu_fd_sc_mcu7t5v0__dffrnq_2
Xoutput152 _3659_/Q cal_timeout VDD VDD VSS VSS gf180mcu_fd_sc_mcu7t5v0__buf_2
Xoutput141 _3649_/ZN cal_phase90_offset[19] VDD VDD VSS VSS gf180mcu_fd_sc_mcu7t5v0__buf_2
Xoutput130 _1943_/ZN cal_phase270_offset[9] VDD VDD VSS VSS gf180mcu_fd_sc_mcu7t5v0__buf_2
X_2629_ _2631_/A1 _2706_/B _2705_/A1 VDD VDD VSS VSS gf180mcu_fd_sc_mcu7t5v0__nand2_1
Xoutput163 _3655_/Q latch_phase90 VDD VDD VSS VSS gf180mcu_fd_sc_mcu7t5v0__buf_2
Xoutput185 _3677_/Q raw_edge1[9] VDD VDD VSS VSS gf180mcu_fd_sc_mcu7t5v0__buf_2
Xoutput174 _3686_/Q raw_edge1[18] VDD VDD VSS VSS gf180mcu_fd_sc_mcu7t5v0__buf_2
Xoutput196 _2940_/A1 raw_edge2[19] VDD VDD VSS VSS gf180mcu_fd_sc_mcu7t5v0__buf_2
XFILLER_75_506 VDD VDD VSS VSS gf180mcu_fd_sc_mcu7t5v0__fill_1
XFILLER_28_444 VDD VDD VSS VSS gf180mcu_fd_sc_mcu7t5v0__fillcap_8
XTAP_TAPCELL_ROW_58_759 VDD VSS gf180mcu_fd_sc_mcu7t5v0__filltie
XFILLER_62_34 VDD VDD VSS VSS gf180mcu_fd_sc_mcu7t5v0__fill_1
XTAP_TAPCELL_ROW_13_328 VDD VSS gf180mcu_fd_sc_mcu7t5v0__filltie
XFILLER_51_480 VDD VDD VSS VSS gf180mcu_fd_sc_mcu7t5v0__fill_2
Xwire235 wire235/I wire235/Z VDD VDD VSS VSS gf180mcu_fd_sc_mcu7t5v0__buf_2
XTAP_TAPCELL_ROW_94_1102 VDD VSS gf180mcu_fd_sc_mcu7t5v0__filltie
XFILLER_19_422 VDD VDD VSS VSS gf180mcu_fd_sc_mcu7t5v0__fillcap_8
Xfanout390 wire400/Z _2192_/A2 VDD VDD VSS VSS gf180mcu_fd_sc_mcu7t5v0__dlyb_1
XTAP_TAPCELL_ROW_29_483 VDD VSS gf180mcu_fd_sc_mcu7t5v0__filltie
X_2980_ _2980_/I _3113_/A1 VDD VDD VSS VSS gf180mcu_fd_sc_mcu7t5v0__clkinv_1
XFILLER_14_171 VDD VDD VSS VSS gf180mcu_fd_sc_mcu7t5v0__fillcap_4
XFILLER_42_480 VDD VDD VSS VSS gf180mcu_fd_sc_mcu7t5v0__fillcap_4
X_1931_ wire483/Z _3056_/ZN _1931_/B1 _3718_/Q _1932_/I VDD VDD VSS VSS gf180mcu_fd_sc_mcu7t5v0__aoi22_1
X_1862_ _1834_/Z _1848_/Z _1865_/B VDD VDD VSS VSS gf180mcu_fd_sc_mcu7t5v0__nor2_1
Xinput21 cfg_phase0_offset[11] _2978_/I VDD VDD VSS VSS gf180mcu_fd_sc_mcu7t5v0__buf_1
Xinput10 cfg_f_MEMS_fcw[1] input10/Z VDD VDD VSS VSS gf180mcu_fd_sc_mcu7t5v0__buf_1
X_3601_ _3601_/A1 _3601_/A2 _3601_/B _3603_/A2 VDD VDD VSS VSS gf180mcu_fd_sc_mcu7t5v0__oai21_1
Xinput32 cfg_phase0_offset[2] input32/Z VDD VDD VSS VSS gf180mcu_fd_sc_mcu7t5v0__buf_1
Xinput43 cfg_phase270_offset[12] input43/Z VDD VDD VSS VSS gf180mcu_fd_sc_mcu7t5v0__buf_1
Xinput54 cfg_phase270_offset[3] input54/Z VDD VDD VSS VSS gf180mcu_fd_sc_mcu7t5v0__buf_1
Xinput76 cfg_phase90_offset[4] input76/Z VDD VDD VSS VSS gf180mcu_fd_sc_mcu7t5v0__buf_1
Xinput65 cfg_phase90_offset[13] input65/Z VDD VDD VSS VSS gf180mcu_fd_sc_mcu7t5v0__buf_1
X_3532_ _3702_/Q _3065_/I _3532_/Z VDD VDD VSS VSS gf180mcu_fd_sc_mcu7t5v0__xor2_1
XFILLER_6_392 VDD VDD VSS VSS gf180mcu_fd_sc_mcu7t5v0__fillcap_32
X_3463_ _3464_/A1 _3444_/Z _3463_/B _3545_/A2 VDD VDD VSS VSS gf180mcu_fd_sc_mcu7t5v0__oai21_1
X_2414_ _2984_/I _2414_/A2 _2414_/A3 _2414_/Z VDD VDD VSS VSS gf180mcu_fd_sc_mcu7t5v0__xor3_1
X_3394_ wire515/Z _3406_/A1 _3391_/Z _3394_/Z VDD VDD VSS VSS gf180mcu_fd_sc_mcu7t5v0__xor3_2
X_2345_ _2148_/C wire622/Z _2346_/I VDD VDD VSS VSS gf180mcu_fd_sc_mcu7t5v0__xor2_1
X_2276_ _3723_/Q wire255/Z _2277_/B VDD VDD VSS VSS gf180mcu_fd_sc_mcu7t5v0__nand2_1
XFILLER_65_550 VDD VDD VSS VSS gf180mcu_fd_sc_mcu7t5v0__fill_1
XFILLER_25_414 VDD VDD VSS VSS gf180mcu_fd_sc_mcu7t5v0__fill_2
XTAP_TAPCELL_ROW_55_729 VDD VSS gf180mcu_fd_sc_mcu7t5v0__filltie
XFILLER_52_244 VDD VDD VSS VSS gf180mcu_fd_sc_mcu7t5v0__fill_1
XFILLER_80_597 VDD VDD VSS VSS gf180mcu_fd_sc_mcu7t5v0__fill_1
XFILLER_21_620 VDD VDD VSS VSS gf180mcu_fd_sc_mcu7t5v0__fillcap_4
XFILLER_33_480 VDD VDD VSS VSS gf180mcu_fd_sc_mcu7t5v0__fill_1
XFILLER_40_439 VDD VDD VSS VSS gf180mcu_fd_sc_mcu7t5v0__fillcap_4
XFILLER_32_37 VDD VDD VSS VSS gf180mcu_fd_sc_mcu7t5v0__fillcap_64
XFILLER_4_329 VDD VDD VSS VSS gf180mcu_fd_sc_mcu7t5v0__fill_2
XFILLER_0_546 VDD VDD VSS VSS gf180mcu_fd_sc_mcu7t5v0__fillcap_16
XFILLER_88_675 VDD VDD VSS VSS gf180mcu_fd_sc_mcu7t5v0__fill_2
XFILLER_90_317 VDD VDD VSS VSS gf180mcu_fd_sc_mcu7t5v0__fillcap_64
XFILLER_16_403 VDD VDD VSS VSS gf180mcu_fd_sc_mcu7t5v0__fillcap_4
XFILLER_56_583 VDD VDD VSS VSS gf180mcu_fd_sc_mcu7t5v0__fill_2
XTAP_TAPCELL_ROW_26_453 VDD VSS gf180mcu_fd_sc_mcu7t5v0__filltie
XFILLER_73_66 VDD VDD VSS VSS gf180mcu_fd_sc_mcu7t5v0__fillcap_4
XFILLER_71_597 VDD VDD VSS VSS gf180mcu_fd_sc_mcu7t5v0__fill_1
XFILLER_8_613 VDD VDD VSS VSS gf180mcu_fd_sc_mcu7t5v0__fill_2
XFILLER_12_675 VDD VDD VSS VSS gf180mcu_fd_sc_mcu7t5v0__fill_2
XFILLER_8_624 VDD VDD VSS VSS gf180mcu_fd_sc_mcu7t5v0__fillcap_4
XFILLER_3_384 VDD VDD VSS VSS gf180mcu_fd_sc_mcu7t5v0__fill_2
XFILLER_79_675 VDD VDD VSS VSS gf180mcu_fd_sc_mcu7t5v0__fill_2
XFILLER_39_506 VDD VDD VSS VSS gf180mcu_fd_sc_mcu7t5v0__fill_2
X_2130_ _3626_/A2 _2211_/A2 _2211_/B VDD VDD VSS VSS gf180mcu_fd_sc_mcu7t5v0__nand2_1
XFILLER_94_667 VDD VDD VSS VSS gf180mcu_fd_sc_mcu7t5v0__fillcap_8
X_2061_ _2059_/Z _2063_/A3 _2061_/Z VDD VDD VSS VSS gf180mcu_fd_sc_mcu7t5v0__xor2_1
XFILLER_34_222 VDD VDD VSS VSS gf180mcu_fd_sc_mcu7t5v0__fillcap_16
XFILLER_34_244 VDD VDD VSS VSS gf180mcu_fd_sc_mcu7t5v0__fill_1
X_2963_ _2963_/A1 _2963_/A2 _2963_/B _3719_/D VDD VDD VSS VSS gf180mcu_fd_sc_mcu7t5v0__oai21_1
XFILLER_62_597 VDD VDD VSS VSS gf180mcu_fd_sc_mcu7t5v0__fill_2
X_1914_ wire483/Z _1954_/A1 _1914_/Z VDD VDD VSS VSS gf180mcu_fd_sc_mcu7t5v0__xor2_1
X_2894_ _3688_/Q _2894_/A2 _2894_/B _2895_/B2 VDD VDD VSS VSS gf180mcu_fd_sc_mcu7t5v0__oai21_1
XTAP_TAPCELL_ROW_60_776 VDD VSS gf180mcu_fd_sc_mcu7t5v0__filltie
X_1845_ _1857_/B1 _1845_/A2 _1846_/A2 VDD VDD VSS VSS gf180mcu_fd_sc_mcu7t5v0__nor2_1
X_3515_ _3483_/Z _3500_/Z _3518_/A3 VDD VDD VSS VSS gf180mcu_fd_sc_mcu7t5v0__nand2_1
X_3446_ _3444_/Z _3446_/A2 _3446_/ZN VDD VDD VSS VSS gf180mcu_fd_sc_mcu7t5v0__nor2_1
X_3377_ _3670_/Q _3375_/Z _3397_/A2 VDD VDD VSS VSS gf180mcu_fd_sc_mcu7t5v0__nand2_1
X_2328_ _2315_/Z _2407_/A2 _2328_/Z VDD VDD VSS VSS gf180mcu_fd_sc_mcu7t5v0__and2_1
Xload_slew560 _3761_/RN wire559/I VDD VDD VSS VSS gf180mcu_fd_sc_mcu7t5v0__clkbuf_1
Xload_slew571 _3736_/RN _3667_/RN VDD VDD VSS VSS gf180mcu_fd_sc_mcu7t5v0__buf_1
Xload_slew582 _3723_/RN _3703_/RN VDD VDD VSS VSS gf180mcu_fd_sc_mcu7t5v0__clkbuf_1
Xload_slew593 _3751_/RN _3774_/RN VDD VDD VSS VSS gf180mcu_fd_sc_mcu7t5v0__clkbuf_2
XTAP_TAPCELL_ROW_68_854 VDD VSS gf180mcu_fd_sc_mcu7t5v0__filltie
XFILLER_84_177 VDD VDD VSS VSS gf180mcu_fd_sc_mcu7t5v0__fillcap_64
X_2259_ _2259_/A1 _2259_/A2 _2260_/C VDD VDD VSS VSS gf180mcu_fd_sc_mcu7t5v0__nand2_1
XFILLER_80_361 VDD VDD VSS VSS gf180mcu_fd_sc_mcu7t5v0__fillcap_4
XFILLER_53_586 VDD VDD VSS VSS gf180mcu_fd_sc_mcu7t5v0__fill_2
XTAP_TAPCELL_ROW_23_423 VDD VSS gf180mcu_fd_sc_mcu7t5v0__filltie
XFILLER_40_247 VDD VDD VSS VSS gf180mcu_fd_sc_mcu7t5v0__fillcap_16
XFILLER_4_115 VDD VDD VSS VSS gf180mcu_fd_sc_mcu7t5v0__fill_2
XFILLER_4_126 VDD VDD VSS VSS gf180mcu_fd_sc_mcu7t5v0__fillcap_32
XFILLER_0_376 VDD VDD VSS VSS gf180mcu_fd_sc_mcu7t5v0__fillcap_32
XFILLER_76_667 VDD VDD VSS VSS gf180mcu_fd_sc_mcu7t5v0__fill_2
XFILLER_91_626 VDD VDD VSS VSS gf180mcu_fd_sc_mcu7t5v0__fillcap_4
XTAP_TAPCELL_ROW_89_1056 VDD VSS gf180mcu_fd_sc_mcu7t5v0__filltie
XFILLER_63_339 VDD VDD VSS VSS gf180mcu_fd_sc_mcu7t5v0__fill_1
XFILLER_44_553 VDD VDD VSS VSS gf180mcu_fd_sc_mcu7t5v0__fill_1
XFILLER_16_299 VDD VDD VSS VSS gf180mcu_fd_sc_mcu7t5v0__fillcap_4
XFILLER_44_597 VDD VDD VSS VSS gf180mcu_fd_sc_mcu7t5v0__fillcap_4
X_3300_ _3303_/A1 _3251_/C _3302_/A2 _3301_/A3 VDD VDD VSS VSS gf180mcu_fd_sc_mcu7t5v0__nand3_1
X_3231_ _3237_/B _3254_/A1 _3231_/Z VDD VDD VSS VSS gf180mcu_fd_sc_mcu7t5v0__xor2_1
XFILLER_79_472 VDD VDD VSS VSS gf180mcu_fd_sc_mcu7t5v0__fill_1
X_3162_ _3163_/A1 _3163_/A2 _3162_/B _3170_/C VDD VDD VSS VSS gf180mcu_fd_sc_mcu7t5v0__aoi21_1
X_2113_ _3709_/Q _2113_/A2 _2113_/A3 _2113_/ZN VDD VDD VSS VSS gf180mcu_fd_sc_mcu7t5v0__xnor3_2
XFILLER_12_2 VDD VDD VSS VSS gf180mcu_fd_sc_mcu7t5v0__fillcap_32
XFILLER_82_615 VDD VDD VSS VSS gf180mcu_fd_sc_mcu7t5v0__fill_1
X_3093_ _3664_/Q _3093_/ZN VDD VDD VSS VSS gf180mcu_fd_sc_mcu7t5v0__clkinv_1
XTAP_TAPCELL_ROW_65_824 VDD VSS gf180mcu_fd_sc_mcu7t5v0__filltie
XFILLER_66_166 VDD VDD VSS VSS gf180mcu_fd_sc_mcu7t5v0__fill_1
XFILLER_66_177 VDD VDD VSS VSS gf180mcu_fd_sc_mcu7t5v0__fillcap_32
XFILLER_81_136 VDD VDD VSS VSS gf180mcu_fd_sc_mcu7t5v0__fillcap_4
X_2044_ _2044_/A1 _2008_/I _2044_/B _2048_/A2 VDD VDD VSS VSS gf180mcu_fd_sc_mcu7t5v0__oai21_1
XFILLER_47_391 VDD VDD VSS VSS gf180mcu_fd_sc_mcu7t5v0__fillcap_8
XFILLER_54_339 VDD VDD VSS VSS gf180mcu_fd_sc_mcu7t5v0__fill_1
XTAP_TAPCELL_ROW_37_559 VDD VSS gf180mcu_fd_sc_mcu7t5v0__filltie
XFILLER_50_501 VDD VDD VSS VSS gf180mcu_fd_sc_mcu7t5v0__fillcap_16
XFILLER_22_247 VDD VDD VSS VSS gf180mcu_fd_sc_mcu7t5v0__fillcap_16
X_2946_ _3781_/I _2948_/A2 _2947_/B VDD VDD VSS VSS gf180mcu_fd_sc_mcu7t5v0__nand2_1
X_2877_ _3571_/A1 _2877_/A2 _2877_/B1 _2877_/B2 _3682_/D VDD VDD VSS VSS gf180mcu_fd_sc_mcu7t5v0__oai22_1
X_1828_ _1830_/A1 _1827_/I _1829_/I VDD VDD VSS VSS gf180mcu_fd_sc_mcu7t5v0__nor2_2
X_3429_ _3429_/A1 _3443_/B1 _3427_/Z _3429_/ZN VDD VDD VSS VSS gf180mcu_fd_sc_mcu7t5v0__xnor3_1
XFILLER_58_667 VDD VDD VSS VSS gf180mcu_fd_sc_mcu7t5v0__fill_2
XTAP_TAPCELL_ROW_0_195 VDD VSS gf180mcu_fd_sc_mcu7t5v0__filltie
XFILLER_41_512 VDD VDD VSS VSS gf180mcu_fd_sc_mcu7t5v0__fillcap_4
XFILLER_9_218 VDD VDD VSS VSS gf180mcu_fd_sc_mcu7t5v0__fill_1
XFILLER_41_578 VDD VDD VSS VSS gf180mcu_fd_sc_mcu7t5v0__fill_2
XFILLER_70_34 VDD VDD VSS VSS gf180mcu_fd_sc_mcu7t5v0__fill_1
XFILLER_95_206 VDD VDD VSS VSS gf180mcu_fd_sc_mcu7t5v0__fillcap_4
XTAP_TAPCELL_ROW_8_284 VDD VSS gf180mcu_fd_sc_mcu7t5v0__filltie
XFILLER_48_155 VDD VDD VSS VSS gf180mcu_fd_sc_mcu7t5v0__fillcap_4
XFILLER_48_177 VDD VDD VSS VSS gf180mcu_fd_sc_mcu7t5v0__fillcap_4
XFILLER_17_520 VDD VDD VSS VSS gf180mcu_fd_sc_mcu7t5v0__fill_1
XFILLER_63_136 VDD VDD VSS VSS gf180mcu_fd_sc_mcu7t5v0__fillcap_4
XFILLER_32_523 VDD VDD VSS VSS gf180mcu_fd_sc_mcu7t5v0__fill_2
XTAP_TAPCELL_ROW_34_529 VDD VSS gf180mcu_fd_sc_mcu7t5v0__filltie
X_2800_ _3094_/ZN _2831_/B _2805_/C VDD VDD VSS VSS gf180mcu_fd_sc_mcu7t5v0__nor2_1
X_3780_ _3780_/I _3780_/Z VDD VDD VSS VSS gf180mcu_fd_sc_mcu7t5v0__buf_1
XTAP_TAPCELL_ROW_70_871 VDD VSS gf180mcu_fd_sc_mcu7t5v0__filltie
X_2731_ wire525/Z _2683_/Z _2731_/B _2731_/C _2732_/C VDD VDD VSS VSS gf180mcu_fd_sc_mcu7t5v0__oai211_1
X_2662_ _2663_/B _2663_/C _2685_/A3 VDD VDD VSS VSS gf180mcu_fd_sc_mcu7t5v0__nor2_1
X_2593_ _2593_/A1 _2593_/A2 _2593_/A3 _2609_/A1 VDD VDD VSS VSS gf180mcu_fd_sc_mcu7t5v0__nand3_1
X_3214_ _3214_/I _3217_/A3 VDD VDD VSS VSS gf180mcu_fd_sc_mcu7t5v0__clkinv_1
Xclkbuf_4_7_0_clk clkbuf_0_clk/Z clkload6/I VDD VDD VSS VSS gf180mcu_fd_sc_mcu7t5v0__clkbuf_8
XFILLER_39_122 VDD VDD VSS VSS gf180mcu_fd_sc_mcu7t5v0__fill_1
X_3145_ _3146_/A1 _3712_/Q _3147_/A2 VDD VDD VSS VSS gf180mcu_fd_sc_mcu7t5v0__nor2_1
X_3076_ _3708_/Q _3627_/A1 VDD VDD VSS VSS gf180mcu_fd_sc_mcu7t5v0__inv_2
X_2027_ _2028_/A1 _2028_/A2 _2028_/B _2027_/Z VDD VDD VSS VSS gf180mcu_fd_sc_mcu7t5v0__or3_1
XFILLER_54_147 VDD VDD VSS VSS gf180mcu_fd_sc_mcu7t5v0__fill_2
XFILLER_23_578 VDD VDD VSS VSS gf180mcu_fd_sc_mcu7t5v0__fillcap_4
XFILLER_50_375 VDD VDD VSS VSS gf180mcu_fd_sc_mcu7t5v0__fill_2
X_2929_ _2929_/A1 _2935_/A2 _2929_/B _3702_/D VDD VDD VSS VSS gf180mcu_fd_sc_mcu7t5v0__oai21_1
XFILLER_40_37 VDD VDD VSS VSS gf180mcu_fd_sc_mcu7t5v0__fillcap_64
XFILLER_77_206 VDD VDD VSS VSS gf180mcu_fd_sc_mcu7t5v0__fillcap_4
XTAP_TAPCELL_ROW_5_254 VDD VSS gf180mcu_fd_sc_mcu7t5v0__filltie
XFILLER_58_453 VDD VDD VSS VSS gf180mcu_fd_sc_mcu7t5v0__fill_2
XTAP_TAPCELL_ROW_86_1026 VDD VSS gf180mcu_fd_sc_mcu7t5v0__filltie
XFILLER_18_339 VDD VDD VSS VSS gf180mcu_fd_sc_mcu7t5v0__fillcap_4
XFILLER_61_607 VDD VDD VSS VSS gf180mcu_fd_sc_mcu7t5v0__fill_1
XFILLER_73_489 VDD VDD VSS VSS gf180mcu_fd_sc_mcu7t5v0__fill_1
XFILLER_81_66 VDD VDD VSS VSS gf180mcu_fd_sc_mcu7t5v0__fillcap_4
Xinput8 cfg_f_MEMS_fcw[14] input8/Z VDD VDD VSS VSS gf180mcu_fd_sc_mcu7t5v0__clkbuf_3
XFILLER_49_475 VDD VDD VSS VSS gf180mcu_fd_sc_mcu7t5v0__fill_1
XFILLER_49_464 VDD VDD VSS VSS gf180mcu_fd_sc_mcu7t5v0__fill_2
XFILLER_36_103 VDD VDD VSS VSS gf180mcu_fd_sc_mcu7t5v0__fill_2
XFILLER_36_147 VDD VDD VSS VSS gf180mcu_fd_sc_mcu7t5v0__fillcap_4
XTAP_TAPCELL_ROW_47_654 VDD VSS gf180mcu_fd_sc_mcu7t5v0__filltie
XFILLER_64_467 VDD VDD VSS VSS gf180mcu_fd_sc_mcu7t5v0__fill_1
XFILLER_64_478 VDD VDD VSS VSS gf180mcu_fd_sc_mcu7t5v0__fill_2
XTAP_TAPCELL_ROW_19_389 VDD VSS gf180mcu_fd_sc_mcu7t5v0__filltie
X_3763_ _3763_/D _3763_/RN clkload3/I _3763_/Q VDD VDD VSS VSS gf180mcu_fd_sc_mcu7t5v0__dffrnq_1
X_2714_ _3168_/A1 _2698_/Z _2699_/Z _3170_/A1 _2716_/B2 VDD VDD VSS VSS gf180mcu_fd_sc_mcu7t5v0__oai22_1
X_3694_ _3694_/D wire616/Z _3694_/CLK _3694_/Q VDD VDD VSS VSS gf180mcu_fd_sc_mcu7t5v0__dffrnq_2
X_2645_ _2645_/A1 input60/Z _2645_/Z VDD VDD VSS VSS gf180mcu_fd_sc_mcu7t5v0__xor2_1
X_2576_ _2576_/A1 _2576_/A2 _2576_/B _2578_/B2 VDD VDD VSS VSS gf180mcu_fd_sc_mcu7t5v0__aoi21_1
XFILLER_87_548 VDD VDD VSS VSS gf180mcu_fd_sc_mcu7t5v0__fill_1
XTAP_TAPCELL_ROW_2_224 VDD VSS gf180mcu_fd_sc_mcu7t5v0__filltie
X_3128_ _2675_/C _2972_/I _2211_/C input29/Z _3128_/C _3131_/A2 VDD VDD VSS VSS gf180mcu_fd_sc_mcu7t5v0__aoi221_1
XFILLER_67_294 VDD VDD VSS VSS gf180mcu_fd_sc_mcu7t5v0__fillcap_4
XFILLER_27_136 VDD VDD VSS VSS gf180mcu_fd_sc_mcu7t5v0__fillcap_4
XFILLER_55_489 VDD VDD VSS VSS gf180mcu_fd_sc_mcu7t5v0__fill_1
X_3059_ _3678_/Q _3506_/A1 VDD VDD VSS VSS gf180mcu_fd_sc_mcu7t5v0__clkinv_1
XFILLER_42_128 VDD VDD VSS VSS gf180mcu_fd_sc_mcu7t5v0__fillcap_32
XFILLER_70_437 VDD VDD VSS VSS gf180mcu_fd_sc_mcu7t5v0__fillcap_8
XTAP_TAPCELL_ROW_81_977 VDD VSS gf180mcu_fd_sc_mcu7t5v0__filltie
Xwire439 _2356_/C wire439/Z VDD VDD VSS VSS gf180mcu_fd_sc_mcu7t5v0__buf_1
Xwire428 wire428/I wire428/Z VDD VDD VSS VSS gf180mcu_fd_sc_mcu7t5v0__buf_1
XTAP_TAPCELL_ROW_92_1085 VDD VSS gf180mcu_fd_sc_mcu7t5v0__filltie
XFILLER_78_515 VDD VDD VSS VSS gf180mcu_fd_sc_mcu7t5v0__fillcap_8
Xfanout583 fanout583/I wire586/I VDD VDD VSS VSS gf180mcu_fd_sc_mcu7t5v0__dlyb_1
XFILLER_65_209 VDD VDD VSS VSS gf180mcu_fd_sc_mcu7t5v0__fill_1
XFILLER_33_139 VDD VDD VSS VSS gf180mcu_fd_sc_mcu7t5v0__fill_1
XTAP_TAPCELL_ROW_44_624 VDD VSS gf180mcu_fd_sc_mcu7t5v0__filltie
XFILLER_73_297 VDD VDD VSS VSS gf180mcu_fd_sc_mcu7t5v0__fill_1
XTAP_TAPCELL_ROW_16_359 VDD VSS gf180mcu_fd_sc_mcu7t5v0__filltie
XFILLER_10_592 VDD VDD VSS VSS gf180mcu_fd_sc_mcu7t5v0__fill_2
X_2430_ _2353_/Z _2430_/A2 _2430_/Z VDD VDD VSS VSS gf180mcu_fd_sc_mcu7t5v0__xor2_1
X_2361_ _3235_/A1 _3757_/Q _3243_/ZN _2444_/A4 _2361_/Z VDD VDD VSS VSS gf180mcu_fd_sc_mcu7t5v0__and4_1
X_2292_ _2743_/A2 _2939_/A1 _2292_/B _3728_/D VDD VDD VSS VSS gf180mcu_fd_sc_mcu7t5v0__oai21_1
XFILLER_1_290 VDD VDD VSS VSS gf180mcu_fd_sc_mcu7t5v0__fillcap_32
XFILLER_25_629 VDD VDD VSS VSS gf180mcu_fd_sc_mcu7t5v0__fill_1
XFILLER_52_415 VDD VDD VSS VSS gf180mcu_fd_sc_mcu7t5v0__fillcap_8
XFILLER_52_437 VDD VDD VSS VSS gf180mcu_fd_sc_mcu7t5v0__fillcap_4
X_3746_ _3746_/D _3764_/RN clkload9/I _3746_/Q VDD VDD VSS VSS gf180mcu_fd_sc_mcu7t5v0__dffrnq_1
X_3677_ _3677_/D _3677_/RN _3774_/CLK _3677_/Q VDD VDD VSS VSS gf180mcu_fd_sc_mcu7t5v0__dffrnq_2
Xoutput120 _2110_/ZN cal_phase270_offset[19] VDD VDD VSS VSS gf180mcu_fd_sc_mcu7t5v0__buf_2
X_2628_ _3100_/C input40/Z _2628_/B _2706_/B VDD VDD VSS VSS gf180mcu_fd_sc_mcu7t5v0__oai21_1
Xoutput142 _3367_/ZN cal_phase90_offset[1] VDD VDD VSS VSS gf180mcu_fd_sc_mcu7t5v0__buf_2
Xoutput131 _2116_/ZN cal_phase90_offset[0] VDD VDD VSS VSS gf180mcu_fd_sc_mcu7t5v0__buf_2
X_2559_ _2560_/A1 _2560_/A2 _2560_/B _2559_/Z VDD VDD VSS VSS gf180mcu_fd_sc_mcu7t5v0__and3_1
Xoutput164 _3764_/Q mems_drv VDD VDD VSS VSS gf180mcu_fd_sc_mcu7t5v0__buf_2
Xoutput153 _3660_/Q delay_wave_cycle[0] VDD VDD VSS VSS gf180mcu_fd_sc_mcu7t5v0__buf_2
Xoutput186 _3689_/Q raw_edge2[0] VDD VDD VSS VSS gf180mcu_fd_sc_mcu7t5v0__buf_2
Xoutput175 _3687_/Q raw_edge1[19] VDD VDD VSS VSS gf180mcu_fd_sc_mcu7t5v0__buf_2
Xoutput197 _3041_/I raw_edge2[1] VDD VDD VSS VSS gf180mcu_fd_sc_mcu7t5v0__buf_2
XFILLER_68_581 VDD VDD VSS VSS gf180mcu_fd_sc_mcu7t5v0__fillcap_4
XFILLER_83_562 VDD VDD VSS VSS gf180mcu_fd_sc_mcu7t5v0__fillcap_8
XFILLER_70_267 VDD VDD VSS VSS gf180mcu_fd_sc_mcu7t5v0__fill_2
XTAP_TAPCELL_ROW_13_329 VDD VSS gf180mcu_fd_sc_mcu7t5v0__filltie
XFILLER_51_492 VDD VDD VSS VSS gf180mcu_fd_sc_mcu7t5v0__fillcap_32
XFILLER_11_334 VDD VDD VSS VSS gf180mcu_fd_sc_mcu7t5v0__fillcap_16
XTAP_TAPCELL_ROW_94_1103 VDD VSS gf180mcu_fd_sc_mcu7t5v0__filltie
Xwire258 wire258/I wire258/Z VDD VDD VSS VSS gf180mcu_fd_sc_mcu7t5v0__clkbuf_2
Xwire269 wire269/I wire269/Z VDD VDD VSS VSS gf180mcu_fd_sc_mcu7t5v0__clkbuf_2
XFILLER_11_72 VDD VDD VSS VSS gf180mcu_fd_sc_mcu7t5v0__fillcap_64
XFILLER_38_209 VDD VDD VSS VSS gf180mcu_fd_sc_mcu7t5v0__fillcap_4
XFILLER_66_518 VDD VDD VSS VSS gf180mcu_fd_sc_mcu7t5v0__fillcap_4
XFILLER_74_551 VDD VDD VSS VSS gf180mcu_fd_sc_mcu7t5v0__fill_1
XFILLER_19_489 VDD VDD VSS VSS gf180mcu_fd_sc_mcu7t5v0__fill_1
XTAP_TAPCELL_ROW_29_484 VDD VSS gf180mcu_fd_sc_mcu7t5v0__filltie
XFILLER_34_437 VDD VDD VSS VSS gf180mcu_fd_sc_mcu7t5v0__fillcap_4
XFILLER_61_212 VDD VDD VSS VSS gf180mcu_fd_sc_mcu7t5v0__fill_2
XFILLER_30_621 VDD VDD VSS VSS gf180mcu_fd_sc_mcu7t5v0__fill_2
X_1930_ _3697_/Q _1914_/Z _1931_/B1 VDD VDD VSS VSS gf180mcu_fd_sc_mcu7t5v0__nor2_1
XFILLER_42_492 VDD VDD VSS VSS gf180mcu_fd_sc_mcu7t5v0__fill_1
X_1861_ _3716_/Q _3415_/A1 _1877_/B VDD VDD VSS VSS gf180mcu_fd_sc_mcu7t5v0__nand2_1
X_3600_ _3071_/I _3598_/Z _3600_/Z VDD VDD VSS VSS gf180mcu_fd_sc_mcu7t5v0__xor2_1
Xinput11 cfg_f_MEMS_fcw[2] input11/Z VDD VDD VSS VSS gf180mcu_fd_sc_mcu7t5v0__buf_2
Xinput22 cfg_phase0_offset[12] input22/Z VDD VDD VSS VSS gf180mcu_fd_sc_mcu7t5v0__buf_1
Xinput33 cfg_phase0_offset[3] input33/Z VDD VDD VSS VSS gf180mcu_fd_sc_mcu7t5v0__buf_1
Xinput55 cfg_phase270_offset[4] input55/Z VDD VDD VSS VSS gf180mcu_fd_sc_mcu7t5v0__buf_1
Xinput44 cfg_phase270_offset[13] input44/Z VDD VDD VSS VSS gf180mcu_fd_sc_mcu7t5v0__buf_2
X_3531_ _3531_/A1 _3531_/A2 _3531_/Z VDD VDD VSS VSS gf180mcu_fd_sc_mcu7t5v0__xor2_2
Xinput66 cfg_phase90_offset[14] _3019_/I VDD VDD VSS VSS gf180mcu_fd_sc_mcu7t5v0__buf_1
Xinput77 cfg_phase90_offset[5] _3025_/I VDD VDD VSS VSS gf180mcu_fd_sc_mcu7t5v0__buf_1
X_3462_ _3448_/I _3460_/Z _3463_/B VDD VDD VSS VSS gf180mcu_fd_sc_mcu7t5v0__xnor2_1
X_2413_ _2413_/A1 _2415_/A2 _2412_/Z wire368/I _3747_/D VDD VDD VSS VSS gf180mcu_fd_sc_mcu7t5v0__oai22_1
XFILLER_42_2 VDD VDD VSS VSS gf180mcu_fd_sc_mcu7t5v0__fillcap_32
X_3393_ wire660/Z _3391_/Z _3393_/Z VDD VDD VSS VSS gf180mcu_fd_sc_mcu7t5v0__and2_1
X_2344_ _3753_/Q wire622/Z _2429_/A1 VDD VDD VSS VSS gf180mcu_fd_sc_mcu7t5v0__nand2_1
XFILLER_69_378 VDD VDD VSS VSS gf180mcu_fd_sc_mcu7t5v0__fill_2
X_2275_ _2354_/A1 _2445_/A1 _2929_/A1 VDD VDD VSS VSS gf180mcu_fd_sc_mcu7t5v0__nand2_1
XFILLER_92_381 VDD VDD VSS VSS gf180mcu_fd_sc_mcu7t5v0__fillcap_4
XFILLER_80_543 VDD VDD VSS VSS gf180mcu_fd_sc_mcu7t5v0__fillcap_8
XFILLER_37_286 VDD VDD VSS VSS gf180mcu_fd_sc_mcu7t5v0__fillcap_4
XFILLER_21_632 VDD VDD VSS VSS gf180mcu_fd_sc_mcu7t5v0__fill_1
X_3729_ _3729_/D _3729_/RN clkload3/I _3729_/Q VDD VDD VSS VSS gf180mcu_fd_sc_mcu7t5v0__dffrnq_2
XFILLER_87_142 VDD VDD VSS VSS gf180mcu_fd_sc_mcu7t5v0__fillcap_64
XFILLER_56_551 VDD VDD VSS VSS gf180mcu_fd_sc_mcu7t5v0__fillcap_4
XFILLER_16_459 VDD VDD VSS VSS gf180mcu_fd_sc_mcu7t5v0__fill_1
XTAP_TAPCELL_ROW_26_454 VDD VSS gf180mcu_fd_sc_mcu7t5v0__filltie
XFILLER_43_267 VDD VDD VSS VSS gf180mcu_fd_sc_mcu7t5v0__fill_1
XFILLER_31_418 VDD VDD VSS VSS gf180mcu_fd_sc_mcu7t5v0__fill_2
XFILLER_11_142 VDD VDD VSS VSS gf180mcu_fd_sc_mcu7t5v0__fillcap_64
XFILLER_3_352 VDD VDD VSS VSS gf180mcu_fd_sc_mcu7t5v0__fill_2
X_2060_ _3726_/Q _3581_/A1 _2060_/B _2063_/A3 VDD VDD VSS VSS gf180mcu_fd_sc_mcu7t5v0__aoi21_1
XFILLER_47_551 VDD VDD VSS VSS gf180mcu_fd_sc_mcu7t5v0__fill_2
XFILLER_47_562 VDD VDD VSS VSS gf180mcu_fd_sc_mcu7t5v0__fillcap_16
XFILLER_19_286 VDD VDD VSS VSS gf180mcu_fd_sc_mcu7t5v0__fill_1
XFILLER_62_532 VDD VDD VSS VSS gf180mcu_fd_sc_mcu7t5v0__fill_2
XFILLER_74_370 VDD VDD VSS VSS gf180mcu_fd_sc_mcu7t5v0__fillcap_8
XFILLER_22_407 VDD VDD VSS VSS gf180mcu_fd_sc_mcu7t5v0__fill_2
X_2962_ _3719_/Q _2963_/A1 _2963_/B VDD VDD VSS VSS gf180mcu_fd_sc_mcu7t5v0__nand2_1
X_1913_ _1960_/A1 _1960_/A2 _1942_/A1 VDD VDD VSS VSS gf180mcu_fd_sc_mcu7t5v0__nor2_1
XFILLER_15_492 VDD VDD VSS VSS gf180mcu_fd_sc_mcu7t5v0__fillcap_8
X_2893_ wire408/I _2893_/A2 _2895_/B1 VDD VDD VSS VSS gf180mcu_fd_sc_mcu7t5v0__nor2_1
XTAP_TAPCELL_ROW_60_777 VDD VSS gf180mcu_fd_sc_mcu7t5v0__filltie
X_1844_ _1857_/A1 _1824_/Z _1841_/Z _1845_/A2 VDD VDD VSS VSS gf180mcu_fd_sc_mcu7t5v0__nor3_1
X_3514_ _3509_/Z _3530_/A2 _3514_/Z VDD VDD VSS VSS gf180mcu_fd_sc_mcu7t5v0__xor2_2
X_3445_ _3445_/A1 _3445_/A2 _3445_/B _3446_/A2 VDD VDD VSS VSS gf180mcu_fd_sc_mcu7t5v0__aoi21_1
X_3376_ _3670_/Q _3375_/Z _3376_/Z VDD VDD VSS VSS gf180mcu_fd_sc_mcu7t5v0__and2_1
XFILLER_69_142 VDD VDD VSS VSS gf180mcu_fd_sc_mcu7t5v0__fillcap_64
XFILLER_84_101 VDD VDD VSS VSS gf180mcu_fd_sc_mcu7t5v0__fillcap_4
Xload_slew561 _3767_/RN _3761_/RN VDD VDD VSS VSS gf180mcu_fd_sc_mcu7t5v0__clkbuf_2
X_2327_ _2404_/A3 _2327_/A2 _2327_/B _2407_/A2 VDD VDD VSS VSS gf180mcu_fd_sc_mcu7t5v0__oai21_1
Xload_slew572 _3735_/RN _3738_/RN VDD VDD VSS VSS gf180mcu_fd_sc_mcu7t5v0__clkbuf_2
X_2258_ _2210_/B _2212_/I _2259_/A2 VDD VDD VSS VSS gf180mcu_fd_sc_mcu7t5v0__nand2_1
XFILLER_57_348 VDD VDD VSS VSS gf180mcu_fd_sc_mcu7t5v0__fill_2
XTAP_TAPCELL_ROW_68_855 VDD VSS gf180mcu_fd_sc_mcu7t5v0__filltie
XFILLER_38_551 VDD VDD VSS VSS gf180mcu_fd_sc_mcu7t5v0__fill_1
XFILLER_25_212 VDD VDD VSS VSS gf180mcu_fd_sc_mcu7t5v0__fillcap_8
X_2189_ _2422_/A1 _2189_/A2 _2190_/I VDD VDD VSS VSS gf180mcu_fd_sc_mcu7t5v0__nand2_1
XFILLER_80_395 VDD VDD VSS VSS gf180mcu_fd_sc_mcu7t5v0__fill_1
XFILLER_80_384 VDD VDD VSS VSS gf180mcu_fd_sc_mcu7t5v0__fill_1
XFILLER_40_215 VDD VDD VSS VSS gf180mcu_fd_sc_mcu7t5v0__fill_2
XTAP_TAPCELL_ROW_23_424 VDD VSS gf180mcu_fd_sc_mcu7t5v0__filltie
XFILLER_21_484 VDD VDD VSS VSS gf180mcu_fd_sc_mcu7t5v0__fillcap_4
XFILLER_68_34 VDD VDD VSS VSS gf180mcu_fd_sc_mcu7t5v0__fill_1
XFILLER_88_440 VDD VDD VSS VSS gf180mcu_fd_sc_mcu7t5v0__fill_1
XTAP_TAPCELL_ROW_89_1057 VDD VSS gf180mcu_fd_sc_mcu7t5v0__filltie
XFILLER_29_551 VDD VDD VSS VSS gf180mcu_fd_sc_mcu7t5v0__fillcap_8
XFILLER_29_562 VDD VDD VSS VSS gf180mcu_fd_sc_mcu7t5v0__fillcap_32
XFILLER_56_370 VDD VDD VSS VSS gf180mcu_fd_sc_mcu7t5v0__fillcap_8
XFILLER_12_473 VDD VDD VSS VSS gf180mcu_fd_sc_mcu7t5v0__fill_2
XFILLER_12_451 VDD VDD VSS VSS gf180mcu_fd_sc_mcu7t5v0__fillcap_4
XFILLER_4_661 VDD VDD VSS VSS gf180mcu_fd_sc_mcu7t5v0__fillcap_4
X_3230_ _3299_/B _3282_/A1 _3225_/Z _3286_/A1 VDD VDD VSS VSS gf180mcu_fd_sc_mcu7t5v0__nor3_1
X_3161_ _3161_/I _3162_/B VDD VDD VSS VSS gf180mcu_fd_sc_mcu7t5v0__clkinv_1
XFILLER_66_101 VDD VDD VSS VSS gf180mcu_fd_sc_mcu7t5v0__fillcap_4
X_2112_ _2109_/B _2108_/Z _2111_/Z _2112_/B2 _2112_/C _2113_/A3 VDD VDD VSS VSS gf180mcu_fd_sc_mcu7t5v0__aoi221_1
X_3092_ _3663_/Q _3092_/ZN VDD VDD VSS VSS gf180mcu_fd_sc_mcu7t5v0__clkinv_1
X_2043_ _2014_/B _2028_/B _2044_/B VDD VDD VSS VSS gf180mcu_fd_sc_mcu7t5v0__nor2_1
XTAP_TAPCELL_ROW_65_825 VDD VSS gf180mcu_fd_sc_mcu7t5v0__filltie
XFILLER_62_373 VDD VDD VSS VSS gf180mcu_fd_sc_mcu7t5v0__fillcap_4
XFILLER_62_395 VDD VDD VSS VSS gf180mcu_fd_sc_mcu7t5v0__fill_2
X_2945_ _2948_/A2 _2945_/A2 _2945_/B _3710_/D VDD VDD VSS VSS gf180mcu_fd_sc_mcu7t5v0__oai21_1
X_2876_ _3682_/Q wire233/Z _2885_/B _2877_/B2 VDD VDD VSS VSS gf180mcu_fd_sc_mcu7t5v0__oai21_1
X_1827_ _1827_/I _1831_/A2 VDD VDD VSS VSS gf180mcu_fd_sc_mcu7t5v0__clkinv_1
X_3428_ _3443_/B1 _3427_/Z _3445_/A1 VDD VDD VSS VSS gf180mcu_fd_sc_mcu7t5v0__nand2_1
X_3359_ _3360_/B _3361_/B VDD VDD VSS VSS gf180mcu_fd_sc_mcu7t5v0__clkinv_1
XFILLER_38_37 VDD VDD VSS VSS gf180mcu_fd_sc_mcu7t5v0__fillcap_64
Xload_slew391 _2192_/A2 _2183_/A2 VDD VDD VSS VSS gf180mcu_fd_sc_mcu7t5v0__clkbuf_2
Xload_slew380 _2255_/A1 _2748_/A1 VDD VDD VSS VSS gf180mcu_fd_sc_mcu7t5v0__buf_1
XFILLER_85_465 VDD VDD VSS VSS gf180mcu_fd_sc_mcu7t5v0__fillcap_16
XFILLER_45_307 VDD VDD VSS VSS gf180mcu_fd_sc_mcu7t5v0__fillcap_4
XTAP_TAPCELL_ROW_0_196 VDD VSS gf180mcu_fd_sc_mcu7t5v0__filltie
XFILLER_41_546 VDD VDD VSS VSS gf180mcu_fd_sc_mcu7t5v0__fill_1
XFILLER_79_66 VDD VDD VSS VSS gf180mcu_fd_sc_mcu7t5v0__fillcap_4
XTAP_TAPCELL_ROW_8_285 VDD VSS gf180mcu_fd_sc_mcu7t5v0__filltie
XFILLER_1_664 VDD VDD VSS VSS gf180mcu_fd_sc_mcu7t5v0__fillcap_8
XFILLER_48_101 VDD VDD VSS VSS gf180mcu_fd_sc_mcu7t5v0__fillcap_4
XFILLER_76_454 VDD VDD VSS VSS gf180mcu_fd_sc_mcu7t5v0__fill_1
XFILLER_36_329 VDD VDD VSS VSS gf180mcu_fd_sc_mcu7t5v0__fill_2
XFILLER_63_159 VDD VDD VSS VSS gf180mcu_fd_sc_mcu7t5v0__fillcap_8
XPHY_EDGE_ROW_4_Left_101 VDD VSS gf180mcu_fd_sc_mcu7t5v0__endcap
XTAP_TAPCELL_ROW_70_872 VDD VSS gf180mcu_fd_sc_mcu7t5v0__filltie
X_2730_ _2730_/A1 _2733_/C _2731_/C VDD VDD VSS VSS gf180mcu_fd_sc_mcu7t5v0__xnor2_1
X_2661_ _2661_/A1 _2661_/A2 _2661_/B _2663_/C VDD VDD VSS VSS gf180mcu_fd_sc_mcu7t5v0__aoi21_2
X_2592_ _3003_/I _2550_/Z _2592_/B1 _2592_/B2 _2593_/A3 VDD VDD VSS VSS gf180mcu_fd_sc_mcu7t5v0__oai22_1
X_3213_ _3213_/A1 _3206_/Z _3213_/A3 _3213_/B _3214_/I VDD VDD VSS VSS gf180mcu_fd_sc_mcu7t5v0__oai31_2
XTAP_TAPCELL_ROW_78_950 VDD VSS gf180mcu_fd_sc_mcu7t5v0__filltie
X_3144_ wire660/Z _3713_/Q _3146_/B VDD VDD VSS VSS gf180mcu_fd_sc_mcu7t5v0__xnor2_1
X_3075_ _3075_/I _3631_/A1 VDD VDD VSS VSS gf180mcu_fd_sc_mcu7t5v0__clkinv_1
X_2026_ _2028_/A1 _2028_/A2 _2030_/A3 VDD VDD VSS VSS gf180mcu_fd_sc_mcu7t5v0__nor2_1
XFILLER_82_457 VDD VDD VSS VSS gf180mcu_fd_sc_mcu7t5v0__fillcap_8
XPHY_EDGE_ROW_59_Left_156 VDD VSS gf180mcu_fd_sc_mcu7t5v0__endcap
X_2928_ _3702_/Q _2935_/A2 _2929_/B VDD VDD VSS VSS gf180mcu_fd_sc_mcu7t5v0__nand2_1
X_2859_ _3485_/A1 _2865_/A2 _2859_/B1 _2859_/B2 _3676_/D VDD VDD VSS VSS gf180mcu_fd_sc_mcu7t5v0__oai22_1
XPHY_EDGE_ROW_68_Left_165 VDD VSS gf180mcu_fd_sc_mcu7t5v0__endcap
XTAP_TAPCELL_ROW_5_255 VDD VSS gf180mcu_fd_sc_mcu7t5v0__filltie
XFILLER_58_410 VDD VDD VSS VSS gf180mcu_fd_sc_mcu7t5v0__fill_1
XTAP_TAPCELL_ROW_86_1027 VDD VSS gf180mcu_fd_sc_mcu7t5v0__filltie
XFILLER_46_649 VDD VDD VSS VSS gf180mcu_fd_sc_mcu7t5v0__fill_2
XFILLER_58_487 VDD VDD VSS VSS gf180mcu_fd_sc_mcu7t5v0__fillcap_4
XFILLER_58_498 VDD VDD VSS VSS gf180mcu_fd_sc_mcu7t5v0__fillcap_16
XPHY_EDGE_ROW_77_Left_174 VDD VSS gf180mcu_fd_sc_mcu7t5v0__endcap
XFILLER_60_107 VDD VDD VSS VSS gf180mcu_fd_sc_mcu7t5v0__fillcap_16
XFILLER_14_557 VDD VDD VSS VSS gf180mcu_fd_sc_mcu7t5v0__fill_2
XFILLER_14_535 VDD VDD VSS VSS gf180mcu_fd_sc_mcu7t5v0__fillcap_8
XFILLER_41_387 VDD VDD VSS VSS gf180mcu_fd_sc_mcu7t5v0__fill_1
XPHY_EDGE_ROW_86_Left_183 VDD VSS gf180mcu_fd_sc_mcu7t5v0__endcap
XFILLER_39_80 VDD VDD VSS VSS gf180mcu_fd_sc_mcu7t5v0__fillcap_4
XPHY_EDGE_ROW_95_Left_192 VDD VSS gf180mcu_fd_sc_mcu7t5v0__endcap
XTAP_TAPCELL_ROW_75_920 VDD VSS gf180mcu_fd_sc_mcu7t5v0__filltie
Xinput9 cfg_f_MEMS_fcw[15] input9/Z VDD VDD VSS VSS gf180mcu_fd_sc_mcu7t5v0__buf_2
XTAP_TAPCELL_ROW_47_655 VDD VSS gf180mcu_fd_sc_mcu7t5v0__filltie
XFILLER_64_457 VDD VDD VSS VSS gf180mcu_fd_sc_mcu7t5v0__fillcap_8
XFILLER_91_276 VDD VDD VSS VSS gf180mcu_fd_sc_mcu7t5v0__fillcap_4
XFILLER_20_527 VDD VDD VSS VSS gf180mcu_fd_sc_mcu7t5v0__fillcap_8
XFILLER_32_376 VDD VDD VSS VSS gf180mcu_fd_sc_mcu7t5v0__fillcap_8
X_3762_ _3762_/D wire586/Z clkload0/I _3762_/Q VDD VDD VSS VSS gf180mcu_fd_sc_mcu7t5v0__dffsnq_1
XFILLER_72_2 VDD VDD VSS VSS gf180mcu_fd_sc_mcu7t5v0__fillcap_32
X_2713_ _3170_/A1 _2699_/Z _2713_/B _2713_/C _2716_/B1 VDD VDD VSS VSS gf180mcu_fd_sc_mcu7t5v0__aoi211_1
X_3693_ _3693_/D _3715_/RN _3717_/CLK _3693_/Q VDD VDD VSS VSS gf180mcu_fd_sc_mcu7t5v0__dffrnq_2
X_2644_ _2649_/C _2649_/B _2644_/B _2693_/A1 VDD VDD VSS VSS gf180mcu_fd_sc_mcu7t5v0__aoi21_1
X_2575_ _3014_/I _2490_/B _2576_/A2 VDD VDD VSS VSS gf180mcu_fd_sc_mcu7t5v0__nand2_1
XTAP_TAPCELL_ROW_2_225 VDD VSS gf180mcu_fd_sc_mcu7t5v0__filltie
X_3127_ _2211_/C input29/Z _3133_/B VDD VDD VSS VSS gf180mcu_fd_sc_mcu7t5v0__nand2_1
X_3058_ _3058_/I _3483_/A1 VDD VDD VSS VSS gf180mcu_fd_sc_mcu7t5v0__clkinv_1
XFILLER_42_107 VDD VDD VSS VSS gf180mcu_fd_sc_mcu7t5v0__fillcap_8
X_2009_ _2044_/A1 _2008_/I _2017_/A2 VDD VDD VSS VSS gf180mcu_fd_sc_mcu7t5v0__nor2_1
XFILLER_35_192 VDD VDD VSS VSS gf180mcu_fd_sc_mcu7t5v0__fill_2
XTAP_TAPCELL_ROW_81_978 VDD VSS gf180mcu_fd_sc_mcu7t5v0__filltie
XFILLER_7_509 VDD VDD VSS VSS gf180mcu_fd_sc_mcu7t5v0__fillcap_8
Xwire429 _3758_/Q wire429/Z VDD VDD VSS VSS gf180mcu_fd_sc_mcu7t5v0__clkbuf_2
XFILLER_2_225 VDD VDD VSS VSS gf180mcu_fd_sc_mcu7t5v0__fillcap_8
XTAP_TAPCELL_ROW_92_1086 VDD VSS gf180mcu_fd_sc_mcu7t5v0__filltie
XFILLER_78_527 VDD VDD VSS VSS gf180mcu_fd_sc_mcu7t5v0__fillcap_8
XFILLER_76_34 VDD VDD VSS VSS gf180mcu_fd_sc_mcu7t5v0__fill_1
Xfanout551 _3767_/RN _3768_/RN VDD VDD VSS VSS gf180mcu_fd_sc_mcu7t5v0__dlyb_1
Xfanout562 _3779_/RN _3763_/RN VDD VDD VSS VSS gf180mcu_fd_sc_mcu7t5v0__dlyb_1
XFILLER_86_593 VDD VDD VSS VSS gf180mcu_fd_sc_mcu7t5v0__fill_2
XFILLER_46_413 VDD VDD VSS VSS gf180mcu_fd_sc_mcu7t5v0__fillcap_16
XFILLER_46_457 VDD VDD VSS VSS gf180mcu_fd_sc_mcu7t5v0__fill_2
XFILLER_73_287 VDD VDD VSS VSS gf180mcu_fd_sc_mcu7t5v0__fillcap_8
XTAP_TAPCELL_ROW_44_625 VDD VSS gf180mcu_fd_sc_mcu7t5v0__filltie
XFILLER_14_332 VDD VDD VSS VSS gf180mcu_fd_sc_mcu7t5v0__fillcap_16
XFILLER_14_387 VDD VDD VSS VSS gf180mcu_fd_sc_mcu7t5v0__fillcap_4
Xclkbuf_4_6_0_clk clkbuf_0_clk/Z clkload5/I VDD VDD VSS VSS gf180mcu_fd_sc_mcu7t5v0__clkbuf_8
X_2360_ _3757_/Q _2444_/A4 _2443_/A3 VDD VDD VSS VSS gf180mcu_fd_sc_mcu7t5v0__nand2_1
X_2291_ wire421/Z _3139_/A1 _2939_/A1 VDD VDD VSS VSS gf180mcu_fd_sc_mcu7t5v0__nand2_1
XFILLER_84_519 VDD VDD VSS VSS gf180mcu_fd_sc_mcu7t5v0__fillcap_4
XPHY_EDGE_ROW_10_Right_10 VDD VSS gf180mcu_fd_sc_mcu7t5v0__endcap
XFILLER_77_582 VDD VDD VSS VSS gf180mcu_fd_sc_mcu7t5v0__fill_1
XFILLER_24_107 VDD VDD VSS VSS gf180mcu_fd_sc_mcu7t5v0__fillcap_64
XFILLER_32_195 VDD VDD VSS VSS gf180mcu_fd_sc_mcu7t5v0__fill_1
XFILLER_60_493 VDD VDD VSS VSS gf180mcu_fd_sc_mcu7t5v0__fill_1
X_3745_ _3745_/D wire589/I clkload9/I _3745_/Q VDD VDD VSS VSS gf180mcu_fd_sc_mcu7t5v0__dffrnq_2
Xoutput110 _2117_/ZN cal_phase270_offset[0] VDD VDD VSS VSS gf180mcu_fd_sc_mcu7t5v0__buf_2
X_3676_ _3676_/D _3716_/RN _3717_/CLK _3676_/Q VDD VDD VSS VSS gf180mcu_fd_sc_mcu7t5v0__dffrnq_2
Xoutput121 _1815_/ZN cal_phase270_offset[1] VDD VDD VSS VSS gf180mcu_fd_sc_mcu7t5v0__buf_2
Xoutput143 _1796_/Z cal_phase90_offset[20] VDD VDD VSS VSS gf180mcu_fd_sc_mcu7t5v0__buf_2
X_2627_ _3742_/Q input51/Z _2628_/B VDD VDD VSS VSS gf180mcu_fd_sc_mcu7t5v0__xnor2_1
Xoutput132 _3514_/Z cal_phase90_offset[10] VDD VDD VSS VSS gf180mcu_fd_sc_mcu7t5v0__buf_2
X_2558_ _2515_/Z _2516_/Z _2588_/B1 VDD VDD VSS VSS gf180mcu_fd_sc_mcu7t5v0__xnor2_1
Xoutput154 _3661_/Q delay_wave_cycle[1] VDD VDD VSS VSS gf180mcu_fd_sc_mcu7t5v0__buf_2
Xoutput176 _3669_/Q raw_edge1[1] VDD VDD VSS VSS gf180mcu_fd_sc_mcu7t5v0__buf_2
Xoutput165 _3668_/Q raw_edge1[0] VDD VDD VSS VSS gf180mcu_fd_sc_mcu7t5v0__buf_2
X_2489_ _3742_/Q input72/Z _2490_/B VDD VDD VSS VSS gf180mcu_fd_sc_mcu7t5v0__xor2_1
Xoutput187 _3058_/I raw_edge2[10] VDD VDD VSS VSS gf180mcu_fd_sc_mcu7t5v0__buf_2
Xoutput198 _3709_/Q raw_edge2[20] VDD VDD VSS VSS gf180mcu_fd_sc_mcu7t5v0__buf_2
XFILLER_87_379 VDD VDD VSS VSS gf180mcu_fd_sc_mcu7t5v0__fill_1
XFILLER_87_346 VDD VDD VSS VSS gf180mcu_fd_sc_mcu7t5v0__fillcap_4
XFILLER_28_402 VDD VDD VSS VSS gf180mcu_fd_sc_mcu7t5v0__fillcap_8
XFILLER_28_457 VDD VDD VSS VSS gf180mcu_fd_sc_mcu7t5v0__fill_2
XFILLER_46_37 VDD VDD VSS VSS gf180mcu_fd_sc_mcu7t5v0__fillcap_64
XFILLER_83_585 VDD VDD VSS VSS gf180mcu_fd_sc_mcu7t5v0__fill_2
XFILLER_83_574 VDD VDD VSS VSS gf180mcu_fd_sc_mcu7t5v0__fill_1
XTAP_TAPCELL_ROW_94_1104 VDD VSS gf180mcu_fd_sc_mcu7t5v0__filltie
XFILLER_2_2 VDD VDD VSS VSS gf180mcu_fd_sc_mcu7t5v0__fillcap_32
XFILLER_3_556 VDD VDD VSS VSS gf180mcu_fd_sc_mcu7t5v0__fillcap_4
XFILLER_87_66 VDD VDD VSS VSS gf180mcu_fd_sc_mcu7t5v0__fillcap_4
XFILLER_78_313 VDD VDD VSS VSS gf180mcu_fd_sc_mcu7t5v0__fill_2
Xfanout381 _3088_/I _2803_/A1 VDD VDD VSS VSS gf180mcu_fd_sc_mcu7t5v0__dlyb_1
XTAP_TAPCELL_ROW_57_750 VDD VSS gf180mcu_fd_sc_mcu7t5v0__filltie
XTAP_TAPCELL_ROW_29_485 VDD VSS gf180mcu_fd_sc_mcu7t5v0__filltie
XFILLER_46_298 VDD VDD VSS VSS gf180mcu_fd_sc_mcu7t5v0__fillcap_8
X_1860_ _3716_/Q _3415_/A1 _1897_/A1 VDD VDD VSS VSS gf180mcu_fd_sc_mcu7t5v0__nor2_1
Xinput12 cfg_f_MEMS_fcw[3] _3013_/I VDD VDD VSS VSS gf180mcu_fd_sc_mcu7t5v0__buf_2
Xinput34 cfg_phase0_offset[4] input34/Z VDD VDD VSS VSS gf180mcu_fd_sc_mcu7t5v0__buf_1
Xinput23 cfg_phase0_offset[13] _2975_/I VDD VDD VSS VSS gf180mcu_fd_sc_mcu7t5v0__buf_1
Xinput45 cfg_phase270_offset[14] _2998_/I VDD VDD VSS VSS gf180mcu_fd_sc_mcu7t5v0__buf_1
X_3530_ _3509_/Z _3530_/A2 _3530_/B _3531_/A2 VDD VDD VSS VSS gf180mcu_fd_sc_mcu7t5v0__aoi21_1
Xinput78 cfg_phase90_offset[6] input78/Z VDD VDD VSS VSS gf180mcu_fd_sc_mcu7t5v0__buf_1
Xinput67 cfg_phase90_offset[15] _3018_/I VDD VDD VSS VSS gf180mcu_fd_sc_mcu7t5v0__buf_1
Xinput56 cfg_phase270_offset[5] _3002_/I VDD VDD VSS VSS gf180mcu_fd_sc_mcu7t5v0__buf_1
XFILLER_6_383 VDD VDD VSS VSS gf180mcu_fd_sc_mcu7t5v0__fill_2
X_3461_ _3461_/A1 _3460_/Z _3545_/A1 VDD VDD VSS VSS gf180mcu_fd_sc_mcu7t5v0__nand2_1
X_2412_ _2412_/A1 _2412_/A2 _2412_/Z VDD VDD VSS VSS gf180mcu_fd_sc_mcu7t5v0__xor2_1
X_3392_ wire660/Z _3391_/Z _3406_/B VDD VDD VSS VSS gf180mcu_fd_sc_mcu7t5v0__or2_1
X_2343_ _2303_/Z _2343_/A2 _2343_/A3 _2343_/B wire282/I VDD VDD VSS VSS gf180mcu_fd_sc_mcu7t5v0__oai31_2
XFILLER_35_2 VDD VDD VSS VSS gf180mcu_fd_sc_mcu7t5v0__fillcap_64
X_2274_ _2280_/A1 _2927_/A1 _2274_/B _3722_/D VDD VDD VSS VSS gf180mcu_fd_sc_mcu7t5v0__oai21_1
XFILLER_84_349 VDD VDD VSS VSS gf180mcu_fd_sc_mcu7t5v0__fill_1
XFILLER_65_574 VDD VDD VSS VSS gf180mcu_fd_sc_mcu7t5v0__fillcap_8
XFILLER_80_555 VDD VDD VSS VSS gf180mcu_fd_sc_mcu7t5v0__fill_2
XFILLER_40_419 VDD VDD VSS VSS gf180mcu_fd_sc_mcu7t5v0__fill_2
X_1989_ wire517/Z _2004_/B _1989_/A3 _1989_/Z VDD VDD VSS VSS gf180mcu_fd_sc_mcu7t5v0__xor3_1
X_3728_ _3728_/D _3728_/RN clkload3/I _3728_/Q VDD VDD VSS VSS gf180mcu_fd_sc_mcu7t5v0__dffrnq_4
X_3659_ _3659_/D _3659_/RN clkload0/I _3659_/Q VDD VDD VSS VSS gf180mcu_fd_sc_mcu7t5v0__dffrnq_2
XFILLER_28_221 VDD VDD VSS VSS gf180mcu_fd_sc_mcu7t5v0__fillcap_16
XFILLER_16_449 VDD VDD VSS VSS gf180mcu_fd_sc_mcu7t5v0__fillcap_4
XTAP_TAPCELL_ROW_54_720 VDD VSS gf180mcu_fd_sc_mcu7t5v0__filltie
XFILLER_71_533 VDD VDD VSS VSS gf180mcu_fd_sc_mcu7t5v0__fillcap_4
XTAP_TAPCELL_ROW_26_455 VDD VSS gf180mcu_fd_sc_mcu7t5v0__filltie
XFILLER_8_615 VDD VDD VSS VSS gf180mcu_fd_sc_mcu7t5v0__fill_1
XFILLER_7_136 VDD VDD VSS VSS gf180mcu_fd_sc_mcu7t5v0__fillcap_4
XFILLER_39_508 VDD VDD VSS VSS gf180mcu_fd_sc_mcu7t5v0__fill_1
XFILLER_19_232 VDD VDD VSS VSS gf180mcu_fd_sc_mcu7t5v0__fill_1
XFILLER_19_265 VDD VDD VSS VSS gf180mcu_fd_sc_mcu7t5v0__fillcap_4
XFILLER_34_202 VDD VDD VSS VSS gf180mcu_fd_sc_mcu7t5v0__fill_2
XFILLER_74_382 VDD VDD VSS VSS gf180mcu_fd_sc_mcu7t5v0__fill_2
XPHY_EDGE_ROW_22_Left_119 VDD VSS gf180mcu_fd_sc_mcu7t5v0__endcap
X_2961_ _2965_/A1 _2961_/A2 _2961_/B _3718_/D VDD VDD VSS VSS gf180mcu_fd_sc_mcu7t5v0__oai21_1
X_1912_ _1960_/A2 _1911_/Z _1912_/ZN VDD VDD VSS VSS gf180mcu_fd_sc_mcu7t5v0__nor2_1
X_2892_ _3626_/A2 _2892_/A2 _2892_/B1 _2892_/B2 _3687_/D VDD VDD VSS VSS gf180mcu_fd_sc_mcu7t5v0__oai22_1
XTAP_TAPCELL_ROW_60_778 VDD VSS gf180mcu_fd_sc_mcu7t5v0__filltie
X_1843_ _1822_/Z _1843_/A2 _1843_/B _1857_/B1 VDD VDD VSS VSS gf180mcu_fd_sc_mcu7t5v0__aoi21_2
XFILLER_30_485 VDD VDD VSS VSS gf180mcu_fd_sc_mcu7t5v0__fillcap_4
Xmax_cap301 _3555_/A1 _3584_/A1 VDD VDD VSS VSS gf180mcu_fd_sc_mcu7t5v0__clkbuf_2
X_3513_ _3513_/A1 _3513_/A2 _3513_/A3 _3513_/B _3530_/A2 VDD VDD VSS VSS gf180mcu_fd_sc_mcu7t5v0__oai31_2
XPHY_EDGE_ROW_31_Left_128 VDD VSS gf180mcu_fd_sc_mcu7t5v0__endcap
X_3444_ _3445_/A1 _3445_/B _3445_/A2 _3444_/Z VDD VDD VSS VSS gf180mcu_fd_sc_mcu7t5v0__and3_1
X_3375_ _3015_/I _3375_/A2 _3375_/A3 _3375_/Z VDD VDD VSS VSS gf180mcu_fd_sc_mcu7t5v0__xor3_1
Xload_slew540 wire541/Z _3139_/A1 VDD VDD VSS VSS gf180mcu_fd_sc_mcu7t5v0__buf_1
X_2326_ _3744_/Q _3013_/I _2327_/A2 VDD VDD VSS VSS gf180mcu_fd_sc_mcu7t5v0__nor2_1
Xload_slew573 _3735_/RN _3736_/RN VDD VDD VSS VSS gf180mcu_fd_sc_mcu7t5v0__buf_2
Xload_slew595 wire594/I _3751_/RN VDD VDD VSS VSS gf180mcu_fd_sc_mcu7t5v0__buf_2
X_2257_ _2212_/I _2256_/Z _2260_/B VDD VDD VSS VSS gf180mcu_fd_sc_mcu7t5v0__nand2_1
Xload_slew584 _3687_/RN _3684_/RN VDD VDD VSS VSS gf180mcu_fd_sc_mcu7t5v0__clkbuf_2
XTAP_TAPCELL_ROW_68_856 VDD VSS gf180mcu_fd_sc_mcu7t5v0__filltie
XFILLER_38_541 VDD VDD VSS VSS gf180mcu_fd_sc_mcu7t5v0__fillcap_8
X_2188_ _2188_/A1 _2188_/A2 _2188_/B _2193_/A2 VDD VDD VSS VSS gf180mcu_fd_sc_mcu7t5v0__oai21_1
XPHY_EDGE_ROW_40_Left_137 VDD VSS gf180mcu_fd_sc_mcu7t5v0__endcap
XFILLER_13_419 VDD VDD VSS VSS gf180mcu_fd_sc_mcu7t5v0__fill_1
XFILLER_53_588 VDD VDD VSS VSS gf180mcu_fd_sc_mcu7t5v0__fill_1
XTAP_TAPCELL_ROW_23_425 VDD VSS gf180mcu_fd_sc_mcu7t5v0__filltie
XFILLER_33_290 VDD VDD VSS VSS gf180mcu_fd_sc_mcu7t5v0__fill_2
XFILLER_4_117 VDD VDD VSS VSS gf180mcu_fd_sc_mcu7t5v0__fill_1
XFILLER_48_327 VDD VDD VSS VSS gf180mcu_fd_sc_mcu7t5v0__fill_2
XFILLER_84_34 VDD VDD VSS VSS gf180mcu_fd_sc_mcu7t5v0__fill_1
XFILLER_63_308 VDD VDD VSS VSS gf180mcu_fd_sc_mcu7t5v0__fill_2
XTAP_TAPCELL_ROW_39_580 VDD VSS gf180mcu_fd_sc_mcu7t5v0__filltie
XFILLER_56_382 VDD VDD VSS VSS gf180mcu_fd_sc_mcu7t5v0__fill_2
XFILLER_17_72 VDD VDD VSS VSS gf180mcu_fd_sc_mcu7t5v0__fillcap_64
XFILLER_44_544 VDD VDD VSS VSS gf180mcu_fd_sc_mcu7t5v0__fill_2
XFILLER_71_341 VDD VDD VSS VSS gf180mcu_fd_sc_mcu7t5v0__fill_1
XFILLER_71_352 VDD VDD VSS VSS gf180mcu_fd_sc_mcu7t5v0__fillcap_4
XFILLER_12_430 VDD VDD VSS VSS gf180mcu_fd_sc_mcu7t5v0__fill_1
XFILLER_31_227 VDD VDD VSS VSS gf180mcu_fd_sc_mcu7t5v0__fillcap_4
XFILLER_79_485 VDD VDD VSS VSS gf180mcu_fd_sc_mcu7t5v0__fillcap_4
X_3160_ _3447_/A1 _3716_/Q _3161_/I VDD VDD VSS VSS gf180mcu_fd_sc_mcu7t5v0__xor2_1
X_2111_ _2096_/Z _2111_/A2 _2108_/Z _2111_/Z VDD VDD VSS VSS gf180mcu_fd_sc_mcu7t5v0__and3_1
XFILLER_79_496 VDD VDD VSS VSS gf180mcu_fd_sc_mcu7t5v0__fill_1
X_3091_ _3662_/Q _3091_/ZN VDD VDD VSS VSS gf180mcu_fd_sc_mcu7t5v0__clkinv_1
XFILLER_39_349 VDD VDD VSS VSS gf180mcu_fd_sc_mcu7t5v0__fill_1
X_2042_ _3726_/Q _3070_/I _2047_/B VDD VDD VSS VSS gf180mcu_fd_sc_mcu7t5v0__xor2_1
XFILLER_35_500 VDD VDD VSS VSS gf180mcu_fd_sc_mcu7t5v0__fillcap_16
XTAP_TAPCELL_ROW_65_826 VDD VSS gf180mcu_fd_sc_mcu7t5v0__filltie
XPHY_EDGE_ROW_8_Right_8 VDD VSS gf180mcu_fd_sc_mcu7t5v0__endcap
XFILLER_35_588 VDD VDD VSS VSS gf180mcu_fd_sc_mcu7t5v0__fillcap_4
X_2944_ _3780_/I _2948_/A2 _2945_/B VDD VDD VSS VSS gf180mcu_fd_sc_mcu7t5v0__nand2_1
X_2875_ _2974_/I wire269/Z _2877_/B1 VDD VDD VSS VSS gf180mcu_fd_sc_mcu7t5v0__nor2_1
X_1826_ _3388_/A1 _1823_/Z _1827_/I VDD VDD VSS VSS gf180mcu_fd_sc_mcu7t5v0__xor2_2
XPHY_EDGE_ROW_39_Right_39 VDD VSS gf180mcu_fd_sc_mcu7t5v0__endcap
X_3427_ _3673_/Q _3425_/Z _3427_/Z VDD VDD VSS VSS gf180mcu_fd_sc_mcu7t5v0__xor2_2
X_3358_ _3691_/Q _3670_/Q _3360_/B VDD VDD VSS VSS gf180mcu_fd_sc_mcu7t5v0__xor2_1
XFILLER_85_422 VDD VDD VSS VSS gf180mcu_fd_sc_mcu7t5v0__fillcap_8
X_2309_ _2309_/I _2331_/B VDD VDD VSS VSS gf180mcu_fd_sc_mcu7t5v0__clkinv_1
Xload_slew370 _2772_/A2 _2792_/A2 VDD VDD VSS VSS gf180mcu_fd_sc_mcu7t5v0__clkbuf_2
Xload_slew392 _2154_/A2 _2148_/A2 VDD VDD VSS VSS gf180mcu_fd_sc_mcu7t5v0__clkbuf_1
X_3289_ _3289_/A1 _3289_/A2 _3289_/B _3290_/A2 VDD VDD VSS VSS gf180mcu_fd_sc_mcu7t5v0__oai21_1
XFILLER_26_533 VDD VDD VSS VSS gf180mcu_fd_sc_mcu7t5v0__fill_2
XFILLER_53_341 VDD VDD VSS VSS gf180mcu_fd_sc_mcu7t5v0__fill_1
XFILLER_54_37 VDD VDD VSS VSS gf180mcu_fd_sc_mcu7t5v0__fillcap_64
XTAP_TAPCELL_ROW_0_197 VDD VSS gf180mcu_fd_sc_mcu7t5v0__filltie
XTAP_TAPCELL_ROW_36_550 VDD VSS gf180mcu_fd_sc_mcu7t5v0__filltie
XFILLER_53_352 VDD VDD VSS VSS gf180mcu_fd_sc_mcu7t5v0__fill_2
XFILLER_80_171 VDD VDD VSS VSS gf180mcu_fd_sc_mcu7t5v0__fillcap_4
XFILLER_13_238 VDD VDD VSS VSS gf180mcu_fd_sc_mcu7t5v0__fill_1
XPHY_EDGE_ROW_48_Right_48 VDD VSS gf180mcu_fd_sc_mcu7t5v0__endcap
XFILLER_5_415 VDD VDD VSS VSS gf180mcu_fd_sc_mcu7t5v0__fillcap_4
XPHY_EDGE_ROW_57_Right_57 VDD VSS gf180mcu_fd_sc_mcu7t5v0__endcap
XFILLER_1_632 VDD VDD VSS VSS gf180mcu_fd_sc_mcu7t5v0__fillcap_32
XTAP_TAPCELL_ROW_8_286 VDD VSS gf180mcu_fd_sc_mcu7t5v0__filltie
XFILLER_1_676 VDD VDD VSS VSS gf180mcu_fd_sc_mcu7t5v0__fill_1
XFILLER_49_603 VDD VDD VSS VSS gf180mcu_fd_sc_mcu7t5v0__fill_2
XFILLER_95_66 VDD VDD VSS VSS gf180mcu_fd_sc_mcu7t5v0__fillcap_4
XFILLER_76_444 VDD VDD VSS VSS gf180mcu_fd_sc_mcu7t5v0__fillcap_8
XFILLER_0_197 VDD VDD VSS VSS gf180mcu_fd_sc_mcu7t5v0__fillcap_4
XFILLER_17_555 VDD VDD VSS VSS gf180mcu_fd_sc_mcu7t5v0__fillcap_4
XFILLER_32_503 VDD VDD VSS VSS gf180mcu_fd_sc_mcu7t5v0__fillcap_16
XPHY_EDGE_ROW_66_Right_66 VDD VSS gf180mcu_fd_sc_mcu7t5v0__endcap
XFILLER_32_558 VDD VDD VSS VSS gf180mcu_fd_sc_mcu7t5v0__fill_1
XTAP_TAPCELL_ROW_70_873 VDD VSS gf180mcu_fd_sc_mcu7t5v0__filltie
XFILLER_12_271 VDD VDD VSS VSS gf180mcu_fd_sc_mcu7t5v0__fill_2
X_2660_ _2661_/A1 _2661_/A2 _2687_/A2 VDD VDD VSS VSS gf180mcu_fd_sc_mcu7t5v0__nand2_1
XFILLER_8_275 VDD VDD VSS VSS gf180mcu_fd_sc_mcu7t5v0__fillcap_4
XPHY_EDGE_ROW_75_Right_75 VDD VSS gf180mcu_fd_sc_mcu7t5v0__endcap
X_2591_ _3004_/ZN _2552_/Z _2591_/B1 _2591_/B2 _2591_/C _2592_/B2 VDD VDD VSS VSS
+ gf180mcu_fd_sc_mcu7t5v0__aoi221_1
X_3212_ wire528/I _3036_/I _3212_/A3 _3212_/Z VDD VDD VSS VSS gf180mcu_fd_sc_mcu7t5v0__xor3_1
XFILLER_79_282 VDD VDD VSS VSS gf180mcu_fd_sc_mcu7t5v0__fillcap_16
XFILLER_67_411 VDD VDD VSS VSS gf180mcu_fd_sc_mcu7t5v0__fill_2
XFILLER_67_422 VDD VDD VSS VSS gf180mcu_fd_sc_mcu7t5v0__fill_2
XFILLER_94_241 VDD VDD VSS VSS gf180mcu_fd_sc_mcu7t5v0__fillcap_4
XTAP_TAPCELL_ROW_78_951 VDD VSS gf180mcu_fd_sc_mcu7t5v0__filltie
XFILLER_27_308 VDD VDD VSS VSS gf180mcu_fd_sc_mcu7t5v0__fillcap_16
X_3143_ wire515/Z _3713_/Q _3152_/A1 VDD VDD VSS VSS gf180mcu_fd_sc_mcu7t5v0__nand2_1
X_3074_ _3707_/Q _3629_/B2 VDD VDD VSS VSS gf180mcu_fd_sc_mcu7t5v0__inv_2
XPHY_EDGE_ROW_84_Right_84 VDD VSS gf180mcu_fd_sc_mcu7t5v0__endcap
XFILLER_55_628 VDD VDD VSS VSS gf180mcu_fd_sc_mcu7t5v0__fill_2
X_2025_ _3725_/Q _3704_/Q _2028_/B VDD VDD VSS VSS gf180mcu_fd_sc_mcu7t5v0__xor2_2
XFILLER_35_341 VDD VDD VSS VSS gf180mcu_fd_sc_mcu7t5v0__fillcap_8
XFILLER_54_149 VDD VDD VSS VSS gf180mcu_fd_sc_mcu7t5v0__fill_1
XFILLER_35_352 VDD VDD VSS VSS gf180mcu_fd_sc_mcu7t5v0__fillcap_8
XFILLER_50_300 VDD VDD VSS VSS gf180mcu_fd_sc_mcu7t5v0__fill_1
XTAP_TAPCELL_ROW_33_520 VDD VSS gf180mcu_fd_sc_mcu7t5v0__filltie
X_2927_ _2927_/A1 _2927_/A2 _2927_/B _3701_/D VDD VDD VSS VSS gf180mcu_fd_sc_mcu7t5v0__oai21_1
XPHY_EDGE_ROW_93_Right_93 VDD VSS gf180mcu_fd_sc_mcu7t5v0__endcap
X_2858_ _3749_/Q wire267/I _2867_/B _2859_/B2 VDD VDD VSS VSS gf180mcu_fd_sc_mcu7t5v0__oai21_1
X_2789_ _3092_/ZN wire334/Z _2789_/B1 _2789_/B2 _3663_/D VDD VDD VSS VSS gf180mcu_fd_sc_mcu7t5v0__oai22_1
X_1809_ _1797_/Z _1810_/A2 _1809_/B _1864_/B1 VDD VDD VSS VSS gf180mcu_fd_sc_mcu7t5v0__oai21_2
XTAP_TAPCELL_ROW_5_256 VDD VSS gf180mcu_fd_sc_mcu7t5v0__filltie
XTAP_TAPCELL_ROW_86_1028 VDD VSS gf180mcu_fd_sc_mcu7t5v0__filltie
XFILLER_5_212 VDD VDD VSS VSS gf180mcu_fd_sc_mcu7t5v0__fillcap_8
XFILLER_76_241 VDD VDD VSS VSS gf180mcu_fd_sc_mcu7t5v0__fillcap_4
XFILLER_49_466 VDD VDD VSS VSS gf180mcu_fd_sc_mcu7t5v0__fill_1
XTAP_TAPCELL_ROW_75_921 VDD VSS gf180mcu_fd_sc_mcu7t5v0__filltie
XFILLER_64_414 VDD VDD VSS VSS gf180mcu_fd_sc_mcu7t5v0__fillcap_4
XTAP_TAPCELL_ROW_47_656 VDD VSS gf180mcu_fd_sc_mcu7t5v0__filltie
XFILLER_44_182 VDD VDD VSS VSS gf180mcu_fd_sc_mcu7t5v0__fillcap_8
XFILLER_72_480 VDD VDD VSS VSS gf180mcu_fd_sc_mcu7t5v0__fillcap_32
X_3761_ _3761_/D _3761_/RN clkload2/I _3761_/Q VDD VDD VSS VSS gf180mcu_fd_sc_mcu7t5v0__dffrnq_1
XFILLER_9_562 VDD VDD VSS VSS gf180mcu_fd_sc_mcu7t5v0__fillcap_4
X_2712_ _3437_/A1 _2700_/Z _2712_/B1 _2712_/B2 _2713_/C VDD VDD VSS VSS gf180mcu_fd_sc_mcu7t5v0__aoi22_1
X_3692_ _3692_/D _3692_/RN _3715_/CLK _3692_/Q VDD VDD VSS VSS gf180mcu_fd_sc_mcu7t5v0__dffrnq_2
X_2643_ _2694_/A1 _2694_/A2 _2694_/B _2644_/B VDD VDD VSS VSS gf180mcu_fd_sc_mcu7t5v0__and3_1
XFILLER_65_2 VDD VDD VSS VSS gf180mcu_fd_sc_mcu7t5v0__fillcap_64
X_2574_ _3026_/I _2708_/B _2490_/B wire515/I _2574_/C _2578_/B1 VDD VDD VSS VSS gf180mcu_fd_sc_mcu7t5v0__oai221_1
XTAP_TAPCELL_ROW_2_226 VDD VSS gf180mcu_fd_sc_mcu7t5v0__filltie
X_3126_ input28/Z _2734_/C _2211_/C input29/Z _3128_/C VDD VDD VSS VSS gf180mcu_fd_sc_mcu7t5v0__oai22_1
XFILLER_67_263 VDD VDD VSS VSS gf180mcu_fd_sc_mcu7t5v0__fill_2
XFILLER_55_458 VDD VDD VSS VSS gf180mcu_fd_sc_mcu7t5v0__fillcap_4
X_3057_ _3677_/Q _3492_/A2 VDD VDD VSS VSS gf180mcu_fd_sc_mcu7t5v0__clkinv_1
X_2008_ _2008_/I _2014_/A2 VDD VDD VSS VSS gf180mcu_fd_sc_mcu7t5v0__clkinv_1
XTAP_TAPCELL_ROW_81_979 VDD VSS gf180mcu_fd_sc_mcu7t5v0__filltie
XTAP_TAPCELL_ROW_18_380 VDD VSS gf180mcu_fd_sc_mcu7t5v0__filltie
Xwire419 _3760_/Q wire419/Z VDD VDD VSS VSS gf180mcu_fd_sc_mcu7t5v0__clkbuf_2
Xwire408 wire408/I wire408/Z VDD VDD VSS VSS gf180mcu_fd_sc_mcu7t5v0__clkbuf_2
XFILLER_78_539 VDD VDD VSS VSS gf180mcu_fd_sc_mcu7t5v0__fill_1
Xfanout530 wire550/Z _3016_/I VDD VDD VSS VSS gf180mcu_fd_sc_mcu7t5v0__dlyb_1
Xfanout574 wire586/Z _3688_/RN VDD VDD VSS VSS gf180mcu_fd_sc_mcu7t5v0__dlyb_1
XFILLER_86_583 VDD VDD VSS VSS gf180mcu_fd_sc_mcu7t5v0__fill_2
Xfanout596 wire604/Z _3677_/RN VDD VDD VSS VSS gf180mcu_fd_sc_mcu7t5v0__dlyb_1
XFILLER_46_403 VDD VDD VSS VSS gf180mcu_fd_sc_mcu7t5v0__fillcap_4
XFILLER_73_244 VDD VDD VSS VSS gf180mcu_fd_sc_mcu7t5v0__fillcap_16
XFILLER_92_34 VDD VDD VSS VSS gf180mcu_fd_sc_mcu7t5v0__fill_1
XFILLER_61_406 VDD VDD VSS VSS gf180mcu_fd_sc_mcu7t5v0__fill_1
XFILLER_26_171 VDD VDD VSS VSS gf180mcu_fd_sc_mcu7t5v0__fillcap_4
XTAP_TAPCELL_ROW_44_626 VDD VSS gf180mcu_fd_sc_mcu7t5v0__filltie
XFILLER_61_428 VDD VDD VSS VSS gf180mcu_fd_sc_mcu7t5v0__fillcap_16
XFILLER_25_72 VDD VDD VSS VSS gf180mcu_fd_sc_mcu7t5v0__fillcap_64
XFILLER_10_594 VDD VDD VSS VSS gf180mcu_fd_sc_mcu7t5v0__fill_1
XFILLER_6_543 VDD VDD VSS VSS gf180mcu_fd_sc_mcu7t5v0__fillcap_8
X_2290_ _3728_/Q _2290_/A2 _2292_/B VDD VDD VSS VSS gf180mcu_fd_sc_mcu7t5v0__nand2_1
XFILLER_37_458 VDD VDD VSS VSS gf180mcu_fd_sc_mcu7t5v0__fillcap_16
XFILLER_52_406 VDD VDD VSS VSS gf180mcu_fd_sc_mcu7t5v0__fill_2
XFILLER_92_597 VDD VDD VSS VSS gf180mcu_fd_sc_mcu7t5v0__fillcap_64
XFILLER_45_480 VDD VDD VSS VSS gf180mcu_fd_sc_mcu7t5v0__fill_2
XFILLER_32_141 VDD VDD VSS VSS gf180mcu_fd_sc_mcu7t5v0__fillcap_8
XFILLER_20_314 VDD VDD VSS VSS gf180mcu_fd_sc_mcu7t5v0__fill_1
XTAP_TAPCELL_ROW_15_350 VDD VSS gf180mcu_fd_sc_mcu7t5v0__filltie
XFILLER_20_325 VDD VDD VSS VSS gf180mcu_fd_sc_mcu7t5v0__fill_1
X_3744_ _3744_/D wire589/Z clkload9/I _3744_/Q VDD VDD VSS VSS gf180mcu_fd_sc_mcu7t5v0__dffrnq_2
X_3675_ _3675_/D _3717_/RN _3717_/CLK _3675_/Q VDD VDD VSS VSS gf180mcu_fd_sc_mcu7t5v0__dffrnq_2
X_2626_ _3101_/B2 input51/Z _2631_/A1 VDD VDD VSS VSS gf180mcu_fd_sc_mcu7t5v0__nand2_1
Xoutput100 _3781_/I cal_phase0_offset[1] VDD VDD VSS VSS gf180mcu_fd_sc_mcu7t5v0__buf_2
Xoutput122 _2113_/ZN cal_phase270_offset[20] VDD VDD VSS VSS gf180mcu_fd_sc_mcu7t5v0__buf_2
Xoutput133 _3531_/Z cal_phase90_offset[11] VDD VDD VSS VSS gf180mcu_fd_sc_mcu7t5v0__buf_2
Xoutput111 _1963_/ZN cal_phase270_offset[10] VDD VDD VSS VSS gf180mcu_fd_sc_mcu7t5v0__buf_2
X_2557_ _2515_/Z _2516_/Z _2557_/Z VDD VDD VSS VSS gf180mcu_fd_sc_mcu7t5v0__xor2_1
Xoutput155 output155/I delay_wave_cycle[2] VDD VDD VSS VSS gf180mcu_fd_sc_mcu7t5v0__buf_2
Xoutput166 _3678_/Q raw_edge1[10] VDD VDD VSS VSS gf180mcu_fd_sc_mcu7t5v0__buf_2
Xoutput177 output177/I raw_edge1[20] VDD VDD VSS VSS gf180mcu_fd_sc_mcu7t5v0__buf_2
Xoutput144 _3383_/ZN cal_phase90_offset[2] VDD VDD VSS VSS gf180mcu_fd_sc_mcu7t5v0__buf_2
X_2488_ _3742_/Q input72/Z _2491_/B VDD VDD VSS VSS gf180mcu_fd_sc_mcu7t5v0__xnor2_1
Xoutput199 _3039_/I raw_edge2[2] VDD VDD VSS VSS gf180mcu_fd_sc_mcu7t5v0__buf_2
Xoutput188 _3700_/Q raw_edge2[11] VDD VDD VSS VSS gf180mcu_fd_sc_mcu7t5v0__buf_2
XFILLER_28_414 VDD VDD VSS VSS gf180mcu_fd_sc_mcu7t5v0__fill_2
XFILLER_68_594 VDD VDD VSS VSS gf180mcu_fd_sc_mcu7t5v0__fill_1
X_3109_ _3109_/A1 _3109_/A2 _3109_/B _3110_/C VDD VDD VSS VSS gf180mcu_fd_sc_mcu7t5v0__aoi21_1
XFILLER_62_37 VDD VDD VSS VSS gf180mcu_fd_sc_mcu7t5v0__fillcap_64
XFILLER_70_247 VDD VDD VSS VSS gf180mcu_fd_sc_mcu7t5v0__fillcap_16
XFILLER_24_675 VDD VDD VSS VSS gf180mcu_fd_sc_mcu7t5v0__fill_2
Xwire249 wire249/I wire249/Z VDD VDD VSS VSS gf180mcu_fd_sc_mcu7t5v0__buf_1
XTAP_TAPCELL_ROW_94_1105 VDD VSS gf180mcu_fd_sc_mcu7t5v0__filltie
XFILLER_78_369 VDD VDD VSS VSS gf180mcu_fd_sc_mcu7t5v0__fillcap_4
Xfanout360 _2415_/A2 wire362/I VDD VDD VSS VSS gf180mcu_fd_sc_mcu7t5v0__dlyb_1
XFILLER_74_564 VDD VDD VSS VSS gf180mcu_fd_sc_mcu7t5v0__fill_1
XFILLER_46_244 VDD VDD VSS VSS gf180mcu_fd_sc_mcu7t5v0__fill_1
XTAP_TAPCELL_ROW_57_751 VDD VSS gf180mcu_fd_sc_mcu7t5v0__filltie
XTAP_TAPCELL_ROW_29_486 VDD VSS gf180mcu_fd_sc_mcu7t5v0__filltie
XFILLER_61_214 VDD VDD VSS VSS gf180mcu_fd_sc_mcu7t5v0__fill_1
XFILLER_36_93 VDD VDD VSS VSS gf180mcu_fd_sc_mcu7t5v0__fillcap_4
XTAP_TAPCELL_ROW_12_320 VDD VSS gf180mcu_fd_sc_mcu7t5v0__filltie
Xinput13 cfg_f_MEMS_fcw[4] _3012_/I VDD VDD VSS VSS gf180mcu_fd_sc_mcu7t5v0__buf_3
XFILLER_30_667 VDD VDD VSS VSS gf180mcu_fd_sc_mcu7t5v0__fill_2
Xinput24 cfg_phase0_offset[14] input24/Z VDD VDD VSS VSS gf180mcu_fd_sc_mcu7t5v0__buf_1
Xinput35 cfg_phase0_offset[5] input35/Z VDD VDD VSS VSS gf180mcu_fd_sc_mcu7t5v0__buf_1
Xinput46 cfg_phase270_offset[15] _2997_/I VDD VDD VSS VSS gf180mcu_fd_sc_mcu7t5v0__buf_1
Xinput68 cfg_phase90_offset[16] input68/Z VDD VDD VSS VSS gf180mcu_fd_sc_mcu7t5v0__buf_1
Xinput57 cfg_phase270_offset[6] input57/Z VDD VDD VSS VSS gf180mcu_fd_sc_mcu7t5v0__buf_1
Xinput79 cfg_phase90_offset[7] _3024_/I VDD VDD VSS VSS gf180mcu_fd_sc_mcu7t5v0__buf_1
X_3460_ _3675_/Q _3458_/Z _3460_/Z VDD VDD VSS VSS gf180mcu_fd_sc_mcu7t5v0__xor2_1
X_2411_ _3107_/B2 _2415_/A2 _2410_/Z wire368/Z _3746_/D VDD VDD VSS VSS gf180mcu_fd_sc_mcu7t5v0__oai22_1
X_3391_ _3387_/I _3401_/A2 _3391_/Z VDD VDD VSS VSS gf180mcu_fd_sc_mcu7t5v0__xor2_2
X_2342_ _2979_/I _2588_/A1 _3006_/I _2981_/I _2343_/B VDD VDD VSS VSS gf180mcu_fd_sc_mcu7t5v0__aoi22_1
XFILLER_28_2 VDD VDD VSS VSS gf180mcu_fd_sc_mcu7t5v0__fillcap_32
XFILLER_69_358 VDD VDD VSS VSS gf180mcu_fd_sc_mcu7t5v0__fillcap_16
XFILLER_84_317 VDD VDD VSS VSS gf180mcu_fd_sc_mcu7t5v0__fillcap_32
X_2273_ _2977_/I _2422_/A2 _2927_/A1 VDD VDD VSS VSS gf180mcu_fd_sc_mcu7t5v0__nand2_1
XFILLER_37_277 VDD VDD VSS VSS gf180mcu_fd_sc_mcu7t5v0__fill_2
XFILLER_65_586 VDD VDD VSS VSS gf180mcu_fd_sc_mcu7t5v0__fill_2
XFILLER_80_589 VDD VDD VSS VSS gf180mcu_fd_sc_mcu7t5v0__fill_1
X_1988_ wire517/Z _1987_/Z _2021_/A1 VDD VDD VSS VSS gf180mcu_fd_sc_mcu7t5v0__nand2_1
XFILLER_20_177 VDD VDD VSS VSS gf180mcu_fd_sc_mcu7t5v0__fillcap_32
X_3727_ _3727_/D _3727_/RN clkload6/I _3727_/Q VDD VDD VSS VSS gf180mcu_fd_sc_mcu7t5v0__dffrnq_2
X_3658_ _3658_/D _3729_/RN clkload4/I _3658_/Q VDD VDD VSS VSS gf180mcu_fd_sc_mcu7t5v0__dffrnq_2
X_2609_ _2609_/A1 _2609_/A2 _2607_/Z _2609_/A4 _2610_/A2 VDD VDD VSS VSS gf180mcu_fd_sc_mcu7t5v0__nand4_1
X_3589_ _3568_/Z _3590_/A2 _3589_/B _3608_/C VDD VDD VSS VSS gf180mcu_fd_sc_mcu7t5v0__aoi21_2
Xclkbuf_4_5_0_clk clkbuf_0_clk/Z clkload4/I VDD VDD VSS VSS gf180mcu_fd_sc_mcu7t5v0__clkbuf_8
XFILLER_68_391 VDD VDD VSS VSS gf180mcu_fd_sc_mcu7t5v0__fill_2
XFILLER_28_255 VDD VDD VSS VSS gf180mcu_fd_sc_mcu7t5v0__fill_1
XFILLER_56_575 VDD VDD VSS VSS gf180mcu_fd_sc_mcu7t5v0__fillcap_8
XFILLER_16_439 VDD VDD VSS VSS gf180mcu_fd_sc_mcu7t5v0__fillcap_4
XTAP_TAPCELL_ROW_54_721 VDD VSS gf180mcu_fd_sc_mcu7t5v0__filltie
XFILLER_56_597 VDD VDD VSS VSS gf180mcu_fd_sc_mcu7t5v0__fill_1
XFILLER_71_556 VDD VDD VSS VSS gf180mcu_fd_sc_mcu7t5v0__fillcap_4
XFILLER_12_601 VDD VDD VSS VSS gf180mcu_fd_sc_mcu7t5v0__fill_1
XTAP_TAPCELL_ROW_26_456 VDD VSS gf180mcu_fd_sc_mcu7t5v0__filltie
XFILLER_78_177 VDD VDD VSS VSS gf180mcu_fd_sc_mcu7t5v0__fillcap_64
XFILLER_66_317 VDD VDD VSS VSS gf180mcu_fd_sc_mcu7t5v0__fill_2
XFILLER_93_136 VDD VDD VSS VSS gf180mcu_fd_sc_mcu7t5v0__fillcap_4
XFILLER_66_328 VDD VDD VSS VSS gf180mcu_fd_sc_mcu7t5v0__fillcap_4
XFILLER_47_553 VDD VDD VSS VSS gf180mcu_fd_sc_mcu7t5v0__fill_1
XFILLER_74_361 VDD VDD VSS VSS gf180mcu_fd_sc_mcu7t5v0__fill_1
XFILLER_22_409 VDD VDD VSS VSS gf180mcu_fd_sc_mcu7t5v0__fill_1
X_2960_ _3718_/Q _2965_/A1 _2961_/B VDD VDD VSS VSS gf180mcu_fd_sc_mcu7t5v0__nand2_1
X_1911_ _1911_/A1 _1911_/A2 _1910_/B _1911_/Z VDD VDD VSS VSS gf180mcu_fd_sc_mcu7t5v0__and3_1
X_2891_ _3077_/I wire233/I _2894_/B _2892_/B2 VDD VDD VSS VSS gf180mcu_fd_sc_mcu7t5v0__oai21_1
X_1842_ _1842_/A1 _3419_/A1 _1842_/A3 _1843_/B VDD VDD VSS VSS gf180mcu_fd_sc_mcu7t5v0__xor3_1
XTAP_TAPCELL_ROW_60_779 VDD VSS gf180mcu_fd_sc_mcu7t5v0__filltie
X_3512_ _3512_/I _3513_/B VDD VDD VSS VSS gf180mcu_fd_sc_mcu7t5v0__clkinv_1
X_3443_ _3443_/A1 wire284/Z _3443_/B1 _3427_/Z _3443_/C _3445_/A2 VDD VDD VSS VSS
+ gf180mcu_fd_sc_mcu7t5v0__oai221_1
X_3374_ _3015_/I _3372_/Z _3374_/Z VDD VDD VSS VSS gf180mcu_fd_sc_mcu7t5v0__or2_1
X_2325_ _2319_/Z _2402_/A2 _2325_/B _2404_/A3 VDD VDD VSS VSS gf180mcu_fd_sc_mcu7t5v0__aoi21_1
Xload_slew563 _3763_/RN _3659_/RN VDD VDD VSS VSS gf180mcu_fd_sc_mcu7t5v0__clkbuf_2
X_2256_ _2297_/A1 _2129_/I _2256_/Z VDD VDD VSS VSS gf180mcu_fd_sc_mcu7t5v0__xor2_1
Xload_slew585 wire586/Z _3687_/RN VDD VDD VSS VSS gf180mcu_fd_sc_mcu7t5v0__clkbuf_1
XTAP_TAPCELL_ROW_68_857 VDD VSS gf180mcu_fd_sc_mcu7t5v0__filltie
X_2187_ _2187_/A1 _2185_/C _2187_/B _2188_/B VDD VDD VSS VSS gf180mcu_fd_sc_mcu7t5v0__aoi21_1
XFILLER_80_353 VDD VDD VSS VSS gf180mcu_fd_sc_mcu7t5v0__fillcap_8
XFILLER_40_217 VDD VDD VSS VSS gf180mcu_fd_sc_mcu7t5v0__fill_1
XFILLER_53_578 VDD VDD VSS VSS gf180mcu_fd_sc_mcu7t5v0__fillcap_8
XTAP_TAPCELL_ROW_23_426 VDD VSS gf180mcu_fd_sc_mcu7t5v0__filltie
XFILLER_21_442 VDD VDD VSS VSS gf180mcu_fd_sc_mcu7t5v0__fill_1
XFILLER_4_107 VDD VDD VSS VSS gf180mcu_fd_sc_mcu7t5v0__fillcap_8
XFILLER_48_317 VDD VDD VSS VSS gf180mcu_fd_sc_mcu7t5v0__fill_2
XFILLER_75_136 VDD VDD VSS VSS gf180mcu_fd_sc_mcu7t5v0__fillcap_4
XFILLER_44_501 VDD VDD VSS VSS gf180mcu_fd_sc_mcu7t5v0__fillcap_4
XFILLER_16_247 VDD VDD VSS VSS gf180mcu_fd_sc_mcu7t5v0__fillcap_16
XFILLER_16_225 VDD VDD VSS VSS gf180mcu_fd_sc_mcu7t5v0__fill_2
XTAP_TAPCELL_ROW_39_581 VDD VSS gf180mcu_fd_sc_mcu7t5v0__filltie
XFILLER_71_397 VDD VDD VSS VSS gf180mcu_fd_sc_mcu7t5v0__fill_2
XFILLER_12_475 VDD VDD VSS VSS gf180mcu_fd_sc_mcu7t5v0__fill_1
XFILLER_33_72 VDD VDD VSS VSS gf180mcu_fd_sc_mcu7t5v0__fillcap_32
XFILLER_8_457 VDD VDD VSS VSS gf180mcu_fd_sc_mcu7t5v0__fillcap_16
X_2110_ _2093_/Z _2105_/Z _2110_/A3 _2110_/ZN VDD VDD VSS VSS gf180mcu_fd_sc_mcu7t5v0__xnor3_2
X_3090_ _3661_/Q _3090_/ZN VDD VDD VSS VSS gf180mcu_fd_sc_mcu7t5v0__clkinv_1
XFILLER_39_328 VDD VDD VSS VSS gf180mcu_fd_sc_mcu7t5v0__fill_2
X_2041_ _2057_/A1 _2057_/A2 _2041_/Z VDD VDD VSS VSS gf180mcu_fd_sc_mcu7t5v0__xor2_2
XFILLER_66_147 VDD VDD VSS VSS gf180mcu_fd_sc_mcu7t5v0__fillcap_4
XTAP_TAPCELL_ROW_65_827 VDD VSS gf180mcu_fd_sc_mcu7t5v0__filltie
XFILLER_35_578 VDD VDD VSS VSS gf180mcu_fd_sc_mcu7t5v0__fill_2
XFILLER_95_2 VDD VDD VSS VSS gf180mcu_fd_sc_mcu7t5v0__fillcap_64
X_2943_ _2943_/A1 _2943_/A2 _2943_/B _3709_/D VDD VDD VSS VSS gf180mcu_fd_sc_mcu7t5v0__oai21_1
X_2874_ _3558_/A2 _2877_/A2 _2874_/B1 _2874_/B2 _3681_/D VDD VDD VSS VSS gf180mcu_fd_sc_mcu7t5v0__oai22_1
X_1825_ _3039_/I _1823_/Z _1843_/A2 VDD VDD VSS VSS gf180mcu_fd_sc_mcu7t5v0__nand2_1
XFILLER_30_294 VDD VDD VSS VSS gf180mcu_fd_sc_mcu7t5v0__fill_2
XFILLER_89_206 VDD VDD VSS VSS gf180mcu_fd_sc_mcu7t5v0__fillcap_4
X_3426_ _3426_/A1 _3425_/Z _3430_/B VDD VDD VSS VSS gf180mcu_fd_sc_mcu7t5v0__nor2_1
XFILLER_85_401 VDD VDD VSS VSS gf180mcu_fd_sc_mcu7t5v0__fillcap_8
X_3357_ _3357_/A1 _3354_/B _3357_/B _2116_/B VDD VDD VSS VSS gf180mcu_fd_sc_mcu7t5v0__aoi21_2
X_2308_ _3747_/Q _3010_/I _2309_/I VDD VDD VSS VSS gf180mcu_fd_sc_mcu7t5v0__nand2_1
Xload_slew371 _2762_/A2 _2772_/A2 VDD VDD VSS VSS gf180mcu_fd_sc_mcu7t5v0__clkbuf_2
Xload_slew382 _2823_/A1 _2813_/A1 VDD VDD VSS VSS gf180mcu_fd_sc_mcu7t5v0__buf_1
X_3288_ _3231_/Z _3251_/C _3288_/Z VDD VDD VSS VSS gf180mcu_fd_sc_mcu7t5v0__and2_1
Xload_slew393 _2192_/A2 _2154_/A2 VDD VDD VSS VSS gf180mcu_fd_sc_mcu7t5v0__buf_1
XFILLER_57_136 VDD VDD VSS VSS gf180mcu_fd_sc_mcu7t5v0__fillcap_4
XFILLER_73_607 VDD VDD VSS VSS gf180mcu_fd_sc_mcu7t5v0__fill_1
XFILLER_85_489 VDD VDD VSS VSS gf180mcu_fd_sc_mcu7t5v0__fill_1
X_2239_ _3084_/ZN _3662_/Q _2222_/B _2240_/A2 VDD VDD VSS VSS gf180mcu_fd_sc_mcu7t5v0__nand3_1
XFILLER_13_206 VDD VDD VSS VSS gf180mcu_fd_sc_mcu7t5v0__fillcap_4
XTAP_TAPCELL_ROW_36_551 VDD VSS gf180mcu_fd_sc_mcu7t5v0__filltie
XFILLER_41_504 VDD VDD VSS VSS gf180mcu_fd_sc_mcu7t5v0__fillcap_8
XTAP_TAPCELL_ROW_0_198 VDD VSS gf180mcu_fd_sc_mcu7t5v0__filltie
XFILLER_21_261 VDD VDD VSS VSS gf180mcu_fd_sc_mcu7t5v0__fill_2
XFILLER_21_272 VDD VDD VSS VSS gf180mcu_fd_sc_mcu7t5v0__fillcap_8
XFILLER_70_37 VDD VDD VSS VSS gf180mcu_fd_sc_mcu7t5v0__fillcap_64
XTAP_TAPCELL_ROW_8_287 VDD VSS gf180mcu_fd_sc_mcu7t5v0__filltie
XFILLER_36_309 VDD VDD VSS VSS gf180mcu_fd_sc_mcu7t5v0__fillcap_4
XFILLER_29_372 VDD VDD VSS VSS gf180mcu_fd_sc_mcu7t5v0__fill_2
XTAP_TAPCELL_ROW_70_874 VDD VSS gf180mcu_fd_sc_mcu7t5v0__filltie
X_2590_ wire622/I _2590_/A2 _2591_/C VDD VDD VSS VSS gf180mcu_fd_sc_mcu7t5v0__nor2_1
X_3211_ _3213_/A1 _3206_/Z _3212_/A3 VDD VDD VSS VSS gf180mcu_fd_sc_mcu7t5v0__nor2_1
X_3142_ wire541/Z input82/Z _3775_/D VDD VDD VSS VSS gf180mcu_fd_sc_mcu7t5v0__and2_1
XTAP_TAPCELL_ROW_78_952 VDD VSS gf180mcu_fd_sc_mcu7t5v0__filltie
XFILLER_10_2 VDD VDD VSS VSS gf180mcu_fd_sc_mcu7t5v0__fillcap_32
XFILLER_67_478 VDD VDD VSS VSS gf180mcu_fd_sc_mcu7t5v0__fill_2
XFILLER_67_489 VDD VDD VSS VSS gf180mcu_fd_sc_mcu7t5v0__fill_1
X_3073_ _3685_/Q _3612_/A2 VDD VDD VSS VSS gf180mcu_fd_sc_mcu7t5v0__clkinv_1
X_2024_ _2022_/Z _2024_/A2 _2024_/Z VDD VDD VSS VSS gf180mcu_fd_sc_mcu7t5v0__xor2_2
XFILLER_35_364 VDD VDD VSS VSS gf180mcu_fd_sc_mcu7t5v0__fill_2
XTAP_TAPCELL_ROW_33_521 VDD VSS gf180mcu_fd_sc_mcu7t5v0__filltie
XFILLER_50_367 VDD VDD VSS VSS gf180mcu_fd_sc_mcu7t5v0__fillcap_8
X_2926_ _3520_/A1 _2927_/A2 _2927_/B VDD VDD VSS VSS gf180mcu_fd_sc_mcu7t5v0__nand2_1
X_2857_ _3055_/I wire231/I _2859_/B1 VDD VDD VSS VSS gf180mcu_fd_sc_mcu7t5v0__nor2_1
X_1808_ _1808_/A1 _1808_/A2 _1808_/B _1865_/A1 VDD VDD VSS VSS gf180mcu_fd_sc_mcu7t5v0__aoi21_2
X_2788_ _2798_/A1 _2788_/A2 _2789_/B2 VDD VDD VSS VSS gf180mcu_fd_sc_mcu7t5v0__nand2_1
XFILLER_2_419 VDD VDD VSS VSS gf180mcu_fd_sc_mcu7t5v0__fill_1
X_3409_ _3409_/A1 _3376_/Z _3394_/Z _3409_/B1 _3381_/I _3409_/B3 wire292/I VDD VDD
+ VSS VSS gf180mcu_fd_sc_mcu7t5v0__oai33_4
XTAP_TAPCELL_ROW_5_257 VDD VSS gf180mcu_fd_sc_mcu7t5v0__filltie
XFILLER_58_445 VDD VDD VSS VSS gf180mcu_fd_sc_mcu7t5v0__fillcap_8
XFILLER_73_415 VDD VDD VSS VSS gf180mcu_fd_sc_mcu7t5v0__fillcap_4
XTAP_TAPCELL_ROW_86_1029 VDD VSS gf180mcu_fd_sc_mcu7t5v0__filltie
XFILLER_14_504 VDD VDD VSS VSS gf180mcu_fd_sc_mcu7t5v0__fill_1
XFILLER_53_150 VDD VDD VSS VSS gf180mcu_fd_sc_mcu7t5v0__fill_2
XFILLER_81_492 VDD VDD VSS VSS gf180mcu_fd_sc_mcu7t5v0__fill_2
XFILLER_41_301 VDD VDD VSS VSS gf180mcu_fd_sc_mcu7t5v0__fillcap_16
XFILLER_41_367 VDD VDD VSS VSS gf180mcu_fd_sc_mcu7t5v0__fillcap_16
XFILLER_5_224 VDD VDD VSS VSS gf180mcu_fd_sc_mcu7t5v0__fill_2
XFILLER_5_279 VDD VDD VSS VSS gf180mcu_fd_sc_mcu7t5v0__fill_1
XFILLER_89_570 VDD VDD VSS VSS gf180mcu_fd_sc_mcu7t5v0__fillcap_16
XTAP_TAPCELL_ROW_75_922 VDD VSS gf180mcu_fd_sc_mcu7t5v0__filltie
XFILLER_49_489 VDD VDD VSS VSS gf180mcu_fd_sc_mcu7t5v0__fill_1
XFILLER_91_212 VDD VDD VSS VSS gf180mcu_fd_sc_mcu7t5v0__fillcap_64
XFILLER_36_139 VDD VDD VSS VSS gf180mcu_fd_sc_mcu7t5v0__fillcap_8
XFILLER_17_364 VDD VDD VSS VSS gf180mcu_fd_sc_mcu7t5v0__fill_1
XTAP_TAPCELL_ROW_47_657 VDD VSS gf180mcu_fd_sc_mcu7t5v0__filltie
XFILLER_17_397 VDD VDD VSS VSS gf180mcu_fd_sc_mcu7t5v0__fillcap_8
XFILLER_32_312 VDD VDD VSS VSS gf180mcu_fd_sc_mcu7t5v0__fill_2
XFILLER_60_610 VDD VDD VSS VSS gf180mcu_fd_sc_mcu7t5v0__fill_2
X_3760_ _3760_/D wire557/I clkload1/I _3760_/Q VDD VDD VSS VSS gf180mcu_fd_sc_mcu7t5v0__dffrnq_1
XFILLER_13_581 VDD VDD VSS VSS gf180mcu_fd_sc_mcu7t5v0__fillcap_8
X_2711_ wire516/Z _2703_/Z _2711_/B _2711_/C _2712_/B2 VDD VDD VSS VSS gf180mcu_fd_sc_mcu7t5v0__oai211_1
XFILLER_9_574 VDD VDD VSS VSS gf180mcu_fd_sc_mcu7t5v0__fillcap_8
X_3691_ _3691_/D wire612/I _3694_/CLK _3691_/Q VDD VDD VSS VSS gf180mcu_fd_sc_mcu7t5v0__dffrnq_2
X_2642_ _2694_/B _2646_/A1 VDD VDD VSS VSS gf180mcu_fd_sc_mcu7t5v0__clkinv_1
X_2573_ _2578_/A1 _2573_/A2 _2573_/A3 _2576_/B VDD VDD VSS VSS gf180mcu_fd_sc_mcu7t5v0__nor3_1
XFILLER_58_2 VDD VDD VSS VSS gf180mcu_fd_sc_mcu7t5v0__fillcap_32
XFILLER_67_220 VDD VDD VSS VSS gf180mcu_fd_sc_mcu7t5v0__fill_2
XFILLER_95_562 VDD VDD VSS VSS gf180mcu_fd_sc_mcu7t5v0__fillcap_64
XTAP_TAPCELL_ROW_2_227 VDD VSS gf180mcu_fd_sc_mcu7t5v0__filltie
X_3125_ _3122_/Z _3125_/A2 _3125_/A3 _3131_/A1 VDD VDD VSS VSS gf180mcu_fd_sc_mcu7t5v0__nand3_1
X_3056_ _3056_/I _3056_/ZN VDD VDD VSS VSS gf180mcu_fd_sc_mcu7t5v0__clkinv_1
XFILLER_67_286 VDD VDD VSS VSS gf180mcu_fd_sc_mcu7t5v0__fillcap_8
X_2007_ _3193_/A2 _3064_/I _2007_/B _2008_/I VDD VDD VSS VSS gf180mcu_fd_sc_mcu7t5v0__oai21_1
XFILLER_63_492 VDD VDD VSS VSS gf180mcu_fd_sc_mcu7t5v0__fillcap_16
XFILLER_63_481 VDD VDD VSS VSS gf180mcu_fd_sc_mcu7t5v0__fill_1
XTAP_TAPCELL_ROW_18_381 VDD VSS gf180mcu_fd_sc_mcu7t5v0__filltie
XFILLER_23_334 VDD VDD VSS VSS gf180mcu_fd_sc_mcu7t5v0__fill_2
XFILLER_35_194 VDD VDD VSS VSS gf180mcu_fd_sc_mcu7t5v0__fill_1
XFILLER_51_676 VDD VDD VSS VSS gf180mcu_fd_sc_mcu7t5v0__fill_1
XFILLER_50_186 VDD VDD VSS VSS gf180mcu_fd_sc_mcu7t5v0__fillcap_8
X_2909_ _3694_/Q _2910_/A1 _2910_/B VDD VDD VSS VSS gf180mcu_fd_sc_mcu7t5v0__nand2_1
XTAP_TAPCELL_ROW_92_1077 VDD VSS gf180mcu_fd_sc_mcu7t5v0__filltie
Xfanout542 wire548/Z _2422_/A2 VDD VDD VSS VSS gf180mcu_fd_sc_mcu7t5v0__dlyb_1
XFILLER_46_437 VDD VDD VSS VSS gf180mcu_fd_sc_mcu7t5v0__fillcap_4
XFILLER_73_212 VDD VDD VSS VSS gf180mcu_fd_sc_mcu7t5v0__fillcap_32
XTAP_TAPCELL_ROW_44_627 VDD VSS gf180mcu_fd_sc_mcu7t5v0__filltie
XFILLER_42_643 VDD VDD VSS VSS gf180mcu_fd_sc_mcu7t5v0__fill_2
XFILLER_6_522 VDD VDD VSS VSS gf180mcu_fd_sc_mcu7t5v0__fill_2
XFILLER_41_72 VDD VDD VSS VSS gf180mcu_fd_sc_mcu7t5v0__fillcap_32
XFILLER_77_540 VDD VDD VSS VSS gf180mcu_fd_sc_mcu7t5v0__fill_1
XFILLER_1_271 VDD VDD VSS VSS gf180mcu_fd_sc_mcu7t5v0__fill_2
XFILLER_92_521 VDD VDD VSS VSS gf180mcu_fd_sc_mcu7t5v0__fillcap_4
XFILLER_18_640 VDD VDD VSS VSS gf180mcu_fd_sc_mcu7t5v0__fill_2
XFILLER_33_621 VDD VDD VSS VSS gf180mcu_fd_sc_mcu7t5v0__fill_1
XFILLER_52_429 VDD VDD VSS VSS gf180mcu_fd_sc_mcu7t5v0__fillcap_8
XFILLER_33_632 VDD VDD VSS VSS gf180mcu_fd_sc_mcu7t5v0__fill_1
XTAP_TAPCELL_ROW_15_351 VDD VSS gf180mcu_fd_sc_mcu7t5v0__filltie
XFILLER_32_153 VDD VDD VSS VSS gf180mcu_fd_sc_mcu7t5v0__fill_2
X_3743_ _3743_/D wire589/Z clkload9/I _3743_/Q VDD VDD VSS VSS gf180mcu_fd_sc_mcu7t5v0__dffrnq_2
X_3674_ _3674_/D _3717_/RN _3717_/CLK _3674_/Q VDD VDD VSS VSS gf180mcu_fd_sc_mcu7t5v0__dffrnq_1
X_2625_ _3103_/B2 input53/Z _2625_/Z VDD VDD VSS VSS gf180mcu_fd_sc_mcu7t5v0__and2_1
Xoutput101 _3219_/Z cal_phase0_offset[20] VDD VDD VSS VSS gf180mcu_fd_sc_mcu7t5v0__buf_2
Xoutput123 _1831_/ZN cal_phase270_offset[2] VDD VDD VSS VSS gf180mcu_fd_sc_mcu7t5v0__buf_2
Xoutput112 _1984_/Z cal_phase270_offset[11] VDD VDD VSS VSS gf180mcu_fd_sc_mcu7t5v0__buf_2
Xoutput134 _3548_/Z cal_phase90_offset[12] VDD VDD VSS VSS gf180mcu_fd_sc_mcu7t5v0__buf_2
X_2556_ _2556_/A1 _2518_/Z _2556_/Z VDD VDD VSS VSS gf180mcu_fd_sc_mcu7t5v0__xor2_1
Xoutput156 _2225_/A2 delay_wave_cycle[3] VDD VDD VSS VSS gf180mcu_fd_sc_mcu7t5v0__buf_2
Xoutput167 _3679_/Q raw_edge1[11] VDD VDD VSS VSS gf180mcu_fd_sc_mcu7t5v0__buf_2
Xoutput145 _3398_/Z cal_phase90_offset[3] VDD VDD VSS VSS gf180mcu_fd_sc_mcu7t5v0__buf_2
X_2487_ _3101_/B2 input72/Z _2494_/A1 VDD VDD VSS VSS gf180mcu_fd_sc_mcu7t5v0__nand2_1
Xoutput178 _3670_/Q raw_edge1[2] VDD VDD VSS VSS gf180mcu_fd_sc_mcu7t5v0__buf_2
Xoutput189 _3520_/A1 raw_edge2[12] VDD VDD VSS VSS gf180mcu_fd_sc_mcu7t5v0__buf_2
XFILLER_68_551 VDD VDD VSS VSS gf180mcu_fd_sc_mcu7t5v0__fillcap_4
XFILLER_83_532 VDD VDD VSS VSS gf180mcu_fd_sc_mcu7t5v0__fill_2
X_3108_ input37/Z _3110_/B2 input36/Z _3108_/B2 _3109_/B VDD VDD VSS VSS gf180mcu_fd_sc_mcu7t5v0__oai22_1
XFILLER_55_212 VDD VDD VSS VSS gf180mcu_fd_sc_mcu7t5v0__fillcap_4
X_3039_ _3039_/I _3388_/A1 VDD VDD VSS VSS gf180mcu_fd_sc_mcu7t5v0__clkinv_1
XFILLER_24_610 VDD VDD VSS VSS gf180mcu_fd_sc_mcu7t5v0__fill_2
XFILLER_36_481 VDD VDD VSS VSS gf180mcu_fd_sc_mcu7t5v0__fillcap_4
XFILLER_43_418 VDD VDD VSS VSS gf180mcu_fd_sc_mcu7t5v0__fill_2
XFILLER_23_142 VDD VDD VSS VSS gf180mcu_fd_sc_mcu7t5v0__fillcap_64
Xfanout372 _2124_/Z wire374/I VDD VDD VSS VSS gf180mcu_fd_sc_mcu7t5v0__dlyb_1
XFILLER_59_562 VDD VDD VSS VSS gf180mcu_fd_sc_mcu7t5v0__fillcap_16
Xfanout394 wire400/Z wire397/I VDD VDD VSS VSS gf180mcu_fd_sc_mcu7t5v0__dlyb_1
XTAP_TAPCELL_ROW_57_752 VDD VSS gf180mcu_fd_sc_mcu7t5v0__filltie
XTAP_TAPCELL_ROW_29_487 VDD VSS gf180mcu_fd_sc_mcu7t5v0__filltie
XFILLER_15_632 VDD VDD VSS VSS gf180mcu_fd_sc_mcu7t5v0__fill_2
XTAP_TAPCELL_ROW_12_321 VDD VSS gf180mcu_fd_sc_mcu7t5v0__filltie
Xinput14 cfg_f_MEMS_fcw[5] input14/Z VDD VDD VSS VSS gf180mcu_fd_sc_mcu7t5v0__buf_3
Xinput25 cfg_phase0_offset[15] input25/Z VDD VDD VSS VSS gf180mcu_fd_sc_mcu7t5v0__buf_1
Xinput36 cfg_phase0_offset[6] input36/Z VDD VDD VSS VSS gf180mcu_fd_sc_mcu7t5v0__buf_1
Xinput69 cfg_phase90_offset[17] _3017_/I VDD VDD VSS VSS gf180mcu_fd_sc_mcu7t5v0__buf_1
Xinput58 cfg_phase270_offset[7] _3001_/I VDD VDD VSS VSS gf180mcu_fd_sc_mcu7t5v0__buf_1
Xinput47 cfg_phase270_offset[16] _2675_/B VDD VDD VSS VSS gf180mcu_fd_sc_mcu7t5v0__buf_1
X_2410_ _2986_/I input14/Z _2410_/A3 _2410_/Z VDD VDD VSS VSS gf180mcu_fd_sc_mcu7t5v0__xor3_1
X_3390_ _3420_/A1 _3389_/I _3420_/C _3401_/A2 VDD VDD VSS VSS gf180mcu_fd_sc_mcu7t5v0__oai21_1
XFILLER_96_101 VDD VDD VSS VSS gf180mcu_fd_sc_mcu7t5v0__fill_1
X_2341_ _2981_/I _3006_/I _2341_/B _2425_/A3 VDD VDD VSS VSS gf180mcu_fd_sc_mcu7t5v0__aoi21_1
XFILLER_2_580 VDD VDD VSS VSS gf180mcu_fd_sc_mcu7t5v0__fillcap_8
X_2272_ _3722_/Q _2280_/A1 _2274_/B VDD VDD VSS VSS gf180mcu_fd_sc_mcu7t5v0__nand2_1
XFILLER_37_212 VDD VDD VSS VSS gf180mcu_fd_sc_mcu7t5v0__fillcap_4
XFILLER_37_201 VDD VDD VSS VSS gf180mcu_fd_sc_mcu7t5v0__fill_2
XFILLER_80_502 VDD VDD VSS VSS gf180mcu_fd_sc_mcu7t5v0__fill_2
XFILLER_33_440 VDD VDD VSS VSS gf180mcu_fd_sc_mcu7t5v0__fill_2
XFILLER_20_101 VDD VDD VSS VSS gf180mcu_fd_sc_mcu7t5v0__fillcap_4
X_1987_ _2004_/B _1989_/A3 _1987_/Z VDD VDD VSS VSS gf180mcu_fd_sc_mcu7t5v0__xor2_1
X_3726_ _3726_/D _3726_/RN clkload3/I _3726_/Q VDD VDD VSS VSS gf180mcu_fd_sc_mcu7t5v0__dffrnq_4
X_3657_ _3657_/D wire552/Z clkload8/I _3657_/Q VDD VDD VSS VSS gf180mcu_fd_sc_mcu7t5v0__dffrnq_2
X_2608_ _2608_/A1 _2608_/A2 _2608_/B _2609_/A4 VDD VDD VSS VSS gf180mcu_fd_sc_mcu7t5v0__oai21_1
X_3588_ _2051_/B _3683_/Q _3585_/Z _3589_/B VDD VDD VSS VSS gf180mcu_fd_sc_mcu7t5v0__xor3_1
X_2539_ _2595_/A1 _2595_/A2 _2539_/A3 _2603_/A1 VDD VDD VSS VSS gf180mcu_fd_sc_mcu7t5v0__nand3_1
XTAP_TAPCELL_ROW_54_722 VDD VSS gf180mcu_fd_sc_mcu7t5v0__filltie
XTAP_TAPCELL_ROW_26_457 VDD VSS gf180mcu_fd_sc_mcu7t5v0__filltie
XFILLER_8_628 VDD VDD VSS VSS gf180mcu_fd_sc_mcu7t5v0__fill_1
XFILLER_78_101 VDD VDD VSS VSS gf180mcu_fd_sc_mcu7t5v0__fillcap_4
XFILLER_19_212 VDD VDD VSS VSS gf180mcu_fd_sc_mcu7t5v0__fillcap_16
XFILLER_74_384 VDD VDD VSS VSS gf180mcu_fd_sc_mcu7t5v0__fill_1
XFILLER_74_395 VDD VDD VSS VSS gf180mcu_fd_sc_mcu7t5v0__fillcap_4
X_1910_ _1911_/A1 _1911_/A2 _1910_/B _1960_/A2 VDD VDD VSS VSS gf180mcu_fd_sc_mcu7t5v0__aoi21_1
X_2890_ wire419/Z wire269/I _2892_/B1 VDD VDD VSS VSS gf180mcu_fd_sc_mcu7t5v0__nor2_1
X_1841_ wire515/Z _3419_/A1 _1842_/A3 _1841_/Z VDD VDD VSS VSS gf180mcu_fd_sc_mcu7t5v0__xor3_2
XFILLER_6_171 VDD VDD VSS VSS gf180mcu_fd_sc_mcu7t5v0__fillcap_4
X_3511_ _3511_/A1 _3513_/A3 _3511_/B _3512_/I VDD VDD VSS VSS gf180mcu_fd_sc_mcu7t5v0__oai21_1
X_3442_ _3442_/A1 _3440_/I _3445_/B VDD VDD VSS VSS gf180mcu_fd_sc_mcu7t5v0__xnor2_1
XFILLER_40_2 VDD VDD VSS VSS gf180mcu_fd_sc_mcu7t5v0__fillcap_32
X_3373_ _3015_/I _3372_/Z _3409_/A1 VDD VDD VSS VSS gf180mcu_fd_sc_mcu7t5v0__nor2_1
X_2324_ _2324_/A1 _2574_/C _2324_/B _2402_/A2 VDD VDD VSS VSS gf180mcu_fd_sc_mcu7t5v0__oai21_1
Xload_slew520 _2443_/A2 _2121_/A3 VDD VDD VSS VSS gf180mcu_fd_sc_mcu7t5v0__buf_2
Xload_slew531 _2446_/B _2445_/A1 VDD VDD VSS VSS gf180mcu_fd_sc_mcu7t5v0__clkbuf_1
Xload_slew553 wire554/Z wire552/I VDD VDD VSS VSS gf180mcu_fd_sc_mcu7t5v0__buf_1
Xload_slew564 _3778_/RN _3731_/RN VDD VDD VSS VSS gf180mcu_fd_sc_mcu7t5v0__clkbuf_2
X_2255_ _2255_/A1 _2255_/A2 _2255_/A3 _2264_/B VDD VDD VSS VSS gf180mcu_fd_sc_mcu7t5v0__nand3_1
Xload_slew575 _3728_/RN _3729_/RN VDD VDD VSS VSS gf180mcu_fd_sc_mcu7t5v0__clkbuf_2
X_2186_ _2186_/A1 _2186_/A2 _2186_/B _2187_/B VDD VDD VSS VSS gf180mcu_fd_sc_mcu7t5v0__aoi21_1
XTAP_TAPCELL_ROW_68_858 VDD VSS gf180mcu_fd_sc_mcu7t5v0__filltie
XFILLER_53_513 VDD VDD VSS VSS gf180mcu_fd_sc_mcu7t5v0__fill_1
XFILLER_80_365 VDD VDD VSS VSS gf180mcu_fd_sc_mcu7t5v0__fill_2
XFILLER_40_207 VDD VDD VSS VSS gf180mcu_fd_sc_mcu7t5v0__fillcap_8
XFILLER_80_387 VDD VDD VSS VSS gf180mcu_fd_sc_mcu7t5v0__fillcap_8
XTAP_TAPCELL_ROW_23_427 VDD VSS gf180mcu_fd_sc_mcu7t5v0__filltie
X_3709_ _3709_/D _3731_/RN clkload4/I _3709_/Q VDD VDD VSS VSS gf180mcu_fd_sc_mcu7t5v0__dffrnq_4
XFILLER_0_303 VDD VDD VSS VSS gf180mcu_fd_sc_mcu7t5v0__fill_2
XFILLER_68_37 VDD VDD VSS VSS gf180mcu_fd_sc_mcu7t5v0__fillcap_64
XFILLER_48_329 VDD VDD VSS VSS gf180mcu_fd_sc_mcu7t5v0__fill_1
XTAP_TAPCELL_ROW_89_1049 VDD VSS gf180mcu_fd_sc_mcu7t5v0__filltie
XFILLER_90_107 VDD VDD VSS VSS gf180mcu_fd_sc_mcu7t5v0__fillcap_64
XFILLER_44_524 VDD VDD VSS VSS gf180mcu_fd_sc_mcu7t5v0__fill_1
XTAP_TAPCELL_ROW_39_582 VDD VSS gf180mcu_fd_sc_mcu7t5v0__filltie
XFILLER_44_546 VDD VDD VSS VSS gf180mcu_fd_sc_mcu7t5v0__fill_1
XFILLER_56_384 VDD VDD VSS VSS gf180mcu_fd_sc_mcu7t5v0__fill_1
XFILLER_4_653 VDD VDD VSS VSS gf180mcu_fd_sc_mcu7t5v0__fillcap_8
XFILLER_4_675 VDD VDD VSS VSS gf180mcu_fd_sc_mcu7t5v0__fill_2
XFILLER_94_457 VDD VDD VSS VSS gf180mcu_fd_sc_mcu7t5v0__fillcap_64
X_2040_ _2040_/A1 _2071_/A2 _2057_/A2 VDD VDD VSS VSS gf180mcu_fd_sc_mcu7t5v0__nand2_1
XFILLER_47_362 VDD VDD VSS VSS gf180mcu_fd_sc_mcu7t5v0__fillcap_4
XTAP_TAPCELL_ROW_65_828 VDD VSS gf180mcu_fd_sc_mcu7t5v0__filltie
XFILLER_35_524 VDD VDD VSS VSS gf180mcu_fd_sc_mcu7t5v0__fill_1
XFILLER_62_365 VDD VDD VSS VSS gf180mcu_fd_sc_mcu7t5v0__fillcap_8
XFILLER_62_387 VDD VDD VSS VSS gf180mcu_fd_sc_mcu7t5v0__fill_2
X_2942_ _3709_/Q _2943_/A2 _2943_/B VDD VDD VSS VSS gf180mcu_fd_sc_mcu7t5v0__nand2_1
XFILLER_88_2 VDD VDD VSS VSS gf180mcu_fd_sc_mcu7t5v0__fillcap_32
X_2873_ _2873_/A1 wire269/Z _2885_/B _2874_/B2 VDD VDD VSS VSS gf180mcu_fd_sc_mcu7t5v0__oai21_1
X_1824_ _3039_/I _1823_/Z _1824_/Z VDD VDD VSS VSS gf180mcu_fd_sc_mcu7t5v0__and2_1
Xclkbuf_4_4_0_clk clkbuf_0_clk/Z clkload3/I VDD VDD VSS VSS gf180mcu_fd_sc_mcu7t5v0__clkbuf_8
X_3425_ _3425_/A1 _3435_/A1 _3435_/A2 _3425_/Z VDD VDD VSS VSS gf180mcu_fd_sc_mcu7t5v0__xor3_1
X_3356_ _3668_/Q _3360_/A2 _3357_/B VDD VDD VSS VSS gf180mcu_fd_sc_mcu7t5v0__nand2_1
XFILLER_58_605 VDD VDD VSS VSS gf180mcu_fd_sc_mcu7t5v0__fillcap_4
Xload_slew350 _3270_/B _3306_/A2 VDD VDD VSS VSS gf180mcu_fd_sc_mcu7t5v0__buf_2
X_3287_ _3271_/B _3287_/A2 _3289_/A2 VDD VDD VSS VSS gf180mcu_fd_sc_mcu7t5v0__nand2_1
X_2307_ _2984_/I _2414_/A2 _2333_/B VDD VDD VSS VSS gf180mcu_fd_sc_mcu7t5v0__nand2_1
Xload_slew383 _2299_/A1 _2823_/A1 VDD VDD VSS VSS gf180mcu_fd_sc_mcu7t5v0__buf_2
X_2238_ _3739_/Q _3667_/Q _2238_/A3 _2238_/Z VDD VDD VSS VSS gf180mcu_fd_sc_mcu7t5v0__xor3_1
XFILLER_57_159 VDD VDD VSS VSS gf180mcu_fd_sc_mcu7t5v0__fillcap_32
XFILLER_26_513 VDD VDD VSS VSS gf180mcu_fd_sc_mcu7t5v0__fill_2
XFILLER_38_373 VDD VDD VSS VSS gf180mcu_fd_sc_mcu7t5v0__fillcap_4
XFILLER_72_107 VDD VDD VSS VSS gf180mcu_fd_sc_mcu7t5v0__fillcap_64
X_2169_ _3745_/Q _2165_/Z _2169_/B1 wire468/Z _2170_/B VDD VDD VSS VSS gf180mcu_fd_sc_mcu7t5v0__aoi22_1
XFILLER_38_395 VDD VDD VSS VSS gf180mcu_fd_sc_mcu7t5v0__fillcap_4
XTAP_TAPCELL_ROW_36_552 VDD VSS gf180mcu_fd_sc_mcu7t5v0__filltie
XFILLER_41_516 VDD VDD VSS VSS gf180mcu_fd_sc_mcu7t5v0__fill_1
XTAP_TAPCELL_ROW_0_199 VDD VSS gf180mcu_fd_sc_mcu7t5v0__filltie
XFILLER_21_240 VDD VDD VSS VSS gf180mcu_fd_sc_mcu7t5v0__fill_2
XTAP_TAPCELL_ROW_8_288 VDD VSS gf180mcu_fd_sc_mcu7t5v0__filltie
XFILLER_0_133 VDD VDD VSS VSS gf180mcu_fd_sc_mcu7t5v0__fill_2
XFILLER_49_605 VDD VDD VSS VSS gf180mcu_fd_sc_mcu7t5v0__fill_1
XFILLER_76_457 VDD VDD VSS VSS gf180mcu_fd_sc_mcu7t5v0__fillcap_4
XFILLER_48_159 VDD VDD VSS VSS gf180mcu_fd_sc_mcu7t5v0__fill_1
XFILLER_91_416 VDD VDD VSS VSS gf180mcu_fd_sc_mcu7t5v0__fillcap_4
XFILLER_76_479 VDD VDD VSS VSS gf180mcu_fd_sc_mcu7t5v0__fillcap_16
XFILLER_56_181 VDD VDD VSS VSS gf180mcu_fd_sc_mcu7t5v0__fill_1
XFILLER_44_354 VDD VDD VSS VSS gf180mcu_fd_sc_mcu7t5v0__fillcap_16
XFILLER_32_527 VDD VDD VSS VSS gf180mcu_fd_sc_mcu7t5v0__fillcap_8
XTAP_TAPCELL_ROW_70_875 VDD VSS gf180mcu_fd_sc_mcu7t5v0__filltie
XFILLER_12_273 VDD VDD VSS VSS gf180mcu_fd_sc_mcu7t5v0__fill_1
XFILLER_5_66 VDD VDD VSS VSS gf180mcu_fd_sc_mcu7t5v0__fillcap_4
X_3210_ wire528/I _3210_/A2 _3213_/A3 VDD VDD VSS VSS gf180mcu_fd_sc_mcu7t5v0__nor2_1
X_3141_ wire541/Z _3775_/Q _3776_/D VDD VDD VSS VSS gf180mcu_fd_sc_mcu7t5v0__and2_1
XFILLER_67_413 VDD VDD VSS VSS gf180mcu_fd_sc_mcu7t5v0__fill_1
XTAP_TAPCELL_ROW_78_953 VDD VSS gf180mcu_fd_sc_mcu7t5v0__filltie
XPHY_EDGE_ROW_19_Left_116 VDD VSS gf180mcu_fd_sc_mcu7t5v0__endcap
XFILLER_54_107 VDD VDD VSS VSS gf180mcu_fd_sc_mcu7t5v0__fillcap_16
X_3072_ _3706_/Q _3072_/ZN VDD VDD VSS VSS gf180mcu_fd_sc_mcu7t5v0__inv_2
X_2023_ _2023_/A1 _2038_/A1 _2023_/B _2024_/A2 VDD VDD VSS VSS gf180mcu_fd_sc_mcu7t5v0__aoi21_1
XFILLER_23_516 VDD VDD VSS VSS gf180mcu_fd_sc_mcu7t5v0__fill_2
XFILLER_62_173 VDD VDD VSS VSS gf180mcu_fd_sc_mcu7t5v0__fill_2
XTAP_TAPCELL_ROW_33_522 VDD VSS gf180mcu_fd_sc_mcu7t5v0__filltie
XFILLER_50_346 VDD VDD VSS VSS gf180mcu_fd_sc_mcu7t5v0__fill_2
X_2925_ _2927_/A2 _2967_/A2 _2925_/B _3700_/D VDD VDD VSS VSS gf180mcu_fd_sc_mcu7t5v0__oai21_1
XPHY_EDGE_ROW_28_Left_125 VDD VSS gf180mcu_fd_sc_mcu7t5v0__endcap
X_2856_ _3433_/A2 wire346/Z _2856_/B1 _2856_/B2 _3675_/D VDD VDD VSS VSS gf180mcu_fd_sc_mcu7t5v0__oai22_1
X_1807_ _1808_/B _1809_/B VDD VDD VSS VSS gf180mcu_fd_sc_mcu7t5v0__clkinv_1
X_2787_ _2827_/A1 _2787_/A2 _2787_/A3 _2788_/A2 VDD VDD VSS VSS gf180mcu_fd_sc_mcu7t5v0__nand3_1
X_3408_ _3405_/Z _3412_/A2 _3443_/A1 VDD VDD VSS VSS gf180mcu_fd_sc_mcu7t5v0__xnor2_2
XPHY_EDGE_ROW_37_Left_134 VDD VSS gf180mcu_fd_sc_mcu7t5v0__endcap
X_3339_ _2995_/I _3340_/A2 _3339_/B _3340_/B VDD VDD VSS VSS gf180mcu_fd_sc_mcu7t5v0__oai21_1
XTAP_TAPCELL_ROW_5_258 VDD VSS gf180mcu_fd_sc_mcu7t5v0__filltie
XFILLER_85_276 VDD VDD VSS VSS gf180mcu_fd_sc_mcu7t5v0__fillcap_4
XFILLER_38_181 VDD VDD VSS VSS gf180mcu_fd_sc_mcu7t5v0__fill_2
XFILLER_26_387 VDD VDD VSS VSS gf180mcu_fd_sc_mcu7t5v0__fillcap_8
XPHY_EDGE_ROW_46_Left_143 VDD VSS gf180mcu_fd_sc_mcu7t5v0__endcap
XFILLER_5_247 VDD VDD VSS VSS gf180mcu_fd_sc_mcu7t5v0__fillcap_32
XPHY_EDGE_ROW_55_Left_152 VDD VSS gf180mcu_fd_sc_mcu7t5v0__endcap
XFILLER_1_486 VDD VDD VSS VSS gf180mcu_fd_sc_mcu7t5v0__fillcap_4
XFILLER_39_72 VDD VDD VSS VSS gf180mcu_fd_sc_mcu7t5v0__fillcap_8
XFILLER_36_107 VDD VDD VSS VSS gf180mcu_fd_sc_mcu7t5v0__fillcap_8
XFILLER_76_287 VDD VDD VSS VSS gf180mcu_fd_sc_mcu7t5v0__fill_2
XTAP_TAPCELL_ROW_75_923 VDD VSS gf180mcu_fd_sc_mcu7t5v0__filltie
XFILLER_17_343 VDD VDD VSS VSS gf180mcu_fd_sc_mcu7t5v0__fill_1
XTAP_TAPCELL_ROW_47_658 VDD VSS gf180mcu_fd_sc_mcu7t5v0__filltie
XFILLER_44_173 VDD VDD VSS VSS gf180mcu_fd_sc_mcu7t5v0__fill_2
XPHY_EDGE_ROW_64_Left_161 VDD VSS gf180mcu_fd_sc_mcu7t5v0__endcap
XFILLER_13_593 VDD VDD VSS VSS gf180mcu_fd_sc_mcu7t5v0__fill_2
X_2710_ wire656/I _2705_/Z _2711_/C VDD VDD VSS VSS gf180mcu_fd_sc_mcu7t5v0__nand2_1
X_3690_ _3690_/D _3690_/RN _3694_/CLK _3690_/Q VDD VDD VSS VSS gf180mcu_fd_sc_mcu7t5v0__dffrnq_2
X_2641_ wire358/Z _2649_/B _2694_/B VDD VDD VSS VSS gf180mcu_fd_sc_mcu7t5v0__xor2_1
X_2572_ _2573_/A2 _2573_/A3 _2572_/Z VDD VDD VSS VSS gf180mcu_fd_sc_mcu7t5v0__or2_1
XPHY_EDGE_ROW_73_Left_170 VDD VSS gf180mcu_fd_sc_mcu7t5v0__endcap
XTAP_TAPCELL_ROW_2_228 VDD VSS gf180mcu_fd_sc_mcu7t5v0__filltie
X_3124_ _3124_/A1 _3124_/A2 _3124_/B _3124_/C _3125_/A3 VDD VDD VSS VSS gf180mcu_fd_sc_mcu7t5v0__oai211_1
X_3055_ _3055_/I _3485_/A1 VDD VDD VSS VSS gf180mcu_fd_sc_mcu7t5v0__clkinv_1
XFILLER_67_298 VDD VDD VSS VSS gf180mcu_fd_sc_mcu7t5v0__fill_2
X_2006_ _3194_/A2 _3550_/A1 _2006_/B _2006_/C _2007_/B VDD VDD VSS VSS gf180mcu_fd_sc_mcu7t5v0__oai211_1
XTAP_TAPCELL_ROW_18_382 VDD VSS gf180mcu_fd_sc_mcu7t5v0__filltie
XFILLER_23_368 VDD VDD VSS VSS gf180mcu_fd_sc_mcu7t5v0__fill_1
X_2908_ _2911_/A2 _2953_/A2 _2908_/B _3693_/D VDD VDD VSS VSS gf180mcu_fd_sc_mcu7t5v0__oai21_1
X_2839_ _3670_/Q _2843_/A2 _2841_/B1 VDD VDD VSS VSS gf180mcu_fd_sc_mcu7t5v0__nor2_1
XTAP_TAPCELL_ROW_92_1078 VDD VSS gf180mcu_fd_sc_mcu7t5v0__filltie
Xfanout521 input9/Z wire525/I VDD VDD VSS VSS gf180mcu_fd_sc_mcu7t5v0__dlyb_1
XFILLER_76_37 VDD VDD VSS VSS gf180mcu_fd_sc_mcu7t5v0__fillcap_64
XFILLER_18_107 VDD VDD VSS VSS gf180mcu_fd_sc_mcu7t5v0__fillcap_64
Xfanout587 _3774_/RN _3764_/RN VDD VDD VSS VSS gf180mcu_fd_sc_mcu7t5v0__dlyb_1
XFILLER_73_268 VDD VDD VSS VSS gf180mcu_fd_sc_mcu7t5v0__fillcap_4
XTAP_TAPCELL_ROW_44_628 VDD VSS gf180mcu_fd_sc_mcu7t5v0__filltie
XTAP_TAPCELL_ROW_80_970 VDD VSS gf180mcu_fd_sc_mcu7t5v0__filltie
XFILLER_10_563 VDD VDD VSS VSS gf180mcu_fd_sc_mcu7t5v0__fillcap_4
XFILLER_2_34 VDD VDD VSS VSS gf180mcu_fd_sc_mcu7t5v0__fill_1
XFILLER_77_574 VDD VDD VSS VSS gf180mcu_fd_sc_mcu7t5v0__fillcap_8
XFILLER_64_202 VDD VDD VSS VSS gf180mcu_fd_sc_mcu7t5v0__fillcap_4
XFILLER_52_408 VDD VDD VSS VSS gf180mcu_fd_sc_mcu7t5v0__fill_1
XTAP_TAPCELL_ROW_15_352 VDD VSS gf180mcu_fd_sc_mcu7t5v0__filltie
X_3742_ _3742_/D wire589/Z clkload9/I _3742_/Q VDD VDD VSS VSS gf180mcu_fd_sc_mcu7t5v0__dffrnq_2
XFILLER_70_2 VDD VDD VSS VSS gf180mcu_fd_sc_mcu7t5v0__fillcap_32
X_3673_ _3673_/D _3673_/RN _3694_/CLK _3673_/Q VDD VDD VSS VSS gf180mcu_fd_sc_mcu7t5v0__dffrnq_2
X_2624_ _3104_/B2 input54/Z _2636_/A1 VDD VDD VSS VSS gf180mcu_fd_sc_mcu7t5v0__nand2_1
Xoutput124 _1846_/ZN cal_phase270_offset[3] VDD VDD VSS VSS gf180mcu_fd_sc_mcu7t5v0__buf_2
Xoutput113 _2001_/Z cal_phase270_offset[12] VDD VDD VSS VSS gf180mcu_fd_sc_mcu7t5v0__buf_2
Xoutput102 _3220_/Z cal_phase0_offset[2] VDD VDD VSS VSS gf180mcu_fd_sc_mcu7t5v0__buf_2
X_2555_ _2555_/A1 _2555_/A2 _2590_/A2 VDD VDD VSS VSS gf180mcu_fd_sc_mcu7t5v0__nand2_1
Xoutput157 _3664_/Q delay_wave_cycle[4] VDD VDD VSS VSS gf180mcu_fd_sc_mcu7t5v0__buf_2
Xoutput168 _3680_/Q raw_edge1[12] VDD VDD VSS VSS gf180mcu_fd_sc_mcu7t5v0__buf_2
Xoutput135 _3564_/ZN cal_phase90_offset[13] VDD VDD VSS VSS gf180mcu_fd_sc_mcu7t5v0__buf_2
Xoutput146 _3411_/Z cal_phase90_offset[4] VDD VDD VSS VSS gf180mcu_fd_sc_mcu7t5v0__buf_2
X_2486_ _3101_/B2 input72/Z _2486_/Z VDD VDD VSS VSS gf180mcu_fd_sc_mcu7t5v0__and2_1
Xoutput179 _3671_/Q raw_edge1[3] VDD VDD VSS VSS gf180mcu_fd_sc_mcu7t5v0__buf_2
XFILLER_87_338 VDD VDD VSS VSS gf180mcu_fd_sc_mcu7t5v0__fillcap_8
X_3107_ input36/Z _3107_/A2 input35/Z _3107_/B2 _3109_/A2 VDD VDD VSS VSS gf180mcu_fd_sc_mcu7t5v0__aoi22_1
XFILLER_68_585 VDD VDD VSS VSS gf180mcu_fd_sc_mcu7t5v0__fill_2
X_3038_ _3669_/Q _3365_/A1 VDD VDD VSS VSS gf180mcu_fd_sc_mcu7t5v0__clkinv_1
XFILLER_36_493 VDD VDD VSS VSS gf180mcu_fd_sc_mcu7t5v0__fillcap_32
XFILLER_51_430 VDD VDD VSS VSS gf180mcu_fd_sc_mcu7t5v0__fill_2
XFILLER_51_463 VDD VDD VSS VSS gf180mcu_fd_sc_mcu7t5v0__fill_1
XTAP_TAPCELL_ROW_57_753 VDD VSS gf180mcu_fd_sc_mcu7t5v0__filltie
XFILLER_74_577 VDD VDD VSS VSS gf180mcu_fd_sc_mcu7t5v0__fillcap_4
XFILLER_27_482 VDD VDD VSS VSS gf180mcu_fd_sc_mcu7t5v0__fill_2
XFILLER_42_430 VDD VDD VSS VSS gf180mcu_fd_sc_mcu7t5v0__fill_1
XFILLER_15_666 VDD VDD VSS VSS gf180mcu_fd_sc_mcu7t5v0__fill_2
XFILLER_42_452 VDD VDD VSS VSS gf180mcu_fd_sc_mcu7t5v0__fill_2
XFILLER_42_463 VDD VDD VSS VSS gf180mcu_fd_sc_mcu7t5v0__fill_1
XTAP_TAPCELL_ROW_12_322 VDD VSS gf180mcu_fd_sc_mcu7t5v0__filltie
Xinput15 cfg_f_MEMS_fcw[6] _3010_/I VDD VDD VSS VSS gf180mcu_fd_sc_mcu7t5v0__buf_3
Xinput37 cfg_phase0_offset[7] input37/Z VDD VDD VSS VSS gf180mcu_fd_sc_mcu7t5v0__buf_1
Xinput26 cfg_phase0_offset[16] _2972_/I VDD VDD VSS VSS gf180mcu_fd_sc_mcu7t5v0__buf_1
Xinput48 cfg_phase270_offset[17] input48/Z VDD VDD VSS VSS gf180mcu_fd_sc_mcu7t5v0__buf_1
Xinput59 cfg_phase270_offset[8] _2649_/B VDD VDD VSS VSS gf180mcu_fd_sc_mcu7t5v0__buf_1
X_2340_ _2303_/Z _2343_/A2 _2343_/A3 _2341_/B VDD VDD VSS VSS gf180mcu_fd_sc_mcu7t5v0__nor3_1
XFILLER_2_592 VDD VDD VSS VSS gf180mcu_fd_sc_mcu7t5v0__fill_2
X_2271_ _2748_/A1 _2261_/Z _2743_/B _2271_/ZN VDD VDD VSS VSS gf180mcu_fd_sc_mcu7t5v0__aoi21_1
XFILLER_69_327 VDD VDD VSS VSS gf180mcu_fd_sc_mcu7t5v0__fillcap_4
XFILLER_77_360 VDD VDD VSS VSS gf180mcu_fd_sc_mcu7t5v0__fillcap_4
XFILLER_65_544 VDD VDD VSS VSS gf180mcu_fd_sc_mcu7t5v0__fillcap_4
XFILLER_37_279 VDD VDD VSS VSS gf180mcu_fd_sc_mcu7t5v0__fill_1
XFILLER_33_474 VDD VDD VSS VSS gf180mcu_fd_sc_mcu7t5v0__fillcap_4
X_1986_ _2006_/C _2006_/B _1986_/B _1989_/A3 VDD VDD VSS VSS gf180mcu_fd_sc_mcu7t5v0__aoi21_1
X_3725_ _3725_/D _3725_/RN clkload6/I _3725_/Q VDD VDD VSS VSS gf180mcu_fd_sc_mcu7t5v0__dffrnq_2
X_3656_ _3656_/D wire594/I clkload7/I _3656_/Q VDD VDD VSS VSS gf180mcu_fd_sc_mcu7t5v0__dffrnq_1
X_2607_ _2608_/A1 _2608_/A2 _2608_/B _2607_/Z VDD VDD VSS VSS gf180mcu_fd_sc_mcu7t5v0__or3_1
X_3587_ _3587_/A1 _3585_/Z _3601_/A2 VDD VDD VSS VSS gf180mcu_fd_sc_mcu7t5v0__nor2_1
X_2538_ _2595_/A1 _2595_/A2 _2539_/A3 _2538_/Z VDD VDD VSS VSS gf180mcu_fd_sc_mcu7t5v0__and3_1
X_2469_ _2469_/A1 _3019_/I _2469_/Z VDD VDD VSS VSS gf180mcu_fd_sc_mcu7t5v0__xor2_2
XFILLER_56_522 VDD VDD VSS VSS gf180mcu_fd_sc_mcu7t5v0__fill_2
XFILLER_56_555 VDD VDD VSS VSS gf180mcu_fd_sc_mcu7t5v0__fill_2
XFILLER_68_393 VDD VDD VSS VSS gf180mcu_fd_sc_mcu7t5v0__fill_1
XFILLER_83_352 VDD VDD VSS VSS gf180mcu_fd_sc_mcu7t5v0__fill_2
XFILLER_24_430 VDD VDD VSS VSS gf180mcu_fd_sc_mcu7t5v0__fill_2
XTAP_TAPCELL_ROW_54_723 VDD VSS gf180mcu_fd_sc_mcu7t5v0__filltie
XTAP_TAPCELL_ROW_26_458 VDD VSS gf180mcu_fd_sc_mcu7t5v0__filltie
XFILLER_24_474 VDD VDD VSS VSS gf180mcu_fd_sc_mcu7t5v0__fillcap_32
XFILLER_0_2 VDD VDD VSS VSS gf180mcu_fd_sc_mcu7t5v0__fillcap_32
XFILLER_47_72 VDD VDD VSS VSS gf180mcu_fd_sc_mcu7t5v0__fillcap_64
XFILLER_34_216 VDD VDD VSS VSS gf180mcu_fd_sc_mcu7t5v0__fill_1
XFILLER_34_238 VDD VDD VSS VSS gf180mcu_fd_sc_mcu7t5v0__fillcap_4
XFILLER_15_463 VDD VDD VSS VSS gf180mcu_fd_sc_mcu7t5v0__fillcap_16
XFILLER_15_430 VDD VDD VSS VSS gf180mcu_fd_sc_mcu7t5v0__fill_2
X_1840_ _1842_/A1 _1842_/A3 _1840_/Z VDD VDD VSS VSS gf180mcu_fd_sc_mcu7t5v0__and2_1
XFILLER_30_477 VDD VDD VSS VSS gf180mcu_fd_sc_mcu7t5v0__fillcap_8
XFILLER_7_640 VDD VDD VSS VSS gf180mcu_fd_sc_mcu7t5v0__fill_1
X_3510_ _3510_/A1 _3510_/A2 _3545_/B VDD VDD VSS VSS gf180mcu_fd_sc_mcu7t5v0__nand2_1
X_3441_ _3442_/A1 _3441_/A2 _3464_/A1 VDD VDD VSS VSS gf180mcu_fd_sc_mcu7t5v0__nor2_1
X_3372_ _3375_/A2 _3375_/A3 _3372_/Z VDD VDD VSS VSS gf180mcu_fd_sc_mcu7t5v0__xor2_1
X_2323_ _3741_/Q input3/Z _2574_/C VDD VDD VSS VSS gf180mcu_fd_sc_mcu7t5v0__nand2_1
Xload_slew532 _2446_/B _2375_/A1 VDD VDD VSS VSS gf180mcu_fd_sc_mcu7t5v0__buf_2
XFILLER_33_2 VDD VDD VSS VSS gf180mcu_fd_sc_mcu7t5v0__fillcap_64
Xload_slew510 _3663_/Q _2225_/A2 VDD VDD VSS VSS gf180mcu_fd_sc_mcu7t5v0__buf_2
XFILLER_57_308 VDD VDD VSS VSS gf180mcu_fd_sc_mcu7t5v0__fillcap_4
Xload_slew565 _3778_/RN _3777_/RN VDD VDD VSS VSS gf180mcu_fd_sc_mcu7t5v0__clkbuf_1
XFILLER_85_628 VDD VDD VSS VSS gf180mcu_fd_sc_mcu7t5v0__fill_2
XFILLER_38_522 VDD VDD VSS VSS gf180mcu_fd_sc_mcu7t5v0__fill_2
Xload_slew598 wire597/I _3716_/RN VDD VDD VSS VSS gf180mcu_fd_sc_mcu7t5v0__buf_2
X_2254_ wire334/I _2393_/B _2254_/A3 _2255_/A3 VDD VDD VSS VSS gf180mcu_fd_sc_mcu7t5v0__nand3_1
Xload_slew576 _3726_/RN _3728_/RN VDD VDD VSS VSS gf180mcu_fd_sc_mcu7t5v0__clkbuf_1
X_2185_ wire462/Z _2185_/A2 _2185_/B _2185_/C _2188_/A2 VDD VDD VSS VSS gf180mcu_fd_sc_mcu7t5v0__oai211_1
XFILLER_65_341 VDD VDD VSS VSS gf180mcu_fd_sc_mcu7t5v0__fill_1
XFILLER_93_672 VDD VDD VSS VSS gf180mcu_fd_sc_mcu7t5v0__fillcap_4
XFILLER_92_171 VDD VDD VSS VSS gf180mcu_fd_sc_mcu7t5v0__fillcap_4
XFILLER_80_311 VDD VDD VSS VSS gf180mcu_fd_sc_mcu7t5v0__fillcap_4
XFILLER_21_400 VDD VDD VSS VSS gf180mcu_fd_sc_mcu7t5v0__fillcap_16
XFILLER_21_422 VDD VDD VSS VSS gf180mcu_fd_sc_mcu7t5v0__fillcap_16
XTAP_TAPCELL_ROW_23_428 VDD VSS gf180mcu_fd_sc_mcu7t5v0__filltie
XFILLER_33_282 VDD VDD VSS VSS gf180mcu_fd_sc_mcu7t5v0__fillcap_8
XFILLER_61_591 VDD VDD VSS VSS gf180mcu_fd_sc_mcu7t5v0__fillcap_4
XFILLER_21_488 VDD VDD VSS VSS gf180mcu_fd_sc_mcu7t5v0__fill_2
X_1969_ _1929_/C _1973_/A2 _1972_/C VDD VDD VSS VSS gf180mcu_fd_sc_mcu7t5v0__nor2_1
X_3708_ _3708_/D _3729_/RN clkload3/I _3708_/Q VDD VDD VSS VSS gf180mcu_fd_sc_mcu7t5v0__dffrnq_4
X_3639_ _3638_/B _3639_/A2 _3639_/A3 _3639_/Z VDD VDD VSS VSS gf180mcu_fd_sc_mcu7t5v0__or3_1
XFILLER_88_422 VDD VDD VSS VSS gf180mcu_fd_sc_mcu7t5v0__fillcap_4
XFILLER_0_348 VDD VDD VSS VSS gf180mcu_fd_sc_mcu7t5v0__fillcap_16
XFILLER_29_500 VDD VDD VSS VSS gf180mcu_fd_sc_mcu7t5v0__fill_2
XFILLER_84_37 VDD VDD VSS VSS gf180mcu_fd_sc_mcu7t5v0__fillcap_64
XFILLER_16_227 VDD VDD VSS VSS gf180mcu_fd_sc_mcu7t5v0__fill_1
XFILLER_71_377 VDD VDD VSS VSS gf180mcu_fd_sc_mcu7t5v0__fillcap_16
XFILLER_4_621 VDD VDD VSS VSS gf180mcu_fd_sc_mcu7t5v0__fillcap_4
XFILLER_3_142 VDD VDD VSS VSS gf180mcu_fd_sc_mcu7t5v0__fillcap_64
XFILLER_79_466 VDD VDD VSS VSS gf180mcu_fd_sc_mcu7t5v0__fillcap_4
XFILLER_39_308 VDD VDD VSS VSS gf180mcu_fd_sc_mcu7t5v0__fillcap_4
XFILLER_47_352 VDD VDD VSS VSS gf180mcu_fd_sc_mcu7t5v0__fillcap_4
XTAP_TAPCELL_ROW_65_829 VDD VSS gf180mcu_fd_sc_mcu7t5v0__filltie
XFILLER_47_385 VDD VDD VSS VSS gf180mcu_fd_sc_mcu7t5v0__fill_1
XFILLER_74_171 VDD VDD VSS VSS gf180mcu_fd_sc_mcu7t5v0__fillcap_4
XFILLER_50_517 VDD VDD VSS VSS gf180mcu_fd_sc_mcu7t5v0__fillcap_8
X_2941_ _2941_/A1 _2943_/A2 _2941_/B _3708_/D VDD VDD VSS VSS gf180mcu_fd_sc_mcu7t5v0__oai21_1
X_2872_ _3065_/I wire233/Z _2874_/B1 VDD VDD VSS VSS gf180mcu_fd_sc_mcu7t5v0__nor2_1
X_1823_ _3146_/A1 _1816_/Z _1823_/A3 _1823_/Z VDD VDD VSS VSS gf180mcu_fd_sc_mcu7t5v0__xor3_1
XFILLER_30_296 VDD VDD VSS VSS gf180mcu_fd_sc_mcu7t5v0__fill_1
XFILLER_7_492 VDD VDD VSS VSS gf180mcu_fd_sc_mcu7t5v0__fillcap_8
X_3424_ _3435_/A1 _3435_/A2 _3424_/Z VDD VDD VSS VSS gf180mcu_fd_sc_mcu7t5v0__xor2_1
X_3355_ _3355_/A1 _3689_/Q _3355_/B _3360_/A2 VDD VDD VSS VSS gf180mcu_fd_sc_mcu7t5v0__oai21_1
Xload_slew340 _2829_/A2 _2895_/A2 VDD VDD VSS VSS gf180mcu_fd_sc_mcu7t5v0__clkbuf_1
XFILLER_85_414 VDD VDD VSS VSS gf180mcu_fd_sc_mcu7t5v0__fillcap_4
X_3286_ _3286_/A1 _3269_/Z _3286_/A3 _3289_/A1 VDD VDD VSS VSS gf180mcu_fd_sc_mcu7t5v0__nor3_1
X_2306_ wire358/I _3178_/A1 _2338_/C VDD VDD VSS VSS gf180mcu_fd_sc_mcu7t5v0__nor2_1
Xload_slew373 wire374/Z _2822_/A2 VDD VDD VSS VSS gf180mcu_fd_sc_mcu7t5v0__buf_2
XFILLER_85_436 VDD VDD VSS VSS gf180mcu_fd_sc_mcu7t5v0__fillcap_4
Xload_slew395 _2161_/S _2158_/S VDD VDD VSS VSS gf180mcu_fd_sc_mcu7t5v0__clkbuf_1
X_2237_ _2237_/A1 _2218_/Z _2242_/B VDD VDD VSS VSS gf180mcu_fd_sc_mcu7t5v0__xor2_1
Xload_slew384 _2803_/A1 _2773_/A1 VDD VDD VSS VSS gf180mcu_fd_sc_mcu7t5v0__buf_1
X_2168_ _2168_/I _2169_/B1 VDD VDD VSS VSS gf180mcu_fd_sc_mcu7t5v0__clkinv_1
XFILLER_53_300 VDD VDD VSS VSS gf180mcu_fd_sc_mcu7t5v0__fill_1
XFILLER_65_160 VDD VDD VSS VSS gf180mcu_fd_sc_mcu7t5v0__fill_1
X_2099_ _2099_/A1 _2097_/Z _2099_/B _2099_/C _2112_/B2 VDD VDD VSS VSS gf180mcu_fd_sc_mcu7t5v0__oai211_2
XTAP_TAPCELL_ROW_36_553 VDD VSS gf180mcu_fd_sc_mcu7t5v0__filltie
XFILLER_21_263 VDD VDD VSS VSS gf180mcu_fd_sc_mcu7t5v0__fill_1
XPHY_EDGE_ROW_17_Right_17 VDD VSS gf180mcu_fd_sc_mcu7t5v0__endcap
XFILLER_5_407 VDD VDD VSS VSS gf180mcu_fd_sc_mcu7t5v0__fillcap_8
XFILLER_88_241 VDD VDD VSS VSS gf180mcu_fd_sc_mcu7t5v0__fillcap_4
XPHY_EDGE_ROW_26_Right_26 VDD VSS gf180mcu_fd_sc_mcu7t5v0__endcap
XFILLER_0_189 VDD VDD VSS VSS gf180mcu_fd_sc_mcu7t5v0__fillcap_8
XFILLER_29_352 VDD VDD VSS VSS gf180mcu_fd_sc_mcu7t5v0__fillcap_16
XFILLER_17_547 VDD VDD VSS VSS gf180mcu_fd_sc_mcu7t5v0__fillcap_8
XFILLER_44_311 VDD VDD VSS VSS gf180mcu_fd_sc_mcu7t5v0__fillcap_4
XFILLER_12_263 VDD VDD VSS VSS gf180mcu_fd_sc_mcu7t5v0__fillcap_8
XFILLER_12_241 VDD VDD VSS VSS gf180mcu_fd_sc_mcu7t5v0__fillcap_4
XPHY_EDGE_ROW_35_Right_35 VDD VSS gf180mcu_fd_sc_mcu7t5v0__endcap
XTAP_TAPCELL_ROW_70_876 VDD VSS gf180mcu_fd_sc_mcu7t5v0__filltie
XPHY_EDGE_ROW_44_Right_44 VDD VSS gf180mcu_fd_sc_mcu7t5v0__endcap
X_3140_ wire541/Z _3776_/Q _3777_/D VDD VDD VSS VSS gf180mcu_fd_sc_mcu7t5v0__and2_1
X_3071_ _3071_/I _3585_/A2 VDD VDD VSS VSS gf180mcu_fd_sc_mcu7t5v0__clkinv_1
X_2022_ _2022_/A1 _2020_/B _2022_/Z VDD VDD VSS VSS gf180mcu_fd_sc_mcu7t5v0__xor2_2
XFILLER_90_450 VDD VDD VSS VSS gf180mcu_fd_sc_mcu7t5v0__fillcap_4
XFILLER_35_366 VDD VDD VSS VSS gf180mcu_fd_sc_mcu7t5v0__fill_1
XTAP_TAPCELL_ROW_33_523 VDD VSS gf180mcu_fd_sc_mcu7t5v0__filltie
XPHY_EDGE_ROW_53_Right_53 VDD VSS gf180mcu_fd_sc_mcu7t5v0__endcap
X_2924_ _3700_/Q _2927_/A2 _2925_/B VDD VDD VSS VSS gf180mcu_fd_sc_mcu7t5v0__nand2_1
X_2855_ _3675_/Q wire231/Z _2855_/B _2856_/B2 VDD VDD VSS VSS gf180mcu_fd_sc_mcu7t5v0__oai21_1
X_1806_ _3712_/Q _3039_/I _1808_/B VDD VDD VSS VSS gf180mcu_fd_sc_mcu7t5v0__xor2_1
X_2786_ _2796_/A1 _2786_/A2 _2796_/B _2787_/A3 VDD VDD VSS VSS gf180mcu_fd_sc_mcu7t5v0__oai21_1
XPHY_EDGE_ROW_62_Right_62 VDD VSS gf180mcu_fd_sc_mcu7t5v0__endcap
X_3407_ _3405_/Z _3412_/A2 _3443_/C VDD VDD VSS VSS gf180mcu_fd_sc_mcu7t5v0__nand2_1
X_3338_ _3251_/C _3302_/Z _3338_/B _3340_/A2 VDD VDD VSS VSS gf180mcu_fd_sc_mcu7t5v0__oai21_1
XTAP_TAPCELL_ROW_5_259 VDD VSS gf180mcu_fd_sc_mcu7t5v0__filltie
X_3269_ _3299_/B _3269_/A2 _3269_/Z VDD VDD VSS VSS gf180mcu_fd_sc_mcu7t5v0__and2_1
XFILLER_38_171 VDD VDD VSS VSS gf180mcu_fd_sc_mcu7t5v0__fillcap_4
XFILLER_81_483 VDD VDD VSS VSS gf180mcu_fd_sc_mcu7t5v0__fill_1
XPHY_EDGE_ROW_71_Right_71 VDD VSS gf180mcu_fd_sc_mcu7t5v0__endcap
XFILLER_41_336 VDD VDD VSS VSS gf180mcu_fd_sc_mcu7t5v0__fillcap_4
XPHY_EDGE_ROW_80_Right_80 VDD VSS gf180mcu_fd_sc_mcu7t5v0__endcap
XFILLER_39_84 VDD VDD VSS VSS gf180mcu_fd_sc_mcu7t5v0__fill_2
Xclkbuf_4_3_0_clk clkbuf_0_clk/Z clkload2/I VDD VDD VSS VSS gf180mcu_fd_sc_mcu7t5v0__clkbuf_8
XTAP_TAPCELL_ROW_75_924 VDD VSS gf180mcu_fd_sc_mcu7t5v0__filltie
XFILLER_64_428 VDD VDD VSS VSS gf180mcu_fd_sc_mcu7t5v0__fillcap_16
XFILLER_55_72 VDD VDD VSS VSS gf180mcu_fd_sc_mcu7t5v0__fillcap_64
XFILLER_72_450 VDD VDD VSS VSS gf180mcu_fd_sc_mcu7t5v0__fillcap_4
XFILLER_32_314 VDD VDD VSS VSS gf180mcu_fd_sc_mcu7t5v0__fill_1
XFILLER_60_612 VDD VDD VSS VSS gf180mcu_fd_sc_mcu7t5v0__fill_1
XFILLER_32_336 VDD VDD VSS VSS gf180mcu_fd_sc_mcu7t5v0__fill_1
XFILLER_60_667 VDD VDD VSS VSS gf180mcu_fd_sc_mcu7t5v0__fill_2
X_2640_ _2640_/A1 _3001_/ZN _2640_/B1 wire304/Z _2640_/C _2694_/A2 VDD VDD VSS VSS
+ gf180mcu_fd_sc_mcu7t5v0__oai221_4
X_2571_ _2486_/Z _2571_/A2 _2493_/I _2573_/A3 VDD VDD VSS VSS gf180mcu_fd_sc_mcu7t5v0__nor3_1
XFILLER_67_222 VDD VDD VSS VSS gf180mcu_fd_sc_mcu7t5v0__fill_1
XTAP_TAPCELL_ROW_2_229 VDD VSS gf180mcu_fd_sc_mcu7t5v0__filltie
X_3123_ _3118_/B _3123_/A2 _3125_/A2 VDD VDD VSS VSS gf180mcu_fd_sc_mcu7t5v0__nand2_1
X_3054_ _3697_/Q _3450_/A1 VDD VDD VSS VSS gf180mcu_fd_sc_mcu7t5v0__clkinv_1
XFILLER_82_247 VDD VDD VSS VSS gf180mcu_fd_sc_mcu7t5v0__fillcap_64
X_2005_ _2005_/A1 _2005_/A2 _2005_/A3 _2005_/B _2014_/A1 VDD VDD VSS VSS gf180mcu_fd_sc_mcu7t5v0__oai31_2
XTAP_TAPCELL_ROW_18_383 VDD VSS gf180mcu_fd_sc_mcu7t5v0__filltie
XFILLER_23_347 VDD VDD VSS VSS gf180mcu_fd_sc_mcu7t5v0__fill_2
X_2907_ _3693_/Q _2911_/A2 _2908_/B VDD VDD VSS VSS gf180mcu_fd_sc_mcu7t5v0__nand2_1
XFILLER_50_177 VDD VDD VSS VSS gf180mcu_fd_sc_mcu7t5v0__fillcap_4
X_2838_ _3365_/A1 _2844_/A2 _2838_/B1 _2838_/B2 _3669_/D VDD VDD VSS VSS gf180mcu_fd_sc_mcu7t5v0__oai22_1
X_2769_ _3090_/ZN _2779_/A2 _2769_/B1 _2769_/B2 _3661_/D VDD VDD VSS VSS gf180mcu_fd_sc_mcu7t5v0__oai22_1
XTAP_TAPCELL_ROW_92_1079 VDD VSS gf180mcu_fd_sc_mcu7t5v0__filltie
XFILLER_86_553 VDD VDD VSS VSS gf180mcu_fd_sc_mcu7t5v0__fill_2
XFILLER_86_597 VDD VDD VSS VSS gf180mcu_fd_sc_mcu7t5v0__fillcap_32
XFILLER_92_37 VDD VDD VSS VSS gf180mcu_fd_sc_mcu7t5v0__fillcap_64
XTAP_TAPCELL_ROW_44_629 VDD VSS gf180mcu_fd_sc_mcu7t5v0__filltie
XFILLER_14_314 VDD VDD VSS VSS gf180mcu_fd_sc_mcu7t5v0__fill_1
XTAP_TAPCELL_ROW_80_971 VDD VSS gf180mcu_fd_sc_mcu7t5v0__filltie
XFILLER_42_667 VDD VDD VSS VSS gf180mcu_fd_sc_mcu7t5v0__fill_2
XFILLER_41_188 VDD VDD VSS VSS gf180mcu_fd_sc_mcu7t5v0__fill_2
XFILLER_6_502 VDD VDD VSS VSS gf180mcu_fd_sc_mcu7t5v0__fillcap_16
XFILLER_6_524 VDD VDD VSS VSS gf180mcu_fd_sc_mcu7t5v0__fill_1
XFILLER_10_597 VDD VDD VSS VSS gf180mcu_fd_sc_mcu7t5v0__fillcap_32
XFILLER_1_273 VDD VDD VSS VSS gf180mcu_fd_sc_mcu7t5v0__fill_1
XFILLER_18_642 VDD VDD VSS VSS gf180mcu_fd_sc_mcu7t5v0__fill_1
XFILLER_64_247 VDD VDD VSS VSS gf180mcu_fd_sc_mcu7t5v0__fillcap_4
XTAP_TAPCELL_ROW_15_353 VDD VSS gf180mcu_fd_sc_mcu7t5v0__filltie
X_3741_ _3741_/D wire588/Z clkload9/I _3741_/Q VDD VDD VSS VSS gf180mcu_fd_sc_mcu7t5v0__dffrnq_1
XFILLER_32_177 VDD VDD VSS VSS gf180mcu_fd_sc_mcu7t5v0__fillcap_16
XFILLER_60_475 VDD VDD VSS VSS gf180mcu_fd_sc_mcu7t5v0__fillcap_16
X_3672_ _3672_/D wire612/I _3715_/CLK _3672_/Q VDD VDD VSS VSS gf180mcu_fd_sc_mcu7t5v0__dffrnq_2
X_2623_ _3106_/B1 input55/Z _2623_/Z VDD VDD VSS VSS gf180mcu_fd_sc_mcu7t5v0__and2_1
XFILLER_63_2 VDD VDD VSS VSS gf180mcu_fd_sc_mcu7t5v0__fillcap_64
Xoutput114 _2024_/Z cal_phase270_offset[13] VDD VDD VSS VSS gf180mcu_fd_sc_mcu7t5v0__buf_2
Xoutput125 _1858_/Z cal_phase270_offset[4] VDD VDD VSS VSS gf180mcu_fd_sc_mcu7t5v0__buf_2
X_2554_ _2474_/I _2554_/A2 _2525_/I _2555_/A2 VDD VDD VSS VSS gf180mcu_fd_sc_mcu7t5v0__nand3_1
Xoutput103 _3147_/ZN cal_phase0_offset[3] VDD VDD VSS VSS gf180mcu_fd_sc_mcu7t5v0__buf_2
Xoutput136 _3579_/Z cal_phase90_offset[14] VDD VDD VSS VSS gf180mcu_fd_sc_mcu7t5v0__buf_2
Xoutput158 _3665_/Q delay_wave_cycle[5] VDD VDD VSS VSS gf180mcu_fd_sc_mcu7t5v0__buf_2
Xoutput147 _3429_/ZN cal_phase90_offset[5] VDD VDD VSS VSS gf180mcu_fd_sc_mcu7t5v0__buf_2
X_2485_ _2485_/I _2569_/A1 VDD VDD VSS VSS gf180mcu_fd_sc_mcu7t5v0__clkinv_1
Xoutput169 _3681_/Q raw_edge1[13] VDD VDD VSS VSS gf180mcu_fd_sc_mcu7t5v0__buf_2
XFILLER_87_328 VDD VDD VSS VSS gf180mcu_fd_sc_mcu7t5v0__fillcap_4
XFILLER_83_534 VDD VDD VSS VSS gf180mcu_fd_sc_mcu7t5v0__fill_1
X_3106_ input35/Z _3107_/B2 _3106_/B1 input34/Z _3106_/C _3109_/A1 VDD VDD VSS VSS
+ gf180mcu_fd_sc_mcu7t5v0__oai221_1
X_3037_ _3771_/Q _3337_/A1 VDD VDD VSS VSS gf180mcu_fd_sc_mcu7t5v0__clkinv_1
XFILLER_24_612 VDD VDD VSS VSS gf180mcu_fd_sc_mcu7t5v0__fill_1
XFILLER_36_450 VDD VDD VSS VSS gf180mcu_fd_sc_mcu7t5v0__fillcap_4
XFILLER_51_453 VDD VDD VSS VSS gf180mcu_fd_sc_mcu7t5v0__fill_2
XFILLER_11_306 VDD VDD VSS VSS gf180mcu_fd_sc_mcu7t5v0__fillcap_8
XFILLER_11_66 VDD VDD VSS VSS gf180mcu_fd_sc_mcu7t5v0__fillcap_4
Xfanout341 wire346/Z _2868_/A2 VDD VDD VSS VSS gf180mcu_fd_sc_mcu7t5v0__dlyb_1
Xfanout330 _2251_/ZN _2894_/B VDD VDD VSS VSS gf180mcu_fd_sc_mcu7t5v0__dlyb_1
XPHY_EDGE_ROW_92_Left_189 VDD VSS gf180mcu_fd_sc_mcu7t5v0__endcap
Xfanout352 _3108_/B2 _2413_/A1 VDD VDD VSS VSS gf180mcu_fd_sc_mcu7t5v0__dlyb_1
Xfanout363 _2250_/ZN wire366/I VDD VDD VSS VSS gf180mcu_fd_sc_mcu7t5v0__dlyb_1
XFILLER_59_586 VDD VDD VSS VSS gf180mcu_fd_sc_mcu7t5v0__fill_2
XPHY_EDGE_ROW_1_Left_98 VDD VSS gf180mcu_fd_sc_mcu7t5v0__endcap
XFILLER_36_85 VDD VDD VSS VSS gf180mcu_fd_sc_mcu7t5v0__fillcap_8
XFILLER_14_177 VDD VDD VSS VSS gf180mcu_fd_sc_mcu7t5v0__fillcap_32
XTAP_TAPCELL_ROW_12_323 VDD VSS gf180mcu_fd_sc_mcu7t5v0__filltie
Xinput27 cfg_phase0_offset[17] _2969_/I VDD VDD VSS VSS gf180mcu_fd_sc_mcu7t5v0__buf_1
Xinput16 cfg_f_MEMS_fcw[7] wire649/I VDD VDD VSS VSS gf180mcu_fd_sc_mcu7t5v0__buf_1
Xinput38 cfg_phase0_offset[8] input38/Z VDD VDD VSS VSS gf180mcu_fd_sc_mcu7t5v0__buf_1
XFILLER_6_321 VDD VDD VSS VSS gf180mcu_fd_sc_mcu7t5v0__fill_1
Xinput49 cfg_phase270_offset[18] _2734_/B VDD VDD VSS VSS gf180mcu_fd_sc_mcu7t5v0__buf_1
X_2270_ _2270_/I _3762_/D VDD VDD VSS VSS gf180mcu_fd_sc_mcu7t5v0__clkinv_1
XFILLER_37_203 VDD VDD VSS VSS gf180mcu_fd_sc_mcu7t5v0__fill_1
XFILLER_80_504 VDD VDD VSS VSS gf180mcu_fd_sc_mcu7t5v0__fill_1
XFILLER_37_269 VDD VDD VSS VSS gf180mcu_fd_sc_mcu7t5v0__fillcap_8
X_1985_ _3194_/A2 _3064_/I _2004_/B VDD VDD VSS VSS gf180mcu_fd_sc_mcu7t5v0__xor2_2
X_3724_ _3724_/D _3725_/RN clkload6/I _3724_/Q VDD VDD VSS VSS gf180mcu_fd_sc_mcu7t5v0__dffrnq_2
X_3655_ _3655_/D wire552/Z clkload7/I _3655_/Q VDD VDD VSS VSS gf180mcu_fd_sc_mcu7t5v0__dffrnq_1
X_2606_ wire405/Z input73/Z _2608_/B VDD VDD VSS VSS gf180mcu_fd_sc_mcu7t5v0__xor2_1
X_3586_ _3587_/A1 _3585_/Z _3601_/B VDD VDD VSS VSS gf180mcu_fd_sc_mcu7t5v0__nand2_1
X_2537_ _2533_/Z _2594_/B _2539_/A3 VDD VDD VSS VSS gf180mcu_fd_sc_mcu7t5v0__nor2_1
XFILLER_87_136 VDD VDD VSS VSS gf180mcu_fd_sc_mcu7t5v0__fillcap_4
X_2468_ _2468_/A1 _3018_/ZN _2595_/A1 VDD VDD VSS VSS gf180mcu_fd_sc_mcu7t5v0__nand2_1
X_2399_ _2401_/B2 _2945_/A2 _2399_/B _2708_/B _3741_/D VDD VDD VSS VSS gf180mcu_fd_sc_mcu7t5v0__aoi211_1
XFILLER_68_383 VDD VDD VSS VSS gf180mcu_fd_sc_mcu7t5v0__fill_2
XFILLER_28_247 VDD VDD VSS VSS gf180mcu_fd_sc_mcu7t5v0__fillcap_8
XTAP_TAPCELL_ROW_54_724 VDD VSS gf180mcu_fd_sc_mcu7t5v0__filltie
XFILLER_71_537 VDD VDD VSS VSS gf180mcu_fd_sc_mcu7t5v0__fill_2
XTAP_TAPCELL_ROW_26_459 VDD VSS gf180mcu_fd_sc_mcu7t5v0__filltie
XFILLER_11_136 VDD VDD VSS VSS gf180mcu_fd_sc_mcu7t5v0__fillcap_4
XFILLER_51_294 VDD VDD VSS VSS gf180mcu_fd_sc_mcu7t5v0__fillcap_16
XFILLER_19_269 VDD VDD VSS VSS gf180mcu_fd_sc_mcu7t5v0__fill_2
XFILLER_47_578 VDD VDD VSS VSS gf180mcu_fd_sc_mcu7t5v0__fillcap_4
XFILLER_74_353 VDD VDD VSS VSS gf180mcu_fd_sc_mcu7t5v0__fillcap_8
XFILLER_62_548 VDD VDD VSS VSS gf180mcu_fd_sc_mcu7t5v0__fillcap_4
XFILLER_63_72 VDD VDD VSS VSS gf180mcu_fd_sc_mcu7t5v0__fillcap_64
XFILLER_8_34 VDD VDD VSS VSS gf180mcu_fd_sc_mcu7t5v0__fill_1
XFILLER_30_489 VDD VDD VSS VSS gf180mcu_fd_sc_mcu7t5v0__fill_2
Xwire550 wire550/I wire550/Z VDD VDD VSS VSS gf180mcu_fd_sc_mcu7t5v0__buf_1
Xwire594 wire594/I wire594/Z VDD VDD VSS VSS gf180mcu_fd_sc_mcu7t5v0__clkbuf_2
X_3440_ _3440_/I _3441_/A2 VDD VDD VSS VSS gf180mcu_fd_sc_mcu7t5v0__clkinv_1
X_3371_ _3420_/C _3371_/A2 _3375_/A3 VDD VDD VSS VSS gf180mcu_fd_sc_mcu7t5v0__nand2_1
X_2322_ _3742_/Q _3014_/I _2324_/A1 VDD VDD VSS VSS gf180mcu_fd_sc_mcu7t5v0__nor2_1
Xload_slew522 wire525/I _2358_/A2 VDD VDD VSS VSS gf180mcu_fd_sc_mcu7t5v0__clkbuf_1
Xload_slew511 _3662_/Q output155/I VDD VDD VSS VSS gf180mcu_fd_sc_mcu7t5v0__buf_2
Xload_slew500 _3688_/Q output177/I VDD VDD VSS VSS gf180mcu_fd_sc_mcu7t5v0__buf_2
Xload_slew555 _3768_/RN wire554/I VDD VDD VSS VSS gf180mcu_fd_sc_mcu7t5v0__clkbuf_2
XFILLER_69_136 VDD VDD VSS VSS gf180mcu_fd_sc_mcu7t5v0__fillcap_4
XFILLER_26_2 VDD VDD VSS VSS gf180mcu_fd_sc_mcu7t5v0__fillcap_32
Xload_slew599 _3677_/RN wire597/I VDD VDD VSS VSS gf180mcu_fd_sc_mcu7t5v0__clkbuf_1
X_2253_ wire536/Z _2393_/A1 _2123_/Z _2254_/A3 VDD VDD VSS VSS gf180mcu_fd_sc_mcu7t5v0__nand3_1
Xload_slew577 _3688_/RN _3686_/RN VDD VDD VSS VSS gf180mcu_fd_sc_mcu7t5v0__clkbuf_1
Xload_slew566 _3763_/RN _3778_/RN VDD VDD VSS VSS gf180mcu_fd_sc_mcu7t5v0__clkbuf_1
X_2184_ _2186_/B _2186_/A1 _2186_/A2 _2185_/C VDD VDD VSS VSS gf180mcu_fd_sc_mcu7t5v0__nand3_1
XTAP_TAPCELL_ROW_68_849 VDD VSS gf180mcu_fd_sc_mcu7t5v0__filltie
XFILLER_25_206 VDD VDD VSS VSS gf180mcu_fd_sc_mcu7t5v0__fillcap_4
XFILLER_18_291 VDD VDD VSS VSS gf180mcu_fd_sc_mcu7t5v0__fillcap_8
XTAP_TAPCELL_ROW_23_429 VDD VSS gf180mcu_fd_sc_mcu7t5v0__filltie
X_1968_ _1934_/B _1967_/B _1968_/A3 _1973_/A2 VDD VDD VSS VSS gf180mcu_fd_sc_mcu7t5v0__nand3_1
X_3707_ _3707_/D _3728_/RN clkload3/I _3707_/Q VDD VDD VSS VSS gf180mcu_fd_sc_mcu7t5v0__dffrnq_4
X_1899_ _1972_/A1 _1895_/Z _1972_/B _1915_/A1 VDD VDD VSS VSS gf180mcu_fd_sc_mcu7t5v0__oai21_1
X_3638_ _3639_/A2 _3639_/A3 _3638_/B _3648_/B VDD VDD VSS VSS gf180mcu_fd_sc_mcu7t5v0__oai21_1
XFILLER_88_401 VDD VDD VSS VSS gf180mcu_fd_sc_mcu7t5v0__fill_1
X_3569_ wire626/Z _3565_/Z _3569_/A3 _3569_/Z VDD VDD VSS VSS gf180mcu_fd_sc_mcu7t5v0__xor3_1
XFILLER_0_305 VDD VDD VSS VSS gf180mcu_fd_sc_mcu7t5v0__fill_1
XFILLER_71_356 VDD VDD VSS VSS gf180mcu_fd_sc_mcu7t5v0__fill_2
XFILLER_52_581 VDD VDD VSS VSS gf180mcu_fd_sc_mcu7t5v0__fill_2
XFILLER_79_489 VDD VDD VSS VSS gf180mcu_fd_sc_mcu7t5v0__fill_1
XFILLER_66_139 VDD VDD VSS VSS gf180mcu_fd_sc_mcu7t5v0__fillcap_8
XFILLER_35_548 VDD VDD VSS VSS gf180mcu_fd_sc_mcu7t5v0__fillcap_4
XFILLER_62_389 VDD VDD VSS VSS gf180mcu_fd_sc_mcu7t5v0__fill_1
X_2940_ _2940_/A1 _2943_/A2 _2941_/B VDD VDD VSS VSS gf180mcu_fd_sc_mcu7t5v0__nand2_1
X_2871_ _3520_/A2 _2877_/A2 _2871_/B1 _2871_/B2 _3680_/D VDD VDD VSS VSS gf180mcu_fd_sc_mcu7t5v0__oai22_1
X_1822_ _3015_/I _1822_/A2 _1822_/Z VDD VDD VSS VSS gf180mcu_fd_sc_mcu7t5v0__or2_1
X_3423_ _3456_/B2 _3454_/A1 _3435_/A2 VDD VDD VSS VSS gf180mcu_fd_sc_mcu7t5v0__nand2_1
X_3354_ _3668_/Q _3357_/A1 _3354_/B _3362_/A2 VDD VDD VSS VSS gf180mcu_fd_sc_mcu7t5v0__aoi21_1
X_3285_ _3285_/A1 _3284_/Z _3285_/B _3290_/B VDD VDD VSS VSS gf180mcu_fd_sc_mcu7t5v0__oai21_1
X_2305_ wire459/Z _3007_/I _2421_/A2 VDD VDD VSS VSS gf180mcu_fd_sc_mcu7t5v0__nand2_1
XFILLER_38_331 VDD VDD VSS VSS gf180mcu_fd_sc_mcu7t5v0__fillcap_4
X_2236_ _2234_/B _2231_/Z _2236_/B _2236_/C _2245_/A2 VDD VDD VSS VSS gf180mcu_fd_sc_mcu7t5v0__oai211_1
Xload_slew385 _2803_/A1 _2299_/A1 VDD VDD VSS VSS gf180mcu_fd_sc_mcu7t5v0__clkbuf_2
XTAP_TAPCELL_ROW_88_1040 VDD VSS gf180mcu_fd_sc_mcu7t5v0__filltie
XFILLER_93_492 VDD VDD VSS VSS gf180mcu_fd_sc_mcu7t5v0__fillcap_64
XFILLER_81_632 VDD VDD VSS VSS gf180mcu_fd_sc_mcu7t5v0__fill_2
XFILLER_81_621 VDD VDD VSS VSS gf180mcu_fd_sc_mcu7t5v0__fill_1
X_2167_ _3694_/Q _3673_/Q _2167_/S _2168_/I VDD VDD VSS VSS gf180mcu_fd_sc_mcu7t5v0__mux2_2
X_2098_ _2098_/A1 _2085_/Z _2099_/B VDD VDD VSS VSS gf180mcu_fd_sc_mcu7t5v0__nand2_1
XTAP_TAPCELL_ROW_36_554 VDD VSS gf180mcu_fd_sc_mcu7t5v0__filltie
XFILLER_21_242 VDD VDD VSS VSS gf180mcu_fd_sc_mcu7t5v0__fill_1
XFILLER_5_419 VDD VDD VSS VSS gf180mcu_fd_sc_mcu7t5v0__fill_1
XTAP_TAPCELL_ROW_8_279 VDD VSS gf180mcu_fd_sc_mcu7t5v0__filltie
XFILLER_0_135 VDD VDD VSS VSS gf180mcu_fd_sc_mcu7t5v0__fill_1
XFILLER_0_113 VDD VDD VSS VSS gf180mcu_fd_sc_mcu7t5v0__fillcap_16
XFILLER_49_629 VDD VDD VSS VSS gf180mcu_fd_sc_mcu7t5v0__fill_1
XFILLER_48_139 VDD VDD VSS VSS gf180mcu_fd_sc_mcu7t5v0__fillcap_16
XFILLER_29_397 VDD VDD VSS VSS gf180mcu_fd_sc_mcu7t5v0__fill_2
XFILLER_56_161 VDD VDD VSS VSS gf180mcu_fd_sc_mcu7t5v0__fillcap_8
XFILLER_17_559 VDD VDD VSS VSS gf180mcu_fd_sc_mcu7t5v0__fill_1
XFILLER_44_345 VDD VDD VSS VSS gf180mcu_fd_sc_mcu7t5v0__fill_1
XFILLER_71_142 VDD VDD VSS VSS gf180mcu_fd_sc_mcu7t5v0__fillcap_64
XTAP_TAPCELL_ROW_70_877 VDD VSS gf180mcu_fd_sc_mcu7t5v0__filltie
XFILLER_8_235 VDD VDD VSS VSS gf180mcu_fd_sc_mcu7t5v0__fill_2
XFILLER_8_279 VDD VDD VSS VSS gf180mcu_fd_sc_mcu7t5v0__fill_1
X_3070_ _3070_/I _3581_/A1 VDD VDD VSS VSS gf180mcu_fd_sc_mcu7t5v0__inv_2
XTAP_TAPCELL_ROW_78_944 VDD VSS gf180mcu_fd_sc_mcu7t5v0__filltie
XFILLER_39_139 VDD VDD VSS VSS gf180mcu_fd_sc_mcu7t5v0__fill_1
XFILLER_82_418 VDD VDD VSS VSS gf180mcu_fd_sc_mcu7t5v0__fillcap_4
X_2021_ _2021_/A1 _2021_/A2 _2020_/B _2039_/A2 VDD VDD VSS VSS gf180mcu_fd_sc_mcu7t5v0__nand3_1
XFILLER_75_492 VDD VDD VSS VSS gf180mcu_fd_sc_mcu7t5v0__fillcap_8
XFILLER_90_473 VDD VDD VSS VSS gf180mcu_fd_sc_mcu7t5v0__fillcap_4
XFILLER_63_676 VDD VDD VSS VSS gf180mcu_fd_sc_mcu7t5v0__fill_1
XFILLER_93_2 VDD VDD VSS VSS gf180mcu_fd_sc_mcu7t5v0__fillcap_64
XTAP_TAPCELL_ROW_33_524 VDD VSS gf180mcu_fd_sc_mcu7t5v0__filltie
X_2923_ wire243/Z _2965_/A2 _2923_/B _3699_/D VDD VDD VSS VSS gf180mcu_fd_sc_mcu7t5v0__oai21_1
X_2854_ wire466/Z wire267/Z _2856_/B1 VDD VDD VSS VSS gf180mcu_fd_sc_mcu7t5v0__nor2_1
X_1805_ _3712_/Q _3388_/A1 _1836_/A1 VDD VDD VSS VSS gf180mcu_fd_sc_mcu7t5v0__nand2_1
X_2785_ _3735_/Q _2795_/A2 _2825_/B1 _2785_/B2 _2785_/C _2789_/B1 VDD VDD VSS VSS
+ gf180mcu_fd_sc_mcu7t5v0__aoi221_1
X_3406_ _3406_/A1 _3393_/Z _3406_/B _3412_/A2 VDD VDD VSS VSS gf180mcu_fd_sc_mcu7t5v0__oai21_1
X_3337_ _3337_/A1 _3342_/A1 _3337_/A3 _3771_/D VDD VDD VSS VSS gf180mcu_fd_sc_mcu7t5v0__xor3_1
XFILLER_58_404 VDD VDD VSS VSS gf180mcu_fd_sc_mcu7t5v0__fill_1
XFILLER_85_212 VDD VDD VSS VSS gf180mcu_fd_sc_mcu7t5v0__fillcap_64
X_3268_ _3268_/A1 _3268_/A2 _3289_/B _3273_/B VDD VDD VSS VSS gf180mcu_fd_sc_mcu7t5v0__oai21_1
X_3199_ _3205_/B1 _3205_/B2 _3199_/Z VDD VDD VSS VSS gf180mcu_fd_sc_mcu7t5v0__xor2_2
X_2219_ _2237_/A1 _2218_/Z _2241_/A2 VDD VDD VSS VSS gf180mcu_fd_sc_mcu7t5v0__nand2_1
XFILLER_53_120 VDD VDD VSS VSS gf180mcu_fd_sc_mcu7t5v0__fillcap_8
XFILLER_54_654 VDD VDD VSS VSS gf180mcu_fd_sc_mcu7t5v0__fill_2
XFILLER_22_540 VDD VDD VSS VSS gf180mcu_fd_sc_mcu7t5v0__fill_1
XFILLER_1_422 VDD VDD VSS VSS gf180mcu_fd_sc_mcu7t5v0__fillcap_64
XFILLER_64_418 VDD VDD VSS VSS gf180mcu_fd_sc_mcu7t5v0__fill_2
XFILLER_45_632 VDD VDD VSS VSS gf180mcu_fd_sc_mcu7t5v0__fill_2
XFILLER_57_492 VDD VDD VSS VSS gf180mcu_fd_sc_mcu7t5v0__fillcap_32
XFILLER_72_473 VDD VDD VSS VSS gf180mcu_fd_sc_mcu7t5v0__fill_2
XFILLER_13_595 VDD VDD VSS VSS gf180mcu_fd_sc_mcu7t5v0__fill_1
XFILLER_71_72 VDD VDD VSS VSS gf180mcu_fd_sc_mcu7t5v0__fillcap_64
X_2570_ _2577_/B _2577_/A1 _2569_/Z _2570_/Z VDD VDD VSS VSS gf180mcu_fd_sc_mcu7t5v0__and3_1
X_3122_ _3114_/Z _3124_/C _3122_/A3 _3122_/Z VDD VDD VSS VSS gf180mcu_fd_sc_mcu7t5v0__or3_1
XFILLER_67_212 VDD VDD VSS VSS gf180mcu_fd_sc_mcu7t5v0__fillcap_8
X_3053_ _3675_/Q _3433_/A2 VDD VDD VSS VSS gf180mcu_fd_sc_mcu7t5v0__clkinv_1
XFILLER_67_278 VDD VDD VSS VSS gf180mcu_fd_sc_mcu7t5v0__fill_2
X_2004_ _2004_/A1 _2004_/A2 _2004_/B _2004_/C _2044_/A1 VDD VDD VSS VSS gf180mcu_fd_sc_mcu7t5v0__aoi211_2
XFILLER_35_142 VDD VDD VSS VSS gf180mcu_fd_sc_mcu7t5v0__fillcap_16
XFILLER_35_164 VDD VDD VSS VSS gf180mcu_fd_sc_mcu7t5v0__fillcap_16
XFILLER_51_613 VDD VDD VSS VSS gf180mcu_fd_sc_mcu7t5v0__fill_2
XFILLER_50_101 VDD VDD VSS VSS gf180mcu_fd_sc_mcu7t5v0__fillcap_4
X_2906_ _2910_/A1 _2951_/A2 _2906_/B _3692_/D VDD VDD VSS VSS gf180mcu_fd_sc_mcu7t5v0__oai21_1
X_2837_ _3669_/Q _2843_/A2 _2843_/B _2838_/B2 VDD VDD VSS VSS gf180mcu_fd_sc_mcu7t5v0__oai21_1
X_2768_ _2768_/A1 _2768_/A2 _2769_/B2 VDD VDD VSS VSS gf180mcu_fd_sc_mcu7t5v0__nand2_1
X_2699_ _3746_/Q _3002_/I _2699_/A3 _2699_/Z VDD VDD VSS VSS gf180mcu_fd_sc_mcu7t5v0__xor3_1
Xfanout556 _3761_/RN wire557/I VDD VDD VSS VSS gf180mcu_fd_sc_mcu7t5v0__dlyb_1
Xfanout567 _3738_/RN _3779_/RN VDD VDD VSS VSS gf180mcu_fd_sc_mcu7t5v0__dlyb_1
XFILLER_46_429 VDD VDD VSS VSS gf180mcu_fd_sc_mcu7t5v0__fillcap_8
XFILLER_27_632 VDD VDD VSS VSS gf180mcu_fd_sc_mcu7t5v0__fill_2
XFILLER_54_473 VDD VDD VSS VSS gf180mcu_fd_sc_mcu7t5v0__fillcap_4
XFILLER_14_348 VDD VDD VSS VSS gf180mcu_fd_sc_mcu7t5v0__fill_2
XTAP_TAPCELL_ROW_80_972 VDD VSS gf180mcu_fd_sc_mcu7t5v0__filltie
XFILLER_49_212 VDD VDD VSS VSS gf180mcu_fd_sc_mcu7t5v0__fill_1
XFILLER_77_554 VDD VDD VSS VSS gf180mcu_fd_sc_mcu7t5v0__fillcap_4
XFILLER_37_418 VDD VDD VSS VSS gf180mcu_fd_sc_mcu7t5v0__fill_2
XFILLER_17_142 VDD VDD VSS VSS gf180mcu_fd_sc_mcu7t5v0__fillcap_64
XFILLER_33_602 VDD VDD VSS VSS gf180mcu_fd_sc_mcu7t5v0__fill_1
XFILLER_32_101 VDD VDD VSS VSS gf180mcu_fd_sc_mcu7t5v0__fillcap_4
XTAP_TAPCELL_ROW_15_354 VDD VSS gf180mcu_fd_sc_mcu7t5v0__filltie
X_3740_ _3740_/D _3659_/RN clkload0/I _3740_/Q VDD VDD VSS VSS gf180mcu_fd_sc_mcu7t5v0__dffsnq_1
XFILLER_9_352 VDD VDD VSS VSS gf180mcu_fd_sc_mcu7t5v0__fillcap_4
XFILLER_9_385 VDD VDD VSS VSS gf180mcu_fd_sc_mcu7t5v0__fillcap_32
X_3671_ _3671_/D _3692_/RN _3715_/CLK _3671_/Q VDD VDD VSS VSS gf180mcu_fd_sc_mcu7t5v0__dffrnq_2
X_2622_ wire468/Z _3002_/ZN _2638_/B VDD VDD VSS VSS gf180mcu_fd_sc_mcu7t5v0__nand2_1
Xoutput115 _2041_/Z cal_phase270_offset[14] VDD VDD VSS VSS gf180mcu_fd_sc_mcu7t5v0__buf_2
X_2553_ _3004_/ZN _2552_/Z _2592_/B1 VDD VDD VSS VSS gf180mcu_fd_sc_mcu7t5v0__nor2_1
XFILLER_56_2 VDD VDD VSS VSS gf180mcu_fd_sc_mcu7t5v0__fillcap_32
Xoutput104 _3153_/Z cal_phase0_offset[4] VDD VDD VSS VSS gf180mcu_fd_sc_mcu7t5v0__buf_2
Xoutput148 _3446_/ZN cal_phase90_offset[6] VDD VDD VSS VSS gf180mcu_fd_sc_mcu7t5v0__buf_2
Xoutput126 _1874_/Z cal_phase270_offset[5] VDD VDD VSS VSS gf180mcu_fd_sc_mcu7t5v0__buf_2
Xoutput159 _3666_/Q delay_wave_cycle[6] VDD VDD VSS VSS gf180mcu_fd_sc_mcu7t5v0__buf_2
Xoutput137 _3593_/Z cal_phase90_offset[15] VDD VDD VSS VSS gf180mcu_fd_sc_mcu7t5v0__buf_2
X_2484_ _3103_/B2 input74/Z _2485_/I VDD VDD VSS VSS gf180mcu_fd_sc_mcu7t5v0__nand2_1
XFILLER_68_510 VDD VDD VSS VSS gf180mcu_fd_sc_mcu7t5v0__fill_2
XFILLER_68_543 VDD VDD VSS VSS gf180mcu_fd_sc_mcu7t5v0__fillcap_8
XFILLER_83_513 VDD VDD VSS VSS gf180mcu_fd_sc_mcu7t5v0__fillcap_4
X_3105_ _3102_/Z _3105_/A2 _3105_/B _3106_/C VDD VDD VSS VSS gf180mcu_fd_sc_mcu7t5v0__oai21_1
XFILLER_68_587 VDD VDD VSS VSS gf180mcu_fd_sc_mcu7t5v0__fill_1
X_3036_ _3036_/I _3210_/A2 VDD VDD VSS VSS gf180mcu_fd_sc_mcu7t5v0__clkinv_1
XFILLER_83_557 VDD VDD VSS VSS gf180mcu_fd_sc_mcu7t5v0__fill_2
XFILLER_36_473 VDD VDD VSS VSS gf180mcu_fd_sc_mcu7t5v0__fillcap_8
Xclkbuf_4_2_0_clk clkbuf_0_clk/Z clkload1/I VDD VDD VSS VSS gf180mcu_fd_sc_mcu7t5v0__clkbuf_8
XFILLER_59_532 VDD VDD VSS VSS gf180mcu_fd_sc_mcu7t5v0__fillcap_8
XFILLER_86_384 VDD VDD VSS VSS gf180mcu_fd_sc_mcu7t5v0__fill_1
Xfanout386 _3088_/I wire388/I VDD VDD VSS VSS gf180mcu_fd_sc_mcu7t5v0__dlyb_1
XFILLER_74_535 VDD VDD VSS VSS gf180mcu_fd_sc_mcu7t5v0__fillcap_4
XTAP_TAPCELL_ROW_29_479 VDD VSS gf180mcu_fd_sc_mcu7t5v0__filltie
XFILLER_14_101 VDD VDD VSS VSS gf180mcu_fd_sc_mcu7t5v0__fillcap_4
XFILLER_36_97 VDD VDD VSS VSS gf180mcu_fd_sc_mcu7t5v0__fill_2
XFILLER_15_668 VDD VDD VSS VSS gf180mcu_fd_sc_mcu7t5v0__fill_1
XFILLER_42_454 VDD VDD VSS VSS gf180mcu_fd_sc_mcu7t5v0__fill_1
XTAP_TAPCELL_ROW_12_324 VDD VSS gf180mcu_fd_sc_mcu7t5v0__filltie
Xinput17 cfg_f_MEMS_fcw[8] _3008_/I VDD VDD VSS VSS gf180mcu_fd_sc_mcu7t5v0__buf_3
Xinput28 cfg_phase0_offset[18] input28/Z VDD VDD VSS VSS gf180mcu_fd_sc_mcu7t5v0__buf_1
Xinput39 cfg_phase0_offset[9] input39/Z VDD VDD VSS VSS gf180mcu_fd_sc_mcu7t5v0__buf_1
XFILLER_10_384 VDD VDD VSS VSS gf180mcu_fd_sc_mcu7t5v0__fill_1
XFILLER_96_104 VDD VDD VSS VSS gf180mcu_fd_sc_mcu7t5v0__fillcap_32
XFILLER_2_594 VDD VDD VSS VSS gf180mcu_fd_sc_mcu7t5v0__fill_1
XFILLER_92_387 VDD VDD VSS VSS gf180mcu_fd_sc_mcu7t5v0__fillcap_64
XFILLER_80_527 VDD VDD VSS VSS gf180mcu_fd_sc_mcu7t5v0__fillcap_16
XFILLER_33_410 VDD VDD VSS VSS gf180mcu_fd_sc_mcu7t5v0__fillcap_8
X_1984_ _1982_/Z _1984_/A2 _1984_/Z VDD VDD VSS VSS gf180mcu_fd_sc_mcu7t5v0__xor2_2
X_3723_ _3723_/D _3723_/RN clkload6/I _3723_/Q VDD VDD VSS VSS gf180mcu_fd_sc_mcu7t5v0__dffrnq_2
X_3654_ _3654_/D _3775_/RN clkload4/I _3654_/Q VDD VDD VSS VSS gf180mcu_fd_sc_mcu7t5v0__dffrnq_1
X_2605_ _2605_/A1 _2605_/A2 _2608_/A2 VDD VDD VSS VSS gf180mcu_fd_sc_mcu7t5v0__nand2_1
X_3585_ _3070_/I _3585_/A2 _3585_/A3 _3585_/Z VDD VDD VSS VSS gf180mcu_fd_sc_mcu7t5v0__xor3_1
XFILLER_0_509 VDD VDD VSS VSS gf180mcu_fd_sc_mcu7t5v0__fill_1
X_2536_ _3757_/Q input68/Z _2594_/B VDD VDD VSS VSS gf180mcu_fd_sc_mcu7t5v0__xor2_1
X_2467_ _3655_/Q _3080_/ZN _2610_/A1 VDD VDD VSS VSS gf180mcu_fd_sc_mcu7t5v0__nand2_1
XFILLER_68_340 VDD VDD VSS VSS gf180mcu_fd_sc_mcu7t5v0__fillcap_8
X_2398_ _3741_/Q wire543/Z _2945_/A2 VDD VDD VSS VSS gf180mcu_fd_sc_mcu7t5v0__nand2_1
XFILLER_56_502 VDD VDD VSS VSS gf180mcu_fd_sc_mcu7t5v0__fillcap_4
XFILLER_56_524 VDD VDD VSS VSS gf180mcu_fd_sc_mcu7t5v0__fill_1
XFILLER_56_557 VDD VDD VSS VSS gf180mcu_fd_sc_mcu7t5v0__fill_1
XFILLER_56_535 VDD VDD VSS VSS gf180mcu_fd_sc_mcu7t5v0__fillcap_16
XFILLER_83_354 VDD VDD VSS VSS gf180mcu_fd_sc_mcu7t5v0__fill_1
XFILLER_43_207 VDD VDD VSS VSS gf180mcu_fd_sc_mcu7t5v0__fill_2
XFILLER_83_387 VDD VDD VSS VSS gf180mcu_fd_sc_mcu7t5v0__fillcap_4
X_3019_ _3019_/I _3019_/ZN VDD VDD VSS VSS gf180mcu_fd_sc_mcu7t5v0__clkinv_1
XTAP_TAPCELL_ROW_54_725 VDD VSS gf180mcu_fd_sc_mcu7t5v0__filltie
XFILLER_24_432 VDD VDD VSS VSS gf180mcu_fd_sc_mcu7t5v0__fill_1
XFILLER_24_465 VDD VDD VSS VSS gf180mcu_fd_sc_mcu7t5v0__fillcap_4
XFILLER_8_609 VDD VDD VSS VSS gf180mcu_fd_sc_mcu7t5v0__fillcap_4
XFILLER_74_321 VDD VDD VSS VSS gf180mcu_fd_sc_mcu7t5v0__fillcap_16
XFILLER_19_259 VDD VDD VSS VSS gf180mcu_fd_sc_mcu7t5v0__fill_1
XFILLER_15_432 VDD VDD VSS VSS gf180mcu_fd_sc_mcu7t5v0__fill_1
XFILLER_15_487 VDD VDD VSS VSS gf180mcu_fd_sc_mcu7t5v0__fill_2
XFILLER_70_571 VDD VDD VSS VSS gf180mcu_fd_sc_mcu7t5v0__fill_2
X_3370_ _3692_/Q _3406_/A1 _3371_/A2 VDD VDD VSS VSS gf180mcu_fd_sc_mcu7t5v0__nand2_1
X_2321_ _3742_/Q _3014_/I _2324_/B VDD VDD VSS VSS gf180mcu_fd_sc_mcu7t5v0__nand2_1
Xload_slew501 _3687_/Q _3077_/I VDD VDD VSS VSS gf180mcu_fd_sc_mcu7t5v0__buf_2
Xload_slew512 _3658_/Q output88/I VDD VDD VSS VSS gf180mcu_fd_sc_mcu7t5v0__buf_2
Xload_slew534 _3016_/I wire533/I VDD VDD VSS VSS gf180mcu_fd_sc_mcu7t5v0__clkbuf_1
Xload_slew545 _2422_/A2 wire544/I VDD VDD VSS VSS gf180mcu_fd_sc_mcu7t5v0__buf_2
X_2252_ _2263_/A1 wire319/Z _2393_/B VDD VDD VSS VSS gf180mcu_fd_sc_mcu7t5v0__nand2_1
XFILLER_84_107 VDD VDD VSS VSS gf180mcu_fd_sc_mcu7t5v0__fillcap_64
Xload_slew578 _3688_/RN _3726_/RN VDD VDD VSS VSS gf180mcu_fd_sc_mcu7t5v0__clkbuf_1
XFILLER_19_2 VDD VDD VSS VSS gf180mcu_fd_sc_mcu7t5v0__fillcap_64
X_2183_ _3492_/A2 _2183_/A2 _2186_/A2 VDD VDD VSS VSS gf180mcu_fd_sc_mcu7t5v0__nand2_1
XFILLER_38_524 VDD VDD VSS VSS gf180mcu_fd_sc_mcu7t5v0__fill_1
XFILLER_65_387 VDD VDD VSS VSS gf180mcu_fd_sc_mcu7t5v0__fillcap_32
XFILLER_46_590 VDD VDD VSS VSS gf180mcu_fd_sc_mcu7t5v0__fillcap_4
X_3706_ _3706_/D _3727_/RN clkload6/I _3706_/Q VDD VDD VSS VSS gf180mcu_fd_sc_mcu7t5v0__dffrnq_4
X_1967_ _1967_/A1 _1967_/A2 _1967_/B _2005_/A1 VDD VDD VSS VSS gf180mcu_fd_sc_mcu7t5v0__oai21_1
X_1898_ _1879_/Z _1898_/A2 _1971_/B VDD VDD VSS VSS gf180mcu_fd_sc_mcu7t5v0__nand2_1
X_3637_ _3622_/B _3637_/A2 _3637_/B _3639_/A3 VDD VDD VSS VSS gf180mcu_fd_sc_mcu7t5v0__oai21_1
X_3568_ wire626/Z _3567_/Z _3568_/Z VDD VDD VSS VSS gf180mcu_fd_sc_mcu7t5v0__or2_1
X_2519_ _2516_/Z _2518_/Z _2521_/B VDD VDD VSS VSS gf180mcu_fd_sc_mcu7t5v0__or2_1
X_3499_ _3516_/A1 _3679_/Q _3517_/A2 VDD VDD VSS VSS gf180mcu_fd_sc_mcu7t5v0__nand2_1
XFILLER_56_310 VDD VDD VSS VSS gf180mcu_fd_sc_mcu7t5v0__fillcap_4
XFILLER_44_505 VDD VDD VSS VSS gf180mcu_fd_sc_mcu7t5v0__fill_2
XTAP_TAPCELL_ROW_39_574 VDD VSS gf180mcu_fd_sc_mcu7t5v0__filltie
XFILLER_56_387 VDD VDD VSS VSS gf180mcu_fd_sc_mcu7t5v0__fill_2
XFILLER_17_66 VDD VDD VSS VSS gf180mcu_fd_sc_mcu7t5v0__fillcap_4
XFILLER_71_335 VDD VDD VSS VSS gf180mcu_fd_sc_mcu7t5v0__fillcap_4
XFILLER_20_490 VDD VDD VSS VSS gf180mcu_fd_sc_mcu7t5v0__fill_1
XFILLER_4_667 VDD VDD VSS VSS gf180mcu_fd_sc_mcu7t5v0__fillcap_8
XFILLER_66_107 VDD VDD VSS VSS gf180mcu_fd_sc_mcu7t5v0__fillcap_32
XFILLER_35_516 VDD VDD VSS VSS gf180mcu_fd_sc_mcu7t5v0__fillcap_8
XFILLER_62_313 VDD VDD VSS VSS gf180mcu_fd_sc_mcu7t5v0__fill_2
XTAP_TAPCELL_ROW_73_897 VDD VSS gf180mcu_fd_sc_mcu7t5v0__filltie
XFILLER_15_295 VDD VDD VSS VSS gf180mcu_fd_sc_mcu7t5v0__fillcap_4
X_2870_ _2977_/I wire269/Z _2870_/B _2871_/B2 VDD VDD VSS VSS gf180mcu_fd_sc_mcu7t5v0__oai21_1
X_1821_ _3015_/I _1822_/A2 _1857_/A1 VDD VDD VSS VSS gf180mcu_fd_sc_mcu7t5v0__nor2_2
X_3422_ _3048_/I _3426_/A1 _3422_/B1 _3693_/Q _3454_/A1 VDD VDD VSS VSS gf180mcu_fd_sc_mcu7t5v0__aoi22_1
Xload_slew320 _2768_/A1 _2798_/A1 VDD VDD VSS VSS gf180mcu_fd_sc_mcu7t5v0__buf_1
X_3353_ _3669_/Q _3690_/Q _3354_/B VDD VDD VSS VSS gf180mcu_fd_sc_mcu7t5v0__xor2_1
X_2304_ wire459/Z _3007_/I _2343_/A2 VDD VDD VSS VSS gf180mcu_fd_sc_mcu7t5v0__nor2_1
X_3284_ _3303_/A1 _3309_/A2 _3271_/B _3284_/A4 _3284_/Z VDD VDD VSS VSS gf180mcu_fd_sc_mcu7t5v0__and4_1
Xload_slew364 _2423_/A1 _2401_/B2 VDD VDD VSS VSS gf180mcu_fd_sc_mcu7t5v0__clkbuf_2
Xload_slew353 _3107_/A2 _2620_/A1 VDD VDD VSS VSS gf180mcu_fd_sc_mcu7t5v0__clkbuf_2
Xload_slew342 _2850_/A2 _2844_/A2 VDD VDD VSS VSS gf180mcu_fd_sc_mcu7t5v0__buf_2
X_2235_ _2244_/B _2244_/A2 _2236_/B VDD VDD VSS VSS gf180mcu_fd_sc_mcu7t5v0__nand2_1
XTAP_TAPCELL_ROW_88_1041 VDD VSS gf180mcu_fd_sc_mcu7t5v0__filltie
X_2166_ _2905_/A1 _2166_/A2 _2165_/Z _3745_/Q _2170_/A2 VDD VDD VSS VSS gf180mcu_fd_sc_mcu7t5v0__oai22_1
XFILLER_26_527 VDD VDD VSS VSS gf180mcu_fd_sc_mcu7t5v0__fill_1
XFILLER_38_365 VDD VDD VSS VSS gf180mcu_fd_sc_mcu7t5v0__fillcap_8
XFILLER_38_387 VDD VDD VSS VSS gf180mcu_fd_sc_mcu7t5v0__fillcap_8
XTAP_TAPCELL_ROW_64_820 VDD VSS gf180mcu_fd_sc_mcu7t5v0__filltie
X_2097_ _2097_/A1 _2097_/A2 _2097_/Z VDD VDD VSS VSS gf180mcu_fd_sc_mcu7t5v0__or2_1
XFILLER_65_195 VDD VDD VSS VSS gf180mcu_fd_sc_mcu7t5v0__fillcap_8
XPHY_EDGE_ROW_3_Right_3 VDD VSS gf180mcu_fd_sc_mcu7t5v0__endcap
X_2999_ _2999_/I _2999_/ZN VDD VDD VSS VSS gf180mcu_fd_sc_mcu7t5v0__clkinv_1
XFILLER_1_626 VDD VDD VSS VSS gf180mcu_fd_sc_mcu7t5v0__fillcap_4
XFILLER_76_405 VDD VDD VSS VSS gf180mcu_fd_sc_mcu7t5v0__fillcap_4
XFILLER_48_107 VDD VDD VSS VSS gf180mcu_fd_sc_mcu7t5v0__fillcap_32
XFILLER_29_332 VDD VDD VSS VSS gf180mcu_fd_sc_mcu7t5v0__fill_2
XFILLER_17_516 VDD VDD VSS VSS gf180mcu_fd_sc_mcu7t5v0__fillcap_4
XFILLER_56_173 VDD VDD VSS VSS gf180mcu_fd_sc_mcu7t5v0__fill_2
XFILLER_32_519 VDD VDD VSS VSS gf180mcu_fd_sc_mcu7t5v0__fillcap_4
XFILLER_69_72 VDD VDD VSS VSS gf180mcu_fd_sc_mcu7t5v0__fillcap_64
XFILLER_79_276 VDD VDD VSS VSS gf180mcu_fd_sc_mcu7t5v0__fillcap_4
XFILLER_79_298 VDD VDD VSS VSS gf180mcu_fd_sc_mcu7t5v0__fill_2
XTAP_TAPCELL_ROW_78_945 VDD VSS gf180mcu_fd_sc_mcu7t5v0__filltie
X_2020_ _2021_/A1 _2021_/A2 _2020_/B _2039_/B VDD VDD VSS VSS gf180mcu_fd_sc_mcu7t5v0__aoi21_1
XFILLER_35_302 VDD VDD VSS VSS gf180mcu_fd_sc_mcu7t5v0__fillcap_16
XFILLER_90_441 VDD VDD VSS VSS gf180mcu_fd_sc_mcu7t5v0__fill_1
XFILLER_23_508 VDD VDD VSS VSS gf180mcu_fd_sc_mcu7t5v0__fillcap_8
XFILLER_62_165 VDD VDD VSS VSS gf180mcu_fd_sc_mcu7t5v0__fillcap_8
XTAP_TAPCELL_ROW_33_525 VDD VSS gf180mcu_fd_sc_mcu7t5v0__filltie
X_2922_ _3699_/Q wire249/I _2923_/B VDD VDD VSS VSS gf180mcu_fd_sc_mcu7t5v0__nand2_1
XFILLER_86_2 VDD VDD VSS VSS gf180mcu_fd_sc_mcu7t5v0__fillcap_32
X_2853_ _3439_/A1 wire346/Z _2853_/B1 _2853_/B2 _3674_/D VDD VDD VSS VSS gf180mcu_fd_sc_mcu7t5v0__oai22_1
X_2784_ _2796_/A1 _2787_/A2 _2785_/B2 VDD VDD VSS VSS gf180mcu_fd_sc_mcu7t5v0__nand2_1
X_1804_ _3079_/ZN _1801_/B _1804_/B _2117_/B VDD VDD VSS VSS gf180mcu_fd_sc_mcu7t5v0__aoi21_1
X_3405_ _3672_/Q _3404_/Z _3405_/Z VDD VDD VSS VSS gf180mcu_fd_sc_mcu7t5v0__xor2_1
X_3336_ _3337_/A1 _3337_/A3 _3342_/A2 VDD VDD VSS VSS gf180mcu_fd_sc_mcu7t5v0__nand2_1
X_3267_ _3267_/A1 _3267_/A2 _3267_/B _3268_/A2 VDD VDD VSS VSS gf180mcu_fd_sc_mcu7t5v0__oai21_1
X_2218_ _3733_/Q _3090_/ZN _2218_/Z VDD VDD VSS VSS gf180mcu_fd_sc_mcu7t5v0__xor2_1
XFILLER_73_419 VDD VDD VSS VSS gf180mcu_fd_sc_mcu7t5v0__fill_1
X_3198_ _3185_/Z _3188_/Z _3198_/A3 _3198_/B _3205_/B2 VDD VDD VSS VSS gf180mcu_fd_sc_mcu7t5v0__oai31_4
XFILLER_81_430 VDD VDD VSS VSS gf180mcu_fd_sc_mcu7t5v0__fillcap_4
X_2149_ _3065_/I _2196_/A2 _2150_/B VDD VDD VSS VSS gf180mcu_fd_sc_mcu7t5v0__nand2_1
XFILLER_81_463 VDD VDD VSS VSS gf180mcu_fd_sc_mcu7t5v0__fillcap_8
XFILLER_81_452 VDD VDD VSS VSS gf180mcu_fd_sc_mcu7t5v0__fill_2
XFILLER_14_34 VDD VDD VSS VSS gf180mcu_fd_sc_mcu7t5v0__fill_1
XFILLER_22_552 VDD VDD VSS VSS gf180mcu_fd_sc_mcu7t5v0__fillcap_4
XFILLER_22_585 VDD VDD VSS VSS gf180mcu_fd_sc_mcu7t5v0__fillcap_4
XPHY_EDGE_ROW_15_Left_112 VDD VSS gf180mcu_fd_sc_mcu7t5v0__endcap
XFILLER_5_206 VDD VDD VSS VSS gf180mcu_fd_sc_mcu7t5v0__fillcap_4
XTAP_TAPCELL_ROW_4_250 VDD VSS gf180mcu_fd_sc_mcu7t5v0__filltie
XPHY_EDGE_ROW_24_Left_121 VDD VSS gf180mcu_fd_sc_mcu7t5v0__endcap
XFILLER_76_279 VDD VDD VSS VSS gf180mcu_fd_sc_mcu7t5v0__fillcap_8
XFILLER_29_162 VDD VDD VSS VSS gf180mcu_fd_sc_mcu7t5v0__fill_1
XFILLER_17_335 VDD VDD VSS VSS gf180mcu_fd_sc_mcu7t5v0__fillcap_8
XTAP_TAPCELL_ROW_83_992 VDD VSS gf180mcu_fd_sc_mcu7t5v0__filltie
XFILLER_25_390 VDD VDD VSS VSS gf180mcu_fd_sc_mcu7t5v0__fill_2
XFILLER_40_360 VDD VDD VSS VSS gf180mcu_fd_sc_mcu7t5v0__fillcap_4
XPHY_EDGE_ROW_33_Left_130 VDD VSS gf180mcu_fd_sc_mcu7t5v0__endcap
XFILLER_96_70 VDD VDD VSS VSS gf180mcu_fd_sc_mcu7t5v0__fillcap_4
X_3121_ _3124_/A1 _3124_/A2 _3124_/B _3121_/C _3122_/A3 VDD VDD VSS VSS gf180mcu_fd_sc_mcu7t5v0__oai211_1
XFILLER_36_611 VDD VDD VSS VSS gf180mcu_fd_sc_mcu7t5v0__fill_1
X_3052_ _3696_/Q _3431_/A1 VDD VDD VSS VSS gf180mcu_fd_sc_mcu7t5v0__clkinv_1
XTAP_TAPCELL_ROW_85_1011 VDD VSS gf180mcu_fd_sc_mcu7t5v0__filltie
X_2003_ _2004_/C _2004_/B _2005_/B VDD VDD VSS VSS gf180mcu_fd_sc_mcu7t5v0__nor2_1
XFILLER_35_121 VDD VDD VSS VSS gf180mcu_fd_sc_mcu7t5v0__fill_1
XTAP_TAPCELL_ROW_18_374 VDD VSS gf180mcu_fd_sc_mcu7t5v0__filltie
XFILLER_23_349 VDD VDD VSS VSS gf180mcu_fd_sc_mcu7t5v0__fill_1
X_2905_ _2905_/A1 _2912_/A2 _2951_/A2 VDD VDD VSS VSS gf180mcu_fd_sc_mcu7t5v0__nand2_1
X_2836_ _3742_/Q _2842_/A2 _2838_/B1 VDD VDD VSS VSS gf180mcu_fd_sc_mcu7t5v0__nor2_1
X_2767_ _2831_/A2 _2767_/A2 _2767_/A3 _2768_/A2 VDD VDD VSS VSS gf180mcu_fd_sc_mcu7t5v0__nand3_1
XFILLER_2_209 VDD VDD VSS VSS gf180mcu_fd_sc_mcu7t5v0__fillcap_16
X_2698_ _3747_/Q input57/Z wire304/Z _2698_/Z VDD VDD VSS VSS gf180mcu_fd_sc_mcu7t5v0__xor3_1
XFILLER_86_522 VDD VDD VSS VSS gf180mcu_fd_sc_mcu7t5v0__fill_2
Xfanout546 input86/Z wire550/I VDD VDD VSS VSS gf180mcu_fd_sc_mcu7t5v0__dlyb_1
Xfanout535 wire541/I _2390_/B VDD VDD VSS VSS gf180mcu_fd_sc_mcu7t5v0__dlyb_1
X_3319_ _3237_/B _3282_/B _3319_/A3 _3331_/A2 VDD VDD VSS VSS gf180mcu_fd_sc_mcu7t5v0__nand3_1
Xfanout579 _3687_/RN _3723_/RN VDD VDD VSS VSS gf180mcu_fd_sc_mcu7t5v0__dlyb_1
XTAP_TAPCELL_ROW_1_220 VDD VSS gf180mcu_fd_sc_mcu7t5v0__filltie
XFILLER_81_282 VDD VDD VSS VSS gf180mcu_fd_sc_mcu7t5v0__fillcap_32
XFILLER_25_66 VDD VDD VSS VSS gf180mcu_fd_sc_mcu7t5v0__fillcap_4
XTAP_TAPCELL_ROW_52_697 VDD VSS gf180mcu_fd_sc_mcu7t5v0__filltie
XFILLER_10_588 VDD VDD VSS VSS gf180mcu_fd_sc_mcu7t5v0__fillcap_4
XFILLER_96_308 VDD VDD VSS VSS gf180mcu_fd_sc_mcu7t5v0__fillcap_32
XFILLER_89_393 VDD VDD VSS VSS gf180mcu_fd_sc_mcu7t5v0__fillcap_4
XFILLER_2_37 VDD VDD VSS VSS gf180mcu_fd_sc_mcu7t5v0__fillcap_64
XFILLER_45_430 VDD VDD VSS VSS gf180mcu_fd_sc_mcu7t5v0__fill_1
XFILLER_57_290 VDD VDD VSS VSS gf180mcu_fd_sc_mcu7t5v0__fillcap_4
XTAP_TAPCELL_ROW_43_620 VDD VSS gf180mcu_fd_sc_mcu7t5v0__filltie
X_3670_ _3670_/D _3670_/RN _3694_/CLK _3670_/Q VDD VDD VSS VSS gf180mcu_fd_sc_mcu7t5v0__dffrnq_2
XFILLER_40_190 VDD VDD VSS VSS gf180mcu_fd_sc_mcu7t5v0__fillcap_4
X_2621_ wire468/Z _3002_/ZN _2638_/A1 VDD VDD VSS VSS gf180mcu_fd_sc_mcu7t5v0__nor2_1
Xoutput116 _2058_/Z cal_phase270_offset[15] VDD VDD VSS VSS gf180mcu_fd_sc_mcu7t5v0__buf_2
X_2552_ _3119_/A2 input65/Z _2552_/A3 _2552_/Z VDD VDD VSS VSS gf180mcu_fd_sc_mcu7t5v0__xor3_1
Xoutput105 _3158_/Z cal_phase0_offset[5] VDD VDD VSS VSS gf180mcu_fd_sc_mcu7t5v0__buf_2
Xoutput127 _1891_/ZN cal_phase270_offset[6] VDD VDD VSS VSS gf180mcu_fd_sc_mcu7t5v0__buf_2
XFILLER_5_570 VDD VDD VSS VSS gf180mcu_fd_sc_mcu7t5v0__fill_2
XFILLER_49_2 VDD VDD VSS VSS gf180mcu_fd_sc_mcu7t5v0__fillcap_64
Xoutput138 _3610_/Z cal_phase90_offset[16] VDD VDD VSS VSS gf180mcu_fd_sc_mcu7t5v0__buf_2
Xoutput149 _3465_/Z cal_phase90_offset[7] VDD VDD VSS VSS gf180mcu_fd_sc_mcu7t5v0__buf_2
X_2483_ _3104_/B2 input75/Z _2566_/A1 VDD VDD VSS VSS gf180mcu_fd_sc_mcu7t5v0__nand2_1
XTAP_TAPCELL_ROW_91_1070 VDD VSS gf180mcu_fd_sc_mcu7t5v0__filltie
XFILLER_95_352 VDD VDD VSS VSS gf180mcu_fd_sc_mcu7t5v0__fillcap_64
X_3104_ _3106_/B1 input34/Z input33/Z _3104_/B2 _3105_/B VDD VDD VSS VSS gf180mcu_fd_sc_mcu7t5v0__aoi22_1
X_3035_ _3726_/Q _3203_/A2 VDD VDD VSS VSS gf180mcu_fd_sc_mcu7t5v0__clkinv_1
XFILLER_36_485 VDD VDD VSS VSS gf180mcu_fd_sc_mcu7t5v0__fill_1
XFILLER_51_422 VDD VDD VSS VSS gf180mcu_fd_sc_mcu7t5v0__fillcap_8
XFILLER_63_282 VDD VDD VSS VSS gf180mcu_fd_sc_mcu7t5v0__fillcap_16
X_2819_ _3095_/ZN wire334/Z _2819_/B1 _2819_/B2 _3666_/D VDD VDD VSS VSS gf180mcu_fd_sc_mcu7t5v0__oai22_1
XFILLER_86_341 VDD VDD VSS VSS gf180mcu_fd_sc_mcu7t5v0__fillcap_4
XFILLER_74_547 VDD VDD VSS VSS gf180mcu_fd_sc_mcu7t5v0__fillcap_4
XTAP_TAPCELL_ROW_57_745 VDD VSS gf180mcu_fd_sc_mcu7t5v0__filltie
XFILLER_15_603 VDD VDD VSS VSS gf180mcu_fd_sc_mcu7t5v0__fill_2
XFILLER_27_452 VDD VDD VSS VSS gf180mcu_fd_sc_mcu7t5v0__fillcap_4
XTAP_TAPCELL_ROW_12_325 VDD VSS gf180mcu_fd_sc_mcu7t5v0__filltie
Xinput18 cfg_f_MEMS_fcw[9] wire642/I VDD VDD VSS VSS gf180mcu_fd_sc_mcu7t5v0__buf_2
XFILLER_6_312 VDD VDD VSS VSS gf180mcu_fd_sc_mcu7t5v0__fill_2
Xinput29 cfg_phase0_offset[19] input29/Z VDD VDD VSS VSS gf180mcu_fd_sc_mcu7t5v0__buf_1
XFILLER_69_319 VDD VDD VSS VSS gf180mcu_fd_sc_mcu7t5v0__fillcap_8
XFILLER_96_138 VDD VDD VSS VSS gf180mcu_fd_sc_mcu7t5v0__fillcap_32
XFILLER_77_341 VDD VDD VSS VSS gf180mcu_fd_sc_mcu7t5v0__fill_1
XFILLER_77_72 VDD VDD VSS VSS gf180mcu_fd_sc_mcu7t5v0__fillcap_64
XFILLER_77_352 VDD VDD VSS VSS gf180mcu_fd_sc_mcu7t5v0__fillcap_8
XFILLER_92_311 VDD VDD VSS VSS gf180mcu_fd_sc_mcu7t5v0__fillcap_4
XFILLER_33_400 VDD VDD VSS VSS gf180mcu_fd_sc_mcu7t5v0__fill_2
XFILLER_33_422 VDD VDD VSS VSS gf180mcu_fd_sc_mcu7t5v0__fill_1
XFILLER_45_282 VDD VDD VSS VSS gf180mcu_fd_sc_mcu7t5v0__fill_1
X_1983_ _1983_/A1 _1983_/A2 _1996_/B _1984_/A2 VDD VDD VSS VSS gf180mcu_fd_sc_mcu7t5v0__aoi21_1
X_3722_ _3722_/D _3722_/RN clkload5/I _3722_/Q VDD VDD VSS VSS gf180mcu_fd_sc_mcu7t5v0__dffrnq_2
X_3653_ _3653_/D _3775_/RN clkload4/I _3653_/Q VDD VDD VSS VSS gf180mcu_fd_sc_mcu7t5v0__dffrnq_1
X_2604_ _2211_/C input71/Z _2604_/B _2734_/C _2605_/A2 VDD VDD VSS VSS gf180mcu_fd_sc_mcu7t5v0__oai211_1
X_3584_ _3584_/A1 _3584_/A2 _3565_/Z _3584_/B _3585_/A3 VDD VDD VSS VSS gf180mcu_fd_sc_mcu7t5v0__oai31_4
X_2535_ _2675_/C input68/Z _2600_/A2 VDD VDD VSS VSS gf180mcu_fd_sc_mcu7t5v0__nor2_1
X_2466_ _3135_/A1 wire636/Z wire533/I _2742_/A3 _2740_/B VDD VDD VSS VSS gf180mcu_fd_sc_mcu7t5v0__nand4_1
XFILLER_96_672 VDD VDD VSS VSS gf180mcu_fd_sc_mcu7t5v0__fillcap_4
X_2397_ _2397_/A1 _2574_/C _2399_/B VDD VDD VSS VSS gf180mcu_fd_sc_mcu7t5v0__nor2_1
X_3018_ _3018_/I _3018_/ZN VDD VDD VSS VSS gf180mcu_fd_sc_mcu7t5v0__clkinv_1
XFILLER_71_539 VDD VDD VSS VSS gf180mcu_fd_sc_mcu7t5v0__fill_1
XTAP_TAPCELL_ROW_62_792 VDD VSS gf180mcu_fd_sc_mcu7t5v0__filltie
XFILLER_22_34 VDD VDD VSS VSS gf180mcu_fd_sc_mcu7t5v0__fill_1
XFILLER_59_352 VDD VDD VSS VSS gf180mcu_fd_sc_mcu7t5v0__fill_2
XFILLER_86_171 VDD VDD VSS VSS gf180mcu_fd_sc_mcu7t5v0__fillcap_4
XFILLER_47_547 VDD VDD VSS VSS gf180mcu_fd_sc_mcu7t5v0__fillcap_4
XFILLER_74_311 VDD VDD VSS VSS gf180mcu_fd_sc_mcu7t5v0__fillcap_4
XFILLER_74_399 VDD VDD VSS VSS gf180mcu_fd_sc_mcu7t5v0__fill_2
XFILLER_15_422 VDD VDD VSS VSS gf180mcu_fd_sc_mcu7t5v0__fillcap_8
XFILLER_27_282 VDD VDD VSS VSS gf180mcu_fd_sc_mcu7t5v0__fillcap_4
XPHY_EDGE_ROW_7_Left_104 VDD VSS gf180mcu_fd_sc_mcu7t5v0__endcap
XFILLER_11_650 VDD VDD VSS VSS gf180mcu_fd_sc_mcu7t5v0__fill_2
XFILLER_7_632 VDD VDD VSS VSS gf180mcu_fd_sc_mcu7t5v0__fillcap_8
Xwire541 wire541/I wire541/Z VDD VDD VSS VSS gf180mcu_fd_sc_mcu7t5v0__buf_1
XFILLER_10_193 VDD VDD VSS VSS gf180mcu_fd_sc_mcu7t5v0__fillcap_8
XFILLER_10_171 VDD VDD VSS VSS gf180mcu_fd_sc_mcu7t5v0__fillcap_4
Xmax_cap307 _3281_/A1 _3274_/A2 VDD VDD VSS VSS gf180mcu_fd_sc_mcu7t5v0__clkbuf_1
Xwire552 wire552/I wire552/Z VDD VDD VSS VSS gf180mcu_fd_sc_mcu7t5v0__buf_1
X_2320_ _2318_/I _2319_/Z _2402_/A1 VDD VDD VSS VSS gf180mcu_fd_sc_mcu7t5v0__nand2_1
Xload_slew502 _3686_/Q _3075_/I VDD VDD VSS VSS gf180mcu_fd_sc_mcu7t5v0__buf_2
Xload_slew524 wire525/Z wire523/I VDD VDD VSS VSS gf180mcu_fd_sc_mcu7t5v0__clkbuf_2
X_2251_ _2743_/B _2121_/Z _2251_/ZN VDD VDD VSS VSS gf180mcu_fd_sc_mcu7t5v0__nor2_1
Xload_slew568 _3739_/RN _3775_/RN VDD VDD VSS VSS gf180mcu_fd_sc_mcu7t5v0__clkbuf_2
X_2182_ _3056_/ZN _3088_/ZN _2186_/A1 VDD VDD VSS VSS gf180mcu_fd_sc_mcu7t5v0__nand2_1
XFILLER_93_664 VDD VDD VSS VSS gf180mcu_fd_sc_mcu7t5v0__fillcap_8
Xclkbuf_4_1_0_clk clkbuf_0_clk/Z clkload0/I VDD VDD VSS VSS gf180mcu_fd_sc_mcu7t5v0__clkbuf_8
XFILLER_18_260 VDD VDD VSS VSS gf180mcu_fd_sc_mcu7t5v0__fillcap_8
XFILLER_33_241 VDD VDD VSS VSS gf180mcu_fd_sc_mcu7t5v0__fillcap_4
X_1966_ _2006_/C _3701_/Q _2004_/C VDD VDD VSS VSS gf180mcu_fd_sc_mcu7t5v0__xor2_2
X_3705_ _3705_/D _3726_/RN clkload6/I _3705_/Q VDD VDD VSS VSS gf180mcu_fd_sc_mcu7t5v0__dffrnq_4
X_1897_ _1897_/A1 _1893_/B _1897_/B _1972_/B VDD VDD VSS VSS gf180mcu_fd_sc_mcu7t5v0__aoi21_1
X_3636_ _3636_/A1 _3636_/A2 _3636_/B _3636_/C _3639_/A2 VDD VDD VSS VSS gf180mcu_fd_sc_mcu7t5v0__aoi211_1
X_3567_ _3565_/Z _3569_/A3 _3567_/Z VDD VDD VSS VSS gf180mcu_fd_sc_mcu7t5v0__xor2_1
X_2518_ _2518_/A1 _3020_/I _2518_/Z VDD VDD VSS VSS gf180mcu_fd_sc_mcu7t5v0__xor2_1
X_3498_ _3510_/A2 _3498_/A2 _3498_/Z VDD VDD VSS VSS gf180mcu_fd_sc_mcu7t5v0__xor2_1
X_2449_ _3243_/I _2449_/A2 _2451_/A2 VDD VDD VSS VSS gf180mcu_fd_sc_mcu7t5v0__nor2_1
XFILLER_68_171 VDD VDD VSS VSS gf180mcu_fd_sc_mcu7t5v0__fillcap_4
XFILLER_84_664 VDD VDD VSS VSS gf180mcu_fd_sc_mcu7t5v0__fill_1
XTAP_TAPCELL_ROW_67_840 VDD VSS gf180mcu_fd_sc_mcu7t5v0__filltie
XTAP_TAPCELL_ROW_39_575 VDD VSS gf180mcu_fd_sc_mcu7t5v0__filltie
XFILLER_71_358 VDD VDD VSS VSS gf180mcu_fd_sc_mcu7t5v0__fill_1
XTAP_TAPCELL_ROW_22_420 VDD VSS gf180mcu_fd_sc_mcu7t5v0__filltie
XFILLER_33_66 VDD VDD VSS VSS gf180mcu_fd_sc_mcu7t5v0__fillcap_4
XFILLER_4_613 VDD VDD VSS VSS gf180mcu_fd_sc_mcu7t5v0__fillcap_8
XPHY_EDGE_ROW_89_Left_186 VDD VSS gf180mcu_fd_sc_mcu7t5v0__endcap
XFILLER_79_458 VDD VDD VSS VSS gf180mcu_fd_sc_mcu7t5v0__fillcap_8
XFILLER_47_366 VDD VDD VSS VSS gf180mcu_fd_sc_mcu7t5v0__fill_2
XFILLER_90_667 VDD VDD VSS VSS gf180mcu_fd_sc_mcu7t5v0__fill_2
XFILLER_28_591 VDD VDD VSS VSS gf180mcu_fd_sc_mcu7t5v0__fillcap_4
XTAP_TAPCELL_ROW_73_898 VDD VSS gf180mcu_fd_sc_mcu7t5v0__filltie
X_1820_ _1816_/Z _1823_/A3 _1822_/A2 VDD VDD VSS VSS gf180mcu_fd_sc_mcu7t5v0__xnor2_1
XFILLER_30_255 VDD VDD VSS VSS gf180mcu_fd_sc_mcu7t5v0__fill_2
XFILLER_70_391 VDD VDD VSS VSS gf180mcu_fd_sc_mcu7t5v0__fill_2
X_3421_ _3672_/Q _3400_/Z _3422_/B1 VDD VDD VSS VSS gf180mcu_fd_sc_mcu7t5v0__nor2_1
X_3352_ _3669_/Q _3690_/Q _3355_/B VDD VDD VSS VSS gf180mcu_fd_sc_mcu7t5v0__xnor2_1
X_2303_ _2981_/ZN _3006_/I _2303_/Z VDD VDD VSS VSS gf180mcu_fd_sc_mcu7t5v0__xor2_1
XFILLER_31_2 VDD VDD VSS VSS gf180mcu_fd_sc_mcu7t5v0__fillcap_64
Xload_slew310 _2765_/A2 _2775_/A2 VDD VDD VSS VSS gf180mcu_fd_sc_mcu7t5v0__clkbuf_2
Xload_slew321 wire319/I _2768_/A1 VDD VDD VSS VSS gf180mcu_fd_sc_mcu7t5v0__clkbuf_2
Xload_slew354 _2479_/A1 _3107_/A2 VDD VDD VSS VSS gf180mcu_fd_sc_mcu7t5v0__clkbuf_1
X_3283_ _3254_/B _3267_/B _3286_/A3 _3283_/B2 _3285_/A1 VDD VDD VSS VSS gf180mcu_fd_sc_mcu7t5v0__aoi22_1
Xload_slew365 wire366/Z _2423_/A1 VDD VDD VSS VSS gf180mcu_fd_sc_mcu7t5v0__clkbuf_2
Xload_slew343 _2865_/A2 _2850_/A2 VDD VDD VSS VSS gf180mcu_fd_sc_mcu7t5v0__clkbuf_2
Xload_slew332 _2894_/B wire331/I VDD VDD VSS VSS gf180mcu_fd_sc_mcu7t5v0__buf_1
X_2234_ _3737_/Q _3094_/ZN _2234_/B _2244_/A2 VDD VDD VSS VSS gf180mcu_fd_sc_mcu7t5v0__aoi21_1
Xload_slew398 wire397/I _2165_/S VDD VDD VSS VSS gf180mcu_fd_sc_mcu7t5v0__clkbuf_1
Xload_slew387 wire388/I _2211_/A2 VDD VDD VSS VSS gf180mcu_fd_sc_mcu7t5v0__clkbuf_1
Xload_slew376 _2261_/A1 _2389_/A2 VDD VDD VSS VSS gf180mcu_fd_sc_mcu7t5v0__clkbuf_1
XTAP_TAPCELL_ROW_88_1042 VDD VSS gf180mcu_fd_sc_mcu7t5v0__filltie
X_2165_ _3386_/A1 _3385_/A2 _2165_/S _2165_/Z VDD VDD VSS VSS gf180mcu_fd_sc_mcu7t5v0__mux2_2
X_2096_ _2096_/A1 _2094_/Z _2096_/Z VDD VDD VSS VSS gf180mcu_fd_sc_mcu7t5v0__xor2_1
XFILLER_81_634 VDD VDD VSS VSS gf180mcu_fd_sc_mcu7t5v0__fill_1
XFILLER_0_70 VDD VDD VSS VSS gf180mcu_fd_sc_mcu7t5v0__fillcap_32
XFILLER_34_550 VDD VDD VSS VSS gf180mcu_fd_sc_mcu7t5v0__fill_2
XTAP_TAPCELL_ROW_36_545 VDD VSS gf180mcu_fd_sc_mcu7t5v0__filltie
XFILLER_80_177 VDD VDD VSS VSS gf180mcu_fd_sc_mcu7t5v0__fillcap_64
XFILLER_34_594 VDD VDD VSS VSS gf180mcu_fd_sc_mcu7t5v0__fill_1
X_2998_ _2998_/I _2998_/ZN VDD VDD VSS VSS gf180mcu_fd_sc_mcu7t5v0__clkinv_1
X_1949_ _1967_/A1 _1950_/A2 _1949_/B _1951_/A2 VDD VDD VSS VSS gf180mcu_fd_sc_mcu7t5v0__aoi21_1
X_3619_ _3617_/Z _3621_/A2 _3637_/B VDD VDD VSS VSS gf180mcu_fd_sc_mcu7t5v0__nand2_1
XFILLER_0_104 VDD VDD VSS VSS gf180mcu_fd_sc_mcu7t5v0__fill_1
XFILLER_76_428 VDD VDD VSS VSS gf180mcu_fd_sc_mcu7t5v0__fillcap_16
XFILLER_29_344 VDD VDD VSS VSS gf180mcu_fd_sc_mcu7t5v0__fillcap_4
XFILLER_72_601 VDD VDD VSS VSS gf180mcu_fd_sc_mcu7t5v0__fill_2
XFILLER_29_399 VDD VDD VSS VSS gf180mcu_fd_sc_mcu7t5v0__fill_1
XFILLER_72_667 VDD VDD VSS VSS gf180mcu_fd_sc_mcu7t5v0__fill_2
XTAP_TAPCELL_ROW_70_868 VDD VSS gf180mcu_fd_sc_mcu7t5v0__filltie
XTAP_TAPCELL_ROW_78_946 VDD VSS gf180mcu_fd_sc_mcu7t5v0__filltie
XTAP_TAPCELL_ROW_7_270 VDD VSS gf180mcu_fd_sc_mcu7t5v0__filltie
XFILLER_94_247 VDD VDD VSS VSS gf180mcu_fd_sc_mcu7t5v0__fillcap_64
XPHY_EDGE_ROW_13_Right_13 VDD VSS gf180mcu_fd_sc_mcu7t5v0__endcap
XFILLER_85_72 VDD VDD VSS VSS gf180mcu_fd_sc_mcu7t5v0__fillcap_64
XFILLER_75_461 VDD VDD VSS VSS gf180mcu_fd_sc_mcu7t5v0__fillcap_8
XFILLER_48_675 VDD VDD VSS VSS gf180mcu_fd_sc_mcu7t5v0__fill_2
XFILLER_35_325 VDD VDD VSS VSS gf180mcu_fd_sc_mcu7t5v0__fillcap_16
X_2921_ wire249/I _2963_/A2 _2921_/B _3698_/D VDD VDD VSS VSS gf180mcu_fd_sc_mcu7t5v0__oai21_1
XFILLER_50_317 VDD VDD VSS VSS gf180mcu_fd_sc_mcu7t5v0__fill_1
XFILLER_31_575 VDD VDD VSS VSS gf180mcu_fd_sc_mcu7t5v0__fill_2
X_2852_ _3747_/Q wire267/Z _2855_/B _2853_/B2 VDD VDD VSS VSS gf180mcu_fd_sc_mcu7t5v0__oai21_1
XFILLER_79_2 VDD VDD VSS VSS gf180mcu_fd_sc_mcu7t5v0__fillcap_64
X_1803_ _3689_/Q _1808_/A2 _1804_/B VDD VDD VSS VSS gf180mcu_fd_sc_mcu7t5v0__nand2_1
XPHY_EDGE_ROW_22_Right_22 VDD VSS gf180mcu_fd_sc_mcu7t5v0__endcap
X_2783_ _2813_/A1 _2786_/A2 _2793_/B _2787_/A2 VDD VDD VSS VSS gf180mcu_fd_sc_mcu7t5v0__aoi21_1
X_3404_ input11/Z _3400_/Z _3404_/A3 _3404_/Z VDD VDD VSS VSS gf180mcu_fd_sc_mcu7t5v0__xor3_1
X_3335_ _3337_/A1 _3337_/A3 _3342_/B VDD VDD VSS VSS gf180mcu_fd_sc_mcu7t5v0__nor2_1
X_3266_ _3263_/C _3269_/A2 _3267_/B VDD VDD VSS VSS gf180mcu_fd_sc_mcu7t5v0__nand2_1
XPHY_EDGE_ROW_31_Right_31 VDD VSS gf180mcu_fd_sc_mcu7t5v0__endcap
X_2217_ _3733_/Q _3090_/ZN _2241_/A1 VDD VDD VSS VSS gf180mcu_fd_sc_mcu7t5v0__nand2_1
X_3197_ _3205_/C _3197_/A2 _3205_/B1 VDD VDD VSS VSS gf180mcu_fd_sc_mcu7t5v0__nand2_1
XFILLER_38_152 VDD VDD VSS VSS gf180mcu_fd_sc_mcu7t5v0__fill_2
XFILLER_26_325 VDD VDD VSS VSS gf180mcu_fd_sc_mcu7t5v0__fill_2
X_2148_ _3680_/Q _2148_/A2 _2148_/B _2148_/C _2201_/A2 VDD VDD VSS VSS gf180mcu_fd_sc_mcu7t5v0__aoi211_4
XTAP_TAPCELL_ROW_49_670 VDD VSS gf180mcu_fd_sc_mcu7t5v0__filltie
XFILLER_54_656 VDD VDD VSS VSS gf180mcu_fd_sc_mcu7t5v0__fill_1
X_2079_ _3036_/I _3072_/ZN _2060_/B _2079_/B2 _2101_/A2 VDD VDD VSS VSS gf180mcu_fd_sc_mcu7t5v0__oai22_2
XFILLER_54_667 VDD VDD VSS VSS gf180mcu_fd_sc_mcu7t5v0__fill_2
XFILLER_41_317 VDD VDD VSS VSS gf180mcu_fd_sc_mcu7t5v0__fill_1
XFILLER_41_328 VDD VDD VSS VSS gf180mcu_fd_sc_mcu7t5v0__fillcap_8
XPHY_EDGE_ROW_40_Right_40 VDD VSS gf180mcu_fd_sc_mcu7t5v0__endcap
XFILLER_22_597 VDD VDD VSS VSS gf180mcu_fd_sc_mcu7t5v0__fill_2
XFILLER_30_34 VDD VDD VSS VSS gf180mcu_fd_sc_mcu7t5v0__fill_1
XFILLER_89_586 VDD VDD VSS VSS gf180mcu_fd_sc_mcu7t5v0__fillcap_8
XFILLER_76_247 VDD VDD VSS VSS gf180mcu_fd_sc_mcu7t5v0__fillcap_32
XFILLER_91_206 VDD VDD VSS VSS gf180mcu_fd_sc_mcu7t5v0__fillcap_4
XTAP_TAPCELL_ROW_75_916 VDD VSS gf180mcu_fd_sc_mcu7t5v0__filltie
XFILLER_57_450 VDD VDD VSS VSS gf180mcu_fd_sc_mcu7t5v0__fill_1
XFILLER_44_111 VDD VDD VSS VSS gf180mcu_fd_sc_mcu7t5v0__fill_2
XFILLER_72_431 VDD VDD VSS VSS gf180mcu_fd_sc_mcu7t5v0__fill_2
XTAP_TAPCELL_ROW_83_993 VDD VSS gf180mcu_fd_sc_mcu7t5v0__filltie
XFILLER_32_317 VDD VDD VSS VSS gf180mcu_fd_sc_mcu7t5v0__fill_1
XFILLER_44_177 VDD VDD VSS VSS gf180mcu_fd_sc_mcu7t5v0__fill_1
XFILLER_9_524 VDD VDD VSS VSS gf180mcu_fd_sc_mcu7t5v0__fill_2
X_3120_ _2148_/C input22/Z _3121_/C VDD VDD VSS VSS gf180mcu_fd_sc_mcu7t5v0__nand2_1
XFILLER_95_556 VDD VDD VSS VSS gf180mcu_fd_sc_mcu7t5v0__fillcap_4
X_3051_ _3674_/Q _3439_/A1 VDD VDD VSS VSS gf180mcu_fd_sc_mcu7t5v0__clkinv_1
XTAP_TAPCELL_ROW_85_1012 VDD VSS gf180mcu_fd_sc_mcu7t5v0__filltie
X_2002_ _2021_/A1 _2021_/A2 _2022_/A1 VDD VDD VSS VSS gf180mcu_fd_sc_mcu7t5v0__nand2_1
XFILLER_35_133 VDD VDD VSS VSS gf180mcu_fd_sc_mcu7t5v0__fillcap_4
XFILLER_36_667 VDD VDD VSS VSS gf180mcu_fd_sc_mcu7t5v0__fill_2
XTAP_TAPCELL_ROW_46_640 VDD VSS gf180mcu_fd_sc_mcu7t5v0__filltie
XTAP_TAPCELL_ROW_18_375 VDD VSS gf180mcu_fd_sc_mcu7t5v0__filltie
XFILLER_51_615 VDD VDD VSS VSS gf180mcu_fd_sc_mcu7t5v0__fill_1
XFILLER_50_147 VDD VDD VSS VSS gf180mcu_fd_sc_mcu7t5v0__fill_2
X_2904_ _3692_/Q _2910_/A1 _2906_/B VDD VDD VSS VSS gf180mcu_fd_sc_mcu7t5v0__nand2_1
X_2835_ _3355_/A1 _2844_/A2 _2835_/B1 _2835_/B2 _3668_/D VDD VDD VSS VSS gf180mcu_fd_sc_mcu7t5v0__oai22_1
XTAP_TAPCELL_ROW_96_1130 VDD VSS gf180mcu_fd_sc_mcu7t5v0__filltie
X_2766_ wire275/I _2766_/A2 _2806_/B _2767_/A3 VDD VDD VSS VSS gf180mcu_fd_sc_mcu7t5v0__oai21_1
X_2697_ _3110_/B2 _3001_/ZN _2697_/A3 _2697_/Z VDD VDD VSS VSS gf180mcu_fd_sc_mcu7t5v0__xor3_1
X_3318_ _3293_/C _3318_/A2 _3318_/B _3340_/A1 VDD VDD VSS VSS gf180mcu_fd_sc_mcu7t5v0__aoi21_2
Xfanout558 input85/Z _3767_/RN VDD VDD VSS VSS gf180mcu_fd_sc_mcu7t5v0__dlyb_1
XFILLER_58_236 VDD VDD VSS VSS gf180mcu_fd_sc_mcu7t5v0__fill_2
XFILLER_58_247 VDD VDD VSS VSS gf180mcu_fd_sc_mcu7t5v0__fill_2
X_3249_ _3223_/Z _3309_/A2 _3271_/A1 VDD VDD VSS VSS gf180mcu_fd_sc_mcu7t5v0__nand2_1
XFILLER_73_206 VDD VDD VSS VSS gf180mcu_fd_sc_mcu7t5v0__fillcap_4
XTAP_TAPCELL_ROW_1_221 VDD VSS gf180mcu_fd_sc_mcu7t5v0__filltie
XFILLER_27_634 VDD VDD VSS VSS gf180mcu_fd_sc_mcu7t5v0__fill_1
XFILLER_39_483 VDD VDD VSS VSS gf180mcu_fd_sc_mcu7t5v0__fill_1
XFILLER_26_177 VDD VDD VSS VSS gf180mcu_fd_sc_mcu7t5v0__fillcap_32
XTAP_TAPCELL_ROW_80_963 VDD VSS gf180mcu_fd_sc_mcu7t5v0__filltie
XTAP_TAPCELL_ROW_52_698 VDD VSS gf180mcu_fd_sc_mcu7t5v0__filltie
XFILLER_10_567 VDD VDD VSS VSS gf180mcu_fd_sc_mcu7t5v0__fill_1
XFILLER_6_527 VDD VDD VSS VSS gf180mcu_fd_sc_mcu7t5v0__fillcap_16
XFILLER_41_66 VDD VDD VSS VSS gf180mcu_fd_sc_mcu7t5v0__fillcap_4
XFILLER_9_2 VDD VDD VSS VSS gf180mcu_fd_sc_mcu7t5v0__fillcap_64
XFILLER_77_512 VDD VDD VSS VSS gf180mcu_fd_sc_mcu7t5v0__fillcap_16
XFILLER_49_269 VDD VDD VSS VSS gf180mcu_fd_sc_mcu7t5v0__fill_2
XFILLER_64_206 VDD VDD VSS VSS gf180mcu_fd_sc_mcu7t5v0__fill_1
XFILLER_9_321 VDD VDD VSS VSS gf180mcu_fd_sc_mcu7t5v0__fillcap_16
XFILLER_9_376 VDD VDD VSS VSS gf180mcu_fd_sc_mcu7t5v0__fill_2
X_2620_ _2620_/A1 input57/Z _2640_/B1 VDD VDD VSS VSS gf180mcu_fd_sc_mcu7t5v0__nor2_2
X_2551_ _3003_/I _2550_/Z _2593_/A2 VDD VDD VSS VSS gf180mcu_fd_sc_mcu7t5v0__nand2_1
Xoutput106 _3164_/ZN cal_phase0_offset[6] VDD VDD VSS VSS gf180mcu_fd_sc_mcu7t5v0__buf_2
Xoutput128 _1912_/ZN cal_phase270_offset[7] VDD VDD VSS VSS gf180mcu_fd_sc_mcu7t5v0__buf_2
Xoutput117 _2075_/Z cal_phase270_offset[16] VDD VDD VSS VSS gf180mcu_fd_sc_mcu7t5v0__buf_2
Xoutput139 _3623_/ZN cal_phase90_offset[17] VDD VDD VSS VSS gf180mcu_fd_sc_mcu7t5v0__buf_2
X_2482_ _3106_/B1 input76/Z _2482_/Z VDD VDD VSS VSS gf180mcu_fd_sc_mcu7t5v0__and2_1
XTAP_TAPCELL_ROW_91_1071 VDD VSS gf180mcu_fd_sc_mcu7t5v0__filltie
XFILLER_68_512 VDD VDD VSS VSS gf180mcu_fd_sc_mcu7t5v0__fill_1
X_3103_ input33/Z _3104_/B2 input32/Z _3103_/B2 _3105_/A2 VDD VDD VSS VSS gf180mcu_fd_sc_mcu7t5v0__oai22_1
X_3034_ _3725_/Q _3205_/A2 VDD VDD VSS VSS gf180mcu_fd_sc_mcu7t5v0__clkinv_1
XFILLER_83_559 VDD VDD VSS VSS gf180mcu_fd_sc_mcu7t5v0__fill_1
XFILLER_23_136 VDD VDD VSS VSS gf180mcu_fd_sc_mcu7t5v0__fillcap_4
XFILLER_31_191 VDD VDD VSS VSS gf180mcu_fd_sc_mcu7t5v0__fill_2
X_2818_ _2828_/A1 _2818_/A2 _2819_/B2 VDD VDD VSS VSS gf180mcu_fd_sc_mcu7t5v0__nand2_1
X_2749_ _2749_/A1 _2756_/A1 _2756_/A2 _2805_/B1 VDD VDD VSS VSS gf180mcu_fd_sc_mcu7t5v0__nor3_4
XPHY_EDGE_ROW_52_Left_149 VDD VSS gf180mcu_fd_sc_mcu7t5v0__endcap
Xfanout311 _2125_/ZN _2267_/C VDD VDD VSS VSS gf180mcu_fd_sc_mcu7t5v0__dlyb_1
Xfanout322 _2894_/B _2882_/B VDD VDD VSS VSS gf180mcu_fd_sc_mcu7t5v0__dlyb_1
Xfanout333 _2829_/A2 _2809_/A2 VDD VDD VSS VSS gf180mcu_fd_sc_mcu7t5v0__dlyb_1
XFILLER_59_545 VDD VDD VSS VSS gf180mcu_fd_sc_mcu7t5v0__fillcap_4
Xfanout399 _3762_/Q wire400/I VDD VDD VSS VSS gf180mcu_fd_sc_mcu7t5v0__dlyb_1
Xfanout377 _3763_/Q _2255_/A1 VDD VDD VSS VSS gf180mcu_fd_sc_mcu7t5v0__dlyb_1
XFILLER_59_578 VDD VDD VSS VSS gf180mcu_fd_sc_mcu7t5v0__fillcap_8
XTAP_TAPCELL_ROW_57_746 VDD VSS gf180mcu_fd_sc_mcu7t5v0__filltie
XFILLER_15_615 VDD VDD VSS VSS gf180mcu_fd_sc_mcu7t5v0__fill_1
XPHY_EDGE_ROW_61_Left_158 VDD VSS gf180mcu_fd_sc_mcu7t5v0__endcap
XTAP_TAPCELL_ROW_12_326 VDD VSS gf180mcu_fd_sc_mcu7t5v0__filltie
XFILLER_10_353 VDD VDD VSS VSS gf180mcu_fd_sc_mcu7t5v0__fill_2
Xinput19 cfg_phase0_offset[0] _3100_/B VDD VDD VSS VSS gf180mcu_fd_sc_mcu7t5v0__buf_1
XFILLER_6_335 VDD VDD VSS VSS gf180mcu_fd_sc_mcu7t5v0__fillcap_4
XPHY_EDGE_ROW_70_Left_167 VDD VSS gf180mcu_fd_sc_mcu7t5v0__endcap
XFILLER_6_379 VDD VDD VSS VSS gf180mcu_fd_sc_mcu7t5v0__fillcap_4
XFILLER_77_364 VDD VDD VSS VSS gf180mcu_fd_sc_mcu7t5v0__fill_1
XFILLER_65_548 VDD VDD VSS VSS gf180mcu_fd_sc_mcu7t5v0__fill_2
XFILLER_65_559 VDD VDD VSS VSS gf180mcu_fd_sc_mcu7t5v0__fill_1
XFILLER_93_72 VDD VDD VSS VSS gf180mcu_fd_sc_mcu7t5v0__fillcap_64
XFILLER_18_486 VDD VDD VSS VSS gf180mcu_fd_sc_mcu7t5v0__fill_2
XFILLER_18_475 VDD VDD VSS VSS gf180mcu_fd_sc_mcu7t5v0__fill_1
XTAP_TAPCELL_ROW_28_470 VDD VSS gf180mcu_fd_sc_mcu7t5v0__filltie
XFILLER_33_478 VDD VDD VSS VSS gf180mcu_fd_sc_mcu7t5v0__fill_2
X_1982_ _1965_/I _1980_/Z _1982_/Z VDD VDD VSS VSS gf180mcu_fd_sc_mcu7t5v0__xor2_1
XFILLER_33_489 VDD VDD VSS VSS gf180mcu_fd_sc_mcu7t5v0__fill_1
X_3721_ _3721_/D _3721_/RN _3721_/CLK _3721_/Q VDD VDD VSS VSS gf180mcu_fd_sc_mcu7t5v0__dffrnq_2
X_3652_ _3652_/D _3659_/RN clkload0/I _3652_/Q VDD VDD VSS VSS gf180mcu_fd_sc_mcu7t5v0__dffrnq_1
X_2603_ _2603_/A1 _2603_/A2 _2603_/B _2603_/C _2608_/A1 VDD VDD VSS VSS gf180mcu_fd_sc_mcu7t5v0__aoi211_1
XFILLER_61_2 VDD VDD VSS VSS gf180mcu_fd_sc_mcu7t5v0__fillcap_64
X_3583_ _3704_/Q _3601_/A1 _3583_/B _3584_/B VDD VDD VSS VSS gf180mcu_fd_sc_mcu7t5v0__aoi21_1
X_2534_ _2675_/C input68/Z _2540_/B VDD VDD VSS VSS gf180mcu_fd_sc_mcu7t5v0__nand2_1
X_2465_ _3656_/Q _3655_/Q _2742_/A3 VDD VDD VSS VSS gf180mcu_fd_sc_mcu7t5v0__nand2_1
X_2396_ _3741_/Q input3/Z _2708_/B VDD VDD VSS VSS gf180mcu_fd_sc_mcu7t5v0__nor2_1
X_3017_ _3017_/I _3017_/ZN VDD VDD VSS VSS gf180mcu_fd_sc_mcu7t5v0__clkinv_1
XFILLER_43_209 VDD VDD VSS VSS gf180mcu_fd_sc_mcu7t5v0__fill_1
XTAP_TAPCELL_ROW_54_716 VDD VSS gf180mcu_fd_sc_mcu7t5v0__filltie
XFILLER_64_570 VDD VDD VSS VSS gf180mcu_fd_sc_mcu7t5v0__fillcap_8
XTAP_TAPCELL_ROW_62_793 VDD VSS gf180mcu_fd_sc_mcu7t5v0__filltie
XFILLER_87_640 VDD VDD VSS VSS gf180mcu_fd_sc_mcu7t5v0__fill_1
XFILLER_19_228 VDD VDD VSS VSS gf180mcu_fd_sc_mcu7t5v0__fillcap_4
XFILLER_19_206 VDD VDD VSS VSS gf180mcu_fd_sc_mcu7t5v0__fillcap_4
XFILLER_59_375 VDD VDD VSS VSS gf180mcu_fd_sc_mcu7t5v0__fillcap_4
XFILLER_47_559 VDD VDD VSS VSS gf180mcu_fd_sc_mcu7t5v0__fill_1
XFILLER_74_378 VDD VDD VSS VSS gf180mcu_fd_sc_mcu7t5v0__fillcap_4
XPHY_EDGE_ROW_69_Right_69 VDD VSS gf180mcu_fd_sc_mcu7t5v0__endcap
XFILLER_70_551 VDD VDD VSS VSS gf180mcu_fd_sc_mcu7t5v0__fillcap_4
XFILLER_15_489 VDD VDD VSS VSS gf180mcu_fd_sc_mcu7t5v0__fill_1
XFILLER_8_37 VDD VDD VSS VSS gf180mcu_fd_sc_mcu7t5v0__fillcap_64
Xwire586 wire586/I wire586/Z VDD VDD VSS VSS gf180mcu_fd_sc_mcu7t5v0__clkbuf_2
Xwire597 wire597/I wire597/Z VDD VDD VSS VSS gf180mcu_fd_sc_mcu7t5v0__clkbuf_2
XPHY_EDGE_ROW_78_Right_78 VDD VSS gf180mcu_fd_sc_mcu7t5v0__endcap
Xload_slew503 _3685_/Q _2885_/A1 VDD VDD VSS VSS gf180mcu_fd_sc_mcu7t5v0__buf_2
X_2250_ _2445_/A1 _2119_/Z _2250_/ZN VDD VDD VSS VSS gf180mcu_fd_sc_mcu7t5v0__nand2_1
Xload_slew547 wire548/Z _2912_/A2 VDD VDD VSS VSS gf180mcu_fd_sc_mcu7t5v0__clkbuf_1
Xload_slew569 _3779_/RN _3739_/RN VDD VDD VSS VSS gf180mcu_fd_sc_mcu7t5v0__buf_2
XFILLER_93_632 VDD VDD VSS VSS gf180mcu_fd_sc_mcu7t5v0__fillcap_32
X_2181_ _2649_/C _2181_/A2 _2185_/B VDD VDD VSS VSS gf180mcu_fd_sc_mcu7t5v0__xor2_1
XFILLER_93_676 VDD VDD VSS VSS gf180mcu_fd_sc_mcu7t5v0__fill_1
XPHY_EDGE_ROW_87_Right_87 VDD VSS gf180mcu_fd_sc_mcu7t5v0__endcap
XFILLER_18_272 VDD VDD VSS VSS gf180mcu_fd_sc_mcu7t5v0__fill_2
XFILLER_46_581 VDD VDD VSS VSS gf180mcu_fd_sc_mcu7t5v0__fill_1
XFILLER_61_551 VDD VDD VSS VSS gf180mcu_fd_sc_mcu7t5v0__fillcap_4
XFILLER_33_275 VDD VDD VSS VSS gf180mcu_fd_sc_mcu7t5v0__fillcap_4
X_1965_ _1965_/I _1996_/A1 VDD VDD VSS VSS gf180mcu_fd_sc_mcu7t5v0__clkinv_1
XFILLER_21_448 VDD VDD VSS VSS gf180mcu_fd_sc_mcu7t5v0__fillcap_4
X_3704_ _3704_/D _3727_/RN clkload6/I _3704_/Q VDD VDD VSS VSS gf180mcu_fd_sc_mcu7t5v0__dffrnq_4
X_1896_ _1897_/A1 _1893_/B _1898_/A2 VDD VDD VSS VSS gf180mcu_fd_sc_mcu7t5v0__nand2_1
XTAP_TAPCELL_ROW_31_498 VDD VSS gf180mcu_fd_sc_mcu7t5v0__filltie
XPHY_EDGE_ROW_96_Right_96 VDD VSS gf180mcu_fd_sc_mcu7t5v0__endcap
X_3635_ _3648_/A1 _3648_/A2 _3638_/B VDD VDD VSS VSS gf180mcu_fd_sc_mcu7t5v0__xor2_1
X_3566_ _3584_/A1 _3584_/A2 _3582_/B _3569_/A3 VDD VDD VSS VSS gf180mcu_fd_sc_mcu7t5v0__oai21_1
X_2517_ _2517_/A1 _2523_/B _2515_/Z _2516_/Z _2556_/A1 VDD VDD VSS VSS gf180mcu_fd_sc_mcu7t5v0__oai22_1
XFILLER_0_308 VDD VDD VSS VSS gf180mcu_fd_sc_mcu7t5v0__fillcap_32
X_3497_ _3511_/A1 _3513_/A1 _3498_/A2 VDD VDD VSS VSS gf180mcu_fd_sc_mcu7t5v0__nand2_1
XFILLER_88_426 VDD VDD VSS VSS gf180mcu_fd_sc_mcu7t5v0__fill_1
X_2448_ wire422/I _2448_/A2 _2448_/B _2450_/A2 VDD VDD VSS VSS gf180mcu_fd_sc_mcu7t5v0__aoi21_1
X_2379_ _3735_/Q _2388_/B1 _2381_/A3 _2383_/A2 VDD VDD VSS VSS gf180mcu_fd_sc_mcu7t5v0__nand3_1
XFILLER_83_142 VDD VDD VSS VSS gf180mcu_fd_sc_mcu7t5v0__fillcap_64
XFILLER_29_559 VDD VDD VSS VSS gf180mcu_fd_sc_mcu7t5v0__fill_1
XTAP_TAPCELL_ROW_67_841 VDD VSS gf180mcu_fd_sc_mcu7t5v0__filltie
XFILLER_16_209 VDD VDD VSS VSS gf180mcu_fd_sc_mcu7t5v0__fillcap_16
XFILLER_37_570 VDD VDD VSS VSS gf180mcu_fd_sc_mcu7t5v0__fill_1
XTAP_TAPCELL_ROW_39_576 VDD VSS gf180mcu_fd_sc_mcu7t5v0__filltie
XFILLER_44_507 VDD VDD VSS VSS gf180mcu_fd_sc_mcu7t5v0__fill_1
XFILLER_56_378 VDD VDD VSS VSS gf180mcu_fd_sc_mcu7t5v0__fillcap_4
XTAP_TAPCELL_ROW_22_421 VDD VSS gf180mcu_fd_sc_mcu7t5v0__filltie
XFILLER_20_481 VDD VDD VSS VSS gf180mcu_fd_sc_mcu7t5v0__fillcap_4
XFILLER_4_625 VDD VDD VSS VSS gf180mcu_fd_sc_mcu7t5v0__fill_2
XFILLER_87_492 VDD VDD VSS VSS gf180mcu_fd_sc_mcu7t5v0__fill_2
XFILLER_75_676 VDD VDD VSS VSS gf180mcu_fd_sc_mcu7t5v0__fill_1
XFILLER_15_220 VDD VDD VSS VSS gf180mcu_fd_sc_mcu7t5v0__fillcap_4
XFILLER_15_264 VDD VDD VSS VSS gf180mcu_fd_sc_mcu7t5v0__fillcap_4
XTAP_TAPCELL_ROW_73_899 VDD VSS gf180mcu_fd_sc_mcu7t5v0__filltie
XFILLER_30_234 VDD VDD VSS VSS gf180mcu_fd_sc_mcu7t5v0__fill_2
XFILLER_11_470 VDD VDD VSS VSS gf180mcu_fd_sc_mcu7t5v0__fill_2
Xwire361 wire362/Z wire361/Z VDD VDD VSS VSS gf180mcu_fd_sc_mcu7t5v0__buf_1
X_3420_ _3420_/A1 _3389_/I _3420_/B _3420_/C _3456_/B2 VDD VDD VSS VSS gf180mcu_fd_sc_mcu7t5v0__oai211_1
X_3351_ _3365_/A1 _3690_/Q _3360_/A1 VDD VDD VSS VSS gf180mcu_fd_sc_mcu7t5v0__nand2_1
X_2302_ _2979_/ZN _3558_/A1 _2427_/A1 VDD VDD VSS VSS gf180mcu_fd_sc_mcu7t5v0__nand2_1
X_3282_ _3282_/A1 _3282_/A2 _3282_/B _3286_/A3 VDD VDD VSS VSS gf180mcu_fd_sc_mcu7t5v0__aoi21_1
Xload_slew355 _2413_/A1 _2479_/A1 VDD VDD VSS VSS gf180mcu_fd_sc_mcu7t5v0__clkbuf_1
Xload_slew344 _2868_/A2 _2865_/A2 VDD VDD VSS VSS gf180mcu_fd_sc_mcu7t5v0__clkbuf_2
XFILLER_85_418 VDD VDD VSS VSS gf180mcu_fd_sc_mcu7t5v0__fill_2
XFILLER_78_481 VDD VDD VSS VSS gf180mcu_fd_sc_mcu7t5v0__fillcap_16
XFILLER_24_2 VDD VDD VSS VSS gf180mcu_fd_sc_mcu7t5v0__fillcap_32
X_2233_ _3086_/ZN _3666_/Q _2244_/B VDD VDD VSS VSS gf180mcu_fd_sc_mcu7t5v0__xor2_1
X_2164_ _2164_/A1 _2164_/A2 _2166_/A2 _2905_/A1 _2164_/C _2170_/A1 VDD VDD VSS VSS
+ gf180mcu_fd_sc_mcu7t5v0__aoi221_1
XTAP_TAPCELL_ROW_88_1043 VDD VSS gf180mcu_fd_sc_mcu7t5v0__filltie
XTAP_TAPCELL_ROW_64_811 VDD VSS gf180mcu_fd_sc_mcu7t5v0__filltie
XFILLER_65_142 VDD VDD VSS VSS gf180mcu_fd_sc_mcu7t5v0__fillcap_16
X_2095_ _2096_/A1 _2094_/Z _2109_/B VDD VDD VSS VSS gf180mcu_fd_sc_mcu7t5v0__and2_1
XFILLER_80_101 VDD VDD VSS VSS gf180mcu_fd_sc_mcu7t5v0__fillcap_4
XFILLER_53_337 VDD VDD VSS VSS gf180mcu_fd_sc_mcu7t5v0__fillcap_4
XTAP_TAPCELL_ROW_36_546 VDD VSS gf180mcu_fd_sc_mcu7t5v0__filltie
XFILLER_21_212 VDD VDD VSS VSS gf180mcu_fd_sc_mcu7t5v0__fillcap_16
X_2997_ _2997_/I _2997_/ZN VDD VDD VSS VSS gf180mcu_fd_sc_mcu7t5v0__clkinv_1
X_1948_ _1967_/A1 _1950_/A2 _1952_/A3 VDD VDD VSS VSS gf180mcu_fd_sc_mcu7t5v0__nand2_1
X_1879_ _3717_/Q _3431_/A1 _1879_/Z VDD VDD VSS VSS gf180mcu_fd_sc_mcu7t5v0__or2_1
X_3618_ _3003_/I _3618_/A2 _3618_/B _3621_/A2 VDD VDD VSS VSS gf180mcu_fd_sc_mcu7t5v0__oai21_1
X_3549_ _3549_/A1 _3532_/Z _3551_/B2 VDD VDD VSS VSS gf180mcu_fd_sc_mcu7t5v0__nor2_1
XFILLER_0_138 VDD VDD VSS VSS gf180mcu_fd_sc_mcu7t5v0__fillcap_32
XFILLER_28_34 VDD VDD VSS VSS gf180mcu_fd_sc_mcu7t5v0__fill_1
XFILLER_57_632 VDD VDD VSS VSS gf180mcu_fd_sc_mcu7t5v0__fill_2
XFILLER_84_495 VDD VDD VSS VSS gf180mcu_fd_sc_mcu7t5v0__fillcap_16
XFILLER_52_392 VDD VDD VSS VSS gf180mcu_fd_sc_mcu7t5v0__fillcap_8
XTAP_TAPCELL_ROW_70_869 VDD VSS gf180mcu_fd_sc_mcu7t5v0__filltie
XFILLER_40_576 VDD VDD VSS VSS gf180mcu_fd_sc_mcu7t5v0__fill_2
Xclkbuf_4_0_0_clk clkbuf_0_clk/Z _3739_/CLK VDD VDD VSS VSS gf180mcu_fd_sc_mcu7t5v0__clkbuf_8
XFILLER_79_212 VDD VDD VSS VSS gf180mcu_fd_sc_mcu7t5v0__fillcap_64
XFILLER_67_407 VDD VDD VSS VSS gf180mcu_fd_sc_mcu7t5v0__fillcap_4
XTAP_TAPCELL_ROW_7_271 VDD VSS gf180mcu_fd_sc_mcu7t5v0__filltie
XFILLER_0_650 VDD VDD VSS VSS gf180mcu_fd_sc_mcu7t5v0__fill_1
XTAP_TAPCELL_ROW_78_947 VDD VSS gf180mcu_fd_sc_mcu7t5v0__filltie
XFILLER_47_142 VDD VDD VSS VSS gf180mcu_fd_sc_mcu7t5v0__fillcap_16
XFILLER_47_197 VDD VDD VSS VSS gf180mcu_fd_sc_mcu7t5v0__fillcap_4
XFILLER_62_101 VDD VDD VSS VSS gf180mcu_fd_sc_mcu7t5v0__fillcap_4
XFILLER_62_123 VDD VDD VSS VSS gf180mcu_fd_sc_mcu7t5v0__fillcap_8
XFILLER_90_454 VDD VDD VSS VSS gf180mcu_fd_sc_mcu7t5v0__fill_1
XFILLER_16_540 VDD VDD VSS VSS gf180mcu_fd_sc_mcu7t5v0__fillcap_4
X_2920_ _2920_/A1 wire548/Z _2963_/A2 VDD VDD VSS VSS gf180mcu_fd_sc_mcu7t5v0__nand2_1
X_2851_ _3674_/Q wire231/Z _2853_/B1 VDD VDD VSS VSS gf180mcu_fd_sc_mcu7t5v0__nor2_1
X_2782_ _3092_/ZN _2792_/A2 _2782_/B _2786_/A2 VDD VDD VSS VSS gf180mcu_fd_sc_mcu7t5v0__oai21_1
XTAP_TAPCELL_ROW_41_593 VDD VSS gf180mcu_fd_sc_mcu7t5v0__filltie
X_1802_ _3357_/A1 _3780_/I _1802_/B _1808_/A2 VDD VDD VSS VSS gf180mcu_fd_sc_mcu7t5v0__oai21_1
X_3403_ input11/Z _3402_/Z _3413_/B VDD VDD VSS VSS gf180mcu_fd_sc_mcu7t5v0__nor2_1
X_3334_ _3339_/B _3333_/Z _3337_/A3 VDD VDD VSS VSS gf180mcu_fd_sc_mcu7t5v0__nand2_1
X_3265_ _3299_/B _3223_/Z _3270_/B _3265_/C _3267_/A2 VDD VDD VSS VSS gf180mcu_fd_sc_mcu7t5v0__oai211_1
XFILLER_58_429 VDD VDD VSS VSS gf180mcu_fd_sc_mcu7t5v0__fillcap_16
X_2216_ _2366_/S _3660_/Q _2216_/Z VDD VDD VSS VSS gf180mcu_fd_sc_mcu7t5v0__xor2_1
X_3196_ wire626/Z _3196_/A2 _3197_/A2 VDD VDD VSS VSS gf180mcu_fd_sc_mcu7t5v0__nand2_1
XFILLER_66_473 VDD VDD VSS VSS gf180mcu_fd_sc_mcu7t5v0__fill_1
XFILLER_38_197 VDD VDD VSS VSS gf180mcu_fd_sc_mcu7t5v0__fillcap_4
X_2147_ _2006_/B _2154_/A2 _2148_/B VDD VDD VSS VSS gf180mcu_fd_sc_mcu7t5v0__nor2_1
XTAP_TAPCELL_ROW_49_671 VDD VSS gf180mcu_fd_sc_mcu7t5v0__filltie
XFILLER_54_635 VDD VDD VSS VSS gf180mcu_fd_sc_mcu7t5v0__fill_2
X_2078_ _3203_/A2 _3070_/I _3612_/A1 _3210_/A2 _2079_/B2 VDD VDD VSS VSS gf180mcu_fd_sc_mcu7t5v0__oai22_2
XFILLER_81_454 VDD VDD VSS VSS gf180mcu_fd_sc_mcu7t5v0__fill_1
XFILLER_34_370 VDD VDD VSS VSS gf180mcu_fd_sc_mcu7t5v0__fill_1
XFILLER_39_66 VDD VDD VSS VSS gf180mcu_fd_sc_mcu7t5v0__fillcap_4
XTAP_TAPCELL_ROW_4_241 VDD VSS gf180mcu_fd_sc_mcu7t5v0__filltie
XTAP_TAPCELL_ROW_75_917 VDD VSS gf180mcu_fd_sc_mcu7t5v0__filltie
XFILLER_29_142 VDD VDD VSS VSS gf180mcu_fd_sc_mcu7t5v0__fillcap_16
XFILLER_44_101 VDD VDD VSS VSS gf180mcu_fd_sc_mcu7t5v0__fillcap_4
XFILLER_45_668 VDD VDD VSS VSS gf180mcu_fd_sc_mcu7t5v0__fill_1
XFILLER_72_454 VDD VDD VSS VSS gf180mcu_fd_sc_mcu7t5v0__fill_1
XTAP_TAPCELL_ROW_83_994 VDD VSS gf180mcu_fd_sc_mcu7t5v0__filltie
XFILLER_9_503 VDD VDD VSS VSS gf180mcu_fd_sc_mcu7t5v0__fill_1
XFILLER_9_536 VDD VDD VSS VSS gf180mcu_fd_sc_mcu7t5v0__fill_2
XFILLER_40_384 VDD VDD VSS VSS gf180mcu_fd_sc_mcu7t5v0__fill_1
XTAP_TAPCELL_ROW_10_298 VDD VSS gf180mcu_fd_sc_mcu7t5v0__filltie
X_3050_ _3050_/I _3415_/A1 VDD VDD VSS VSS gf180mcu_fd_sc_mcu7t5v0__clkinv_1
X_2001_ _2023_/A1 _2038_/A1 _2001_/Z VDD VDD VSS VSS gf180mcu_fd_sc_mcu7t5v0__xor2_2
XFILLER_67_259 VDD VDD VSS VSS gf180mcu_fd_sc_mcu7t5v0__fillcap_4
XTAP_TAPCELL_ROW_85_1013 VDD VSS gf180mcu_fd_sc_mcu7t5v0__filltie
XFILLER_36_624 VDD VDD VSS VSS gf180mcu_fd_sc_mcu7t5v0__fill_1
XTAP_TAPCELL_ROW_46_641 VDD VSS gf180mcu_fd_sc_mcu7t5v0__filltie
XFILLER_51_605 VDD VDD VSS VSS gf180mcu_fd_sc_mcu7t5v0__fillcap_8
XFILLER_63_432 VDD VDD VSS VSS gf180mcu_fd_sc_mcu7t5v0__fill_2
XFILLER_63_465 VDD VDD VSS VSS gf180mcu_fd_sc_mcu7t5v0__fillcap_4
XTAP_TAPCELL_ROW_18_376 VDD VSS gf180mcu_fd_sc_mcu7t5v0__filltie
XFILLER_16_381 VDD VDD VSS VSS gf180mcu_fd_sc_mcu7t5v0__fillcap_4
XFILLER_91_2 VDD VDD VSS VSS gf180mcu_fd_sc_mcu7t5v0__fillcap_64
X_2903_ _2903_/A1 _2949_/A2 _2903_/B _3691_/D VDD VDD VSS VSS gf180mcu_fd_sc_mcu7t5v0__oai21_1
X_2834_ _3668_/Q _2843_/A2 _2843_/B _2835_/B2 VDD VDD VSS VSS gf180mcu_fd_sc_mcu7t5v0__oai21_1
XTAP_TAPCELL_ROW_96_1131 VDD VSS gf180mcu_fd_sc_mcu7t5v0__filltie
XTAP_TAPCELL_ROW_96_1120 VDD VSS gf180mcu_fd_sc_mcu7t5v0__filltie
XFILLER_8_591 VDD VDD VSS VSS gf180mcu_fd_sc_mcu7t5v0__fillcap_4
X_2765_ _3733_/Q _2765_/A2 _2805_/B1 _2765_/B2 _2765_/C _2769_/B1 VDD VDD VSS VSS
+ gf180mcu_fd_sc_mcu7t5v0__aoi221_1
X_2696_ _2644_/B _2696_/A2 _2696_/B _2718_/A1 VDD VDD VSS VSS gf180mcu_fd_sc_mcu7t5v0__oai21_1
Xfanout526 fanout526/I wire528/I VDD VDD VSS VSS gf180mcu_fd_sc_mcu7t5v0__dlyb_1
XFILLER_86_524 VDD VDD VSS VSS gf180mcu_fd_sc_mcu7t5v0__fill_1
XFILLER_86_502 VDD VDD VSS VSS gf180mcu_fd_sc_mcu7t5v0__fillcap_16
X_3317_ _3317_/A1 _3317_/A2 _3317_/B _3330_/A1 VDD VDD VSS VSS gf180mcu_fd_sc_mcu7t5v0__aoi21_1
X_3248_ _3282_/A1 _3306_/A2 _3251_/B1 VDD VDD VSS VSS gf180mcu_fd_sc_mcu7t5v0__nor2_1
XFILLER_26_101 VDD VDD VSS VSS gf180mcu_fd_sc_mcu7t5v0__fillcap_4
X_3179_ _2696_/B _3179_/A2 _3179_/Z VDD VDD VSS VSS gf180mcu_fd_sc_mcu7t5v0__xor2_2
XFILLER_41_104 VDD VDD VSS VSS gf180mcu_fd_sc_mcu7t5v0__fillcap_4
XFILLER_41_148 VDD VDD VSS VSS gf180mcu_fd_sc_mcu7t5v0__fillcap_32
XTAP_TAPCELL_ROW_80_964 VDD VSS gf180mcu_fd_sc_mcu7t5v0__filltie
XFILLER_22_351 VDD VDD VSS VSS gf180mcu_fd_sc_mcu7t5v0__fillcap_8
XTAP_TAPCELL_ROW_52_699 VDD VSS gf180mcu_fd_sc_mcu7t5v0__filltie
XFILLER_77_546 VDD VDD VSS VSS gf180mcu_fd_sc_mcu7t5v0__fillcap_8
XFILLER_92_527 VDD VDD VSS VSS gf180mcu_fd_sc_mcu7t5v0__fillcap_64
XTAP_TAPCELL_ROW_15_346 VDD VSS gf180mcu_fd_sc_mcu7t5v0__filltie
XFILLER_60_457 VDD VDD VSS VSS gf180mcu_fd_sc_mcu7t5v0__fill_2
X_2550_ _2469_/Z _2550_/A2 _2550_/Z VDD VDD VSS VSS gf180mcu_fd_sc_mcu7t5v0__xor2_1
Xoutput107 _3167_/Z cal_phase0_offset[7] VDD VDD VSS VSS gf180mcu_fd_sc_mcu7t5v0__buf_2
Xoutput118 _2088_/Z cal_phase270_offset[17] VDD VDD VSS VSS gf180mcu_fd_sc_mcu7t5v0__buf_2
Xoutput129 _1923_/Z cal_phase270_offset[8] VDD VDD VSS VSS gf180mcu_fd_sc_mcu7t5v0__buf_2
X_2481_ wire468/I _3025_/ZN _2502_/B VDD VDD VSS VSS gf180mcu_fd_sc_mcu7t5v0__nand2_1
XTAP_TAPCELL_ROW_91_1072 VDD VSS gf180mcu_fd_sc_mcu7t5v0__filltie
XFILLER_83_505 VDD VDD VSS VSS gf180mcu_fd_sc_mcu7t5v0__fillcap_8
X_3102_ _3102_/A1 _3102_/A2 _3102_/Z VDD VDD VSS VSS gf180mcu_fd_sc_mcu7t5v0__and2_1
X_3033_ _3724_/Q _3196_/A2 VDD VDD VSS VSS gf180mcu_fd_sc_mcu7t5v0__clkinv_1
XFILLER_36_454 VDD VDD VSS VSS gf180mcu_fd_sc_mcu7t5v0__fill_1
X_2817_ _2827_/A1 _2817_/A2 _2817_/A3 _2818_/A2 VDD VDD VSS VSS gf180mcu_fd_sc_mcu7t5v0__nand3_1
X_2748_ _2748_/A1 _2823_/A1 _2756_/A2 VDD VDD VSS VSS gf180mcu_fd_sc_mcu7t5v0__nor2_2
X_2679_ _2734_/C _2734_/B _2730_/A1 VDD VDD VSS VSS gf180mcu_fd_sc_mcu7t5v0__nor2_1
Xfanout356 _3111_/B1 wire358/I VDD VDD VSS VSS gf180mcu_fd_sc_mcu7t5v0__dlyb_1
Xfanout345 _2247_/ZN fanout345/Z VDD VDD VSS VSS gf180mcu_fd_sc_mcu7t5v0__dlyb_1
Xfanout367 _2250_/ZN wire368/I VDD VDD VSS VSS gf180mcu_fd_sc_mcu7t5v0__dlyb_1
Xfanout389 wire400/Z _2196_/A2 VDD VDD VSS VSS gf180mcu_fd_sc_mcu7t5v0__dlyb_1
XFILLER_86_376 VDD VDD VSS VSS gf180mcu_fd_sc_mcu7t5v0__fillcap_8
XFILLER_46_207 VDD VDD VSS VSS gf180mcu_fd_sc_mcu7t5v0__fill_2
XFILLER_74_516 VDD VDD VSS VSS gf180mcu_fd_sc_mcu7t5v0__fill_1
XFILLER_36_34 VDD VDD VSS VSS gf180mcu_fd_sc_mcu7t5v0__fill_1
XFILLER_39_292 VDD VDD VSS VSS gf180mcu_fd_sc_mcu7t5v0__fillcap_16
XTAP_TAPCELL_ROW_57_747 VDD VSS gf180mcu_fd_sc_mcu7t5v0__filltie
XFILLER_67_590 VDD VDD VSS VSS gf180mcu_fd_sc_mcu7t5v0__fill_2
XFILLER_82_560 VDD VDD VSS VSS gf180mcu_fd_sc_mcu7t5v0__fill_1
XFILLER_15_605 VDD VDD VSS VSS gf180mcu_fd_sc_mcu7t5v0__fill_1
XFILLER_82_593 VDD VDD VSS VSS gf180mcu_fd_sc_mcu7t5v0__fill_2
XFILLER_10_310 VDD VDD VSS VSS gf180mcu_fd_sc_mcu7t5v0__fillcap_4
XFILLER_10_376 VDD VDD VSS VSS gf180mcu_fd_sc_mcu7t5v0__fillcap_8
XFILLER_6_314 VDD VDD VSS VSS gf180mcu_fd_sc_mcu7t5v0__fill_1
XTAP_TAPCELL_ROW_20_393 VDD VSS gf180mcu_fd_sc_mcu7t5v0__filltie
XFILLER_10_387 VDD VDD VSS VSS gf180mcu_fd_sc_mcu7t5v0__fillcap_16
XFILLER_6_347 VDD VDD VSS VSS gf180mcu_fd_sc_mcu7t5v0__fillcap_32
XFILLER_2_597 VDD VDD VSS VSS gf180mcu_fd_sc_mcu7t5v0__fillcap_64
XFILLER_37_229 VDD VDD VSS VSS gf180mcu_fd_sc_mcu7t5v0__fillcap_8
XFILLER_73_571 VDD VDD VSS VSS gf180mcu_fd_sc_mcu7t5v0__fill_1
XTAP_TAPCELL_ROW_28_471 VDD VSS gf180mcu_fd_sc_mcu7t5v0__filltie
X_1981_ _1996_/A1 _1980_/Z _1999_/A2 VDD VDD VSS VSS gf180mcu_fd_sc_mcu7t5v0__nand2_1
XFILLER_20_107 VDD VDD VSS VSS gf180mcu_fd_sc_mcu7t5v0__fillcap_64
X_3720_ _3720_/D wire604/Z _3774_/CLK _3720_/Q VDD VDD VSS VSS gf180mcu_fd_sc_mcu7t5v0__dffrnq_2
X_3651_ _3651_/D _3739_/RN _3739_/CLK _3651_/Q VDD VDD VSS VSS gf180mcu_fd_sc_mcu7t5v0__dffsnq_1
X_2602_ _2602_/A1 _2602_/A2 _2602_/B _2602_/C _2609_/A2 VDD VDD VSS VSS gf180mcu_fd_sc_mcu7t5v0__aoi211_1
X_3582_ _3582_/A1 _3683_/Q _3582_/B _3583_/B VDD VDD VSS VSS gf180mcu_fd_sc_mcu7t5v0__aoi21_1
X_2533_ _2970_/I _3017_/I _2533_/Z VDD VDD VSS VSS gf180mcu_fd_sc_mcu7t5v0__xor2_1
XFILLER_54_2 VDD VDD VSS VSS gf180mcu_fd_sc_mcu7t5v0__fillcap_32
X_2464_ _2994_/ZN _2463_/B _3654_/D VDD VDD VSS VSS gf180mcu_fd_sc_mcu7t5v0__nor2_1
X_2395_ wire543/Z _2397_/A1 _2415_/A2 VDD VDD VSS VSS gf180mcu_fd_sc_mcu7t5v0__nand2_2
XFILLER_56_527 VDD VDD VSS VSS gf180mcu_fd_sc_mcu7t5v0__fill_2
XFILLER_68_387 VDD VDD VSS VSS gf180mcu_fd_sc_mcu7t5v0__fillcap_4
XFILLER_83_346 VDD VDD VSS VSS gf180mcu_fd_sc_mcu7t5v0__fillcap_4
XFILLER_83_379 VDD VDD VSS VSS gf180mcu_fd_sc_mcu7t5v0__fillcap_8
X_3016_ _3016_/I wire514/I VDD VDD VSS VSS gf180mcu_fd_sc_mcu7t5v0__inv_2
XTAP_TAPCELL_ROW_54_717 VDD VSS gf180mcu_fd_sc_mcu7t5v0__filltie
XFILLER_51_276 VDD VDD VSS VSS gf180mcu_fd_sc_mcu7t5v0__fillcap_4
XTAP_TAPCELL_ROW_62_794 VDD VSS gf180mcu_fd_sc_mcu7t5v0__filltie
XFILLER_78_107 VDD VDD VSS VSS gf180mcu_fd_sc_mcu7t5v0__fillcap_64
XFILLER_59_354 VDD VDD VSS VSS gf180mcu_fd_sc_mcu7t5v0__fill_1
XFILLER_59_343 VDD VDD VSS VSS gf180mcu_fd_sc_mcu7t5v0__fill_2
XFILLER_47_66 VDD VDD VSS VSS gf180mcu_fd_sc_mcu7t5v0__fillcap_4
XTAP_TAPCELL_ROW_25_441 VDD VSS gf180mcu_fd_sc_mcu7t5v0__filltie
XFILLER_70_563 VDD VDD VSS VSS gf180mcu_fd_sc_mcu7t5v0__fillcap_8
XFILLER_15_479 VDD VDD VSS VSS gf180mcu_fd_sc_mcu7t5v0__fillcap_8
XFILLER_7_612 VDD VDD VSS VSS gf180mcu_fd_sc_mcu7t5v0__fill_1
Xwire554 wire554/I wire554/Z VDD VDD VSS VSS gf180mcu_fd_sc_mcu7t5v0__buf_1
Xwire543 wire544/Z wire543/Z VDD VDD VSS VSS gf180mcu_fd_sc_mcu7t5v0__clkbuf_2
XFILLER_6_177 VDD VDD VSS VSS gf180mcu_fd_sc_mcu7t5v0__fillcap_32
Xload_slew504 _3684_/Q _3071_/I VDD VDD VSS VSS gf180mcu_fd_sc_mcu7t5v0__buf_4
Xload_slew537 _2390_/B _2384_/B VDD VDD VSS VSS gf180mcu_fd_sc_mcu7t5v0__buf_2
X_2180_ _2649_/C _2181_/A2 _2187_/A1 VDD VDD VSS VSS gf180mcu_fd_sc_mcu7t5v0__nor2_1
XFILLER_38_549 VDD VDD VSS VSS gf180mcu_fd_sc_mcu7t5v0__fill_2
XFILLER_21_416 VDD VDD VSS VSS gf180mcu_fd_sc_mcu7t5v0__fillcap_4
X_1964_ _3058_/I _1952_/Z _1964_/B _1965_/I VDD VDD VSS VSS gf180mcu_fd_sc_mcu7t5v0__aoi21_1
XFILLER_21_438 VDD VDD VSS VSS gf180mcu_fd_sc_mcu7t5v0__fillcap_4
X_3703_ _3703_/D _3703_/RN clkload5/I _3703_/Q VDD VDD VSS VSS gf180mcu_fd_sc_mcu7t5v0__dffrnq_2
X_1895_ _1895_/A1 _1895_/A2 _1895_/Z VDD VDD VSS VSS gf180mcu_fd_sc_mcu7t5v0__or2_1
XTAP_TAPCELL_ROW_31_499 VDD VSS gf180mcu_fd_sc_mcu7t5v0__filltie
X_3634_ _3648_/A1 _3648_/A2 _3650_/A1 VDD VDD VSS VSS gf180mcu_fd_sc_mcu7t5v0__nor2_1
X_3565_ _3704_/Q _3683_/Q _3565_/Z VDD VDD VSS VSS gf180mcu_fd_sc_mcu7t5v0__xor2_2
X_2516_ _3113_/A2 _3021_/I _2516_/Z VDD VDD VSS VSS gf180mcu_fd_sc_mcu7t5v0__xor2_2
X_3496_ _3513_/A2 _3513_/A3 _3510_/A2 VDD VDD VSS VSS gf180mcu_fd_sc_mcu7t5v0__nor2_1
X_2447_ wire422/I _2448_/A2 _2447_/B _3759_/D VDD VDD VSS VSS gf180mcu_fd_sc_mcu7t5v0__aoi21_1
X_2378_ _3735_/Q _2388_/A1 _2380_/A3 _2378_/B _3735_/D VDD VDD VSS VSS gf180mcu_fd_sc_mcu7t5v0__oai31_1
XFILLER_56_302 VDD VDD VSS VSS gf180mcu_fd_sc_mcu7t5v0__fillcap_8
XFILLER_29_538 VDD VDD VSS VSS gf180mcu_fd_sc_mcu7t5v0__fillcap_4
XTAP_TAPCELL_ROW_67_842 VDD VSS gf180mcu_fd_sc_mcu7t5v0__filltie
XTAP_TAPCELL_ROW_39_577 VDD VSS gf180mcu_fd_sc_mcu7t5v0__filltie
XFILLER_4_637 VDD VDD VSS VSS gf180mcu_fd_sc_mcu7t5v0__fillcap_16
XFILLER_79_416 VDD VDD VSS VSS gf180mcu_fd_sc_mcu7t5v0__fillcap_4
XFILLER_3_136 VDD VDD VSS VSS gf180mcu_fd_sc_mcu7t5v0__fillcap_4
XFILLER_62_305 VDD VDD VSS VSS gf180mcu_fd_sc_mcu7t5v0__fill_2
XFILLER_43_541 VDD VDD VSS VSS gf180mcu_fd_sc_mcu7t5v0__fill_2
XFILLER_15_287 VDD VDD VSS VSS gf180mcu_fd_sc_mcu7t5v0__fillcap_8
XFILLER_70_371 VDD VDD VSS VSS gf180mcu_fd_sc_mcu7t5v0__fillcap_8
XFILLER_70_393 VDD VDD VSS VSS gf180mcu_fd_sc_mcu7t5v0__fill_1
XFILLER_30_257 VDD VDD VSS VSS gf180mcu_fd_sc_mcu7t5v0__fill_1
Xwire351 wire351/I _3237_/B VDD VDD VSS VSS gf180mcu_fd_sc_mcu7t5v0__buf_2
Xwire362 wire362/I wire362/Z VDD VDD VSS VSS gf180mcu_fd_sc_mcu7t5v0__clkbuf_2
X_3350_ _3669_/Q _3350_/A2 _3362_/A1 VDD VDD VSS VSS gf180mcu_fd_sc_mcu7t5v0__nor2_1
X_2301_ _2743_/B _2301_/A2 _2301_/A3 _2301_/B _3731_/D VDD VDD VSS VSS gf180mcu_fd_sc_mcu7t5v0__oai31_1
X_3281_ _3281_/A1 wire306/Z _3281_/B _3292_/A1 VDD VDD VSS VSS gf180mcu_fd_sc_mcu7t5v0__oai21_1
Xload_slew323 _2808_/A1 _2828_/A1 VDD VDD VSS VSS gf180mcu_fd_sc_mcu7t5v0__clkbuf_2
Xload_slew378 _2806_/B _2796_/B VDD VDD VSS VSS gf180mcu_fd_sc_mcu7t5v0__buf_1
XFILLER_38_313 VDD VDD VSS VSS gf180mcu_fd_sc_mcu7t5v0__fill_2
X_2232_ _3086_/ZN _3666_/Q _2238_/A3 VDD VDD VSS VSS gf180mcu_fd_sc_mcu7t5v0__nand2_1
XFILLER_17_2 VDD VDD VSS VSS gf180mcu_fd_sc_mcu7t5v0__fillcap_64
X_2163_ _3103_/B2 _2156_/Z _2164_/C VDD VDD VSS VSS gf180mcu_fd_sc_mcu7t5v0__nor2_1
XTAP_TAPCELL_ROW_88_1044 VDD VSS gf180mcu_fd_sc_mcu7t5v0__filltie
X_2094_ _3629_/B2 _2092_/Z _2094_/Z VDD VDD VSS VSS gf180mcu_fd_sc_mcu7t5v0__xor2_1
XTAP_TAPCELL_ROW_64_812 VDD VSS gf180mcu_fd_sc_mcu7t5v0__filltie
XFILLER_34_541 VDD VDD VSS VSS gf180mcu_fd_sc_mcu7t5v0__fill_1
XFILLER_34_552 VDD VDD VSS VSS gf180mcu_fd_sc_mcu7t5v0__fill_1
XTAP_TAPCELL_ROW_36_547 VDD VSS gf180mcu_fd_sc_mcu7t5v0__filltie
XFILLER_21_257 VDD VDD VSS VSS gf180mcu_fd_sc_mcu7t5v0__fillcap_4
X_2996_ _2996_/I _2211_/C VDD VDD VSS VSS gf180mcu_fd_sc_mcu7t5v0__inv_2
X_1947_ _1967_/B _1968_/A3 _1949_/B VDD VDD VSS VSS gf180mcu_fd_sc_mcu7t5v0__nand2_1
X_1878_ _3717_/Q _3431_/A1 _1897_/B VDD VDD VSS VSS gf180mcu_fd_sc_mcu7t5v0__nor2_1
X_3617_ wire527/Z _3685_/Q _3617_/A3 _3617_/Z VDD VDD VSS VSS gf180mcu_fd_sc_mcu7t5v0__xor3_1
X_3548_ _3563_/A1 _3576_/A1 _3548_/Z VDD VDD VSS VSS gf180mcu_fd_sc_mcu7t5v0__xor2_2
X_3479_ _3479_/I _3510_/A1 VDD VDD VSS VSS gf180mcu_fd_sc_mcu7t5v0__clkinv_1
XFILLER_29_368 VDD VDD VSS VSS gf180mcu_fd_sc_mcu7t5v0__fillcap_4
XFILLER_72_603 VDD VDD VSS VSS gf180mcu_fd_sc_mcu7t5v0__fill_1
XFILLER_84_485 VDD VDD VSS VSS gf180mcu_fd_sc_mcu7t5v0__fillcap_4
XFILLER_56_187 VDD VDD VSS VSS gf180mcu_fd_sc_mcu7t5v0__fill_1
XFILLER_44_34 VDD VDD VSS VSS gf180mcu_fd_sc_mcu7t5v0__fill_1
XFILLER_40_511 VDD VDD VSS VSS gf180mcu_fd_sc_mcu7t5v0__fillcap_8
XTAP_TAPCELL_ROW_7_272 VDD VSS gf180mcu_fd_sc_mcu7t5v0__filltie
XTAP_TAPCELL_ROW_78_948 VDD VSS gf180mcu_fd_sc_mcu7t5v0__filltie
XFILLER_47_165 VDD VDD VSS VSS gf180mcu_fd_sc_mcu7t5v0__fillcap_32
XFILLER_35_349 VDD VDD VSS VSS gf180mcu_fd_sc_mcu7t5v0__fill_1
XFILLER_90_488 VDD VDD VSS VSS gf180mcu_fd_sc_mcu7t5v0__fillcap_32
XFILLER_90_477 VDD VDD VSS VSS gf180mcu_fd_sc_mcu7t5v0__fill_2
XFILLER_31_511 VDD VDD VSS VSS gf180mcu_fd_sc_mcu7t5v0__fill_1
XTAP_TAPCELL_ROW_33_517 VDD VSS gf180mcu_fd_sc_mcu7t5v0__filltie
X_2850_ _3426_/A1 _2850_/A2 _2850_/B1 _2850_/B2 _3673_/D VDD VDD VSS VSS gf180mcu_fd_sc_mcu7t5v0__oai22_1
X_1801_ _3689_/Q _3079_/ZN _1801_/B _1810_/A2 VDD VDD VSS VSS gf180mcu_fd_sc_mcu7t5v0__aoi21_1
X_2781_ _3735_/Q _2792_/A2 _2782_/B VDD VDD VSS VSS gf180mcu_fd_sc_mcu7t5v0__nand2_1
XFILLER_11_290 VDD VDD VSS VSS gf180mcu_fd_sc_mcu7t5v0__fillcap_16
XFILLER_7_250 VDD VDD VSS VSS gf180mcu_fd_sc_mcu7t5v0__fillcap_4
XTAP_TAPCELL_ROW_41_594 VDD VSS gf180mcu_fd_sc_mcu7t5v0__filltie
X_3402_ _3400_/Z _3404_/A3 _3402_/Z VDD VDD VSS VSS gf180mcu_fd_sc_mcu7t5v0__xor2_1
X_3333_ _3340_/A1 _3333_/A2 _3333_/Z VDD VDD VSS VSS gf180mcu_fd_sc_mcu7t5v0__xor2_1
XPHY_EDGE_ROW_7_Right_7 VDD VSS gf180mcu_fd_sc_mcu7t5v0__endcap
X_3264_ _3237_/B _3282_/A1 _3267_/A1 VDD VDD VSS VSS gf180mcu_fd_sc_mcu7t5v0__nor2_1
XFILLER_58_419 VDD VDD VSS VSS gf180mcu_fd_sc_mcu7t5v0__fill_2
X_2215_ _2366_/S _3660_/Q _2237_/A1 VDD VDD VSS VSS gf180mcu_fd_sc_mcu7t5v0__nand2_1
X_3195_ _3195_/A1 _3196_/A2 _3205_/C VDD VDD VSS VSS gf180mcu_fd_sc_mcu7t5v0__or2_1
XFILLER_93_282 VDD VDD VSS VSS gf180mcu_fd_sc_mcu7t5v0__fillcap_64
XFILLER_81_422 VDD VDD VSS VSS gf180mcu_fd_sc_mcu7t5v0__fillcap_8
XFILLER_26_327 VDD VDD VSS VSS gf180mcu_fd_sc_mcu7t5v0__fill_1
XTAP_TAPCELL_ROW_49_672 VDD VSS gf180mcu_fd_sc_mcu7t5v0__filltie
X_2146_ _3520_/A1 _2192_/A2 _2196_/B VDD VDD VSS VSS gf180mcu_fd_sc_mcu7t5v0__nor2_1
X_2077_ _3728_/Q _3707_/Q _2077_/Z VDD VDD VSS VSS gf180mcu_fd_sc_mcu7t5v0__xor2_1
XFILLER_14_37 VDD VDD VSS VSS gf180mcu_fd_sc_mcu7t5v0__fillcap_64
XFILLER_22_577 VDD VDD VSS VSS gf180mcu_fd_sc_mcu7t5v0__fillcap_8
X_2979_ _2979_/I _2979_/ZN VDD VDD VSS VSS gf180mcu_fd_sc_mcu7t5v0__clkinv_1
XFILLER_49_419 VDD VDD VSS VSS gf180mcu_fd_sc_mcu7t5v0__fill_1
XTAP_TAPCELL_ROW_4_242 VDD VSS gf180mcu_fd_sc_mcu7t5v0__filltie
XTAP_TAPCELL_ROW_75_918 VDD VSS gf180mcu_fd_sc_mcu7t5v0__filltie
XFILLER_72_411 VDD VDD VSS VSS gf180mcu_fd_sc_mcu7t5v0__fillcap_16
XFILLER_55_66 VDD VDD VSS VSS gf180mcu_fd_sc_mcu7t5v0__fillcap_4
XTAP_TAPCELL_ROW_83_995 VDD VSS gf180mcu_fd_sc_mcu7t5v0__filltie
XFILLER_25_382 VDD VDD VSS VSS gf180mcu_fd_sc_mcu7t5v0__fillcap_8
XFILLER_40_330 VDD VDD VSS VSS gf180mcu_fd_sc_mcu7t5v0__fillcap_8
XTAP_TAPCELL_ROW_10_299 VDD VSS gf180mcu_fd_sc_mcu7t5v0__filltie
X_2000_ _1997_/Z _1998_/Z _1999_/Z _2000_/B2 _2073_/A1 VDD VDD VSS VSS gf180mcu_fd_sc_mcu7t5v0__aoi22_2
XTAP_TAPCELL_ROW_85_1014 VDD VSS gf180mcu_fd_sc_mcu7t5v0__filltie
XFILLER_75_282 VDD VDD VSS VSS gf180mcu_fd_sc_mcu7t5v0__fillcap_16
XFILLER_48_474 VDD VDD VSS VSS gf180mcu_fd_sc_mcu7t5v0__fill_1
XFILLER_90_241 VDD VDD VSS VSS gf180mcu_fd_sc_mcu7t5v0__fillcap_4
XTAP_TAPCELL_ROW_46_642 VDD VSS gf180mcu_fd_sc_mcu7t5v0__filltie
XFILLER_63_488 VDD VDD VSS VSS gf180mcu_fd_sc_mcu7t5v0__fill_2
XFILLER_63_477 VDD VDD VSS VSS gf180mcu_fd_sc_mcu7t5v0__fillcap_4
XTAP_TAPCELL_ROW_18_377 VDD VSS gf180mcu_fd_sc_mcu7t5v0__filltie
X_2902_ _3743_/Q wire544/Z _2949_/A2 VDD VDD VSS VSS gf180mcu_fd_sc_mcu7t5v0__nand2_1
XFILLER_31_352 VDD VDD VSS VSS gf180mcu_fd_sc_mcu7t5v0__fillcap_4
XFILLER_84_2 VDD VDD VSS VSS gf180mcu_fd_sc_mcu7t5v0__fillcap_32
X_2833_ _3741_/Q _2842_/A2 _2835_/B1 VDD VDD VSS VSS gf180mcu_fd_sc_mcu7t5v0__nor2_1
X_2764_ wire275/I _2767_/A2 _2765_/B2 VDD VDD VSS VSS gf180mcu_fd_sc_mcu7t5v0__nand2_1
XTAP_TAPCELL_ROW_96_1132 VDD VSS gf180mcu_fd_sc_mcu7t5v0__filltie
XTAP_TAPCELL_ROW_96_1121 VDD VSS gf180mcu_fd_sc_mcu7t5v0__filltie
X_2695_ _2644_/B _2696_/A2 _2719_/B1 VDD VDD VSS VSS gf180mcu_fd_sc_mcu7t5v0__nor2_1
X_3316_ _3317_/A1 _3317_/A2 _3769_/D VDD VDD VSS VSS gf180mcu_fd_sc_mcu7t5v0__xor2_1
Xfanout538 wire550/Z wire541/I VDD VDD VSS VSS gf180mcu_fd_sc_mcu7t5v0__dlyb_1
XFILLER_58_238 VDD VDD VSS VSS gf180mcu_fd_sc_mcu7t5v0__fill_1
X_3247_ _3237_/B _3225_/Z _3322_/A2 VDD VDD VSS VSS gf180mcu_fd_sc_mcu7t5v0__nand2_1
X_3178_ _3178_/A1 _3179_/A2 _3187_/C VDD VDD VSS VSS gf180mcu_fd_sc_mcu7t5v0__nand2_1
XFILLER_94_591 VDD VDD VSS VSS gf180mcu_fd_sc_mcu7t5v0__fillcap_4
X_2129_ _2129_/I _2214_/A2 VDD VDD VSS VSS gf180mcu_fd_sc_mcu7t5v0__clkinv_1
XFILLER_54_444 VDD VDD VSS VSS gf180mcu_fd_sc_mcu7t5v0__fill_2
XFILLER_54_477 VDD VDD VSS VSS gf180mcu_fd_sc_mcu7t5v0__fill_2
XFILLER_41_127 VDD VDD VSS VSS gf180mcu_fd_sc_mcu7t5v0__fillcap_4
XTAP_TAPCELL_ROW_80_965 VDD VSS gf180mcu_fd_sc_mcu7t5v0__filltie
XFILLER_22_330 VDD VDD VSS VSS gf180mcu_fd_sc_mcu7t5v0__fill_2
XFILLER_6_518 VDD VDD VSS VSS gf180mcu_fd_sc_mcu7t5v0__fillcap_4
XFILLER_1_212 VDD VDD VSS VSS gf180mcu_fd_sc_mcu7t5v0__fillcap_16
XFILLER_89_352 VDD VDD VSS VSS gf180mcu_fd_sc_mcu7t5v0__fillcap_16
XFILLER_77_536 VDD VDD VSS VSS gf180mcu_fd_sc_mcu7t5v0__fillcap_4
XFILLER_77_558 VDD VDD VSS VSS gf180mcu_fd_sc_mcu7t5v0__fill_2
XFILLER_18_614 VDD VDD VSS VSS gf180mcu_fd_sc_mcu7t5v0__fill_2
XFILLER_45_411 VDD VDD VSS VSS gf180mcu_fd_sc_mcu7t5v0__fill_2
XFILLER_85_591 VDD VDD VSS VSS gf180mcu_fd_sc_mcu7t5v0__fillcap_32
XFILLER_57_282 VDD VDD VSS VSS gf180mcu_fd_sc_mcu7t5v0__fillcap_8
XFILLER_60_403 VDD VDD VSS VSS gf180mcu_fd_sc_mcu7t5v0__fill_1
XFILLER_72_241 VDD VDD VSS VSS gf180mcu_fd_sc_mcu7t5v0__fillcap_4
XFILLER_72_263 VDD VDD VSS VSS gf180mcu_fd_sc_mcu7t5v0__fillcap_4
XTAP_TAPCELL_ROW_43_612 VDD VSS gf180mcu_fd_sc_mcu7t5v0__filltie
XTAP_TAPCELL_ROW_15_347 VDD VSS gf180mcu_fd_sc_mcu7t5v0__filltie
XFILLER_13_352 VDD VDD VSS VSS gf180mcu_fd_sc_mcu7t5v0__fill_2
XFILLER_32_149 VDD VDD VSS VSS gf180mcu_fd_sc_mcu7t5v0__fillcap_4
XFILLER_9_345 VDD VDD VSS VSS gf180mcu_fd_sc_mcu7t5v0__fillcap_4
XFILLER_9_356 VDD VDD VSS VSS gf180mcu_fd_sc_mcu7t5v0__fill_2
XFILLER_9_378 VDD VDD VSS VSS gf180mcu_fd_sc_mcu7t5v0__fill_1
Xoutput119 _2100_/Z cal_phase270_offset[18] VDD VDD VSS VSS gf180mcu_fd_sc_mcu7t5v0__buf_2
X_2480_ wire468/I _3025_/ZN _2502_/A1 VDD VDD VSS VSS gf180mcu_fd_sc_mcu7t5v0__nor2_1
XFILLER_5_562 VDD VDD VSS VSS gf180mcu_fd_sc_mcu7t5v0__fillcap_8
Xoutput108 _3172_/ZN cal_phase0_offset[8] VDD VDD VSS VSS gf180mcu_fd_sc_mcu7t5v0__buf_2
XTAP_TAPCELL_ROW_91_1073 VDD VSS gf180mcu_fd_sc_mcu7t5v0__filltie
XFILLER_68_503 VDD VDD VSS VSS gf180mcu_fd_sc_mcu7t5v0__fill_2
X_3101_ input32/Z _3103_/B2 input30/Z _3101_/B2 _3102_/A2 VDD VDD VSS VSS gf180mcu_fd_sc_mcu7t5v0__aoi22_1
Xoutput90 _3181_/Z cal_phase0_offset[10] VDD VDD VSS VSS gf180mcu_fd_sc_mcu7t5v0__buf_2
X_3032_ _3723_/Q _3193_/A2 VDD VDD VSS VSS gf180mcu_fd_sc_mcu7t5v0__clkinv_1
XFILLER_24_639 VDD VDD VSS VSS gf180mcu_fd_sc_mcu7t5v0__fill_1
X_2816_ _2826_/A1 _2816_/A2 _3763_/Q _2817_/A3 VDD VDD VSS VSS gf180mcu_fd_sc_mcu7t5v0__oai21_1
X_2747_ _3089_/ZN _2775_/A2 _2754_/C VDD VDD VSS VSS gf180mcu_fd_sc_mcu7t5v0__nor2_1
X_2678_ _2733_/A1 _2733_/A2 _2681_/A1 VDD VDD VSS VSS gf180mcu_fd_sc_mcu7t5v0__nand2_1
XFILLER_86_311 VDD VDD VSS VSS gf180mcu_fd_sc_mcu7t5v0__fillcap_4
XFILLER_86_333 VDD VDD VSS VSS gf180mcu_fd_sc_mcu7t5v0__fillcap_8
XFILLER_74_539 VDD VDD VSS VSS gf180mcu_fd_sc_mcu7t5v0__fill_2
XFILLER_39_260 VDD VDD VSS VSS gf180mcu_fd_sc_mcu7t5v0__fillcap_8
XFILLER_46_219 VDD VDD VSS VSS gf180mcu_fd_sc_mcu7t5v0__fill_1
XFILLER_27_422 VDD VDD VSS VSS gf180mcu_fd_sc_mcu7t5v0__fill_2
XFILLER_39_282 VDD VDD VSS VSS gf180mcu_fd_sc_mcu7t5v0__fill_2
XTAP_TAPCELL_ROW_57_748 VDD VSS gf180mcu_fd_sc_mcu7t5v0__filltie
XFILLER_54_241 VDD VDD VSS VSS gf180mcu_fd_sc_mcu7t5v0__fillcap_4
XTAP_TAPCELL_ROW_12_317 VDD VSS gf180mcu_fd_sc_mcu7t5v0__filltie
XFILLER_52_34 VDD VDD VSS VSS gf180mcu_fd_sc_mcu7t5v0__fill_1
XFILLER_22_171 VDD VDD VSS VSS gf180mcu_fd_sc_mcu7t5v0__fillcap_4
XFILLER_10_355 VDD VDD VSS VSS gf180mcu_fd_sc_mcu7t5v0__fill_1
XFILLER_6_304 VDD VDD VSS VSS gf180mcu_fd_sc_mcu7t5v0__fillcap_8
XTAP_TAPCELL_ROW_20_394 VDD VSS gf180mcu_fd_sc_mcu7t5v0__filltie
XFILLER_18_400 VDD VDD VSS VSS gf180mcu_fd_sc_mcu7t5v0__fill_1
XFILLER_37_208 VDD VDD VSS VSS gf180mcu_fd_sc_mcu7t5v0__fill_2
XTAP_TAPCELL_ROW_28_472 VDD VSS gf180mcu_fd_sc_mcu7t5v0__filltie
X_1980_ _3526_/A1 _3516_/A1 _1977_/Z _1980_/Z VDD VDD VSS VSS gf180mcu_fd_sc_mcu7t5v0__xor3_2
XFILLER_9_142 VDD VDD VSS VSS gf180mcu_fd_sc_mcu7t5v0__fillcap_64
X_3650_ _3650_/A1 _3650_/A2 _3650_/ZN VDD VDD VSS VSS gf180mcu_fd_sc_mcu7t5v0__nor2_1
X_3581_ _3581_/A1 _3071_/I _3612_/B1 VDD VDD VSS VSS gf180mcu_fd_sc_mcu7t5v0__nand2_1
X_2601_ _2601_/A1 _2595_/Z _2599_/Z _2600_/Z _2602_/C VDD VDD VSS VSS gf180mcu_fd_sc_mcu7t5v0__or4_1
X_2532_ wire428/Z _3017_/ZN _2545_/A1 VDD VDD VSS VSS gf180mcu_fd_sc_mcu7t5v0__nor2_1
XFILLER_47_2 VDD VDD VSS VSS gf180mcu_fd_sc_mcu7t5v0__fillcap_64
X_2463_ _2993_/ZN _2459_/Z _2463_/B _3653_/D VDD VDD VSS VSS gf180mcu_fd_sc_mcu7t5v0__aoi21_1
X_2394_ _2394_/I _3740_/D VDD VDD VSS VSS gf180mcu_fd_sc_mcu7t5v0__clkinv_1
XFILLER_96_664 VDD VDD VSS VSS gf180mcu_fd_sc_mcu7t5v0__fillcap_8
XFILLER_3_72 VDD VDD VSS VSS gf180mcu_fd_sc_mcu7t5v0__fillcap_64
X_3015_ _3015_/I _3146_/A1 VDD VDD VSS VSS gf180mcu_fd_sc_mcu7t5v0__clkinv_1
XTAP_TAPCELL_ROW_54_718 VDD VSS gf180mcu_fd_sc_mcu7t5v0__filltie
XFILLER_64_594 VDD VDD VSS VSS gf180mcu_fd_sc_mcu7t5v0__fill_1
XFILLER_24_469 VDD VDD VSS VSS gf180mcu_fd_sc_mcu7t5v0__fill_1
XFILLER_51_288 VDD VDD VSS VSS gf180mcu_fd_sc_mcu7t5v0__fill_1
XTAP_TAPCELL_ROW_62_795 VDD VSS gf180mcu_fd_sc_mcu7t5v0__filltie
XFILLER_22_37 VDD VDD VSS VSS gf180mcu_fd_sc_mcu7t5v0__fillcap_64
X_3779_ _3779_/D _3779_/RN clkload0/I _3779_/Q VDD VDD VSS VSS gf180mcu_fd_sc_mcu7t5v0__dffrnq_1
XFILLER_47_539 VDD VDD VSS VSS gf180mcu_fd_sc_mcu7t5v0__fill_2
XTAP_TAPCELL_ROW_25_442 VDD VSS gf180mcu_fd_sc_mcu7t5v0__filltie
XFILLER_63_66 VDD VDD VSS VSS gf180mcu_fd_sc_mcu7t5v0__fillcap_4
XFILLER_30_439 VDD VDD VSS VSS gf180mcu_fd_sc_mcu7t5v0__fillcap_16
XFILLER_6_101 VDD VDD VSS VSS gf180mcu_fd_sc_mcu7t5v0__fillcap_4
Xwire533 wire533/I _2446_/B VDD VDD VSS VSS gf180mcu_fd_sc_mcu7t5v0__clkbuf_2
Xwire544 wire544/I wire544/Z VDD VDD VSS VSS gf180mcu_fd_sc_mcu7t5v0__clkbuf_2
Xwire588 wire589/I wire588/Z VDD VDD VSS VSS gf180mcu_fd_sc_mcu7t5v0__clkbuf_2
Xload_slew505 _3683_/Q _2140_/A1 VDD VDD VSS VSS gf180mcu_fd_sc_mcu7t5v0__buf_2
XFILLER_53_509 VDD VDD VSS VSS gf180mcu_fd_sc_mcu7t5v0__fillcap_4
XFILLER_92_177 VDD VDD VSS VSS gf180mcu_fd_sc_mcu7t5v0__fillcap_64
XFILLER_46_594 VDD VDD VSS VSS gf180mcu_fd_sc_mcu7t5v0__fill_1
XFILLER_73_380 VDD VDD VSS VSS gf180mcu_fd_sc_mcu7t5v0__fillcap_4
XFILLER_33_233 VDD VDD VSS VSS gf180mcu_fd_sc_mcu7t5v0__fillcap_8
XFILLER_61_575 VDD VDD VSS VSS gf180mcu_fd_sc_mcu7t5v0__fillcap_16
X_1963_ _1998_/A1 _1983_/A2 _1963_/ZN VDD VDD VSS VSS gf180mcu_fd_sc_mcu7t5v0__xnor2_2
X_1894_ _1895_/A1 _1895_/A2 _1971_/A2 VDD VDD VSS VSS gf180mcu_fd_sc_mcu7t5v0__nor2_1
X_3702_ _3702_/D _3703_/RN clkload5/I _3702_/Q VDD VDD VSS VSS gf180mcu_fd_sc_mcu7t5v0__dffrnq_2
X_3633_ _3633_/I _3648_/A2 VDD VDD VSS VSS gf180mcu_fd_sc_mcu7t5v0__clkinv_1
X_3564_ _3564_/A1 _3564_/A2 _3564_/ZN VDD VDD VSS VSS gf180mcu_fd_sc_mcu7t5v0__xnor2_2
X_2515_ _2521_/A1 _2521_/A2 _2515_/Z VDD VDD VSS VSS gf180mcu_fd_sc_mcu7t5v0__and2_1
X_3495_ _3495_/A1 _3473_/Z _3494_/B _3513_/A3 VDD VDD VSS VSS gf180mcu_fd_sc_mcu7t5v0__nor3_2
X_2446_ wire422/I _2448_/A2 _2446_/B _2447_/B VDD VDD VSS VSS gf180mcu_fd_sc_mcu7t5v0__oai21_1
XPHY_EDGE_ROW_3_Left_100 VDD VSS gf180mcu_fd_sc_mcu7t5v0__endcap
XFILLER_29_506 VDD VDD VSS VSS gf180mcu_fd_sc_mcu7t5v0__fillcap_32
X_2377_ _2384_/A1 _2380_/A3 _2384_/B _3735_/Q _2378_/B VDD VDD VSS VSS gf180mcu_fd_sc_mcu7t5v0__oai211_1
XFILLER_56_314 VDD VDD VSS VSS gf180mcu_fd_sc_mcu7t5v0__fill_1
XTAP_TAPCELL_ROW_67_843 VDD VSS gf180mcu_fd_sc_mcu7t5v0__filltie
XFILLER_84_667 VDD VDD VSS VSS gf180mcu_fd_sc_mcu7t5v0__fill_2
XTAP_TAPCELL_ROW_39_578 VDD VSS gf180mcu_fd_sc_mcu7t5v0__filltie
XFILLER_52_520 VDD VDD VSS VSS gf180mcu_fd_sc_mcu7t5v0__fillcap_4
XFILLER_71_339 VDD VDD VSS VSS gf180mcu_fd_sc_mcu7t5v0__fill_2
XFILLER_52_553 VDD VDD VSS VSS gf180mcu_fd_sc_mcu7t5v0__fillcap_16
XFILLER_64_391 VDD VDD VSS VSS gf180mcu_fd_sc_mcu7t5v0__fill_1
XTAP_TAPCELL_ROW_22_412 VDD VSS gf180mcu_fd_sc_mcu7t5v0__filltie
XFILLER_52_597 VDD VDD VSS VSS gf180mcu_fd_sc_mcu7t5v0__fillcap_16
XPHY_EDGE_ROW_49_Left_146 VDD VSS gf180mcu_fd_sc_mcu7t5v0__endcap
XPHY_EDGE_ROW_58_Left_155 VDD VSS gf180mcu_fd_sc_mcu7t5v0__endcap
XFILLER_87_494 VDD VDD VSS VSS gf180mcu_fd_sc_mcu7t5v0__fill_1
XFILLER_47_347 VDD VDD VSS VSS gf180mcu_fd_sc_mcu7t5v0__fill_2
XFILLER_28_550 VDD VDD VSS VSS gf180mcu_fd_sc_mcu7t5v0__fill_1
XFILLER_62_317 VDD VDD VSS VSS gf180mcu_fd_sc_mcu7t5v0__fillcap_4
XFILLER_74_177 VDD VDD VSS VSS gf180mcu_fd_sc_mcu7t5v0__fillcap_64
XFILLER_55_380 VDD VDD VSS VSS gf180mcu_fd_sc_mcu7t5v0__fillcap_4
XFILLER_15_299 VDD VDD VSS VSS gf180mcu_fd_sc_mcu7t5v0__fill_2
XFILLER_30_236 VDD VDD VSS VSS gf180mcu_fd_sc_mcu7t5v0__fill_1
XPHY_EDGE_ROW_67_Left_164 VDD VSS gf180mcu_fd_sc_mcu7t5v0__endcap
XFILLER_70_383 VDD VDD VSS VSS gf180mcu_fd_sc_mcu7t5v0__fill_2
XFILLER_11_450 VDD VDD VSS VSS gf180mcu_fd_sc_mcu7t5v0__fill_2
Xwire374 wire374/I wire374/Z VDD VDD VSS VSS gf180mcu_fd_sc_mcu7t5v0__clkbuf_2
Xwire396 _2165_/S _2161_/S VDD VDD VSS VSS gf180mcu_fd_sc_mcu7t5v0__buf_1
XPHY_EDGE_ROW_76_Left_173 VDD VSS gf180mcu_fd_sc_mcu7t5v0__endcap
X_3280_ _3280_/A1 _3280_/A2 _3280_/B _3297_/A1 VDD VDD VSS VSS gf180mcu_fd_sc_mcu7t5v0__oai21_1
X_2300_ _3731_/Q _2301_/A3 _2301_/B VDD VDD VSS VSS gf180mcu_fd_sc_mcu7t5v0__nand2_1
Xload_slew302 _3177_/A2 _3180_/A2 VDD VDD VSS VSS gf180mcu_fd_sc_mcu7t5v0__clkbuf_1
X_2231_ _3085_/ZN _3664_/Q _2227_/Z _2231_/Z VDD VDD VSS VSS gf180mcu_fd_sc_mcu7t5v0__and3_1
Xload_slew335 _2809_/A2 _2779_/A2 VDD VDD VSS VSS gf180mcu_fd_sc_mcu7t5v0__clkbuf_2
Xload_slew324 _2882_/B _2885_/B VDD VDD VSS VSS gf180mcu_fd_sc_mcu7t5v0__clkbuf_2
Xload_slew357 wire358/Z _2649_/C VDD VDD VSS VSS gf180mcu_fd_sc_mcu7t5v0__clkbuf_2
Xload_slew379 _2748_/A1 _2806_/B VDD VDD VSS VSS gf180mcu_fd_sc_mcu7t5v0__clkbuf_2
X_2162_ _2162_/I _2166_/A2 VDD VDD VSS VSS gf180mcu_fd_sc_mcu7t5v0__clkinv_1
X_2093_ _3707_/Q _2092_/Z _2093_/Z VDD VDD VSS VSS gf180mcu_fd_sc_mcu7t5v0__or2_1
XTAP_TAPCELL_ROW_88_1045 VDD VSS gf180mcu_fd_sc_mcu7t5v0__filltie
XFILLER_26_509 VDD VDD VSS VSS gf180mcu_fd_sc_mcu7t5v0__fillcap_4
XFILLER_66_667 VDD VDD VSS VSS gf180mcu_fd_sc_mcu7t5v0__fill_2
XFILLER_93_486 VDD VDD VSS VSS gf180mcu_fd_sc_mcu7t5v0__fillcap_4
XTAP_TAPCELL_ROW_64_813 VDD VSS gf180mcu_fd_sc_mcu7t5v0__filltie
XTAP_TAPCELL_ROW_36_548 VDD VSS gf180mcu_fd_sc_mcu7t5v0__filltie
XPHY_EDGE_ROW_85_Left_182 VDD VSS gf180mcu_fd_sc_mcu7t5v0__endcap
XFILLER_34_586 VDD VDD VSS VSS gf180mcu_fd_sc_mcu7t5v0__fillcap_8
XFILLER_61_372 VDD VDD VSS VSS gf180mcu_fd_sc_mcu7t5v0__fillcap_4
XFILLER_21_236 VDD VDD VSS VSS gf180mcu_fd_sc_mcu7t5v0__fillcap_4
XFILLER_34_597 VDD VDD VSS VSS gf180mcu_fd_sc_mcu7t5v0__fill_2
XTAP_TAPCELL_ROW_72_890 VDD VSS gf180mcu_fd_sc_mcu7t5v0__filltie
X_2995_ _2995_/I _3318_/B VDD VDD VSS VSS gf180mcu_fd_sc_mcu7t5v0__clkinv_1
X_1946_ _3187_/A2 _3700_/Q _1968_/A3 VDD VDD VSS VSS gf180mcu_fd_sc_mcu7t5v0__nand2_1
X_1877_ _1897_/A1 _1877_/A2 _1877_/B _1884_/A2 VDD VDD VSS VSS gf180mcu_fd_sc_mcu7t5v0__oai21_1
X_3616_ wire527/Z _3617_/A3 _3624_/A2 VDD VDD VSS VSS gf180mcu_fd_sc_mcu7t5v0__nand2_1
XPHY_EDGE_ROW_94_Left_191 VDD VSS gf180mcu_fd_sc_mcu7t5v0__endcap
X_3547_ wire280/Z _3607_/A2 _3576_/A1 VDD VDD VSS VSS gf180mcu_fd_sc_mcu7t5v0__nor2_1
XFILLER_88_247 VDD VDD VSS VSS gf180mcu_fd_sc_mcu7t5v0__fillcap_64
XFILLER_0_129 VDD VDD VSS VSS gf180mcu_fd_sc_mcu7t5v0__fillcap_4
X_3478_ _3475_/Z _3478_/A2 _3479_/I VDD VDD VSS VSS gf180mcu_fd_sc_mcu7t5v0__xnor2_1
XFILLER_76_409 VDD VDD VSS VSS gf180mcu_fd_sc_mcu7t5v0__fill_2
X_2429_ _2429_/A1 _2432_/A1 _2430_/A2 VDD VDD VSS VSS gf180mcu_fd_sc_mcu7t5v0__nand2_1
XFILLER_57_634 VDD VDD VSS VSS gf180mcu_fd_sc_mcu7t5v0__fill_1
XFILLER_56_177 VDD VDD VSS VSS gf180mcu_fd_sc_mcu7t5v0__fillcap_4
XFILLER_71_136 VDD VDD VSS VSS gf180mcu_fd_sc_mcu7t5v0__fillcap_4
XFILLER_40_523 VDD VDD VSS VSS gf180mcu_fd_sc_mcu7t5v0__fill_2
XFILLER_52_383 VDD VDD VSS VSS gf180mcu_fd_sc_mcu7t5v0__fill_2
XFILLER_40_578 VDD VDD VSS VSS gf180mcu_fd_sc_mcu7t5v0__fill_1
XFILLER_60_34 VDD VDD VSS VSS gf180mcu_fd_sc_mcu7t5v0__fill_1
XFILLER_4_457 VDD VDD VSS VSS gf180mcu_fd_sc_mcu7t5v0__fillcap_64
XTAP_TAPCELL_ROW_7_273 VDD VSS gf180mcu_fd_sc_mcu7t5v0__filltie
XTAP_TAPCELL_ROW_78_949 VDD VSS gf180mcu_fd_sc_mcu7t5v0__filltie
XFILLER_90_423 VDD VDD VSS VSS gf180mcu_fd_sc_mcu7t5v0__fill_2
XTAP_TAPCELL_ROW_33_518 VDD VSS gf180mcu_fd_sc_mcu7t5v0__filltie
XFILLER_16_597 VDD VDD VSS VSS gf180mcu_fd_sc_mcu7t5v0__fillcap_4
XFILLER_43_372 VDD VDD VSS VSS gf180mcu_fd_sc_mcu7t5v0__fill_2
XFILLER_31_556 VDD VDD VSS VSS gf180mcu_fd_sc_mcu7t5v0__fillcap_4
X_1800_ _3041_/I _3781_/I _1801_/B VDD VDD VSS VSS gf180mcu_fd_sc_mcu7t5v0__xor2_1
X_2780_ _3092_/ZN _2795_/A2 _2785_/C VDD VDD VSS VSS gf180mcu_fd_sc_mcu7t5v0__nor2_1
XTAP_TAPCELL_ROW_41_595 VDD VSS gf180mcu_fd_sc_mcu7t5v0__filltie
XFILLER_7_295 VDD VDD VSS VSS gf180mcu_fd_sc_mcu7t5v0__fill_1
X_3401_ _3401_/A1 _3401_/A2 _3401_/B _3404_/A3 VDD VDD VSS VSS gf180mcu_fd_sc_mcu7t5v0__oai21_1
X_3332_ _3332_/A1 _3254_/B _3332_/B1 _3272_/B _3332_/C _3333_/A2 VDD VDD VSS VSS gf180mcu_fd_sc_mcu7t5v0__oai221_1
XFILLER_85_206 VDD VDD VSS VSS gf180mcu_fd_sc_mcu7t5v0__fillcap_4
X_3263_ _3263_/A1 _3263_/A2 _3270_/B _3263_/C _3268_/A1 VDD VDD VSS VSS gf180mcu_fd_sc_mcu7t5v0__aoi211_1
X_2214_ _2214_/A1 _2214_/A2 _2260_/A1 _2214_/B2 _2246_/A1 VDD VDD VSS VSS gf180mcu_fd_sc_mcu7t5v0__aoi22_2
X_3194_ wire629/Z _3194_/A2 _3194_/A3 _3194_/Z VDD VDD VSS VSS gf180mcu_fd_sc_mcu7t5v0__xor3_1
X_2145_ _3118_/A2 _2194_/A2 _2145_/B _2201_/A1 VDD VDD VSS VSS gf180mcu_fd_sc_mcu7t5v0__oai21_2
XTAP_TAPCELL_ROW_49_673 VDD VSS gf180mcu_fd_sc_mcu7t5v0__filltie
XFILLER_54_637 VDD VDD VSS VSS gf180mcu_fd_sc_mcu7t5v0__fill_1
X_2076_ _3728_/Q _3629_/B2 _2101_/C VDD VDD VSS VSS gf180mcu_fd_sc_mcu7t5v0__nand2_1
XFILLER_22_556 VDD VDD VSS VSS gf180mcu_fd_sc_mcu7t5v0__fill_2
X_2978_ _2978_/I _3099_/A1 VDD VDD VSS VSS gf180mcu_fd_sc_mcu7t5v0__clkinv_1
XFILLER_22_589 VDD VDD VSS VSS gf180mcu_fd_sc_mcu7t5v0__fill_1
X_1929_ _1971_/A1 _1971_/A2 _1971_/B _1929_/C _1934_/A1 VDD VDD VSS VSS gf180mcu_fd_sc_mcu7t5v0__aoi211_1
XFILLER_30_37 VDD VDD VSS VSS gf180mcu_fd_sc_mcu7t5v0__fillcap_64
XFILLER_89_512 VDD VDD VSS VSS gf180mcu_fd_sc_mcu7t5v0__fillcap_4
XFILLER_1_416 VDD VDD VSS VSS gf180mcu_fd_sc_mcu7t5v0__fillcap_4
XTAP_TAPCELL_ROW_75_919 VDD VSS gf180mcu_fd_sc_mcu7t5v0__filltie
XTAP_TAPCELL_ROW_4_243 VDD VSS gf180mcu_fd_sc_mcu7t5v0__filltie
XFILLER_17_306 VDD VDD VSS VSS gf180mcu_fd_sc_mcu7t5v0__fill_2
XFILLER_29_199 VDD VDD VSS VSS gf180mcu_fd_sc_mcu7t5v0__fillcap_4
XFILLER_44_169 VDD VDD VSS VSS gf180mcu_fd_sc_mcu7t5v0__fillcap_4
XTAP_TAPCELL_ROW_83_996 VDD VSS gf180mcu_fd_sc_mcu7t5v0__filltie
XFILLER_13_589 VDD VDD VSS VSS gf180mcu_fd_sc_mcu7t5v0__fillcap_4
XFILLER_9_538 VDD VDD VSS VSS gf180mcu_fd_sc_mcu7t5v0__fill_1
XFILLER_71_66 VDD VDD VSS VSS gf180mcu_fd_sc_mcu7t5v0__fillcap_4
XFILLER_4_221 VDD VDD VSS VSS gf180mcu_fd_sc_mcu7t5v0__fill_1
XFILLER_67_206 VDD VDD VSS VSS gf180mcu_fd_sc_mcu7t5v0__fillcap_4
XFILLER_96_85 VDD VDD VSS VSS gf180mcu_fd_sc_mcu7t5v0__fillcap_16
XFILLER_96_74 VDD VDD VSS VSS gf180mcu_fd_sc_mcu7t5v0__fill_1
XFILLER_48_453 VDD VDD VSS VSS gf180mcu_fd_sc_mcu7t5v0__fill_2
XTAP_TAPCELL_ROW_85_1015 VDD VSS gf180mcu_fd_sc_mcu7t5v0__filltie
XTAP_TAPCELL_ROW_46_643 VDD VSS gf180mcu_fd_sc_mcu7t5v0__filltie
XFILLER_35_158 VDD VDD VSS VSS gf180mcu_fd_sc_mcu7t5v0__fill_1
XTAP_TAPCELL_ROW_18_378 VDD VSS gf180mcu_fd_sc_mcu7t5v0__filltie
X_2901_ _3691_/Q _2903_/A1 _2903_/B VDD VDD VSS VSS gf180mcu_fd_sc_mcu7t5v0__nand2_1
XFILLER_50_139 VDD VDD VSS VSS gf180mcu_fd_sc_mcu7t5v0__fillcap_8
X_2832_ _2832_/A1 _2832_/A2 wire235/I VDD VDD VSS VSS gf180mcu_fd_sc_mcu7t5v0__nand2_1
XFILLER_77_2 VDD VDD VSS VSS gf180mcu_fd_sc_mcu7t5v0__fillcap_64
X_2763_ _2773_/A1 _2766_/A2 _2763_/B _2767_/A2 VDD VDD VSS VSS gf180mcu_fd_sc_mcu7t5v0__aoi21_1
XTAP_TAPCELL_ROW_96_1133 VDD VSS gf180mcu_fd_sc_mcu7t5v0__filltie
XTAP_TAPCELL_ROW_96_1122 VDD VSS gf180mcu_fd_sc_mcu7t5v0__filltie
X_2694_ _2694_/A1 _2694_/A2 _2694_/B _2696_/A2 VDD VDD VSS VSS gf180mcu_fd_sc_mcu7t5v0__aoi21_1
X_3315_ _3317_/B _3315_/A2 _3317_/A2 VDD VDD VSS VSS gf180mcu_fd_sc_mcu7t5v0__nor2_1
X_3246_ _3223_/Z _3271_/B _3289_/B _3255_/B1 VDD VDD VSS VSS gf180mcu_fd_sc_mcu7t5v0__oai21_2
XTAP_TAPCELL_ROW_1_213 VDD VSS gf180mcu_fd_sc_mcu7t5v0__filltie
X_3177_ _3180_/A1 _3177_/A2 _3177_/Z VDD VDD VSS VSS gf180mcu_fd_sc_mcu7t5v0__xor2_1
XFILLER_54_423 VDD VDD VSS VSS gf180mcu_fd_sc_mcu7t5v0__fill_2
X_2128_ _3078_/ZN _3088_/ZN _2128_/B _2129_/I VDD VDD VSS VSS gf180mcu_fd_sc_mcu7t5v0__oai21_2
X_2059_ _3727_/Q _3612_/A1 _2059_/Z VDD VDD VSS VSS gf180mcu_fd_sc_mcu7t5v0__xor2_1
XFILLER_41_139 VDD VDD VSS VSS gf180mcu_fd_sc_mcu7t5v0__fill_1
XTAP_TAPCELL_ROW_80_966 VDD VSS gf180mcu_fd_sc_mcu7t5v0__filltie
XFILLER_17_136 VDD VDD VSS VSS gf180mcu_fd_sc_mcu7t5v0__fillcap_4
XTAP_TAPCELL_ROW_43_613 VDD VSS gf180mcu_fd_sc_mcu7t5v0__filltie
XTAP_TAPCELL_ROW_15_348 VDD VSS gf180mcu_fd_sc_mcu7t5v0__filltie
XFILLER_40_150 VDD VDD VSS VSS gf180mcu_fd_sc_mcu7t5v0__fillcap_8
XFILLER_9_368 VDD VDD VSS VSS gf180mcu_fd_sc_mcu7t5v0__fillcap_8
XFILLER_40_172 VDD VDD VSS VSS gf180mcu_fd_sc_mcu7t5v0__fill_2
XFILLER_40_194 VDD VDD VSS VSS gf180mcu_fd_sc_mcu7t5v0__fill_2
XTAP_TAPCELL_ROW_51_690 VDD VSS gf180mcu_fd_sc_mcu7t5v0__filltie
XFILLER_5_552 VDD VDD VSS VSS gf180mcu_fd_sc_mcu7t5v0__fillcap_8
Xoutput109 _3177_/Z cal_phase0_offset[9] VDD VDD VSS VSS gf180mcu_fd_sc_mcu7t5v0__buf_2
XTAP_TAPCELL_ROW_91_1074 VDD VSS gf180mcu_fd_sc_mcu7t5v0__filltie
X_3100_ input30/Z _3101_/B2 _3100_/B _3100_/C _3102_/A1 VDD VDD VSS VSS gf180mcu_fd_sc_mcu7t5v0__oai211_1
Xoutput91 _3184_/Z cal_phase0_offset[11] VDD VDD VSS VSS gf180mcu_fd_sc_mcu7t5v0__buf_2
X_3031_ _3721_/Q _3187_/A2 VDD VDD VSS VSS gf180mcu_fd_sc_mcu7t5v0__clkinv_1
XFILLER_91_562 VDD VDD VSS VSS gf180mcu_fd_sc_mcu7t5v0__fillcap_64
XPHY_EDGE_ROW_12_Left_109 VDD VSS gf180mcu_fd_sc_mcu7t5v0__endcap
XFILLER_31_183 VDD VDD VSS VSS gf180mcu_fd_sc_mcu7t5v0__fillcap_8
X_2815_ _3738_/Q wire312/Z _2825_/B1 _2815_/B2 _2815_/C _2819_/B1 VDD VDD VSS VSS
+ gf180mcu_fd_sc_mcu7t5v0__aoi221_1
X_2746_ _2746_/A1 _2746_/A2 _3659_/D VDD VDD VSS VSS gf180mcu_fd_sc_mcu7t5v0__nand2_1
X_2677_ _2677_/I _2733_/A2 VDD VDD VSS VSS gf180mcu_fd_sc_mcu7t5v0__clkinv_1
XPHY_EDGE_ROW_21_Left_118 VDD VSS gf180mcu_fd_sc_mcu7t5v0__endcap
XFILLER_86_345 VDD VDD VSS VSS gf180mcu_fd_sc_mcu7t5v0__fill_2
Xfanout369 wire375/Z _2762_/A2 VDD VDD VSS VSS gf180mcu_fd_sc_mcu7t5v0__dlyb_1
X_3229_ _3237_/B _3282_/A2 _3303_/A1 VDD VDD VSS VSS gf180mcu_fd_sc_mcu7t5v0__nand2_1
XFILLER_67_570 VDD VDD VSS VSS gf180mcu_fd_sc_mcu7t5v0__fillcap_16
XFILLER_39_272 VDD VDD VSS VSS gf180mcu_fd_sc_mcu7t5v0__fill_2
XTAP_TAPCELL_ROW_57_749 VDD VSS gf180mcu_fd_sc_mcu7t5v0__filltie
XFILLER_27_456 VDD VDD VSS VSS gf180mcu_fd_sc_mcu7t5v0__fill_2
XFILLER_27_478 VDD VDD VSS VSS gf180mcu_fd_sc_mcu7t5v0__fillcap_4
XFILLER_36_69 VDD VDD VSS VSS gf180mcu_fd_sc_mcu7t5v0__fillcap_16
XFILLER_82_573 VDD VDD VSS VSS gf180mcu_fd_sc_mcu7t5v0__fill_1
XFILLER_23_640 VDD VDD VSS VSS gf180mcu_fd_sc_mcu7t5v0__fill_1
XTAP_TAPCELL_ROW_12_318 VDD VSS gf180mcu_fd_sc_mcu7t5v0__filltie
XPHY_EDGE_ROW_30_Left_127 VDD VSS gf180mcu_fd_sc_mcu7t5v0__endcap
XFILLER_10_345 VDD VDD VSS VSS gf180mcu_fd_sc_mcu7t5v0__fillcap_8
XFILLER_6_327 VDD VDD VSS VSS gf180mcu_fd_sc_mcu7t5v0__fillcap_8
XTAP_TAPCELL_ROW_20_395 VDD VSS gf180mcu_fd_sc_mcu7t5v0__filltie
XFILLER_7_2 VDD VDD VSS VSS gf180mcu_fd_sc_mcu7t5v0__fillcap_64
XFILLER_2_588 VDD VDD VSS VSS gf180mcu_fd_sc_mcu7t5v0__fillcap_4
XFILLER_58_581 VDD VDD VSS VSS gf180mcu_fd_sc_mcu7t5v0__fillcap_4
XFILLER_73_562 VDD VDD VSS VSS gf180mcu_fd_sc_mcu7t5v0__fill_1
XTAP_TAPCELL_ROW_28_473 VDD VSS gf180mcu_fd_sc_mcu7t5v0__filltie
X_3580_ _3581_/A1 _3071_/I _3612_/C VDD VDD VSS VSS gf180mcu_fd_sc_mcu7t5v0__nor2_1
X_2600_ _2533_/Z _2600_/A2 _2600_/Z VDD VDD VSS VSS gf180mcu_fd_sc_mcu7t5v0__xor2_1
X_2531_ _2469_/Z _2547_/A2 _2528_/Z _2531_/B _2595_/A2 VDD VDD VSS VSS gf180mcu_fd_sc_mcu7t5v0__oai31_4
X_2462_ _2459_/Z _2462_/A2 _2992_/I input2/Z _2463_/B VDD VDD VSS VSS gf180mcu_fd_sc_mcu7t5v0__oai211_1
X_2393_ _2393_/A1 wire334/I _2393_/B _2393_/C _2394_/I VDD VDD VSS VSS gf180mcu_fd_sc_mcu7t5v0__oai211_1
XFILLER_96_676 VDD VDD VSS VSS gf180mcu_fd_sc_mcu7t5v0__fill_1
XFILLER_95_142 VDD VDD VSS VSS gf180mcu_fd_sc_mcu7t5v0__fillcap_64
XFILLER_56_518 VDD VDD VSS VSS gf180mcu_fd_sc_mcu7t5v0__fillcap_4
XFILLER_56_529 VDD VDD VSS VSS gf180mcu_fd_sc_mcu7t5v0__fill_1
X_3014_ _3014_/I wire515/I VDD VDD VSS VSS gf180mcu_fd_sc_mcu7t5v0__inv_2
XTAP_TAPCELL_ROW_54_719 VDD VSS gf180mcu_fd_sc_mcu7t5v0__filltie
XFILLER_36_264 VDD VDD VSS VSS gf180mcu_fd_sc_mcu7t5v0__fill_2
XTAP_TAPCELL_ROW_62_796 VDD VSS gf180mcu_fd_sc_mcu7t5v0__filltie
X_3778_ _3778_/D _3778_/RN clkload0/I _3778_/Q VDD VDD VSS VSS gf180mcu_fd_sc_mcu7t5v0__dffrnq_1
X_2729_ _2996_/I input50/Z _2733_/C VDD VDD VSS VSS gf180mcu_fd_sc_mcu7t5v0__xor2_1
XFILLER_87_676 VDD VDD VSS VSS gf180mcu_fd_sc_mcu7t5v0__fill_1
XFILLER_59_367 VDD VDD VSS VSS gf180mcu_fd_sc_mcu7t5v0__fill_2
XPHY_EDGE_ROW_29_Right_29 VDD VSS gf180mcu_fd_sc_mcu7t5v0__endcap
XFILLER_74_337 VDD VDD VSS VSS gf180mcu_fd_sc_mcu7t5v0__fillcap_8
XFILLER_27_242 VDD VDD VSS VSS gf180mcu_fd_sc_mcu7t5v0__fill_2
XFILLER_70_543 VDD VDD VSS VSS gf180mcu_fd_sc_mcu7t5v0__fillcap_8
XTAP_TAPCELL_ROW_25_443 VDD VSS gf180mcu_fd_sc_mcu7t5v0__filltie
XFILLER_11_632 VDD VDD VSS VSS gf180mcu_fd_sc_mcu7t5v0__fill_2
XFILLER_11_610 VDD VDD VSS VSS gf180mcu_fd_sc_mcu7t5v0__fill_1
XFILLER_23_492 VDD VDD VSS VSS gf180mcu_fd_sc_mcu7t5v0__fillcap_16
XFILLER_11_676 VDD VDD VSS VSS gf180mcu_fd_sc_mcu7t5v0__fill_1
XPHY_EDGE_ROW_38_Right_38 VDD VSS gf180mcu_fd_sc_mcu7t5v0__endcap
Xwire523 wire523/I wire523/Z VDD VDD VSS VSS gf180mcu_fd_sc_mcu7t5v0__buf_2
Xwire589 wire589/I wire589/Z VDD VDD VSS VSS gf180mcu_fd_sc_mcu7t5v0__buf_1
Xload_slew506 _3682_/Q _2143_/A1 VDD VDD VSS VSS gf180mcu_fd_sc_mcu7t5v0__buf_2
Xload_slew539 _3139_/A1 _2288_/A2 VDD VDD VSS VSS gf180mcu_fd_sc_mcu7t5v0__clkbuf_2
XFILLER_77_142 VDD VDD VSS VSS gf180mcu_fd_sc_mcu7t5v0__fillcap_64
XFILLER_38_518 VDD VDD VSS VSS gf180mcu_fd_sc_mcu7t5v0__fillcap_4
XPHY_EDGE_ROW_47_Right_47 VDD VSS gf180mcu_fd_sc_mcu7t5v0__endcap
XFILLER_92_101 VDD VDD VSS VSS gf180mcu_fd_sc_mcu7t5v0__fillcap_4
XFILLER_33_245 VDD VDD VSS VSS gf180mcu_fd_sc_mcu7t5v0__fill_1
XFILLER_61_543 VDD VDD VSS VSS gf180mcu_fd_sc_mcu7t5v0__fillcap_8
X_1962_ _2000_/B2 _1999_/A1 _1983_/A2 VDD VDD VSS VSS gf180mcu_fd_sc_mcu7t5v0__nand2_1
XPHY_EDGE_ROW_56_Right_56 VDD VSS gf180mcu_fd_sc_mcu7t5v0__endcap
X_1893_ _1877_/B _1897_/B _1893_/B _1895_/A2 VDD VDD VSS VSS gf180mcu_fd_sc_mcu7t5v0__oai21_1
X_3701_ _3701_/D _3722_/RN clkload5/I _3701_/Q VDD VDD VSS VSS gf180mcu_fd_sc_mcu7t5v0__dffrnq_2
X_3632_ _3075_/I _3630_/Z _3633_/I VDD VDD VSS VSS gf180mcu_fd_sc_mcu7t5v0__xor2_1
X_3563_ _3563_/A1 _3576_/A1 _3563_/B _3564_/A2 VDD VDD VSS VSS gf180mcu_fd_sc_mcu7t5v0__oai21_1
X_2514_ _2522_/A1 _2522_/A3 _2521_/A2 VDD VDD VSS VSS gf180mcu_fd_sc_mcu7t5v0__nor2_1
X_3494_ _3495_/A1 _3473_/Z _3494_/B _3511_/B VDD VDD VSS VSS gf180mcu_fd_sc_mcu7t5v0__oai21_1
X_2445_ _2445_/A1 _2445_/A2 _2449_/A2 _3758_/D VDD VDD VSS VSS gf180mcu_fd_sc_mcu7t5v0__and3_1
XPHY_EDGE_ROW_65_Right_65 VDD VSS gf180mcu_fd_sc_mcu7t5v0__endcap
XFILLER_69_632 VDD VDD VSS VSS gf180mcu_fd_sc_mcu7t5v0__fill_2
X_2376_ _3084_/ZN _2376_/A2 _2376_/B1 _2388_/B1 _3734_/D VDD VDD VSS VSS gf180mcu_fd_sc_mcu7t5v0__aoi22_1
XTAP_TAPCELL_ROW_67_844 VDD VSS gf180mcu_fd_sc_mcu7t5v0__filltie
XTAP_TAPCELL_ROW_39_579 VDD VSS gf180mcu_fd_sc_mcu7t5v0__filltie
XPHY_EDGE_ROW_74_Right_74 VDD VSS gf180mcu_fd_sc_mcu7t5v0__endcap
XTAP_TAPCELL_ROW_22_413 VDD VSS gf180mcu_fd_sc_mcu7t5v0__filltie
XTAP_TAPCELL_ROW_30_490 VDD VSS gf180mcu_fd_sc_mcu7t5v0__filltie
XPHY_EDGE_ROW_83_Right_83 VDD VSS gf180mcu_fd_sc_mcu7t5v0__endcap
XFILLER_58_34 VDD VDD VSS VSS gf180mcu_fd_sc_mcu7t5v0__fill_1
XFILLER_87_440 VDD VDD VSS VSS gf180mcu_fd_sc_mcu7t5v0__fill_2
XFILLER_74_101 VDD VDD VSS VSS gf180mcu_fd_sc_mcu7t5v0__fillcap_4
XFILLER_62_307 VDD VDD VSS VSS gf180mcu_fd_sc_mcu7t5v0__fill_1
XPHY_EDGE_ROW_92_Right_92 VDD VSS gf180mcu_fd_sc_mcu7t5v0__endcap
XFILLER_15_212 VDD VDD VSS VSS gf180mcu_fd_sc_mcu7t5v0__fillcap_8
XFILLER_43_543 VDD VDD VSS VSS gf180mcu_fd_sc_mcu7t5v0__fill_1
XFILLER_15_256 VDD VDD VSS VSS gf180mcu_fd_sc_mcu7t5v0__fillcap_8
XFILLER_30_226 VDD VDD VSS VSS gf180mcu_fd_sc_mcu7t5v0__fillcap_8
XFILLER_7_422 VDD VDD VSS VSS gf180mcu_fd_sc_mcu7t5v0__fillcap_64
Xwire331 wire331/I _2855_/B VDD VDD VSS VSS gf180mcu_fd_sc_mcu7t5v0__clkbuf_2
Xwire375 _2124_/Z wire375/Z VDD VDD VSS VSS gf180mcu_fd_sc_mcu7t5v0__dlyb_1
Xwire397 wire397/I _2167_/S VDD VDD VSS VSS gf180mcu_fd_sc_mcu7t5v0__buf_1
XFILLER_3_672 VDD VDD VSS VSS gf180mcu_fd_sc_mcu7t5v0__fillcap_4
Xload_slew303 _3523_/A1 _3551_/B1 VDD VDD VSS VSS gf180mcu_fd_sc_mcu7t5v0__clkbuf_2
XFILLER_2_171 VDD VDD VSS VSS gf180mcu_fd_sc_mcu7t5v0__fillcap_4
X_2230_ _3085_/ZN _3664_/Q _2227_/Z _2234_/B VDD VDD VSS VSS gf180mcu_fd_sc_mcu7t5v0__nor3_1
Xload_slew314 _2125_/ZN fanout308/I VDD VDD VSS VSS gf180mcu_fd_sc_mcu7t5v0__dlyb_1
Xload_slew325 _2882_/B _2808_/A1 VDD VDD VSS VSS gf180mcu_fd_sc_mcu7t5v0__clkbuf_1
Xload_slew336 _2809_/A2 wire334/I VDD VDD VSS VSS gf180mcu_fd_sc_mcu7t5v0__clkbuf_1
Xload_slew347 fanout345/Z wire346/I VDD VDD VSS VSS gf180mcu_fd_sc_mcu7t5v0__clkbuf_2
X_2161_ _3692_/Q _3671_/Q _2161_/S _2162_/I VDD VDD VSS VSS gf180mcu_fd_sc_mcu7t5v0__mux2_2
XTAP_TAPCELL_ROW_88_1046 VDD VSS gf180mcu_fd_sc_mcu7t5v0__filltie
X_2092_ _3729_/Q _3627_/A1 _2092_/A3 _2092_/Z VDD VDD VSS VSS gf180mcu_fd_sc_mcu7t5v0__xor3_1
XTAP_TAPCELL_ROW_64_814 VDD VSS gf180mcu_fd_sc_mcu7t5v0__filltie
XTAP_TAPCELL_ROW_36_549 VDD VSS gf180mcu_fd_sc_mcu7t5v0__filltie
XFILLER_61_340 VDD VDD VSS VSS gf180mcu_fd_sc_mcu7t5v0__fillcap_4
X_2994_ _3654_/Q _2994_/ZN VDD VDD VSS VSS gf180mcu_fd_sc_mcu7t5v0__clkinv_1
XTAP_TAPCELL_ROW_72_891 VDD VSS gf180mcu_fd_sc_mcu7t5v0__filltie
XFILLER_9_72 VDD VDD VSS VSS gf180mcu_fd_sc_mcu7t5v0__fillcap_64
X_1945_ _3721_/Q _3516_/A1 _1967_/A2 VDD VDD VSS VSS gf180mcu_fd_sc_mcu7t5v0__nor2_1
X_1876_ _1876_/I _1886_/A1 VDD VDD VSS VSS gf180mcu_fd_sc_mcu7t5v0__clkinv_1
X_3615_ wire527/Z _3617_/A3 _3624_/B VDD VDD VSS VSS gf180mcu_fd_sc_mcu7t5v0__nor2_1
X_3546_ _3513_/B _3545_/C _3546_/B _3546_/C _3607_/A2 VDD VDD VSS VSS gf180mcu_fd_sc_mcu7t5v0__oai211_1
X_3477_ _3475_/Z _3478_/A2 _3511_/A1 VDD VDD VSS VSS gf180mcu_fd_sc_mcu7t5v0__nand2_1
X_2428_ wire366/Z _2347_/Z _2428_/A3 wire361/Z _2148_/C _3753_/D VDD VDD VSS VSS gf180mcu_fd_sc_mcu7t5v0__oai32_1
X_2359_ _2432_/A1 _2359_/A2 _2353_/Z _2359_/B _2444_/A4 VDD VDD VSS VSS gf180mcu_fd_sc_mcu7t5v0__oai31_4
XFILLER_28_37 VDD VDD VSS VSS gf180mcu_fd_sc_mcu7t5v0__fillcap_64
XFILLER_56_101 VDD VDD VSS VSS gf180mcu_fd_sc_mcu7t5v0__fillcap_4
XFILLER_84_465 VDD VDD VSS VSS gf180mcu_fd_sc_mcu7t5v0__fillcap_4
XFILLER_29_348 VDD VDD VSS VSS gf180mcu_fd_sc_mcu7t5v0__fill_2
XFILLER_56_123 VDD VDD VSS VSS gf180mcu_fd_sc_mcu7t5v0__fill_2
XFILLER_44_329 VDD VDD VSS VSS gf180mcu_fd_sc_mcu7t5v0__fillcap_16
XFILLER_69_66 VDD VDD VSS VSS gf180mcu_fd_sc_mcu7t5v0__fillcap_4
XTAP_TAPCELL_ROW_7_274 VDD VSS gf180mcu_fd_sc_mcu7t5v0__filltie
XFILLER_0_675 VDD VDD VSS VSS gf180mcu_fd_sc_mcu7t5v0__fill_2
XFILLER_35_318 VDD VDD VSS VSS gf180mcu_fd_sc_mcu7t5v0__fill_1
XFILLER_90_457 VDD VDD VSS VSS gf180mcu_fd_sc_mcu7t5v0__fillcap_16
XFILLER_90_479 VDD VDD VSS VSS gf180mcu_fd_sc_mcu7t5v0__fill_1
XTAP_TAPCELL_ROW_33_519 VDD VSS gf180mcu_fd_sc_mcu7t5v0__filltie
XFILLER_31_546 VDD VDD VSS VSS gf180mcu_fd_sc_mcu7t5v0__fill_1
XTAP_TAPCELL_ROW_41_596 VDD VSS gf180mcu_fd_sc_mcu7t5v0__filltie
X_3400_ _3048_/I _3673_/Q _3400_/Z VDD VDD VSS VSS gf180mcu_fd_sc_mcu7t5v0__xor2_1
X_3331_ _3285_/B _3331_/A2 _3332_/C VDD VDD VSS VSS gf180mcu_fd_sc_mcu7t5v0__nand2_1
X_3262_ _3299_/B _3282_/A1 _3225_/Z _3263_/A2 VDD VDD VSS VSS gf180mcu_fd_sc_mcu7t5v0__nand3_1
XFILLER_22_2 VDD VDD VSS VSS gf180mcu_fd_sc_mcu7t5v0__fillcap_32
XFILLER_38_101 VDD VDD VSS VSS gf180mcu_fd_sc_mcu7t5v0__fillcap_4
X_2213_ _3318_/B _2129_/I _2213_/B _2214_/B2 VDD VDD VSS VSS gf180mcu_fd_sc_mcu7t5v0__aoi21_1
XFILLER_66_421 VDD VDD VSS VSS gf180mcu_fd_sc_mcu7t5v0__fill_2
X_3193_ wire629/Z _3193_/A2 _3198_/B VDD VDD VSS VSS gf180mcu_fd_sc_mcu7t5v0__nand2_1
X_2144_ _3553_/A1 _2196_/A2 _2144_/B _2194_/A2 VDD VDD VSS VSS gf180mcu_fd_sc_mcu7t5v0__oai21_1
XFILLER_66_454 VDD VDD VSS VSS gf180mcu_fd_sc_mcu7t5v0__fill_1
XTAP_TAPCELL_ROW_49_674 VDD VSS gf180mcu_fd_sc_mcu7t5v0__filltie
XFILLER_53_104 VDD VDD VSS VSS gf180mcu_fd_sc_mcu7t5v0__fillcap_16
X_2075_ _2097_/A1 _2099_/A1 _2075_/Z VDD VDD VSS VSS gf180mcu_fd_sc_mcu7t5v0__xor2_2
XFILLER_38_189 VDD VDD VSS VSS gf180mcu_fd_sc_mcu7t5v0__fillcap_8
XFILLER_34_362 VDD VDD VSS VSS gf180mcu_fd_sc_mcu7t5v0__fillcap_8
XFILLER_34_384 VDD VDD VSS VSS gf180mcu_fd_sc_mcu7t5v0__fill_1
XFILLER_34_395 VDD VDD VSS VSS gf180mcu_fd_sc_mcu7t5v0__fillcap_4
XFILLER_61_181 VDD VDD VSS VSS gf180mcu_fd_sc_mcu7t5v0__fill_2
X_2977_ _2977_/I _2148_/C VDD VDD VSS VSS gf180mcu_fd_sc_mcu7t5v0__inv_2
X_1928_ _1901_/Z _1914_/Z _1929_/C VDD VDD VSS VSS gf180mcu_fd_sc_mcu7t5v0__or2_1
X_1859_ _3046_/I _1859_/A2 _1859_/B _1888_/B1 VDD VDD VSS VSS gf180mcu_fd_sc_mcu7t5v0__aoi21_2
X_3529_ _3546_/C _3528_/Z _3531_/A1 VDD VDD VSS VSS gf180mcu_fd_sc_mcu7t5v0__nand2_1
XFILLER_69_270 VDD VDD VSS VSS gf180mcu_fd_sc_mcu7t5v0__fill_1
XTAP_TAPCELL_ROW_4_244 VDD VSS gf180mcu_fd_sc_mcu7t5v0__filltie
XFILLER_57_487 VDD VDD VSS VSS gf180mcu_fd_sc_mcu7t5v0__fill_2
XFILLER_72_402 VDD VDD VSS VSS gf180mcu_fd_sc_mcu7t5v0__fill_2
XFILLER_72_457 VDD VDD VSS VSS gf180mcu_fd_sc_mcu7t5v0__fillcap_16
XTAP_TAPCELL_ROW_83_997 VDD VSS gf180mcu_fd_sc_mcu7t5v0__filltie
XFILLER_13_568 VDD VDD VSS VSS gf180mcu_fd_sc_mcu7t5v0__fill_1
XFILLER_40_376 VDD VDD VSS VSS gf180mcu_fd_sc_mcu7t5v0__fillcap_8
XFILLER_40_387 VDD VDD VSS VSS gf180mcu_fd_sc_mcu7t5v0__fillcap_32
XFILLER_21_590 VDD VDD VSS VSS gf180mcu_fd_sc_mcu7t5v0__fill_1
XFILLER_0_494 VDD VDD VSS VSS gf180mcu_fd_sc_mcu7t5v0__fill_1
XFILLER_48_465 VDD VDD VSS VSS gf180mcu_fd_sc_mcu7t5v0__fillcap_4
XTAP_TAPCELL_ROW_85_1016 VDD VSS gf180mcu_fd_sc_mcu7t5v0__filltie
XFILLER_35_137 VDD VDD VSS VSS gf180mcu_fd_sc_mcu7t5v0__fill_2
XTAP_TAPCELL_ROW_46_644 VDD VSS gf180mcu_fd_sc_mcu7t5v0__filltie
XTAP_TAPCELL_ROW_18_379 VDD VSS gf180mcu_fd_sc_mcu7t5v0__filltie
X_2900_ _2900_/A1 _2947_/A2 _2900_/B _3690_/D VDD VDD VSS VSS gf180mcu_fd_sc_mcu7t5v0__oai21_1
XFILLER_50_107 VDD VDD VSS VSS gf180mcu_fd_sc_mcu7t5v0__fillcap_32
X_2831_ _2831_/A1 _2831_/A2 _2831_/B _2848_/A2 VDD VDD VSS VSS gf180mcu_fd_sc_mcu7t5v0__aoi21_4
X_2762_ _3090_/ZN _2762_/A2 _2762_/B _2766_/A2 VDD VDD VSS VSS gf180mcu_fd_sc_mcu7t5v0__oai21_1
XTAP_TAPCELL_ROW_96_1123 VDD VSS gf180mcu_fd_sc_mcu7t5v0__filltie
XFILLER_8_583 VDD VDD VSS VSS gf180mcu_fd_sc_mcu7t5v0__fill_2
X_2693_ _2693_/A1 _2645_/Z _2693_/Z VDD VDD VSS VSS gf180mcu_fd_sc_mcu7t5v0__xor2_1
X_3314_ _3314_/A1 _3314_/A2 _3769_/Q _3315_/A2 VDD VDD VSS VSS gf180mcu_fd_sc_mcu7t5v0__aoi21_1
XFILLER_86_549 VDD VDD VSS VSS gf180mcu_fd_sc_mcu7t5v0__fillcap_4
XFILLER_86_527 VDD VDD VSS VSS gf180mcu_fd_sc_mcu7t5v0__fillcap_16
X_3245_ _2734_/C _3245_/A2 _3338_/B VDD VDD VSS VSS gf180mcu_fd_sc_mcu7t5v0__xor2_2
XTAP_TAPCELL_ROW_1_214 VDD VSS gf180mcu_fd_sc_mcu7t5v0__filltie
X_3176_ _3176_/A1 _3169_/Z _3176_/A3 _3176_/B _3177_/A2 VDD VDD VSS VSS gf180mcu_fd_sc_mcu7t5v0__oai31_2
X_2127_ _3709_/Q _3088_/ZN _2128_/B VDD VDD VSS VSS gf180mcu_fd_sc_mcu7t5v0__nand2_1
XFILLER_54_446 VDD VDD VSS VSS gf180mcu_fd_sc_mcu7t5v0__fill_1
X_2058_ _2056_/Z _2058_/A2 _2058_/Z VDD VDD VSS VSS gf180mcu_fd_sc_mcu7t5v0__xor2_2
XFILLER_54_457 VDD VDD VSS VSS gf180mcu_fd_sc_mcu7t5v0__fillcap_16
XFILLER_81_276 VDD VDD VSS VSS gf180mcu_fd_sc_mcu7t5v0__fillcap_4
XTAP_TAPCELL_ROW_80_967 VDD VSS gf180mcu_fd_sc_mcu7t5v0__filltie
XFILLER_22_321 VDD VDD VSS VSS gf180mcu_fd_sc_mcu7t5v0__fill_1
XFILLER_22_332 VDD VDD VSS VSS gf180mcu_fd_sc_mcu7t5v0__fill_1
XFILLER_22_387 VDD VDD VSS VSS gf180mcu_fd_sc_mcu7t5v0__fillcap_4
XFILLER_1_236 VDD VDD VSS VSS gf180mcu_fd_sc_mcu7t5v0__fill_1
XFILLER_89_376 VDD VDD VSS VSS gf180mcu_fd_sc_mcu7t5v0__fill_2
XFILLER_66_34 VDD VDD VSS VSS gf180mcu_fd_sc_mcu7t5v0__fill_1
XFILLER_18_616 VDD VDD VSS VSS gf180mcu_fd_sc_mcu7t5v0__fill_1
XFILLER_57_240 VDD VDD VSS VSS gf180mcu_fd_sc_mcu7t5v0__fill_2
XFILLER_33_619 VDD VDD VSS VSS gf180mcu_fd_sc_mcu7t5v0__fill_2
XTAP_TAPCELL_ROW_43_614 VDD VSS gf180mcu_fd_sc_mcu7t5v0__filltie
XTAP_TAPCELL_ROW_15_349 VDD VSS gf180mcu_fd_sc_mcu7t5v0__filltie
XFILLER_13_354 VDD VDD VSS VSS gf180mcu_fd_sc_mcu7t5v0__fill_1
XFILLER_40_162 VDD VDD VSS VSS gf180mcu_fd_sc_mcu7t5v0__fill_1
XFILLER_9_358 VDD VDD VSS VSS gf180mcu_fd_sc_mcu7t5v0__fill_1
XTAP_TAPCELL_ROW_51_691 VDD VSS gf180mcu_fd_sc_mcu7t5v0__filltie
XFILLER_68_505 VDD VDD VSS VSS gf180mcu_fd_sc_mcu7t5v0__fill_1
XTAP_TAPCELL_ROW_91_1075 VDD VSS gf180mcu_fd_sc_mcu7t5v0__filltie
Xoutput92 _3190_/ZN cal_phase0_offset[12] VDD VDD VSS VSS gf180mcu_fd_sc_mcu7t5v0__buf_2
XFILLER_68_527 VDD VDD VSS VSS gf180mcu_fd_sc_mcu7t5v0__fillcap_16
XFILLER_95_346 VDD VDD VSS VSS gf180mcu_fd_sc_mcu7t5v0__fillcap_4
XFILLER_76_571 VDD VDD VSS VSS gf180mcu_fd_sc_mcu7t5v0__fillcap_8
X_3030_ _3716_/Q _3159_/A2 VDD VDD VSS VSS gf180mcu_fd_sc_mcu7t5v0__clkinv_1
XFILLER_36_457 VDD VDD VSS VSS gf180mcu_fd_sc_mcu7t5v0__fillcap_16
XFILLER_63_276 VDD VDD VSS VSS gf180mcu_fd_sc_mcu7t5v0__fillcap_4
XFILLER_63_298 VDD VDD VSS VSS gf180mcu_fd_sc_mcu7t5v0__fillcap_4
X_2814_ _2826_/A1 _2817_/A2 _2815_/B2 VDD VDD VSS VSS gf180mcu_fd_sc_mcu7t5v0__nand2_1
X_2745_ _3739_/Q _2828_/A1 _2386_/Z _2746_/A2 VDD VDD VSS VSS gf180mcu_fd_sc_mcu7t5v0__nand3_1
X_2676_ _2676_/A1 _2676_/A2 _2677_/I VDD VDD VSS VSS gf180mcu_fd_sc_mcu7t5v0__nand2_1
Xfanout326 wire331/I _2870_/B VDD VDD VSS VSS gf180mcu_fd_sc_mcu7t5v0__dlyb_1
Xfanout337 fanout345/Z _2829_/A2 VDD VDD VSS VSS gf180mcu_fd_sc_mcu7t5v0__dlyb_1
XFILLER_59_549 VDD VDD VSS VSS gf180mcu_fd_sc_mcu7t5v0__fill_1
X_3228_ _3299_/B _3225_/Z _3332_/A1 VDD VDD VSS VSS gf180mcu_fd_sc_mcu7t5v0__nor2_1
XFILLER_27_424 VDD VDD VSS VSS gf180mcu_fd_sc_mcu7t5v0__fill_1
XFILLER_36_37 VDD VDD VSS VSS gf180mcu_fd_sc_mcu7t5v0__fillcap_32
X_3159_ _3437_/A1 _3159_/A2 _3170_/B VDD VDD VSS VSS gf180mcu_fd_sc_mcu7t5v0__nor2_1
XFILLER_14_107 VDD VDD VSS VSS gf180mcu_fd_sc_mcu7t5v0__fillcap_64
XTAP_TAPCELL_ROW_12_319 VDD VSS gf180mcu_fd_sc_mcu7t5v0__filltie
XFILLER_6_317 VDD VDD VSS VSS gf180mcu_fd_sc_mcu7t5v0__fillcap_4
XFILLER_6_339 VDD VDD VSS VSS gf180mcu_fd_sc_mcu7t5v0__fill_2
XTAP_TAPCELL_ROW_20_396 VDD VSS gf180mcu_fd_sc_mcu7t5v0__filltie
XFILLER_77_66 VDD VDD VSS VSS gf180mcu_fd_sc_mcu7t5v0__fillcap_4
XFILLER_18_457 VDD VDD VSS VSS gf180mcu_fd_sc_mcu7t5v0__fill_1
XTAP_TAPCELL_ROW_28_474 VDD VSS gf180mcu_fd_sc_mcu7t5v0__filltie
XFILLER_14_630 VDD VDD VSS VSS gf180mcu_fd_sc_mcu7t5v0__fill_2
XFILLER_26_490 VDD VDD VSS VSS gf180mcu_fd_sc_mcu7t5v0__fill_2
X_2530_ _3117_/A2 _3018_/I _3019_/I _3118_/A2 _2531_/B VDD VDD VSS VSS gf180mcu_fd_sc_mcu7t5v0__aoi22_2
XFILLER_5_361 VDD VDD VSS VSS gf180mcu_fd_sc_mcu7t5v0__fillcap_8
X_2461_ _3653_/Q _3651_/Q _2462_/A2 VDD VDD VSS VSS gf180mcu_fd_sc_mcu7t5v0__nor2_1
XFILLER_96_611 VDD VDD VSS VSS gf180mcu_fd_sc_mcu7t5v0__fill_1
XFILLER_96_600 VDD VDD VSS VSS gf180mcu_fd_sc_mcu7t5v0__fill_2
X_2392_ wire312/Z wire319/Z _2393_/C VDD VDD VSS VSS gf180mcu_fd_sc_mcu7t5v0__nand2_1
X_3013_ _3013_/I _2577_/B VDD VDD VSS VSS gf180mcu_fd_sc_mcu7t5v0__inv_2
XTAP_TAPCELL_ROW_62_797 VDD VSS gf180mcu_fd_sc_mcu7t5v0__filltie
X_3777_ _3777_/D _3777_/RN clkload4/I _3777_/Q VDD VDD VSS VSS gf180mcu_fd_sc_mcu7t5v0__dffrnq_1
X_2728_ _2211_/C input50/Z _2735_/A1 VDD VDD VSS VSS gf180mcu_fd_sc_mcu7t5v0__nand2_1
X_2659_ _2979_/ZN _2999_/I _2659_/B1 _2981_/ZN _2661_/A2 VDD VDD VSS VSS gf180mcu_fd_sc_mcu7t5v0__aoi22_1
XFILLER_87_622 VDD VDD VSS VSS gf180mcu_fd_sc_mcu7t5v0__fill_2
XFILLER_59_379 VDD VDD VSS VSS gf180mcu_fd_sc_mcu7t5v0__fill_1
XFILLER_70_555 VDD VDD VSS VSS gf180mcu_fd_sc_mcu7t5v0__fill_2
XFILLER_11_600 VDD VDD VSS VSS gf180mcu_fd_sc_mcu7t5v0__fillcap_8
XTAP_TAPCELL_ROW_25_444 VDD VSS gf180mcu_fd_sc_mcu7t5v0__filltie
XFILLER_7_604 VDD VDD VSS VSS gf180mcu_fd_sc_mcu7t5v0__fillcap_8
Xwire513 _3657_/Q wire513/Z VDD VDD VSS VSS gf180mcu_fd_sc_mcu7t5v0__buf_2
XFILLER_7_626 VDD VDD VSS VSS gf180mcu_fd_sc_mcu7t5v0__fillcap_4
Xwire557 wire557/I wire557/Z VDD VDD VSS VSS gf180mcu_fd_sc_mcu7t5v0__clkbuf_2
Xload_slew529 input9/Z fanout526/I VDD VDD VSS VSS gf180mcu_fd_sc_mcu7t5v0__buf_2
Xload_slew518 _3004_/ZN _3587_/A1 VDD VDD VSS VSS gf180mcu_fd_sc_mcu7t5v0__buf_2
Xload_slew507 _3681_/Q _3065_/I VDD VDD VSS VSS gf180mcu_fd_sc_mcu7t5v0__buf_2
XFILLER_33_202 VDD VDD VSS VSS gf180mcu_fd_sc_mcu7t5v0__fill_2
XFILLER_61_500 VDD VDD VSS VSS gf180mcu_fd_sc_mcu7t5v0__fillcap_8
XFILLER_33_279 VDD VDD VSS VSS gf180mcu_fd_sc_mcu7t5v0__fill_1
XFILLER_61_555 VDD VDD VSS VSS gf180mcu_fd_sc_mcu7t5v0__fill_1
X_1961_ _1961_/A1 _1961_/A2 _1999_/A1 VDD VDD VSS VSS gf180mcu_fd_sc_mcu7t5v0__nand2_1
X_3700_ _3700_/D _3722_/RN _3721_/CLK _3700_/Q VDD VDD VSS VSS gf180mcu_fd_sc_mcu7t5v0__dffrnq_2
XFILLER_61_599 VDD VDD VSS VSS gf180mcu_fd_sc_mcu7t5v0__fillcap_8
X_1892_ _3050_/I _1884_/Z _1892_/B _1909_/A1 VDD VDD VSS VSS gf180mcu_fd_sc_mcu7t5v0__aoi21_1
X_3631_ _3631_/A1 _3630_/Z _3646_/B VDD VDD VSS VSS gf180mcu_fd_sc_mcu7t5v0__and2_1
X_3562_ _3577_/B _3561_/I _3564_/A1 VDD VDD VSS VSS gf180mcu_fd_sc_mcu7t5v0__nand2_1
X_2513_ _2982_/I _3022_/ZN _2513_/B _3749_/Q _2522_/A3 VDD VDD VSS VSS gf180mcu_fd_sc_mcu7t5v0__aoi211_1
XFILLER_52_2 VDD VDD VSS VSS gf180mcu_fd_sc_mcu7t5v0__fillcap_32
X_3493_ _3471_/Z _3493_/A2 _3493_/B _3513_/A2 VDD VDD VSS VSS gf180mcu_fd_sc_mcu7t5v0__aoi21_1
X_2444_ _3235_/A1 _3757_/Q _2119_/Z _2444_/A4 _2449_/A2 VDD VDD VSS VSS gf180mcu_fd_sc_mcu7t5v0__nand4_1
X_2375_ _2375_/A1 _2380_/A3 _2376_/B1 VDD VDD VSS VSS gf180mcu_fd_sc_mcu7t5v0__nand2_1
XFILLER_96_441 VDD VDD VSS VSS gf180mcu_fd_sc_mcu7t5v0__fill_1
XTAP_TAPCELL_ROW_67_845 VDD VSS gf180mcu_fd_sc_mcu7t5v0__filltie
XFILLER_71_319 VDD VDD VSS VSS gf180mcu_fd_sc_mcu7t5v0__fillcap_16
XFILLER_64_382 VDD VDD VSS VSS gf180mcu_fd_sc_mcu7t5v0__fill_2
XFILLER_52_577 VDD VDD VSS VSS gf180mcu_fd_sc_mcu7t5v0__fillcap_4
XTAP_TAPCELL_ROW_22_414 VDD VSS gf180mcu_fd_sc_mcu7t5v0__filltie
XFILLER_20_485 VDD VDD VSS VSS gf180mcu_fd_sc_mcu7t5v0__fill_1
XTAP_TAPCELL_ROW_30_491 VDD VSS gf180mcu_fd_sc_mcu7t5v0__filltie
XFILLER_87_474 VDD VDD VSS VSS gf180mcu_fd_sc_mcu7t5v0__fill_2
XFILLER_47_349 VDD VDD VSS VSS gf180mcu_fd_sc_mcu7t5v0__fill_1
XFILLER_74_34 VDD VDD VSS VSS gf180mcu_fd_sc_mcu7t5v0__fill_1
XFILLER_15_224 VDD VDD VSS VSS gf180mcu_fd_sc_mcu7t5v0__fill_2
XFILLER_55_371 VDD VDD VSS VSS gf180mcu_fd_sc_mcu7t5v0__fillcap_4
XFILLER_15_268 VDD VDD VSS VSS gf180mcu_fd_sc_mcu7t5v0__fill_1
XFILLER_11_430 VDD VDD VSS VSS gf180mcu_fd_sc_mcu7t5v0__fill_2
Xload_slew315 _3339_/B _3314_/A1 VDD VDD VSS VSS gf180mcu_fd_sc_mcu7t5v0__buf_2
XFILLER_78_452 VDD VDD VSS VSS gf180mcu_fd_sc_mcu7t5v0__fill_2
Xload_slew348 _3263_/C _3251_/C VDD VDD VSS VSS gf180mcu_fd_sc_mcu7t5v0__buf_2
XFILLER_93_422 VDD VDD VSS VSS gf180mcu_fd_sc_mcu7t5v0__fillcap_64
X_2160_ _3103_/B2 _2156_/Z _2157_/Z _3101_/B2 _2164_/A2 VDD VDD VSS VSS gf180mcu_fd_sc_mcu7t5v0__aoi22_1
XTAP_TAPCELL_ROW_88_1047 VDD VSS gf180mcu_fd_sc_mcu7t5v0__filltie
X_2091_ _2077_/Z _2101_/A2 _2101_/C _2092_/A3 VDD VDD VSS VSS gf180mcu_fd_sc_mcu7t5v0__oai21_1
XTAP_TAPCELL_ROW_64_815 VDD VSS gf180mcu_fd_sc_mcu7t5v0__filltie
XFILLER_19_596 VDD VDD VSS VSS gf180mcu_fd_sc_mcu7t5v0__fillcap_8
XFILLER_61_352 VDD VDD VSS VSS gf180mcu_fd_sc_mcu7t5v0__fillcap_4
XFILLER_61_330 VDD VDD VSS VSS gf180mcu_fd_sc_mcu7t5v0__fill_2
X_2993_ _3653_/Q _2993_/ZN VDD VDD VSS VSS gf180mcu_fd_sc_mcu7t5v0__clkinv_1
XTAP_TAPCELL_ROW_72_892 VDD VSS gf180mcu_fd_sc_mcu7t5v0__filltie
XFILLER_14_290 VDD VDD VSS VSS gf180mcu_fd_sc_mcu7t5v0__fillcap_8
XFILLER_21_249 VDD VDD VSS VSS gf180mcu_fd_sc_mcu7t5v0__fillcap_8
X_1944_ _3721_/Q _3516_/A1 _1967_/B VDD VDD VSS VSS gf180mcu_fd_sc_mcu7t5v0__nand2_1
X_3614_ _3611_/Z _3613_/Z _3617_/A3 VDD VDD VSS VSS gf180mcu_fd_sc_mcu7t5v0__xnor2_1
X_1875_ _3048_/I _1870_/Z _1875_/B _1876_/I VDD VDD VSS VSS gf180mcu_fd_sc_mcu7t5v0__aoi21_1
X_3545_ _3545_/A1 _3545_/A2 _3545_/B _3545_/C wire280/I VDD VDD VSS VSS gf180mcu_fd_sc_mcu7t5v0__aoi211_2
X_3476_ _3011_/I _3457_/Z _3476_/B _3478_/A2 VDD VDD VSS VSS gf180mcu_fd_sc_mcu7t5v0__oai21_1
X_2427_ _2427_/A1 wire282/Z _2427_/B _2428_/A3 VDD VDD VSS VSS gf180mcu_fd_sc_mcu7t5v0__aoi21_1
Xclkbuf_4_15_0_clk clkbuf_0_clk/Z _3715_/CLK VDD VDD VSS VSS gf180mcu_fd_sc_mcu7t5v0__clkbuf_8
XFILLER_96_271 VDD VDD VSS VSS gf180mcu_fd_sc_mcu7t5v0__fill_1
XFILLER_84_422 VDD VDD VSS VSS gf180mcu_fd_sc_mcu7t5v0__fill_2
X_2358_ _2358_/A1 _2358_/A2 _2358_/B _2358_/C _2359_/B VDD VDD VSS VSS gf180mcu_fd_sc_mcu7t5v0__aoi211_4
XFILLER_29_316 VDD VDD VSS VSS gf180mcu_fd_sc_mcu7t5v0__fillcap_16
XFILLER_69_496 VDD VDD VSS VSS gf180mcu_fd_sc_mcu7t5v0__fill_2
X_2289_ wire255/I _2937_/A1 _2289_/B _3727_/D VDD VDD VSS VSS gf180mcu_fd_sc_mcu7t5v0__oai21_1
XFILLER_44_37 VDD VDD VSS VSS gf180mcu_fd_sc_mcu7t5v0__fillcap_64
XTAP_TAPCELL_ROW_7_275 VDD VSS gf180mcu_fd_sc_mcu7t5v0__filltie
XFILLER_75_400 VDD VDD VSS VSS gf180mcu_fd_sc_mcu7t5v0__fillcap_8
XFILLER_87_282 VDD VDD VSS VSS gf180mcu_fd_sc_mcu7t5v0__fillcap_32
XFILLER_85_66 VDD VDD VSS VSS gf180mcu_fd_sc_mcu7t5v0__fillcap_4
XFILLER_90_403 VDD VDD VSS VSS gf180mcu_fd_sc_mcu7t5v0__fillcap_8
XFILLER_63_628 VDD VDD VSS VSS gf180mcu_fd_sc_mcu7t5v0__fill_2
XFILLER_43_352 VDD VDD VSS VSS gf180mcu_fd_sc_mcu7t5v0__fillcap_16
XFILLER_70_171 VDD VDD VSS VSS gf180mcu_fd_sc_mcu7t5v0__fillcap_4
XFILLER_7_220 VDD VDD VSS VSS gf180mcu_fd_sc_mcu7t5v0__fillcap_4
XTAP_TAPCELL_ROW_41_597 VDD VSS gf180mcu_fd_sc_mcu7t5v0__filltie
X_3330_ _3330_/A1 _3330_/A2 _3330_/B _3342_/A1 VDD VDD VSS VSS gf180mcu_fd_sc_mcu7t5v0__oai21_1
XFILLER_3_470 VDD VDD VSS VSS gf180mcu_fd_sc_mcu7t5v0__fillcap_16
X_3261_ _3237_/B _3269_/A2 _3263_/A1 VDD VDD VSS VSS gf180mcu_fd_sc_mcu7t5v0__nand2_1
XFILLER_3_492 VDD VDD VSS VSS gf180mcu_fd_sc_mcu7t5v0__fillcap_64
X_3192_ wire629/Z _3193_/A2 _3198_/A3 VDD VDD VSS VSS gf180mcu_fd_sc_mcu7t5v0__nor2_1
X_2212_ _2212_/I _2213_/B VDD VDD VSS VSS gf180mcu_fd_sc_mcu7t5v0__clkinv_1
XTAP_TAPCELL_ROW_77_940 VDD VSS gf180mcu_fd_sc_mcu7t5v0__filltie
XFILLER_15_2 VDD VDD VSS VSS gf180mcu_fd_sc_mcu7t5v0__fillcap_64
X_2143_ _2143_/A1 _2196_/A2 _2144_/B VDD VDD VSS VSS gf180mcu_fd_sc_mcu7t5v0__nand2_1
XTAP_TAPCELL_ROW_49_675 VDD VSS gf180mcu_fd_sc_mcu7t5v0__filltie
X_2074_ _2097_/A1 _2099_/A1 _2087_/A2 VDD VDD VSS VSS gf180mcu_fd_sc_mcu7t5v0__nor2_1
XFILLER_22_536 VDD VDD VSS VSS gf180mcu_fd_sc_mcu7t5v0__fillcap_4
X_2976_ _3754_/Q _3119_/A2 VDD VDD VSS VSS gf180mcu_fd_sc_mcu7t5v0__inv_2
X_1927_ _3179_/A2 _3058_/I _1927_/Z VDD VDD VSS VSS gf180mcu_fd_sc_mcu7t5v0__xor2_1
XFILLER_30_591 VDD VDD VSS VSS gf180mcu_fd_sc_mcu7t5v0__fillcap_4
X_1858_ _1888_/A1 _1858_/A2 _1858_/Z VDD VDD VSS VSS gf180mcu_fd_sc_mcu7t5v0__xor2_1
X_3528_ _3528_/A1 _3505_/Z _3527_/B _3528_/Z VDD VDD VSS VSS gf180mcu_fd_sc_mcu7t5v0__or3_1
X_3459_ _3675_/Q _3458_/Z _3476_/B VDD VDD VSS VSS gf180mcu_fd_sc_mcu7t5v0__nand2_1
XFILLER_57_400 VDD VDD VSS VSS gf180mcu_fd_sc_mcu7t5v0__fillcap_4
XFILLER_69_260 VDD VDD VSS VSS gf180mcu_fd_sc_mcu7t5v0__fillcap_8
XTAP_TAPCELL_ROW_4_245 VDD VSS gf180mcu_fd_sc_mcu7t5v0__filltie
XFILLER_57_422 VDD VDD VSS VSS gf180mcu_fd_sc_mcu7t5v0__fillcap_16
XFILLER_84_241 VDD VDD VSS VSS gf180mcu_fd_sc_mcu7t5v0__fillcap_4
XFILLER_17_308 VDD VDD VSS VSS gf180mcu_fd_sc_mcu7t5v0__fill_1
XFILLER_37_190 VDD VDD VSS VSS gf180mcu_fd_sc_mcu7t5v0__fill_2
XTAP_TAPCELL_ROW_83_998 VDD VSS gf180mcu_fd_sc_mcu7t5v0__filltie
XFILLER_25_374 VDD VDD VSS VSS gf180mcu_fd_sc_mcu7t5v0__fill_2
XTAP_TAPCELL_ROW_85_1017 VDD VSS gf180mcu_fd_sc_mcu7t5v0__filltie
XTAP_TAPCELL_ROW_74_910 VDD VSS gf180mcu_fd_sc_mcu7t5v0__filltie
XTAP_TAPCELL_ROW_46_645 VDD VSS gf180mcu_fd_sc_mcu7t5v0__filltie
X_2830_ _2831_/A1 _2831_/A2 _2832_/A2 VDD VDD VSS VSS gf180mcu_fd_sc_mcu7t5v0__nand2_1
X_2761_ _3733_/Q _2762_/A2 _2762_/B VDD VDD VSS VSS gf180mcu_fd_sc_mcu7t5v0__nand2_1
XTAP_TAPCELL_ROW_96_1124 VDD VSS gf180mcu_fd_sc_mcu7t5v0__filltie
X_2692_ _2691_/B _2655_/B _2692_/A3 _2721_/C VDD VDD VSS VSS gf180mcu_fd_sc_mcu7t5v0__or3_1
X_3313_ _3769_/Q _3314_/A1 _3314_/A2 _3317_/B VDD VDD VSS VSS gf180mcu_fd_sc_mcu7t5v0__and3_1
X_3244_ _2968_/I _3244_/A2 _3285_/B VDD VDD VSS VSS gf180mcu_fd_sc_mcu7t5v0__xor2_2
XFILLER_39_422 VDD VDD VSS VSS gf180mcu_fd_sc_mcu7t5v0__fillcap_16
XTAP_TAPCELL_ROW_1_215 VDD VSS gf180mcu_fd_sc_mcu7t5v0__filltie
X_3175_ _3175_/I _3180_/A1 VDD VDD VSS VSS gf180mcu_fd_sc_mcu7t5v0__clkinv_1
XFILLER_27_628 VDD VDD VSS VSS gf180mcu_fd_sc_mcu7t5v0__fill_2
X_2126_ _2763_/B wire374/Z _2832_/A1 VDD VDD VSS VSS gf180mcu_fd_sc_mcu7t5v0__nand2_1
X_2057_ _2057_/A1 _2057_/A2 _2069_/B _2058_/A2 VDD VDD VSS VSS gf180mcu_fd_sc_mcu7t5v0__aoi21_1
XFILLER_41_108 VDD VDD VSS VSS gf180mcu_fd_sc_mcu7t5v0__fill_1
XTAP_TAPCELL_ROW_80_968 VDD VSS gf180mcu_fd_sc_mcu7t5v0__filltie
XFILLER_34_193 VDD VDD VSS VSS gf180mcu_fd_sc_mcu7t5v0__fill_2
XFILLER_62_480 VDD VDD VSS VSS gf180mcu_fd_sc_mcu7t5v0__fillcap_32
XFILLER_50_675 VDD VDD VSS VSS gf180mcu_fd_sc_mcu7t5v0__fill_2
XFILLER_22_399 VDD VDD VSS VSS gf180mcu_fd_sc_mcu7t5v0__fillcap_8
X_2959_ _2959_/A1 _2959_/A2 _2959_/B _3717_/D VDD VDD VSS VSS gf180mcu_fd_sc_mcu7t5v0__oai21_1
XFILLER_77_528 VDD VDD VSS VSS gf180mcu_fd_sc_mcu7t5v0__fillcap_8
XFILLER_82_34 VDD VDD VSS VSS gf180mcu_fd_sc_mcu7t5v0__fill_1
XTAP_TAPCELL_ROW_43_615 VDD VSS gf180mcu_fd_sc_mcu7t5v0__filltie
XFILLER_60_439 VDD VDD VSS VSS gf180mcu_fd_sc_mcu7t5v0__fillcap_16
XFILLER_72_299 VDD VDD VSS VSS gf180mcu_fd_sc_mcu7t5v0__fill_2
XFILLER_15_72 VDD VDD VSS VSS gf180mcu_fd_sc_mcu7t5v0__fillcap_64
XFILLER_9_337 VDD VDD VSS VSS gf180mcu_fd_sc_mcu7t5v0__fillcap_8
XFILLER_40_174 VDD VDD VSS VSS gf180mcu_fd_sc_mcu7t5v0__fill_1
XTAP_TAPCELL_ROW_51_692 VDD VSS gf180mcu_fd_sc_mcu7t5v0__filltie
XFILLER_40_196 VDD VDD VSS VSS gf180mcu_fd_sc_mcu7t5v0__fill_1
XTAP_TAPCELL_ROW_91_1076 VDD VSS gf180mcu_fd_sc_mcu7t5v0__filltie
Xoutput93 _3194_/Z cal_phase0_offset[13] VDD VDD VSS VSS gf180mcu_fd_sc_mcu7t5v0__buf_2
XFILLER_48_274 VDD VDD VSS VSS gf180mcu_fd_sc_mcu7t5v0__fill_1
XTAP_TAPCELL_ROW_59_770 VDD VSS gf180mcu_fd_sc_mcu7t5v0__filltie
XFILLER_16_171 VDD VDD VSS VSS gf180mcu_fd_sc_mcu7t5v0__fillcap_4
XFILLER_32_653 VDD VDD VSS VSS gf180mcu_fd_sc_mcu7t5v0__fillcap_4
XFILLER_82_2 VDD VDD VSS VSS gf180mcu_fd_sc_mcu7t5v0__fillcap_32
X_2813_ _2813_/A1 _2816_/A2 _3740_/Q _2817_/A2 VDD VDD VSS VSS gf180mcu_fd_sc_mcu7t5v0__aoi21_1
X_2744_ _2390_/B _3659_/Q _2746_/A1 VDD VDD VSS VSS gf180mcu_fd_sc_mcu7t5v0__nand2_1
X_2675_ _2442_/B input48/Z _2675_/B _2675_/C _2676_/A2 VDD VDD VSS VSS gf180mcu_fd_sc_mcu7t5v0__oai211_1
XFILLER_86_347 VDD VDD VSS VSS gf180mcu_fd_sc_mcu7t5v0__fill_1
XFILLER_86_358 VDD VDD VSS VSS gf180mcu_fd_sc_mcu7t5v0__fill_2
X_3227_ _3223_/Z _3282_/A2 _3254_/A1 VDD VDD VSS VSS gf180mcu_fd_sc_mcu7t5v0__nand2_1
XFILLER_39_274 VDD VDD VSS VSS gf180mcu_fd_sc_mcu7t5v0__fill_1
X_3158_ _3163_/A2 _3157_/Z _3158_/Z VDD VDD VSS VSS gf180mcu_fd_sc_mcu7t5v0__and2_1
X_2109_ _2096_/Z _2112_/B2 _2109_/B _2110_/A3 VDD VDD VSS VSS gf180mcu_fd_sc_mcu7t5v0__aoi21_1
XFILLER_27_436 VDD VDD VSS VSS gf180mcu_fd_sc_mcu7t5v0__fillcap_16
X_3089_ _3660_/Q _3089_/ZN VDD VDD VSS VSS gf180mcu_fd_sc_mcu7t5v0__clkinv_1
XFILLER_52_37 VDD VDD VSS VSS gf180mcu_fd_sc_mcu7t5v0__fillcap_64
XFILLER_10_314 VDD VDD VSS VSS gf180mcu_fd_sc_mcu7t5v0__fill_1
XTAP_TAPCELL_ROW_20_397 VDD VSS gf180mcu_fd_sc_mcu7t5v0__filltie
XFILLER_92_317 VDD VDD VSS VSS gf180mcu_fd_sc_mcu7t5v0__fillcap_64
XFILLER_93_66 VDD VDD VSS VSS gf180mcu_fd_sc_mcu7t5v0__fillcap_4
XTAP_TAPCELL_ROW_56_740 VDD VSS gf180mcu_fd_sc_mcu7t5v0__filltie
XFILLER_73_542 VDD VDD VSS VSS gf180mcu_fd_sc_mcu7t5v0__fillcap_4
XTAP_TAPCELL_ROW_28_475 VDD VSS gf180mcu_fd_sc_mcu7t5v0__filltie
XFILLER_45_266 VDD VDD VSS VSS gf180mcu_fd_sc_mcu7t5v0__fillcap_8
XFILLER_45_299 VDD VDD VSS VSS gf180mcu_fd_sc_mcu7t5v0__fillcap_8
XFILLER_60_247 VDD VDD VSS VSS gf180mcu_fd_sc_mcu7t5v0__fill_2
X_2460_ _2460_/A1 _2459_/Z _2460_/B _3652_/D VDD VDD VSS VSS gf180mcu_fd_sc_mcu7t5v0__aoi21_1
X_2391_ _3739_/Q _2389_/Z _2391_/B _3739_/D VDD VDD VSS VSS gf180mcu_fd_sc_mcu7t5v0__aoi21_1
XFILLER_68_358 VDD VDD VSS VSS gf180mcu_fd_sc_mcu7t5v0__fill_2
X_3012_ _3012_/I _3447_/A1 VDD VDD VSS VSS gf180mcu_fd_sc_mcu7t5v0__clkinv_1
XFILLER_76_391 VDD VDD VSS VSS gf180mcu_fd_sc_mcu7t5v0__fill_1
XFILLER_64_542 VDD VDD VSS VSS gf180mcu_fd_sc_mcu7t5v0__fill_2
XFILLER_64_597 VDD VDD VSS VSS gf180mcu_fd_sc_mcu7t5v0__fill_2
XTAP_TAPCELL_ROW_62_798 VDD VSS gf180mcu_fd_sc_mcu7t5v0__filltie
X_3776_ _3776_/D _3777_/RN clkload4/I _3776_/Q VDD VDD VSS VSS gf180mcu_fd_sc_mcu7t5v0__dffrnq_1
X_2727_ _2727_/A1 _2670_/Z _2731_/B VDD VDD VSS VSS gf180mcu_fd_sc_mcu7t5v0__xnor2_1
X_2658_ wire448/Z _2999_/ZN _2658_/B _2659_/B1 VDD VDD VSS VSS gf180mcu_fd_sc_mcu7t5v0__aoi21_1
X_2589_ wire622/Z _2590_/A2 _2556_/Z _3005_/I _2591_/B2 VDD VDD VSS VSS gf180mcu_fd_sc_mcu7t5v0__aoi22_1
XFILLER_59_369 VDD VDD VSS VSS gf180mcu_fd_sc_mcu7t5v0__fill_1
XFILLER_86_177 VDD VDD VSS VSS gf180mcu_fd_sc_mcu7t5v0__fillcap_64
XFILLER_27_244 VDD VDD VSS VSS gf180mcu_fd_sc_mcu7t5v0__fill_1
XFILLER_27_277 VDD VDD VSS VSS gf180mcu_fd_sc_mcu7t5v0__fill_2
XTAP_TAPCELL_ROW_53_710 VDD VSS gf180mcu_fd_sc_mcu7t5v0__filltie
XTAP_TAPCELL_ROW_25_445 VDD VSS gf180mcu_fd_sc_mcu7t5v0__filltie
XFILLER_42_247 VDD VDD VSS VSS gf180mcu_fd_sc_mcu7t5v0__fill_1
XFILLER_11_634 VDD VDD VSS VSS gf180mcu_fd_sc_mcu7t5v0__fill_1
Xwire514 wire514/I _2743_/B VDD VDD VSS VSS gf180mcu_fd_sc_mcu7t5v0__buf_2
XFILLER_10_177 VDD VDD VSS VSS gf180mcu_fd_sc_mcu7t5v0__fillcap_16
Xwire525 wire525/I wire525/Z VDD VDD VSS VSS gf180mcu_fd_sc_mcu7t5v0__clkbuf_2
Xwire536 _2390_/B wire536/Z VDD VDD VSS VSS gf180mcu_fd_sc_mcu7t5v0__clkbuf_2
Xload_slew519 _2443_/A2 _2397_/A1 VDD VDD VSS VSS gf180mcu_fd_sc_mcu7t5v0__buf_2
Xload_slew508 _3680_/Q _3063_/I VDD VDD VSS VSS gf180mcu_fd_sc_mcu7t5v0__buf_2
XPHY_EDGE_ROW_0_Left_97 VDD VSS gf180mcu_fd_sc_mcu7t5v0__endcap
XFILLER_2_387 VDD VDD VSS VSS gf180mcu_fd_sc_mcu7t5v0__fillcap_32
XFILLER_78_667 VDD VDD VSS VSS gf180mcu_fd_sc_mcu7t5v0__fill_2
XFILLER_93_626 VDD VDD VSS VSS gf180mcu_fd_sc_mcu7t5v0__fillcap_4
XFILLER_65_339 VDD VDD VSS VSS gf180mcu_fd_sc_mcu7t5v0__fill_2
XFILLER_18_233 VDD VDD VSS VSS gf180mcu_fd_sc_mcu7t5v0__fillcap_4
XFILLER_46_575 VDD VDD VSS VSS gf180mcu_fd_sc_mcu7t5v0__fillcap_4
XFILLER_73_361 VDD VDD VSS VSS gf180mcu_fd_sc_mcu7t5v0__fill_2
XFILLER_46_597 VDD VDD VSS VSS gf180mcu_fd_sc_mcu7t5v0__fill_2
X_1960_ _1960_/A1 _1960_/A2 _1960_/B _2000_/B2 VDD VDD VSS VSS gf180mcu_fd_sc_mcu7t5v0__oai21_1
XFILLER_14_472 VDD VDD VSS VSS gf180mcu_fd_sc_mcu7t5v0__fillcap_4
X_1891_ _1891_/A1 _1891_/A2 _1891_/ZN VDD VDD VSS VSS gf180mcu_fd_sc_mcu7t5v0__xnor2_1
X_3630_ _3630_/A1 wire281/Z _3630_/Z VDD VDD VSS VSS gf180mcu_fd_sc_mcu7t5v0__xor2_1
X_3561_ _3561_/I _3577_/A2 VDD VDD VSS VSS gf180mcu_fd_sc_mcu7t5v0__clkinv_1
X_2512_ _2512_/A1 _2512_/A2 _2512_/A3 _2521_/A1 VDD VDD VSS VSS gf180mcu_fd_sc_mcu7t5v0__nand3_1
X_3492_ wire649/Z _3492_/A2 _3492_/A3 _3493_/B VDD VDD VSS VSS gf180mcu_fd_sc_mcu7t5v0__xor3_1
X_2443_ _2442_/B _2443_/A2 _2443_/A3 _2448_/A2 VDD VDD VSS VSS gf180mcu_fd_sc_mcu7t5v0__nor3_2
XFILLER_45_2 VDD VDD VSS VSS gf180mcu_fd_sc_mcu7t5v0__fillcap_64
X_2374_ _3733_/Q _3732_/Q _3734_/Q _2380_/A3 VDD VDD VSS VSS gf180mcu_fd_sc_mcu7t5v0__nand3_1
XFILLER_69_634 VDD VDD VSS VSS gf180mcu_fd_sc_mcu7t5v0__fill_1
XFILLER_56_317 VDD VDD VSS VSS gf180mcu_fd_sc_mcu7t5v0__fill_2
XFILLER_68_177 VDD VDD VSS VSS gf180mcu_fd_sc_mcu7t5v0__fillcap_64
XFILLER_83_136 VDD VDD VSS VSS gf180mcu_fd_sc_mcu7t5v0__fillcap_4
XFILLER_37_542 VDD VDD VSS VSS gf180mcu_fd_sc_mcu7t5v0__fill_2
XTAP_TAPCELL_ROW_67_846 VDD VSS gf180mcu_fd_sc_mcu7t5v0__filltie
XFILLER_52_501 VDD VDD VSS VSS gf180mcu_fd_sc_mcu7t5v0__fillcap_4
XTAP_TAPCELL_ROW_22_415 VDD VSS gf180mcu_fd_sc_mcu7t5v0__filltie
XPHY_EDGE_ROW_18_Left_115 VDD VSS gf180mcu_fd_sc_mcu7t5v0__endcap
X_3759_ _3759_/D wire557/I clkload1/I _3759_/Q VDD VDD VSS VSS gf180mcu_fd_sc_mcu7t5v0__dffrnq_1
XTAP_TAPCELL_ROW_30_492 VDD VSS gf180mcu_fd_sc_mcu7t5v0__filltie
XFILLER_28_520 VDD VDD VSS VSS gf180mcu_fd_sc_mcu7t5v0__fillcap_4
XFILLER_47_339 VDD VDD VSS VSS gf180mcu_fd_sc_mcu7t5v0__fillcap_8
XFILLER_90_629 VDD VDD VSS VSS gf180mcu_fd_sc_mcu7t5v0__fillcap_4
XPHY_EDGE_ROW_27_Left_124 VDD VSS gf180mcu_fd_sc_mcu7t5v0__endcap
XFILLER_28_597 VDD VDD VSS VSS gf180mcu_fd_sc_mcu7t5v0__fill_2
XTAP_TAPCELL_ROW_38_570 VDD VSS gf180mcu_fd_sc_mcu7t5v0__filltie
XFILLER_90_34 VDD VDD VSS VSS gf180mcu_fd_sc_mcu7t5v0__fill_1
Xwire300 wire300/I wire300/Z VDD VDD VSS VSS gf180mcu_fd_sc_mcu7t5v0__dlyb_1
XFILLER_23_72 VDD VDD VSS VSS gf180mcu_fd_sc_mcu7t5v0__fillcap_64
Xwire366 wire366/I wire366/Z VDD VDD VSS VSS gf180mcu_fd_sc_mcu7t5v0__clkbuf_2
XPHY_EDGE_ROW_36_Left_133 VDD VSS gf180mcu_fd_sc_mcu7t5v0__endcap
Xwire388 wire388/I wire388/Z VDD VDD VSS VSS gf180mcu_fd_sc_mcu7t5v0__buf_1
Xload_slew316 _3338_/B _3289_/B VDD VDD VSS VSS gf180mcu_fd_sc_mcu7t5v0__buf_2
Xload_slew327 _2861_/B _2843_/B VDD VDD VSS VSS gf180mcu_fd_sc_mcu7t5v0__clkbuf_2
Xload_slew338 _2892_/A2 _2877_/A2 VDD VDD VSS VSS gf180mcu_fd_sc_mcu7t5v0__buf_1
Xload_slew349 _3265_/C _3271_/B VDD VDD VSS VSS gf180mcu_fd_sc_mcu7t5v0__buf_2
XFILLER_78_497 VDD VDD VSS VSS gf180mcu_fd_sc_mcu7t5v0__fillcap_4
XTAP_TAPCELL_ROW_88_1048 VDD VSS gf180mcu_fd_sc_mcu7t5v0__filltie
X_2090_ _3729_/Q _3627_/A1 _2101_/B VDD VDD VSS VSS gf180mcu_fd_sc_mcu7t5v0__nand2_1
XPHY_EDGE_ROW_45_Left_142 VDD VSS gf180mcu_fd_sc_mcu7t5v0__endcap
XFILLER_65_136 VDD VDD VSS VSS gf180mcu_fd_sc_mcu7t5v0__fillcap_4
XTAP_TAPCELL_ROW_64_816 VDD VSS gf180mcu_fd_sc_mcu7t5v0__filltie
XFILLER_65_158 VDD VDD VSS VSS gf180mcu_fd_sc_mcu7t5v0__fill_2
XFILLER_46_383 VDD VDD VSS VSS gf180mcu_fd_sc_mcu7t5v0__fill_2
X_2992_ _2992_/I _3135_/A1 VDD VDD VSS VSS gf180mcu_fd_sc_mcu7t5v0__clkinv_1
XFILLER_21_206 VDD VDD VSS VSS gf180mcu_fd_sc_mcu7t5v0__fillcap_4
XFILLER_21_228 VDD VDD VSS VSS gf180mcu_fd_sc_mcu7t5v0__fillcap_8
XTAP_TAPCELL_ROW_72_893 VDD VSS gf180mcu_fd_sc_mcu7t5v0__filltie
X_1943_ _1941_/Z _1943_/A2 _1943_/ZN VDD VDD VSS VSS gf180mcu_fd_sc_mcu7t5v0__xnor2_2
XPHY_EDGE_ROW_54_Left_151 VDD VSS gf180mcu_fd_sc_mcu7t5v0__endcap
X_1874_ _1888_/B1 _1871_/Z _1874_/A3 _1874_/Z VDD VDD VSS VSS gf180mcu_fd_sc_mcu7t5v0__xor3_1
X_3613_ _3629_/A1 _3629_/A3 _3613_/Z VDD VDD VSS VSS gf180mcu_fd_sc_mcu7t5v0__or2_1
X_3544_ _3509_/Z _3546_/C _3528_/Z _3545_/C VDD VDD VSS VSS gf180mcu_fd_sc_mcu7t5v0__nand3_1
X_3475_ _3055_/I _3472_/Z _3475_/Z VDD VDD VSS VSS gf180mcu_fd_sc_mcu7t5v0__xor2_1
X_2426_ _2979_/ZN wire361/Z _2425_/Z wire366/Z _3752_/D VDD VDD VSS VSS gf180mcu_fd_sc_mcu7t5v0__oai22_1
XFILLER_69_431 VDD VDD VSS VSS gf180mcu_fd_sc_mcu7t5v0__fillcap_8
XFILLER_96_250 VDD VDD VSS VSS gf180mcu_fd_sc_mcu7t5v0__fill_1
X_2357_ _2357_/I _2358_/C VDD VDD VSS VSS gf180mcu_fd_sc_mcu7t5v0__clkinv_1
XPHY_EDGE_ROW_63_Left_160 VDD VSS gf180mcu_fd_sc_mcu7t5v0__endcap
X_2288_ wire429/Z _2288_/A2 _2937_/A1 VDD VDD VSS VSS gf180mcu_fd_sc_mcu7t5v0__nand2_1
XFILLER_84_489 VDD VDD VSS VSS gf180mcu_fd_sc_mcu7t5v0__fill_1
XFILLER_56_169 VDD VDD VSS VSS gf180mcu_fd_sc_mcu7t5v0__fillcap_4
XFILLER_25_523 VDD VDD VSS VSS gf180mcu_fd_sc_mcu7t5v0__fill_2
XFILLER_25_567 VDD VDD VSS VSS gf180mcu_fd_sc_mcu7t5v0__fill_2
XTAP_TAPCELL_ROW_35_540 VDD VSS gf180mcu_fd_sc_mcu7t5v0__filltie
XFILLER_60_37 VDD VDD VSS VSS gf180mcu_fd_sc_mcu7t5v0__fillcap_64
XFILLER_20_261 VDD VDD VSS VSS gf180mcu_fd_sc_mcu7t5v0__fill_2
XFILLER_4_427 VDD VDD VSS VSS gf180mcu_fd_sc_mcu7t5v0__fillcap_4
XFILLER_79_206 VDD VDD VSS VSS gf180mcu_fd_sc_mcu7t5v0__fillcap_4
XTAP_TAPCELL_ROW_7_276 VDD VSS gf180mcu_fd_sc_mcu7t5v0__filltie
XFILLER_75_445 VDD VDD VSS VSS gf180mcu_fd_sc_mcu7t5v0__fillcap_16
XFILLER_47_136 VDD VDD VSS VSS gf180mcu_fd_sc_mcu7t5v0__fillcap_4
XFILLER_75_478 VDD VDD VSS VSS gf180mcu_fd_sc_mcu7t5v0__fillcap_4
XFILLER_47_158 VDD VDD VSS VSS gf180mcu_fd_sc_mcu7t5v0__fill_2
XFILLER_43_331 VDD VDD VSS VSS gf180mcu_fd_sc_mcu7t5v0__fillcap_16
XTAP_TAPCELL_ROW_41_598 VDD VSS gf180mcu_fd_sc_mcu7t5v0__filltie
XTAP_TAPCELL_ROW_94_1096 VDD VSS gf180mcu_fd_sc_mcu7t5v0__filltie
X_3260_ wire439/Z _3260_/A2 _3269_/A2 VDD VDD VSS VSS gf180mcu_fd_sc_mcu7t5v0__xnor2_1
X_2211_ _2940_/A1 _2211_/A2 _2211_/B _2211_/C _2212_/I VDD VDD VSS VSS gf180mcu_fd_sc_mcu7t5v0__oai211_1
XFILLER_66_401 VDD VDD VSS VSS gf180mcu_fd_sc_mcu7t5v0__fillcap_16
X_3191_ _3185_/Z _3188_/Z _3194_/A3 VDD VDD VSS VSS gf180mcu_fd_sc_mcu7t5v0__nor2_1
XTAP_TAPCELL_ROW_77_941 VDD VSS gf180mcu_fd_sc_mcu7t5v0__filltie
X_2142_ _2195_/B _2195_/A1 _2195_/A2 _2145_/B VDD VDD VSS VSS gf180mcu_fd_sc_mcu7t5v0__nand3_1
X_2073_ _2073_/A1 _2073_/A2 _2073_/B _2099_/A1 VDD VDD VSS VSS gf180mcu_fd_sc_mcu7t5v0__aoi21_2
XFILLER_81_404 VDD VDD VSS VSS gf180mcu_fd_sc_mcu7t5v0__fillcap_16
XTAP_TAPCELL_ROW_49_676 VDD VSS gf180mcu_fd_sc_mcu7t5v0__filltie
XFILLER_54_618 VDD VDD VSS VSS gf180mcu_fd_sc_mcu7t5v0__fill_1
XFILLER_53_128 VDD VDD VSS VSS gf180mcu_fd_sc_mcu7t5v0__fillcap_4
XFILLER_22_504 VDD VDD VSS VSS gf180mcu_fd_sc_mcu7t5v0__fillcap_4
XFILLER_61_161 VDD VDD VSS VSS gf180mcu_fd_sc_mcu7t5v0__fillcap_16
XTAP_TAPCELL_ROW_32_510 VDD VSS gf180mcu_fd_sc_mcu7t5v0__filltie
XFILLER_61_183 VDD VDD VSS VSS gf180mcu_fd_sc_mcu7t5v0__fill_1
X_2975_ _2975_/I _3124_/A1 VDD VDD VSS VSS gf180mcu_fd_sc_mcu7t5v0__clkinv_1
X_1926_ _3179_/A2 _3483_/A1 _1934_/B VDD VDD VSS VSS gf180mcu_fd_sc_mcu7t5v0__xor2_1
X_1857_ _1857_/A1 _1824_/Z _1841_/Z _1857_/B1 _1829_/I _1857_/B3 wire300/I VDD VDD
+ VSS VSS gf180mcu_fd_sc_mcu7t5v0__oai33_4
X_3527_ _3528_/A1 _3505_/Z _3527_/B _3546_/C VDD VDD VSS VSS gf180mcu_fd_sc_mcu7t5v0__oai21_1
X_3458_ _3011_/I _3450_/Z _3518_/A1 _3458_/Z VDD VDD VSS VSS gf180mcu_fd_sc_mcu7t5v0__xor3_1
X_2409_ wire468/Z wire544/Z _2955_/A2 VDD VDD VSS VSS gf180mcu_fd_sc_mcu7t5v0__nand2_1
X_3389_ _3389_/I _3419_/B2 VDD VDD VSS VSS gf180mcu_fd_sc_mcu7t5v0__clkinv_1
XFILLER_57_412 VDD VDD VSS VSS gf180mcu_fd_sc_mcu7t5v0__fill_1
XTAP_TAPCELL_ROW_4_246 VDD VSS gf180mcu_fd_sc_mcu7t5v0__filltie
XFILLER_29_136 VDD VDD VSS VSS gf180mcu_fd_sc_mcu7t5v0__fillcap_4
XFILLER_29_158 VDD VDD VSS VSS gf180mcu_fd_sc_mcu7t5v0__fillcap_4
XFILLER_72_404 VDD VDD VSS VSS gf180mcu_fd_sc_mcu7t5v0__fill_1
XFILLER_57_489 VDD VDD VSS VSS gf180mcu_fd_sc_mcu7t5v0__fill_1
XTAP_TAPCELL_ROW_83_999 VDD VSS gf180mcu_fd_sc_mcu7t5v0__filltie
XFILLER_13_526 VDD VDD VSS VSS gf180mcu_fd_sc_mcu7t5v0__fill_2
XFILLER_52_172 VDD VDD VSS VSS gf180mcu_fd_sc_mcu7t5v0__fill_2
XFILLER_0_441 VDD VDD VSS VSS gf180mcu_fd_sc_mcu7t5v0__fill_1
XFILLER_88_581 VDD VDD VSS VSS gf180mcu_fd_sc_mcu7t5v0__fill_2
XTAP_TAPCELL_ROW_85_1018 VDD VSS gf180mcu_fd_sc_mcu7t5v0__filltie
XFILLER_35_128 VDD VDD VSS VSS gf180mcu_fd_sc_mcu7t5v0__fill_1
XFILLER_63_415 VDD VDD VSS VSS gf180mcu_fd_sc_mcu7t5v0__fillcap_4
XTAP_TAPCELL_ROW_74_911 VDD VSS gf180mcu_fd_sc_mcu7t5v0__filltie
XFILLER_16_342 VDD VDD VSS VSS gf180mcu_fd_sc_mcu7t5v0__fill_2
XFILLER_35_139 VDD VDD VSS VSS gf180mcu_fd_sc_mcu7t5v0__fill_1
XTAP_TAPCELL_ROW_46_646 VDD VSS gf180mcu_fd_sc_mcu7t5v0__filltie
XFILLER_43_194 VDD VDD VSS VSS gf180mcu_fd_sc_mcu7t5v0__fill_1
XFILLER_71_492 VDD VDD VSS VSS gf180mcu_fd_sc_mcu7t5v0__fillcap_4
XFILLER_31_345 VDD VDD VSS VSS gf180mcu_fd_sc_mcu7t5v0__fillcap_4
X_2760_ _3090_/ZN _2765_/A2 _2765_/C VDD VDD VSS VSS gf180mcu_fd_sc_mcu7t5v0__nor2_1
Xclkbuf_4_14_0_clk clkbuf_0_clk/Z _3694_/CLK VDD VDD VSS VSS gf180mcu_fd_sc_mcu7t5v0__clkbuf_8
XTAP_TAPCELL_ROW_96_1125 VDD VSS gf180mcu_fd_sc_mcu7t5v0__filltie
XFILLER_8_541 VDD VDD VSS VSS gf180mcu_fd_sc_mcu7t5v0__fill_2
X_2691_ _2655_/B _2692_/A3 _2691_/B _2720_/B VDD VDD VSS VSS gf180mcu_fd_sc_mcu7t5v0__oai21_1
X_3312_ _3318_/A2 _3312_/A2 _3314_/A2 VDD VDD VSS VSS gf180mcu_fd_sc_mcu7t5v0__xnor2_1
XFILLER_86_518 VDD VDD VSS VSS gf180mcu_fd_sc_mcu7t5v0__fillcap_4
X_3243_ _3243_/I _3243_/ZN VDD VDD VSS VSS gf180mcu_fd_sc_mcu7t5v0__clkinv_1
XFILLER_79_581 VDD VDD VSS VSS gf180mcu_fd_sc_mcu7t5v0__fill_1
XFILLER_39_412 VDD VDD VSS VSS gf180mcu_fd_sc_mcu7t5v0__fillcap_8
XTAP_TAPCELL_ROW_1_216 VDD VSS gf180mcu_fd_sc_mcu7t5v0__filltie
XFILLER_27_618 VDD VDD VSS VSS gf180mcu_fd_sc_mcu7t5v0__fillcap_4
X_3174_ wire647/Z wire483/Z _3175_/I VDD VDD VSS VSS gf180mcu_fd_sc_mcu7t5v0__xor2_1
XFILLER_81_212 VDD VDD VSS VSS gf180mcu_fd_sc_mcu7t5v0__fillcap_64
X_2125_ _3097_/ZN _2123_/Z _2125_/ZN VDD VDD VSS VSS gf180mcu_fd_sc_mcu7t5v0__nor2_1
X_2056_ _2052_/Z _2056_/A2 _2056_/Z VDD VDD VSS VSS gf180mcu_fd_sc_mcu7t5v0__xor2_1
XFILLER_22_301 VDD VDD VSS VSS gf180mcu_fd_sc_mcu7t5v0__fillcap_4
XTAP_TAPCELL_ROW_80_969 VDD VSS gf180mcu_fd_sc_mcu7t5v0__filltie
XTAP_TAPCELL_ROW_17_370 VDD VSS gf180mcu_fd_sc_mcu7t5v0__filltie
XFILLER_34_172 VDD VDD VSS VSS gf180mcu_fd_sc_mcu7t5v0__fill_2
X_2958_ _3717_/Q _2959_/A1 _2959_/B VDD VDD VSS VSS gf180mcu_fd_sc_mcu7t5v0__nand2_1
X_1909_ _1909_/A1 _1907_/I _1910_/B VDD VDD VSS VSS gf180mcu_fd_sc_mcu7t5v0__xor2_1
X_2889_ _3631_/A1 _2895_/A2 _2889_/B1 _2889_/B2 _3686_/D VDD VDD VSS VSS gf180mcu_fd_sc_mcu7t5v0__oai22_1
XFILLER_89_378 VDD VDD VSS VSS gf180mcu_fd_sc_mcu7t5v0__fill_1
XFILLER_85_562 VDD VDD VSS VSS gf180mcu_fd_sc_mcu7t5v0__fillcap_16
XFILLER_57_242 VDD VDD VSS VSS gf180mcu_fd_sc_mcu7t5v0__fill_1
XTAP_TAPCELL_ROW_43_616 VDD VSS gf180mcu_fd_sc_mcu7t5v0__filltie
XFILLER_41_632 VDD VDD VSS VSS gf180mcu_fd_sc_mcu7t5v0__fill_2
XFILLER_53_470 VDD VDD VSS VSS gf180mcu_fd_sc_mcu7t5v0__fill_2
XFILLER_13_345 VDD VDD VSS VSS gf180mcu_fd_sc_mcu7t5v0__fillcap_4
XFILLER_9_349 VDD VDD VSS VSS gf180mcu_fd_sc_mcu7t5v0__fill_1
XTAP_TAPCELL_ROW_51_693 VDD VSS gf180mcu_fd_sc_mcu7t5v0__filltie
XFILLER_31_72 VDD VDD VSS VSS gf180mcu_fd_sc_mcu7t5v0__fillcap_32
Xoutput94 _3199_/Z cal_phase0_offset[14] VDD VDD VSS VSS gf180mcu_fd_sc_mcu7t5v0__buf_2
XFILLER_0_271 VDD VDD VSS VSS gf180mcu_fd_sc_mcu7t5v0__fill_1
XFILLER_0_260 VDD VDD VSS VSS gf180mcu_fd_sc_mcu7t5v0__fill_1
XTAP_TAPCELL_ROW_59_771 VDD VSS gf180mcu_fd_sc_mcu7t5v0__filltie
XFILLER_63_212 VDD VDD VSS VSS gf180mcu_fd_sc_mcu7t5v0__fillcap_4
XFILLER_51_418 VDD VDD VSS VSS gf180mcu_fd_sc_mcu7t5v0__fill_2
XFILLER_63_256 VDD VDD VSS VSS gf180mcu_fd_sc_mcu7t5v0__fill_1
XTAP_TAPCELL_ROW_14_340 VDD VSS gf180mcu_fd_sc_mcu7t5v0__filltie
XFILLER_31_120 VDD VDD VSS VSS gf180mcu_fd_sc_mcu7t5v0__fill_2
XFILLER_31_142 VDD VDD VSS VSS gf180mcu_fd_sc_mcu7t5v0__fillcap_4
X_2812_ _3095_/ZN _2822_/A2 _2812_/B _2816_/A2 VDD VDD VSS VSS gf180mcu_fd_sc_mcu7t5v0__oai21_1
XFILLER_75_2 VDD VDD VSS VSS gf180mcu_fd_sc_mcu7t5v0__fillcap_64
X_2743_ _3087_/ZN _2743_/A2 _2743_/B _3658_/D VDD VDD VSS VSS gf180mcu_fd_sc_mcu7t5v0__aoi21_1
X_2674_ _2674_/A1 _2674_/A2 _2674_/A3 _2733_/A1 VDD VDD VSS VSS gf180mcu_fd_sc_mcu7t5v0__nand3_1
X_3226_ wire439/Z _3226_/A2 _3282_/A2 VDD VDD VSS VSS gf180mcu_fd_sc_mcu7t5v0__xnor2_2
XFILLER_67_540 VDD VDD VSS VSS gf180mcu_fd_sc_mcu7t5v0__fillcap_16
X_3157_ _3157_/A1 _3157_/A2 _3156_/B _3157_/Z VDD VDD VSS VSS gf180mcu_fd_sc_mcu7t5v0__or3_1
XFILLER_94_381 VDD VDD VSS VSS gf180mcu_fd_sc_mcu7t5v0__fillcap_4
X_2108_ _2093_/Z _2105_/Z _2108_/Z VDD VDD VSS VSS gf180mcu_fd_sc_mcu7t5v0__or2_1
X_3088_ _3088_/I _3088_/ZN VDD VDD VSS VSS gf180mcu_fd_sc_mcu7t5v0__inv_2
X_2039_ _2023_/B _2039_/A2 _2039_/B _2071_/A2 VDD VDD VSS VSS gf180mcu_fd_sc_mcu7t5v0__aoi21_1
XFILLER_35_481 VDD VDD VSS VSS gf180mcu_fd_sc_mcu7t5v0__fill_1
XTAP_TAPCELL_ROW_20_398 VDD VSS gf180mcu_fd_sc_mcu7t5v0__filltie
XFILLER_89_142 VDD VDD VSS VSS gf180mcu_fd_sc_mcu7t5v0__fillcap_64
XFILLER_58_573 VDD VDD VSS VSS gf180mcu_fd_sc_mcu7t5v0__fillcap_8
XFILLER_45_212 VDD VDD VSS VSS gf180mcu_fd_sc_mcu7t5v0__fill_2
XTAP_TAPCELL_ROW_56_741 VDD VSS gf180mcu_fd_sc_mcu7t5v0__filltie
XFILLER_33_418 VDD VDD VSS VSS gf180mcu_fd_sc_mcu7t5v0__fill_2
XFILLER_14_632 VDD VDD VSS VSS gf180mcu_fd_sc_mcu7t5v0__fill_1
XTAP_TAPCELL_ROW_28_476 VDD VSS gf180mcu_fd_sc_mcu7t5v0__filltie
XFILLER_13_142 VDD VDD VSS VSS gf180mcu_fd_sc_mcu7t5v0__fillcap_64
XTAP_TAPCELL_ROW_11_310 VDD VSS gf180mcu_fd_sc_mcu7t5v0__filltie
XFILLER_5_352 VDD VDD VSS VSS gf180mcu_fd_sc_mcu7t5v0__fillcap_4
XFILLER_96_602 VDD VDD VSS VSS gf180mcu_fd_sc_mcu7t5v0__fill_1
X_2390_ _3739_/Q _2389_/Z _2390_/B _2391_/B VDD VDD VSS VSS gf180mcu_fd_sc_mcu7t5v0__oai21_1
XFILLER_68_348 VDD VDD VSS VSS gf180mcu_fd_sc_mcu7t5v0__fill_2
X_3011_ _3011_/I _3170_/A1 VDD VDD VSS VSS gf180mcu_fd_sc_mcu7t5v0__inv_2
XFILLER_49_562 VDD VDD VSS VSS gf180mcu_fd_sc_mcu7t5v0__fillcap_4
XTAP_TAPCELL_ROW_62_799 VDD VSS gf180mcu_fd_sc_mcu7t5v0__filltie
X_3775_ _3775_/D _3775_/RN clkload4/I _3775_/Q VDD VDD VSS VSS gf180mcu_fd_sc_mcu7t5v0__dffrnq_1
X_2726_ _2726_/A1 _2726_/A2 _2732_/B VDD VDD VSS VSS gf180mcu_fd_sc_mcu7t5v0__xor2_1
X_2657_ _2647_/Z _2651_/I _2657_/B _2657_/C _2661_/A1 VDD VDD VSS VSS gf180mcu_fd_sc_mcu7t5v0__oai211_1
X_2588_ _2588_/A1 _2556_/Z _2588_/B1 _3006_/I _2588_/C _2591_/B1 VDD VDD VSS VSS gf180mcu_fd_sc_mcu7t5v0__oai221_1
XFILLER_86_101 VDD VDD VSS VSS gf180mcu_fd_sc_mcu7t5v0__fillcap_4
X_3209_ wire528/Z _3210_/A2 _3213_/B VDD VDD VSS VSS gf180mcu_fd_sc_mcu7t5v0__nand2_1
XFILLER_15_418 VDD VDD VSS VSS gf180mcu_fd_sc_mcu7t5v0__fill_2
XFILLER_82_395 VDD VDD VSS VSS gf180mcu_fd_sc_mcu7t5v0__fill_2
XTAP_TAPCELL_ROW_53_711 VDD VSS gf180mcu_fd_sc_mcu7t5v0__filltie
XFILLER_55_598 VDD VDD VSS VSS gf180mcu_fd_sc_mcu7t5v0__fill_2
XFILLER_70_535 VDD VDD VSS VSS gf180mcu_fd_sc_mcu7t5v0__fill_2
XTAP_TAPCELL_ROW_25_446 VDD VSS gf180mcu_fd_sc_mcu7t5v0__filltie
XFILLER_70_557 VDD VDD VSS VSS gf180mcu_fd_sc_mcu7t5v0__fill_1
XFILLER_10_101 VDD VDD VSS VSS gf180mcu_fd_sc_mcu7t5v0__fillcap_4
XFILLER_23_462 VDD VDD VSS VSS gf180mcu_fd_sc_mcu7t5v0__fill_1
XFILLER_23_484 VDD VDD VSS VSS gf180mcu_fd_sc_mcu7t5v0__fillcap_4
Xwire515 wire515/I wire515/Z VDD VDD VSS VSS gf180mcu_fd_sc_mcu7t5v0__buf_2
Xwire548 wire549/Z wire548/Z VDD VDD VSS VSS gf180mcu_fd_sc_mcu7t5v0__buf_2
Xwire559 wire559/I wire559/Z VDD VDD VSS VSS gf180mcu_fd_sc_mcu7t5v0__clkbuf_2
XFILLER_88_34 VDD VDD VSS VSS gf180mcu_fd_sc_mcu7t5v0__fill_1
XFILLER_5_2 VDD VDD VSS VSS gf180mcu_fd_sc_mcu7t5v0__fillcap_64
Xload_slew509 _3676_/Q _3055_/I VDD VDD VSS VSS gf180mcu_fd_sc_mcu7t5v0__buf_2
XFILLER_58_381 VDD VDD VSS VSS gf180mcu_fd_sc_mcu7t5v0__fillcap_4
XPHY_EDGE_ROW_16_Right_16 VDD VSS gf180mcu_fd_sc_mcu7t5v0__endcap
XFILLER_33_204 VDD VDD VSS VSS gf180mcu_fd_sc_mcu7t5v0__fill_1
XFILLER_73_384 VDD VDD VSS VSS gf180mcu_fd_sc_mcu7t5v0__fill_2
XFILLER_33_259 VDD VDD VSS VSS gf180mcu_fd_sc_mcu7t5v0__fillcap_16
X_1890_ _1890_/A1 _1891_/A1 _1890_/A3 _1911_/A2 VDD VDD VSS VSS gf180mcu_fd_sc_mcu7t5v0__nand3_1
XPHY_EDGE_ROW_25_Right_25 VDD VSS gf180mcu_fd_sc_mcu7t5v0__endcap
X_3560_ _3560_/A1 _3537_/Z _3559_/B _3561_/I VDD VDD VSS VSS gf180mcu_fd_sc_mcu7t5v0__or3_1
X_2511_ _2512_/A1 _2512_/A2 _2512_/A3 _2511_/Z VDD VDD VSS VSS gf180mcu_fd_sc_mcu7t5v0__and3_1
XFILLER_6_650 VDD VDD VSS VSS gf180mcu_fd_sc_mcu7t5v0__fill_2
X_3491_ _3491_/A1 _3492_/A2 _3492_/A3 _3494_/B VDD VDD VSS VSS gf180mcu_fd_sc_mcu7t5v0__xor3_1
X_2442_ _2443_/A2 _2443_/A3 _2442_/B _2445_/A2 VDD VDD VSS VSS gf180mcu_fd_sc_mcu7t5v0__oai21_1
XFILLER_96_410 VDD VDD VSS VSS gf180mcu_fd_sc_mcu7t5v0__fillcap_16
X_2373_ _3084_/ZN _2373_/A2 _2381_/A3 VDD VDD VSS VSS gf180mcu_fd_sc_mcu7t5v0__nor2_1
XFILLER_38_2 VDD VDD VSS VSS gf180mcu_fd_sc_mcu7t5v0__fillcap_32
XFILLER_68_101 VDD VDD VSS VSS gf180mcu_fd_sc_mcu7t5v0__fillcap_4
XPHY_EDGE_ROW_34_Right_34 VDD VSS gf180mcu_fd_sc_mcu7t5v0__endcap
XFILLER_49_370 VDD VDD VSS VSS gf180mcu_fd_sc_mcu7t5v0__fillcap_8
XTAP_TAPCELL_ROW_67_847 VDD VSS gf180mcu_fd_sc_mcu7t5v0__filltie
XFILLER_52_524 VDD VDD VSS VSS gf180mcu_fd_sc_mcu7t5v0__fill_1
XFILLER_52_535 VDD VDD VSS VSS gf180mcu_fd_sc_mcu7t5v0__fillcap_4
XFILLER_64_384 VDD VDD VSS VSS gf180mcu_fd_sc_mcu7t5v0__fill_1
XTAP_TAPCELL_ROW_22_416 VDD VSS gf180mcu_fd_sc_mcu7t5v0__filltie
XFILLER_20_432 VDD VDD VSS VSS gf180mcu_fd_sc_mcu7t5v0__fill_2
XFILLER_32_281 VDD VDD VSS VSS gf180mcu_fd_sc_mcu7t5v0__fill_2
XPHY_EDGE_ROW_43_Right_43 VDD VSS gf180mcu_fd_sc_mcu7t5v0__endcap
X_3758_ _3758_/D wire557/Z clkload8/I _3758_/Q VDD VDD VSS VSS gf180mcu_fd_sc_mcu7t5v0__dffrnq_1
X_2709_ wire656/I _2705_/Z _2709_/B1 _2709_/B2 _2709_/C _2711_/B VDD VDD VSS VSS gf180mcu_fd_sc_mcu7t5v0__oai221_1
XTAP_TAPCELL_ROW_30_493 VDD VSS gf180mcu_fd_sc_mcu7t5v0__filltie
X_3689_ _3689_/D _3690_/RN _3694_/CLK _3689_/Q VDD VDD VSS VSS gf180mcu_fd_sc_mcu7t5v0__dffrnq_2
XFILLER_87_410 VDD VDD VSS VSS gf180mcu_fd_sc_mcu7t5v0__fillcap_8
XFILLER_58_37 VDD VDD VSS VSS gf180mcu_fd_sc_mcu7t5v0__fillcap_64
XFILLER_87_476 VDD VDD VSS VSS gf180mcu_fd_sc_mcu7t5v0__fill_1
XPHY_EDGE_ROW_52_Right_52 VDD VSS gf180mcu_fd_sc_mcu7t5v0__endcap
XFILLER_28_510 VDD VDD VSS VSS gf180mcu_fd_sc_mcu7t5v0__fillcap_4
XTAP_TAPCELL_ROW_38_571 VDD VSS gf180mcu_fd_sc_mcu7t5v0__filltie
XFILLER_43_568 VDD VDD VSS VSS gf180mcu_fd_sc_mcu7t5v0__fill_2
XFILLER_70_387 VDD VDD VSS VSS gf180mcu_fd_sc_mcu7t5v0__fillcap_4
XPHY_EDGE_ROW_61_Right_61 VDD VSS gf180mcu_fd_sc_mcu7t5v0__endcap
Xwire312 _2267_/C wire312/Z VDD VDD VSS VSS gf180mcu_fd_sc_mcu7t5v0__clkbuf_2
XFILLER_11_498 VDD VDD VSS VSS gf180mcu_fd_sc_mcu7t5v0__fillcap_16
Xwire334 wire334/I wire334/Z VDD VDD VSS VSS gf180mcu_fd_sc_mcu7t5v0__buf_1
XFILLER_3_664 VDD VDD VSS VSS gf180mcu_fd_sc_mcu7t5v0__fillcap_8
Xload_slew317 _3282_/B _3309_/A2 VDD VDD VSS VSS gf180mcu_fd_sc_mcu7t5v0__buf_2
Xload_slew328 _2867_/B _2861_/B VDD VDD VSS VSS gf180mcu_fd_sc_mcu7t5v0__buf_1
XPHY_EDGE_ROW_70_Right_70 VDD VSS gf180mcu_fd_sc_mcu7t5v0__endcap
XFILLER_78_454 VDD VDD VSS VSS gf180mcu_fd_sc_mcu7t5v0__fill_1
Xload_slew339 _2895_/A2 _2892_/A2 VDD VDD VSS VSS gf180mcu_fd_sc_mcu7t5v0__clkbuf_2
XFILLER_19_543 VDD VDD VSS VSS gf180mcu_fd_sc_mcu7t5v0__fill_2
XTAP_TAPCELL_ROW_64_817 VDD VSS gf180mcu_fd_sc_mcu7t5v0__filltie
XFILLER_80_107 VDD VDD VSS VSS gf180mcu_fd_sc_mcu7t5v0__fillcap_64
XFILLER_34_535 VDD VDD VSS VSS gf180mcu_fd_sc_mcu7t5v0__fillcap_4
X_2991_ _3741_/Q _3100_/C VDD VDD VSS VSS gf180mcu_fd_sc_mcu7t5v0__clkinv_1
XFILLER_61_376 VDD VDD VSS VSS gf180mcu_fd_sc_mcu7t5v0__fill_2
X_1942_ _1942_/A1 _1959_/A1 _1942_/B _1943_/A2 VDD VDD VSS VSS gf180mcu_fd_sc_mcu7t5v0__oai21_1
XTAP_TAPCELL_ROW_72_894 VDD VSS gf180mcu_fd_sc_mcu7t5v0__filltie
X_1873_ _1888_/A1 wire294/Z _1888_/C _1874_/A3 VDD VDD VSS VSS gf180mcu_fd_sc_mcu7t5v0__oai21_1
X_3612_ _3612_/A1 _3612_/A2 _3612_/B1 _3612_/B2 _3612_/C _3629_/A3 VDD VDD VSS VSS
+ gf180mcu_fd_sc_mcu7t5v0__aoi221_4
X_3543_ _3530_/B _3528_/Z _3546_/B VDD VDD VSS VSS gf180mcu_fd_sc_mcu7t5v0__nand2_1
X_3474_ _3055_/I _3472_/Z _3493_/A2 VDD VDD VSS VSS gf180mcu_fd_sc_mcu7t5v0__nand2_1
X_2425_ _2979_/I _2588_/A1 _2425_/A3 _2425_/Z VDD VDD VSS VSS gf180mcu_fd_sc_mcu7t5v0__xor3_1
XFILLER_96_240 VDD VDD VSS VSS gf180mcu_fd_sc_mcu7t5v0__fillcap_8
X_2356_ _2468_/A1 wire525/I _3003_/I _2356_/C _2357_/I VDD VDD VSS VSS gf180mcu_fd_sc_mcu7t5v0__oai211_1
X_2287_ _3727_/Q wire255/Z _2289_/B VDD VDD VSS VSS gf180mcu_fd_sc_mcu7t5v0__nand2_1
XFILLER_84_457 VDD VDD VSS VSS gf180mcu_fd_sc_mcu7t5v0__fillcap_8
XTAP_TAPCELL_ROW_35_541 VDD VSS gf180mcu_fd_sc_mcu7t5v0__filltie
XFILLER_40_527 VDD VDD VSS VSS gf180mcu_fd_sc_mcu7t5v0__fill_1
XFILLER_20_295 VDD VDD VSS VSS gf180mcu_fd_sc_mcu7t5v0__fill_1
XFILLER_4_439 VDD VDD VSS VSS gf180mcu_fd_sc_mcu7t5v0__fillcap_16
XTAP_TAPCELL_ROW_7_277 VDD VSS gf180mcu_fd_sc_mcu7t5v0__filltie
XFILLER_63_619 VDD VDD VSS VSS gf180mcu_fd_sc_mcu7t5v0__fill_1
XFILLER_16_524 VDD VDD VSS VSS gf180mcu_fd_sc_mcu7t5v0__fill_1
XFILLER_28_373 VDD VDD VSS VSS gf180mcu_fd_sc_mcu7t5v0__fillcap_4
XFILLER_62_107 VDD VDD VSS VSS gf180mcu_fd_sc_mcu7t5v0__fillcap_16
XFILLER_31_505 VDD VDD VSS VSS gf180mcu_fd_sc_mcu7t5v0__fillcap_4
XFILLER_43_398 VDD VDD VSS VSS gf180mcu_fd_sc_mcu7t5v0__fill_2
XTAP_TAPCELL_ROW_41_599 VDD VSS gf180mcu_fd_sc_mcu7t5v0__filltie
XFILLER_7_277 VDD VDD VSS VSS gf180mcu_fd_sc_mcu7t5v0__fill_2
XTAP_TAPCELL_ROW_94_1097 VDD VSS gf180mcu_fd_sc_mcu7t5v0__filltie
X_2210_ _2210_/A1 _2210_/A2 _2210_/B _2260_/A1 VDD VDD VSS VSS gf180mcu_fd_sc_mcu7t5v0__oai21_1
XFILLER_39_605 VDD VDD VSS VSS gf180mcu_fd_sc_mcu7t5v0__fill_1
X_3190_ _3188_/Z _3190_/A2 _3190_/ZN VDD VDD VSS VSS gf180mcu_fd_sc_mcu7t5v0__nor2_1
XTAP_TAPCELL_ROW_77_942 VDD VSS gf180mcu_fd_sc_mcu7t5v0__filltie
XFILLER_78_295 VDD VDD VSS VSS gf180mcu_fd_sc_mcu7t5v0__fillcap_4
X_2141_ _3704_/Q _3088_/ZN _2195_/A2 VDD VDD VSS VSS gf180mcu_fd_sc_mcu7t5v0__nand2_1
X_2072_ _2072_/A1 _2072_/A2 _2071_/Z _2073_/B VDD VDD VSS VSS gf180mcu_fd_sc_mcu7t5v0__nand3_1
XFILLER_38_148 VDD VDD VSS VSS gf180mcu_fd_sc_mcu7t5v0__fillcap_4
XFILLER_66_457 VDD VDD VSS VSS gf180mcu_fd_sc_mcu7t5v0__fillcap_16
XFILLER_93_276 VDD VDD VSS VSS gf180mcu_fd_sc_mcu7t5v0__fillcap_4
XTAP_TAPCELL_ROW_49_677 VDD VSS gf180mcu_fd_sc_mcu7t5v0__filltie
XFILLER_34_376 VDD VDD VSS VSS gf180mcu_fd_sc_mcu7t5v0__fillcap_8
XTAP_TAPCELL_ROW_32_511 VDD VSS gf180mcu_fd_sc_mcu7t5v0__filltie
XFILLER_34_387 VDD VDD VSS VSS gf180mcu_fd_sc_mcu7t5v0__fillcap_8
X_2974_ _2974_/I _3118_/A2 VDD VDD VSS VSS gf180mcu_fd_sc_mcu7t5v0__inv_2
X_1925_ _3179_/A2 _3483_/A1 _1967_/A1 VDD VDD VSS VSS gf180mcu_fd_sc_mcu7t5v0__nand2_1
X_1856_ _1853_/Z _1856_/A2 _1888_/A1 VDD VDD VSS VSS gf180mcu_fd_sc_mcu7t5v0__xnor2_2
X_3526_ _3526_/A1 _3539_/A1 _3523_/Z _3527_/B VDD VDD VSS VSS gf180mcu_fd_sc_mcu7t5v0__xor3_1
XFILLER_89_516 VDD VDD VSS VSS gf180mcu_fd_sc_mcu7t5v0__fill_1
X_3457_ _3450_/Z _3518_/A1 _3457_/Z VDD VDD VSS VSS gf180mcu_fd_sc_mcu7t5v0__xor2_1
X_2408_ wire368/Z _2328_/Z _2408_/A3 _2415_/A2 _3106_/B1 _3745_/D VDD VDD VSS VSS
+ gf180mcu_fd_sc_mcu7t5v0__oai32_1
X_3388_ _3388_/A1 _3670_/Q _3419_/A1 _3671_/Q _3389_/I VDD VDD VSS VSS gf180mcu_fd_sc_mcu7t5v0__oai22_2
X_2339_ wire459/Z _3007_/I _2339_/B _2421_/A3 VDD VDD VSS VSS gf180mcu_fd_sc_mcu7t5v0__oai21_1
XTAP_TAPCELL_ROW_4_247 VDD VSS gf180mcu_fd_sc_mcu7t5v0__filltie
XPHY_EDGE_ROW_2_Right_2 VDD VSS gf180mcu_fd_sc_mcu7t5v0__endcap
XFILLER_57_446 VDD VDD VSS VSS gf180mcu_fd_sc_mcu7t5v0__fillcap_4
XFILLER_57_479 VDD VDD VSS VSS gf180mcu_fd_sc_mcu7t5v0__fillcap_8
XFILLER_44_107 VDD VDD VSS VSS gf180mcu_fd_sc_mcu7t5v0__fillcap_4
XFILLER_72_427 VDD VDD VSS VSS gf180mcu_fd_sc_mcu7t5v0__fillcap_4
XFILLER_37_192 VDD VDD VSS VSS gf180mcu_fd_sc_mcu7t5v0__fill_1
XFILLER_29_72 VDD VDD VSS VSS gf180mcu_fd_sc_mcu7t5v0__fillcap_64
XFILLER_48_457 VDD VDD VSS VSS gf180mcu_fd_sc_mcu7t5v0__fillcap_8
XTAP_TAPCELL_ROW_85_1019 VDD VSS gf180mcu_fd_sc_mcu7t5v0__filltie
XFILLER_75_276 VDD VDD VSS VSS gf180mcu_fd_sc_mcu7t5v0__fillcap_4
XTAP_TAPCELL_ROW_74_912 VDD VSS gf180mcu_fd_sc_mcu7t5v0__filltie
XPHY_EDGE_ROW_82_Left_179 VDD VSS gf180mcu_fd_sc_mcu7t5v0__endcap
XFILLER_75_298 VDD VDD VSS VSS gf180mcu_fd_sc_mcu7t5v0__fillcap_4
XTAP_TAPCELL_ROW_46_647 VDD VSS gf180mcu_fd_sc_mcu7t5v0__filltie
XFILLER_43_151 VDD VDD VSS VSS gf180mcu_fd_sc_mcu7t5v0__fill_2
XFILLER_12_560 VDD VDD VSS VSS gf180mcu_fd_sc_mcu7t5v0__fill_2
XTAP_TAPCELL_ROW_96_1115 VDD VSS gf180mcu_fd_sc_mcu7t5v0__filltie
XFILLER_12_593 VDD VDD VSS VSS gf180mcu_fd_sc_mcu7t5v0__fill_2
X_2690_ _2647_/Z _2651_/I _2657_/B _2692_/A3 VDD VDD VSS VSS gf180mcu_fd_sc_mcu7t5v0__nor3_1
XTAP_TAPCELL_ROW_96_1126 VDD VSS gf180mcu_fd_sc_mcu7t5v0__filltie
XPHY_EDGE_ROW_91_Left_188 VDD VSS gf180mcu_fd_sc_mcu7t5v0__endcap
XFILLER_8_597 VDD VDD VSS VSS gf180mcu_fd_sc_mcu7t5v0__fillcap_8
X_3311_ _3318_/B _3293_/C _3312_/A2 VDD VDD VSS VSS gf180mcu_fd_sc_mcu7t5v0__nor2_1
X_3242_ _2968_/I _2448_/B _3243_/I VDD VDD VSS VSS gf180mcu_fd_sc_mcu7t5v0__nand2_1
XFILLER_20_2 VDD VDD VSS VSS gf180mcu_fd_sc_mcu7t5v0__fillcap_32
X_3173_ _3491_/A1 wire483/Z _3180_/B VDD VDD VSS VSS gf180mcu_fd_sc_mcu7t5v0__and2_1
XFILLER_39_446 VDD VDD VSS VSS gf180mcu_fd_sc_mcu7t5v0__fill_1
X_2124_ _3778_/Q _3779_/Q _2124_/Z VDD VDD VSS VSS gf180mcu_fd_sc_mcu7t5v0__xor2_1
XFILLER_66_221 VDD VDD VSS VSS gf180mcu_fd_sc_mcu7t5v0__fill_2
XTAP_TAPCELL_ROW_1_217 VDD VSS gf180mcu_fd_sc_mcu7t5v0__filltie
XFILLER_26_107 VDD VDD VSS VSS gf180mcu_fd_sc_mcu7t5v0__fillcap_64
X_2055_ _2052_/Z _2054_/Z _2072_/A1 VDD VDD VSS VSS gf180mcu_fd_sc_mcu7t5v0__nand2_1
XFILLER_54_438 VDD VDD VSS VSS gf180mcu_fd_sc_mcu7t5v0__fill_1
XFILLER_34_140 VDD VDD VSS VSS gf180mcu_fd_sc_mcu7t5v0__fillcap_32
XTAP_TAPCELL_ROW_17_371 VDD VSS gf180mcu_fd_sc_mcu7t5v0__filltie
XFILLER_10_519 VDD VDD VSS VSS gf180mcu_fd_sc_mcu7t5v0__fill_1
X_2957_ _2959_/A1 _2957_/A2 _2957_/B _3716_/D VDD VDD VSS VSS gf180mcu_fd_sc_mcu7t5v0__oai21_1
X_1908_ _1909_/A1 _1908_/A2 _1960_/A1 VDD VDD VSS VSS gf180mcu_fd_sc_mcu7t5v0__nor2_1
X_2888_ _3686_/Q _2894_/A2 _2894_/B _2889_/B2 VDD VDD VSS VSS gf180mcu_fd_sc_mcu7t5v0__oai21_1
X_1839_ _1842_/A1 _1842_/A3 _1854_/B VDD VDD VSS VSS gf180mcu_fd_sc_mcu7t5v0__or2_1
XFILLER_1_206 VDD VDD VSS VSS gf180mcu_fd_sc_mcu7t5v0__fillcap_4
XFILLER_89_346 VDD VDD VSS VSS gf180mcu_fd_sc_mcu7t5v0__fillcap_4
XFILLER_1_228 VDD VDD VSS VSS gf180mcu_fd_sc_mcu7t5v0__fillcap_8
Xmax_cap272 _2805_/B1 _2825_/B1 VDD VDD VSS VSS gf180mcu_fd_sc_mcu7t5v0__buf_2
X_3509_ _3506_/Z _3509_/A2 _3509_/Z VDD VDD VSS VSS gf180mcu_fd_sc_mcu7t5v0__xor2_1
XFILLER_89_368 VDD VDD VSS VSS gf180mcu_fd_sc_mcu7t5v0__fillcap_8
XFILLER_66_37 VDD VDD VSS VSS gf180mcu_fd_sc_mcu7t5v0__fillcap_64
XFILLER_57_276 VDD VDD VSS VSS gf180mcu_fd_sc_mcu7t5v0__fillcap_4
XTAP_TAPCELL_ROW_43_617 VDD VSS gf180mcu_fd_sc_mcu7t5v0__filltie
XTAP_TAPCELL_ROW_51_694 VDD VSS gf180mcu_fd_sc_mcu7t5v0__filltie
Xoutput95 _3202_/Z cal_phase0_offset[15] VDD VDD VSS VSS gf180mcu_fd_sc_mcu7t5v0__buf_2
XTAP_TAPCELL_ROW_59_772 VDD VSS gf180mcu_fd_sc_mcu7t5v0__filltie
XTAP_TAPCELL_ROW_14_341 VDD VSS gf180mcu_fd_sc_mcu7t5v0__filltie
X_2811_ _3738_/Q _2822_/A2 _2812_/B VDD VDD VSS VSS gf180mcu_fd_sc_mcu7t5v0__nand2_1
X_2742_ wire514/I _3326_/A1 _2742_/A3 _2742_/B _3657_/D VDD VDD VSS VSS gf180mcu_fd_sc_mcu7t5v0__oai31_1
X_2673_ _2670_/Z _2726_/A2 _2674_/A3 VDD VDD VSS VSS gf180mcu_fd_sc_mcu7t5v0__nor2_1
XFILLER_68_2 VDD VDD VSS VSS gf180mcu_fd_sc_mcu7t5v0__fillcap_32
Xfanout318 _2808_/A1 wire319/I VDD VDD VSS VSS gf180mcu_fd_sc_mcu7t5v0__dlyb_1
X_3225_ wire439/Z _3225_/A2 _3225_/Z VDD VDD VSS VSS gf180mcu_fd_sc_mcu7t5v0__xor2_2
XFILLER_27_405 VDD VDD VSS VSS gf180mcu_fd_sc_mcu7t5v0__fillcap_4
X_3156_ _3157_/A1 _3157_/A2 _3156_/B _3163_/A2 VDD VDD VSS VSS gf180mcu_fd_sc_mcu7t5v0__oai21_1
X_2107_ _2093_/Z _2105_/Z _2111_/A2 VDD VDD VSS VSS gf180mcu_fd_sc_mcu7t5v0__nand2_1
X_3087_ _3658_/Q _3087_/ZN VDD VDD VSS VSS gf180mcu_fd_sc_mcu7t5v0__clkinv_1
X_2038_ _2038_/A1 _2038_/A2 _2040_/A1 VDD VDD VSS VSS gf180mcu_fd_sc_mcu7t5v0__nand2_1
XTAP_TAPCELL_ROW_20_399 VDD VSS gf180mcu_fd_sc_mcu7t5v0__filltie
Xclkbuf_4_13_0_clk clkbuf_0_clk/Z _3721_/CLK VDD VDD VSS VSS gf180mcu_fd_sc_mcu7t5v0__clkbuf_8
XFILLER_85_360 VDD VDD VSS VSS gf180mcu_fd_sc_mcu7t5v0__fill_2
XFILLER_58_585 VDD VDD VSS VSS gf180mcu_fd_sc_mcu7t5v0__fill_2
XFILLER_73_500 VDD VDD VSS VSS gf180mcu_fd_sc_mcu7t5v0__fillcap_4
XTAP_TAPCELL_ROW_56_742 VDD VSS gf180mcu_fd_sc_mcu7t5v0__filltie
XTAP_TAPCELL_ROW_28_477 VDD VSS gf180mcu_fd_sc_mcu7t5v0__filltie
XTAP_TAPCELL_ROW_11_311 VDD VSS gf180mcu_fd_sc_mcu7t5v0__filltie
XFILLER_9_136 VDD VDD VSS VSS gf180mcu_fd_sc_mcu7t5v0__fillcap_4
XFILLER_5_375 VDD VDD VSS VSS gf180mcu_fd_sc_mcu7t5v0__fillcap_32
XFILLER_96_614 VDD VDD VSS VSS gf180mcu_fd_sc_mcu7t5v0__fillcap_32
XFILLER_3_66 VDD VDD VSS VSS gf180mcu_fd_sc_mcu7t5v0__fillcap_4
X_3010_ _3010_/I _3168_/A1 VDD VDD VSS VSS gf180mcu_fd_sc_mcu7t5v0__inv_2
XFILLER_76_382 VDD VDD VSS VSS gf180mcu_fd_sc_mcu7t5v0__fill_2
XFILLER_76_371 VDD VDD VSS VSS gf180mcu_fd_sc_mcu7t5v0__fill_1
XFILLER_49_596 VDD VDD VSS VSS gf180mcu_fd_sc_mcu7t5v0__fill_2
XFILLER_91_352 VDD VDD VSS VSS gf180mcu_fd_sc_mcu7t5v0__fillcap_64
XFILLER_64_599 VDD VDD VSS VSS gf180mcu_fd_sc_mcu7t5v0__fill_1
XFILLER_32_485 VDD VDD VSS VSS gf180mcu_fd_sc_mcu7t5v0__fillcap_8
X_3774_ _3774_/D _3774_/RN _3774_/CLK _3774_/Q VDD VDD VSS VSS gf180mcu_fd_sc_mcu7t5v0__dffrnq_1
X_2725_ wire525/Z _2683_/Z _2684_/Z _3003_/I _2732_/A2 VDD VDD VSS VSS gf180mcu_fd_sc_mcu7t5v0__aoi22_1
X_2656_ _2979_/ZN _2999_/I _2657_/C VDD VDD VSS VSS gf180mcu_fd_sc_mcu7t5v0__xor2_1
X_2587_ wire517/I _2557_/Z _2587_/B1 _2587_/B2 _2587_/C _2588_/C VDD VDD VSS VSS gf180mcu_fd_sc_mcu7t5v0__oai221_1
X_3208_ _3206_/Z _3208_/A2 _3208_/ZN VDD VDD VSS VSS gf180mcu_fd_sc_mcu7t5v0__nor2_1
XFILLER_55_500 VDD VDD VSS VSS gf180mcu_fd_sc_mcu7t5v0__fill_1
X_3139_ _3139_/A1 _3777_/Q _3778_/D VDD VDD VSS VSS gf180mcu_fd_sc_mcu7t5v0__and2_1
XFILLER_27_279 VDD VDD VSS VSS gf180mcu_fd_sc_mcu7t5v0__fill_1
XTAP_TAPCELL_ROW_53_712 VDD VSS gf180mcu_fd_sc_mcu7t5v0__filltie
XTAP_TAPCELL_ROW_25_447 VDD VSS gf180mcu_fd_sc_mcu7t5v0__filltie
XFILLER_35_290 VDD VDD VSS VSS gf180mcu_fd_sc_mcu7t5v0__fill_1
Xwire527 wire528/Z wire527/Z VDD VDD VSS VSS gf180mcu_fd_sc_mcu7t5v0__buf_2
Xwire516 _2577_/B wire516/Z VDD VDD VSS VSS gf180mcu_fd_sc_mcu7t5v0__buf_2
Xwire549 wire550/I wire549/Z VDD VDD VSS VSS gf180mcu_fd_sc_mcu7t5v0__buf_2
XFILLER_18_268 VDD VDD VSS VSS gf180mcu_fd_sc_mcu7t5v0__fillcap_4
XFILLER_37_72 VDD VDD VSS VSS gf180mcu_fd_sc_mcu7t5v0__fillcap_32
XFILLER_14_463 VDD VDD VSS VSS gf180mcu_fd_sc_mcu7t5v0__fill_2
XFILLER_41_282 VDD VDD VSS VSS gf180mcu_fd_sc_mcu7t5v0__fill_2
X_2510_ _2510_/A1 _2560_/B _2512_/A3 VDD VDD VSS VSS gf180mcu_fd_sc_mcu7t5v0__nor2_1
X_3490_ wire649/Z _3492_/A3 _3507_/A2 VDD VDD VSS VSS gf180mcu_fd_sc_mcu7t5v0__nand2_1
X_2441_ _2935_/A1 _2441_/A2 _2441_/B _3757_/D VDD VDD VSS VSS gf180mcu_fd_sc_mcu7t5v0__aoi21_1
X_2372_ _3733_/Q _3732_/Q _2388_/B1 _2376_/A2 VDD VDD VSS VSS gf180mcu_fd_sc_mcu7t5v0__nand3_1
XFILLER_96_444 VDD VDD VSS VSS gf180mcu_fd_sc_mcu7t5v0__fillcap_32
XFILLER_37_500 VDD VDD VSS VSS gf180mcu_fd_sc_mcu7t5v0__fillcap_8
XFILLER_56_319 VDD VDD VSS VSS gf180mcu_fd_sc_mcu7t5v0__fill_1
XTAP_TAPCELL_ROW_67_848 VDD VSS gf180mcu_fd_sc_mcu7t5v0__filltie
XFILLER_92_661 VDD VDD VSS VSS gf180mcu_fd_sc_mcu7t5v0__fillcap_4
XFILLER_64_374 VDD VDD VSS VSS gf180mcu_fd_sc_mcu7t5v0__fillcap_8
XFILLER_52_569 VDD VDD VSS VSS gf180mcu_fd_sc_mcu7t5v0__fillcap_8
XFILLER_20_411 VDD VDD VSS VSS gf180mcu_fd_sc_mcu7t5v0__fill_1
XTAP_TAPCELL_ROW_22_417 VDD VSS gf180mcu_fd_sc_mcu7t5v0__filltie
X_3757_ _3757_/D wire557/Z clkload8/I _3757_/Q VDD VDD VSS VSS gf180mcu_fd_sc_mcu7t5v0__dffrnq_2
X_2708_ input40/Z _2574_/C _2708_/B _2709_/B2 VDD VDD VSS VSS gf180mcu_fd_sc_mcu7t5v0__aoi21_1
XTAP_TAPCELL_ROW_30_494 VDD VSS gf180mcu_fd_sc_mcu7t5v0__filltie
X_3688_ _3688_/D _3688_/RN clkload3/I _3688_/Q VDD VDD VSS VSS gf180mcu_fd_sc_mcu7t5v0__dffrnq_2
X_2639_ _2640_/B1 wire304/Z _2640_/C _2697_/A3 VDD VDD VSS VSS gf180mcu_fd_sc_mcu7t5v0__oai21_1
XFILLER_87_422 VDD VDD VSS VSS gf180mcu_fd_sc_mcu7t5v0__fillcap_8
XFILLER_55_352 VDD VDD VSS VSS gf180mcu_fd_sc_mcu7t5v0__fill_2
XFILLER_74_37 VDD VDD VSS VSS gf180mcu_fd_sc_mcu7t5v0__fillcap_64
XFILLER_82_171 VDD VDD VSS VSS gf180mcu_fd_sc_mcu7t5v0__fillcap_4
XTAP_TAPCELL_ROW_38_572 VDD VSS gf180mcu_fd_sc_mcu7t5v0__filltie
XFILLER_70_300 VDD VDD VSS VSS gf180mcu_fd_sc_mcu7t5v0__fillcap_4
XFILLER_70_355 VDD VDD VSS VSS gf180mcu_fd_sc_mcu7t5v0__fillcap_16
XFILLER_11_400 VDD VDD VSS VSS gf180mcu_fd_sc_mcu7t5v0__fillcap_4
XFILLER_11_422 VDD VDD VSS VSS gf180mcu_fd_sc_mcu7t5v0__fillcap_8
XFILLER_23_260 VDD VDD VSS VSS gf180mcu_fd_sc_mcu7t5v0__fillcap_8
XFILLER_23_282 VDD VDD VSS VSS gf180mcu_fd_sc_mcu7t5v0__fill_2
XFILLER_11_466 VDD VDD VSS VSS gf180mcu_fd_sc_mcu7t5v0__fillcap_4
Xwire313 _2267_/C _2831_/B VDD VDD VSS VSS gf180mcu_fd_sc_mcu7t5v0__buf_1
Xwire346 wire346/I wire346/Z VDD VDD VSS VSS gf180mcu_fd_sc_mcu7t5v0__buf_2
Xwire368 wire368/I wire368/Z VDD VDD VSS VSS gf180mcu_fd_sc_mcu7t5v0__buf_1
XFILLER_3_632 VDD VDD VSS VSS gf180mcu_fd_sc_mcu7t5v0__fillcap_32
XFILLER_3_676 VDD VDD VSS VSS gf180mcu_fd_sc_mcu7t5v0__fill_1
Xload_slew329 _2870_/B _2867_/B VDD VDD VSS VSS gf180mcu_fd_sc_mcu7t5v0__clkbuf_2
XFILLER_78_444 VDD VDD VSS VSS gf180mcu_fd_sc_mcu7t5v0__fillcap_8
XTAP_TAPCELL_ROW_88_1039 VDD VSS gf180mcu_fd_sc_mcu7t5v0__filltie
XTAP_TAPCELL_ROW_64_818 VDD VSS gf180mcu_fd_sc_mcu7t5v0__filltie
X_2990_ _3742_/Q _3101_/B2 VDD VDD VSS VSS gf180mcu_fd_sc_mcu7t5v0__inv_2
X_1941_ _1958_/B1 _1939_/I _1941_/Z VDD VDD VSS VSS gf180mcu_fd_sc_mcu7t5v0__xor2_1
XTAP_TAPCELL_ROW_72_895 VDD VSS gf180mcu_fd_sc_mcu7t5v0__filltie
X_1872_ _1888_/B1 _1871_/Z _1890_/A1 VDD VDD VSS VSS gf180mcu_fd_sc_mcu7t5v0__nand2_1
X_3611_ _3707_/Q _3075_/I _3611_/Z VDD VDD VSS VSS gf180mcu_fd_sc_mcu7t5v0__xor2_2
XFILLER_50_2 VDD VDD VSS VSS gf180mcu_fd_sc_mcu7t5v0__fillcap_32
X_3542_ _3563_/B _3541_/Z _3563_/A1 VDD VDD VSS VSS gf180mcu_fd_sc_mcu7t5v0__nand2_1
X_3473_ _3055_/I _3472_/Z _3473_/Z VDD VDD VSS VSS gf180mcu_fd_sc_mcu7t5v0__and2_1
X_2424_ wire451/Z wire548/Z _2967_/A2 VDD VDD VSS VSS gf180mcu_fd_sc_mcu7t5v0__nand2_1
X_2355_ _2359_/A2 _2432_/B _2432_/A2 _2358_/B VDD VDD VSS VSS gf180mcu_fd_sc_mcu7t5v0__nor3_2
XFILLER_69_422 VDD VDD VSS VSS gf180mcu_fd_sc_mcu7t5v0__fill_2
XFILLER_57_628 VDD VDD VSS VSS gf180mcu_fd_sc_mcu7t5v0__fill_2
XFILLER_96_274 VDD VDD VSS VSS gf180mcu_fd_sc_mcu7t5v0__fillcap_32
X_2286_ _2290_/A2 _2935_/A1 _2286_/B _3726_/D VDD VDD VSS VSS gf180mcu_fd_sc_mcu7t5v0__oai21_1
XFILLER_84_469 VDD VDD VSS VSS gf180mcu_fd_sc_mcu7t5v0__fill_1
XFILLER_25_525 VDD VDD VSS VSS gf180mcu_fd_sc_mcu7t5v0__fill_1
XFILLER_37_352 VDD VDD VSS VSS gf180mcu_fd_sc_mcu7t5v0__fillcap_4
XFILLER_25_569 VDD VDD VSS VSS gf180mcu_fd_sc_mcu7t5v0__fill_1
XTAP_TAPCELL_ROW_35_542 VDD VSS gf180mcu_fd_sc_mcu7t5v0__filltie
XFILLER_20_263 VDD VDD VSS VSS gf180mcu_fd_sc_mcu7t5v0__fill_1
XTAP_TAPCELL_ROW_7_278 VDD VSS gf180mcu_fd_sc_mcu7t5v0__filltie
XFILLER_75_469 VDD VDD VSS VSS gf180mcu_fd_sc_mcu7t5v0__fill_1
XFILLER_7_212 VDD VDD VSS VSS gf180mcu_fd_sc_mcu7t5v0__fillcap_8
XTAP_TAPCELL_ROW_94_1098 VDD VSS gf180mcu_fd_sc_mcu7t5v0__filltie
XFILLER_78_241 VDD VDD VSS VSS gf180mcu_fd_sc_mcu7t5v0__fillcap_4
X_2140_ _2140_/A1 wire388/Z _2195_/A1 VDD VDD VSS VSS gf180mcu_fd_sc_mcu7t5v0__nand2_1
X_2071_ _2036_/I _2071_/A2 _2056_/Z _2071_/Z VDD VDD VSS VSS gf180mcu_fd_sc_mcu7t5v0__or3_1
XTAP_TAPCELL_ROW_77_943 VDD VSS gf180mcu_fd_sc_mcu7t5v0__filltie
XFILLER_19_352 VDD VDD VSS VSS gf180mcu_fd_sc_mcu7t5v0__fill_1
XFILLER_34_300 VDD VDD VSS VSS gf180mcu_fd_sc_mcu7t5v0__fill_1
XFILLER_34_333 VDD VDD VSS VSS gf180mcu_fd_sc_mcu7t5v0__fillcap_4
XFILLER_46_193 VDD VDD VSS VSS gf180mcu_fd_sc_mcu7t5v0__fill_1
XFILLER_74_491 VDD VDD VSS VSS gf180mcu_fd_sc_mcu7t5v0__fillcap_8
X_2973_ _2973_/I _3117_/A2 VDD VDD VSS VSS gf180mcu_fd_sc_mcu7t5v0__inv_2
XTAP_TAPCELL_ROW_32_512 VDD VSS gf180mcu_fd_sc_mcu7t5v0__filltie
XFILLER_34_399 VDD VDD VSS VSS gf180mcu_fd_sc_mcu7t5v0__fill_2
XFILLER_15_591 VDD VDD VSS VSS gf180mcu_fd_sc_mcu7t5v0__fillcap_4
X_1924_ _3697_/Q _1918_/Z _1924_/B _1958_/B1 VDD VDD VSS VSS gf180mcu_fd_sc_mcu7t5v0__aoi21_2
X_1855_ _1853_/Z _1856_/A2 _1888_/C VDD VDD VSS VSS gf180mcu_fd_sc_mcu7t5v0__nand2_1
X_3525_ wire642/Z _3523_/Z _3525_/Z VDD VDD VSS VSS gf180mcu_fd_sc_mcu7t5v0__and2_1
X_3456_ _3456_/A1 _3456_/A2 _3453_/Z _3456_/B2 _3456_/C _3468_/A2 VDD VDD VSS VSS
+ gf180mcu_fd_sc_mcu7t5v0__aoi221_1
X_2407_ _2315_/Z _2407_/A2 _2408_/A3 VDD VDD VSS VSS gf180mcu_fd_sc_mcu7t5v0__nor2_1
X_3387_ _3387_/I _3401_/A1 VDD VDD VSS VSS gf180mcu_fd_sc_mcu7t5v0__clkinv_1
X_2338_ wire459/I wire638/I _2417_/A1 _2334_/Z _2338_/C _2343_/A3 VDD VDD VSS VSS
+ gf180mcu_fd_sc_mcu7t5v0__aoi221_4
XTAP_TAPCELL_ROW_4_248 VDD VSS gf180mcu_fd_sc_mcu7t5v0__filltie
X_2269_ _2269_/A1 _2269_/A2 _2270_/I VDD VDD VSS VSS gf180mcu_fd_sc_mcu7t5v0__nor2_1
XFILLER_38_661 VDD VDD VSS VSS gf180mcu_fd_sc_mcu7t5v0__fillcap_4
XFILLER_25_322 VDD VDD VSS VSS gf180mcu_fd_sc_mcu7t5v0__fill_2
XFILLER_13_506 VDD VDD VSS VSS gf180mcu_fd_sc_mcu7t5v0__fillcap_4
XFILLER_25_366 VDD VDD VSS VSS gf180mcu_fd_sc_mcu7t5v0__fillcap_8
XFILLER_80_483 VDD VDD VSS VSS gf180mcu_fd_sc_mcu7t5v0__fillcap_4
XFILLER_13_528 VDD VDD VSS VSS gf180mcu_fd_sc_mcu7t5v0__fill_1
XFILLER_40_314 VDD VDD VSS VSS gf180mcu_fd_sc_mcu7t5v0__fill_1
XFILLER_40_325 VDD VDD VSS VSS gf180mcu_fd_sc_mcu7t5v0__fill_1
XFILLER_52_174 VDD VDD VSS VSS gf180mcu_fd_sc_mcu7t5v0__fill_1
XFILLER_4_259 VDD VDD VSS VSS gf180mcu_fd_sc_mcu7t5v0__fill_2
XFILLER_0_410 VDD VDD VSS VSS gf180mcu_fd_sc_mcu7t5v0__fillcap_4
XFILLER_88_550 VDD VDD VSS VSS gf180mcu_fd_sc_mcu7t5v0__fill_2
XTAP_TAPCELL_ROW_74_913 VDD VSS gf180mcu_fd_sc_mcu7t5v0__filltie
XFILLER_90_247 VDD VDD VSS VSS gf180mcu_fd_sc_mcu7t5v0__fillcap_64
XFILLER_28_193 VDD VDD VSS VSS gf180mcu_fd_sc_mcu7t5v0__fill_2
XFILLER_28_171 VDD VDD VSS VSS gf180mcu_fd_sc_mcu7t5v0__fillcap_4
XTAP_TAPCELL_ROW_46_648 VDD VSS gf180mcu_fd_sc_mcu7t5v0__filltie
XFILLER_16_344 VDD VDD VSS VSS gf180mcu_fd_sc_mcu7t5v0__fill_1
XFILLER_45_72 VDD VDD VSS VSS gf180mcu_fd_sc_mcu7t5v0__fillcap_16
XTAP_TAPCELL_ROW_82_990 VDD VSS gf180mcu_fd_sc_mcu7t5v0__filltie
XTAP_TAPCELL_ROW_96_1116 VDD VSS gf180mcu_fd_sc_mcu7t5v0__filltie
XTAP_TAPCELL_ROW_96_1127 VDD VSS gf180mcu_fd_sc_mcu7t5v0__filltie
X_3310_ _3310_/A1 _3310_/A2 _3310_/A3 _3318_/A2 VDD VDD VSS VSS gf180mcu_fd_sc_mcu7t5v0__nand3_1
X_3241_ _3231_/Z _3309_/A2 _3301_/A2 _3272_/B _3255_/B2 VDD VDD VSS VSS gf180mcu_fd_sc_mcu7t5v0__aoi22_2
X_3172_ _3169_/Z _3172_/A2 _3172_/ZN VDD VDD VSS VSS gf180mcu_fd_sc_mcu7t5v0__xnor2_1
XFILLER_13_2 VDD VDD VSS VSS gf180mcu_fd_sc_mcu7t5v0__fillcap_64
X_2123_ _3138_/A2 _3779_/Q _2123_/Z VDD VDD VSS VSS gf180mcu_fd_sc_mcu7t5v0__xor2_2
XFILLER_66_244 VDD VDD VSS VSS gf180mcu_fd_sc_mcu7t5v0__fill_1
XFILLER_94_597 VDD VDD VSS VSS gf180mcu_fd_sc_mcu7t5v0__fillcap_64
XTAP_TAPCELL_ROW_1_218 VDD VSS gf180mcu_fd_sc_mcu7t5v0__filltie
XFILLER_66_255 VDD VDD VSS VSS gf180mcu_fd_sc_mcu7t5v0__fillcap_4
X_2054_ _2053_/B _2031_/Z _2054_/Z VDD VDD VSS VSS gf180mcu_fd_sc_mcu7t5v0__or2_1
XTAP_TAPCELL_ROW_17_372 VDD VSS gf180mcu_fd_sc_mcu7t5v0__filltie
XFILLER_34_174 VDD VDD VSS VSS gf180mcu_fd_sc_mcu7t5v0__fill_1
XFILLER_62_461 VDD VDD VSS VSS gf180mcu_fd_sc_mcu7t5v0__fill_1
X_2956_ _3716_/Q _2959_/A1 _2957_/B VDD VDD VSS VSS gf180mcu_fd_sc_mcu7t5v0__nand2_1
X_1907_ _1907_/I _1908_/A2 VDD VDD VSS VSS gf180mcu_fd_sc_mcu7t5v0__clkinv_1
X_2887_ wire424/Z _2893_/A2 _2889_/B1 VDD VDD VSS VSS gf180mcu_fd_sc_mcu7t5v0__nor2_1
X_1838_ _1834_/Z _1849_/A2 _1842_/A3 VDD VDD VSS VSS gf180mcu_fd_sc_mcu7t5v0__xnor2_2
Xmax_cap295 wire296/Z _1888_/A2 VDD VDD VSS VSS gf180mcu_fd_sc_mcu7t5v0__dlyb_1
X_3508_ _3506_/Z _3509_/A2 _3530_/B VDD VDD VSS VSS gf180mcu_fd_sc_mcu7t5v0__nor2_1
X_3439_ _3439_/A1 _3437_/Z _3440_/I VDD VDD VSS VSS gf180mcu_fd_sc_mcu7t5v0__xor2_1
Xload_slew490 _3702_/Q _3064_/I VDD VDD VSS VSS gf180mcu_fd_sc_mcu7t5v0__buf_2
XFILLER_82_37 VDD VDD VSS VSS gf180mcu_fd_sc_mcu7t5v0__fillcap_64
XFILLER_72_247 VDD VDD VSS VSS gf180mcu_fd_sc_mcu7t5v0__fillcap_16
XTAP_TAPCELL_ROW_43_618 VDD VSS gf180mcu_fd_sc_mcu7t5v0__filltie
XFILLER_40_177 VDD VDD VSS VSS gf180mcu_fd_sc_mcu7t5v0__fill_1
XTAP_TAPCELL_ROW_51_695 VDD VSS gf180mcu_fd_sc_mcu7t5v0__filltie
XTAP_TAPCELL_ROW_91_1068 VDD VSS gf180mcu_fd_sc_mcu7t5v0__filltie
XFILLER_0_240 VDD VDD VSS VSS gf180mcu_fd_sc_mcu7t5v0__fillcap_16
Xoutput96 _3208_/ZN cal_phase0_offset[16] VDD VDD VSS VSS gf180mcu_fd_sc_mcu7t5v0__buf_2
XFILLER_76_597 VDD VDD VSS VSS gf180mcu_fd_sc_mcu7t5v0__fill_1
XFILLER_91_556 VDD VDD VSS VSS gf180mcu_fd_sc_mcu7t5v0__fillcap_4
XFILLER_32_667 VDD VDD VSS VSS gf180mcu_fd_sc_mcu7t5v0__fill_2
XTAP_TAPCELL_ROW_14_342 VDD VSS gf180mcu_fd_sc_mcu7t5v0__filltie
X_2810_ _3095_/ZN wire312/Z _2815_/C VDD VDD VSS VSS gf180mcu_fd_sc_mcu7t5v0__nor2_1
X_2741_ wire549/Z _3657_/Q _2742_/B VDD VDD VSS VSS gf180mcu_fd_sc_mcu7t5v0__nand2_1
XFILLER_8_384 VDD VDD VSS VSS gf180mcu_fd_sc_mcu7t5v0__fill_1
X_2672_ _2672_/I _2726_/A2 VDD VDD VSS VSS gf180mcu_fd_sc_mcu7t5v0__clkinv_1
Xfanout308 fanout308/I _2765_/A2 VDD VDD VSS VSS gf180mcu_fd_sc_mcu7t5v0__dlyb_1
XFILLER_86_317 VDD VDD VSS VSS gf180mcu_fd_sc_mcu7t5v0__fillcap_16
X_3224_ _3260_/A2 _3226_/A2 _3282_/A1 VDD VDD VSS VSS gf180mcu_fd_sc_mcu7t5v0__xnor2_2
.ends
