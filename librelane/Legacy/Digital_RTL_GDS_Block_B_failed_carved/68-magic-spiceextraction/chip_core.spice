* NGSPICE file created from chip_core.ext - technology: gf180mcuD

* Black-box entry subcircuit for gf180mcu_fd_sc_mcu7t5v0__dffrnq_1 abstract view
.subckt gf180mcu_fd_sc_mcu7t5v0__dffrnq_1 D RN CLK Q VDD VNW VPW VSS
.ends

* Black-box entry subcircuit for gf180mcu_fd_sc_mcu7t5v0__fillcap_4 abstract view
.subckt gf180mcu_fd_sc_mcu7t5v0__fillcap_4 VDD VNW VPW VSS
.ends

* Black-box entry subcircuit for gf180mcu_fd_sc_mcu7t5v0__filltie abstract view
.subckt gf180mcu_fd_sc_mcu7t5v0__filltie VDD VSS
.ends

* Black-box entry subcircuit for gf180mcu_fd_sc_mcu7t5v0__fill_2 abstract view
.subckt gf180mcu_fd_sc_mcu7t5v0__fill_2 VDD VNW VPW VSS
.ends

* Black-box entry subcircuit for gf180mcu_fd_sc_mcu7t5v0__mux2_2 abstract view
.subckt gf180mcu_fd_sc_mcu7t5v0__mux2_2 I0 I1 S Z VDD VNW VPW VSS
.ends

* Black-box entry subcircuit for gf180mcu_fd_sc_mcu7t5v0__fill_1 abstract view
.subckt gf180mcu_fd_sc_mcu7t5v0__fill_1 VDD VNW VPW VSS
.ends

* Black-box entry subcircuit for gf180mcu_fd_sc_mcu7t5v0__nor2_1 abstract view
.subckt gf180mcu_fd_sc_mcu7t5v0__nor2_1 A1 A2 ZN VDD VNW VPW VSS
.ends

* Black-box entry subcircuit for gf180mcu_fd_sc_mcu7t5v0__xnor2_1 abstract view
.subckt gf180mcu_fd_sc_mcu7t5v0__xnor2_1 A1 A2 ZN VDD VNW VPW VSS
.ends

* Black-box entry subcircuit for gf180mcu_fd_sc_mcu7t5v0__fillcap_32 abstract view
.subckt gf180mcu_fd_sc_mcu7t5v0__fillcap_32 VDD VNW VPW VSS
.ends

* Black-box entry subcircuit for gf180mcu_fd_sc_mcu7t5v0__fillcap_64 abstract view
.subckt gf180mcu_fd_sc_mcu7t5v0__fillcap_64 VDD VNW VPW VSS
.ends

* Black-box entry subcircuit for gf180mcu_fd_sc_mcu7t5v0__fillcap_8 abstract view
.subckt gf180mcu_fd_sc_mcu7t5v0__fillcap_8 VDD VNW VPW VSS
.ends

* Black-box entry subcircuit for gf180mcu_fd_sc_mcu7t5v0__or2_1 abstract view
.subckt gf180mcu_fd_sc_mcu7t5v0__or2_1 A1 A2 Z VDD VNW VPW VSS
.ends

* Black-box entry subcircuit for gf180mcu_fd_sc_mcu7t5v0__aoi22_1 abstract view
.subckt gf180mcu_fd_sc_mcu7t5v0__aoi22_1 A1 A2 B1 B2 ZN VDD VNW VPW VSS
.ends

* Black-box entry subcircuit for gf180mcu_fd_sc_mcu7t5v0__and3_1 abstract view
.subckt gf180mcu_fd_sc_mcu7t5v0__and3_1 A1 A2 A3 Z VDD VNW VPW VSS
.ends

* Black-box entry subcircuit for gf180mcu_fd_sc_mcu7t5v0__fillcap_16 abstract view
.subckt gf180mcu_fd_sc_mcu7t5v0__fillcap_16 VDD VNW VPW VSS
.ends

* Black-box entry subcircuit for gf180mcu_fd_sc_mcu7t5v0__clkinv_1 abstract view
.subckt gf180mcu_fd_sc_mcu7t5v0__clkinv_1 I ZN VDD VNW VPW VSS
.ends

* Black-box entry subcircuit for gf180mcu_fd_sc_mcu7t5v0__aoi211_1 abstract view
.subckt gf180mcu_fd_sc_mcu7t5v0__aoi211_1 A1 A2 B C ZN VDD VNW VPW VSS
.ends

* Black-box entry subcircuit for gf180mcu_fd_sc_mcu7t5v0__xor2_1 abstract view
.subckt gf180mcu_fd_sc_mcu7t5v0__xor2_1 A1 A2 Z VDD VNW VPW VSS
.ends

* Black-box entry subcircuit for gf180mcu_fd_sc_mcu7t5v0__buf_1 abstract view
.subckt gf180mcu_fd_sc_mcu7t5v0__buf_1 I Z VDD VNW VPW VSS
.ends

* Black-box entry subcircuit for gf180mcu_fd_sc_mcu7t5v0__endcap abstract view
.subckt gf180mcu_fd_sc_mcu7t5v0__endcap VDD VSS
.ends

* Black-box entry subcircuit for gf180mcu_fd_sc_mcu7t5v0__dffsnq_1 abstract view
.subckt gf180mcu_fd_sc_mcu7t5v0__dffsnq_1 D SETN CLK Q VDD VNW VPW VSS
.ends

* Black-box entry subcircuit for gf180mcu_fd_sc_mcu7t5v0__nand2_1 abstract view
.subckt gf180mcu_fd_sc_mcu7t5v0__nand2_1 A1 A2 ZN VDD VNW VPW VSS
.ends

* Black-box entry subcircuit for gf180mcu_fd_sc_mcu7t5v0__oai32_1 abstract view
.subckt gf180mcu_fd_sc_mcu7t5v0__oai32_1 A1 A2 A3 B1 B2 ZN VDD VNW VPW VSS
.ends

* Black-box entry subcircuit for gf180mcu_fd_sc_mcu7t5v0__xor3_1 abstract view
.subckt gf180mcu_fd_sc_mcu7t5v0__xor3_1 A1 A2 A3 Z VDD VNW VPW VSS
.ends

* Black-box entry subcircuit for gf180mcu_fd_sc_mcu7t5v0__oai31_1 abstract view
.subckt gf180mcu_fd_sc_mcu7t5v0__oai31_1 A1 A2 A3 B ZN VDD VNW VPW VSS
.ends

* Black-box entry subcircuit for gf180mcu_fd_sc_mcu7t5v0__aoi21_1 abstract view
.subckt gf180mcu_fd_sc_mcu7t5v0__aoi21_1 A1 A2 B ZN VDD VNW VPW VSS
.ends

* Black-box entry subcircuit for gf180mcu_fd_sc_mcu7t5v0__nand4_1 abstract view
.subckt gf180mcu_fd_sc_mcu7t5v0__nand4_1 A1 A2 A3 A4 ZN VDD VNW VPW VSS
.ends

* Black-box entry subcircuit for gf180mcu_fd_sc_mcu7t5v0__and2_1 abstract view
.subckt gf180mcu_fd_sc_mcu7t5v0__and2_1 A1 A2 Z VDD VNW VPW VSS
.ends

* Black-box entry subcircuit for gf180mcu_fd_sc_mcu7t5v0__nand3_1 abstract view
.subckt gf180mcu_fd_sc_mcu7t5v0__nand3_1 A1 A2 A3 ZN VDD VNW VPW VSS
.ends

* Black-box entry subcircuit for gf180mcu_fd_sc_mcu7t5v0__dlyb_1 abstract view
.subckt gf180mcu_fd_sc_mcu7t5v0__dlyb_1 I Z VDD VNW VPW VSS
.ends

* Black-box entry subcircuit for gf180mcu_fd_sc_mcu7t5v0__oai21_1 abstract view
.subckt gf180mcu_fd_sc_mcu7t5v0__oai21_1 A1 A2 B ZN VDD VNW VPW VSS
.ends

* Black-box entry subcircuit for gf180mcu_fd_sc_mcu7t5v0__xnor3_1 abstract view
.subckt gf180mcu_fd_sc_mcu7t5v0__xnor3_1 A1 A2 A3 ZN VDD VNW VPW VSS
.ends

* Black-box entry subcircuit for gf180mcu_fd_sc_mcu7t5v0__nor3_1 abstract view
.subckt gf180mcu_fd_sc_mcu7t5v0__nor3_1 A1 A2 A3 ZN VDD VNW VPW VSS
.ends

* Black-box entry subcircuit for gf180mcu_fd_sc_mcu7t5v0__buf_2 abstract view
.subckt gf180mcu_fd_sc_mcu7t5v0__buf_2 I Z VDD VNW VPW VSS
.ends

* Black-box entry subcircuit for gf180mcu_fd_sc_mcu7t5v0__buf_4 abstract view
.subckt gf180mcu_fd_sc_mcu7t5v0__buf_4 I Z VDD VNW VPW VSS
.ends

* Black-box entry subcircuit for gf180mcu_fd_sc_mcu7t5v0__aoi222_1 abstract view
.subckt gf180mcu_fd_sc_mcu7t5v0__aoi222_1 A1 A2 B1 B2 C1 C2 ZN VDD VNW VPW VSS
.ends

* Black-box entry subcircuit for gf180mcu_fd_sc_mcu7t5v0__clkbuf_3 abstract view
.subckt gf180mcu_fd_sc_mcu7t5v0__clkbuf_3 I Z VDD VNW VPW VSS
.ends

* Black-box entry subcircuit for gf180mcu_fd_sc_mcu7t5v0__buf_3 abstract view
.subckt gf180mcu_fd_sc_mcu7t5v0__buf_3 I Z VDD VNW VPW VSS
.ends

* Black-box entry subcircuit for gf180mcu_fd_sc_mcu7t5v0__oai22_1 abstract view
.subckt gf180mcu_fd_sc_mcu7t5v0__oai22_1 A1 A2 B1 B2 ZN VDD VNW VPW VSS
.ends

* Black-box entry subcircuit for gf180mcu_fd_sc_mcu7t5v0__oai221_1 abstract view
.subckt gf180mcu_fd_sc_mcu7t5v0__oai221_1 A1 A2 B1 B2 C ZN VDD VNW VPW VSS
.ends

* Black-box entry subcircuit for gf180mcu_fd_sc_mcu7t5v0__dlyc_1 abstract view
.subckt gf180mcu_fd_sc_mcu7t5v0__dlyc_1 I Z VDD VNW VPW VSS
.ends

* Black-box entry subcircuit for gf180mcu_fd_sc_mcu7t5v0__clkbuf_16 abstract view
.subckt gf180mcu_fd_sc_mcu7t5v0__clkbuf_16 I Z VDD VNW VPW VSS
.ends

* Black-box entry subcircuit for gf180mcu_fd_sc_mcu7t5v0__and4_1 abstract view
.subckt gf180mcu_fd_sc_mcu7t5v0__and4_1 A1 A2 A3 A4 Z VDD VNW VPW VSS
.ends

* Black-box entry subcircuit for gf180mcu_fd_sc_mcu7t5v0__aoi221_1 abstract view
.subckt gf180mcu_fd_sc_mcu7t5v0__aoi221_1 A1 A2 B1 B2 C ZN VDD VNW VPW VSS
.ends

* Black-box entry subcircuit for gf180mcu_fd_sc_mcu7t5v0__clkbuf_8 abstract view
.subckt gf180mcu_fd_sc_mcu7t5v0__clkbuf_8 I Z VDD VNW VPW VSS
.ends

* Black-box entry subcircuit for gf180mcu_fd_sc_mcu7t5v0__nor2_2 abstract view
.subckt gf180mcu_fd_sc_mcu7t5v0__nor2_2 A1 A2 ZN VDD VNW VPW VSS
.ends

* Black-box entry subcircuit for gf180mcu_fd_sc_mcu7t5v0__nor4_1 abstract view
.subckt gf180mcu_fd_sc_mcu7t5v0__nor4_1 A1 A2 A3 A4 ZN VDD VNW VPW VSS
.ends

* Black-box entry subcircuit for gf180mcu_fd_sc_mcu7t5v0__clkbuf_1 abstract view
.subckt gf180mcu_fd_sc_mcu7t5v0__clkbuf_1 I Z VDD VNW VPW VSS
.ends

* Black-box entry subcircuit for gf180mcu_fd_sc_mcu7t5v0__nor3_2 abstract view
.subckt gf180mcu_fd_sc_mcu7t5v0__nor3_2 A1 A2 A3 ZN VDD VNW VPW VSS
.ends

* Black-box entry subcircuit for gf180mcu_fd_sc_mcu7t5v0__oai211_1 abstract view
.subckt gf180mcu_fd_sc_mcu7t5v0__oai211_1 A1 A2 B C ZN VDD VNW VPW VSS
.ends

* Black-box entry subcircuit for gf180mcu_fd_sc_mcu7t5v0__nand4_2 abstract view
.subckt gf180mcu_fd_sc_mcu7t5v0__nand4_2 A1 A2 A3 A4 ZN VDD VNW VPW VSS
.ends

* Black-box entry subcircuit for gf180mcu_fd_sc_mcu7t5v0__or3_1 abstract view
.subckt gf180mcu_fd_sc_mcu7t5v0__or3_1 A1 A2 A3 Z VDD VNW VPW VSS
.ends

* Black-box entry subcircuit for gf180mcu_fd_sc_mcu7t5v0__clkbuf_2 abstract view
.subckt gf180mcu_fd_sc_mcu7t5v0__clkbuf_2 I Z VDD VNW VPW VSS
.ends

* Black-box entry subcircuit for gf180mcu_fd_sc_mcu7t5v0__clkbuf_4 abstract view
.subckt gf180mcu_fd_sc_mcu7t5v0__clkbuf_4 I Z VDD VNW VPW VSS
.ends

* Black-box entry subcircuit for gf180mcu_fd_sc_mcu7t5v0__buf_8 abstract view
.subckt gf180mcu_fd_sc_mcu7t5v0__buf_8 I Z VDD VNW VPW VSS
.ends

* Black-box entry subcircuit for gf180mcu_fd_sc_mcu7t5v0__clkinv_2 abstract view
.subckt gf180mcu_fd_sc_mcu7t5v0__clkinv_2 I ZN VDD VNW VPW VSS
.ends

* Black-box entry subcircuit for gf180mcu_fd_sc_mcu7t5v0__tieh abstract view
.subckt gf180mcu_fd_sc_mcu7t5v0__tieh Z VDD VNW VPW VSS
.ends

* Black-box entry subcircuit for gf180mcu_fd_sc_mcu7t5v0__inv_2 abstract view
.subckt gf180mcu_fd_sc_mcu7t5v0__inv_2 I ZN VDD VNW VPW VSS
.ends

* Black-box entry subcircuit for gf180mcu_fd_sc_mcu7t5v0__tiel abstract view
.subckt gf180mcu_fd_sc_mcu7t5v0__tiel ZN VDD VNW VPW VSS
.ends

* Black-box entry subcircuit for gf180mcu_fd_sc_mcu7t5v0__inv_3 abstract view
.subckt gf180mcu_fd_sc_mcu7t5v0__inv_3 I ZN VDD VNW VPW VSS
.ends

* Black-box entry subcircuit for gf180mcu_fd_sc_mcu7t5v0__inv_4 abstract view
.subckt gf180mcu_fd_sc_mcu7t5v0__inv_4 I ZN VDD VNW VPW VSS
.ends

* Black-box entry subcircuit for gf180mcu_fd_sc_mcu7t5v0__or4_1 abstract view
.subckt gf180mcu_fd_sc_mcu7t5v0__or4_1 A1 A2 A3 A4 Z VDD VNW VPW VSS
.ends

* Black-box entry subcircuit for gf180mcu_fd_sc_mcu7t5v0__nor4_2 abstract view
.subckt gf180mcu_fd_sc_mcu7t5v0__nor4_2 A1 A2 A3 A4 ZN VDD VNW VPW VSS
.ends

* Black-box entry subcircuit for gf180mcu_fd_sc_mcu7t5v0__inv_1 abstract view
.subckt gf180mcu_fd_sc_mcu7t5v0__inv_1 I ZN VDD VNW VPW VSS
.ends

* Black-box entry subcircuit for gf180mcu_fd_sc_mcu7t5v0__dffq_1 abstract view
.subckt gf180mcu_fd_sc_mcu7t5v0__dffq_1 D CLK Q VDD VNW VPW VSS
.ends

* Black-box entry subcircuit for gf180mcu_fd_sc_mcu7t5v0__oai31_2 abstract view
.subckt gf180mcu_fd_sc_mcu7t5v0__oai31_2 A1 A2 A3 B ZN VDD VNW VPW VSS
.ends

* Black-box entry subcircuit for gf180mcu_fd_sc_mcu7t5v0__oai222_1 abstract view
.subckt gf180mcu_fd_sc_mcu7t5v0__oai222_1 A1 A2 B1 B2 C1 C2 ZN VDD VNW VPW VSS
.ends

.subckt chip_core VDD VSS analog[0] analog[1] analog[2] analog[3] bidir_cs[0] bidir_cs[1]
+ bidir_cs[2] bidir_cs[3] bidir_cs[4] bidir_cs[5] bidir_cs[6] bidir_cs[7] bidir_cs[8]
+ bidir_cs[9] bidir_ie[0] bidir_ie[1] bidir_ie[2] bidir_ie[3] bidir_ie[4] bidir_ie[5]
+ bidir_ie[6] bidir_ie[7] bidir_ie[8] bidir_ie[9] bidir_in[0] bidir_in[1] bidir_in[2]
+ bidir_in[3] bidir_in[4] bidir_in[5] bidir_in[6] bidir_in[7] bidir_in[8] bidir_in[9]
+ bidir_oe[0] bidir_oe[1] bidir_oe[2] bidir_oe[3] bidir_oe[4] bidir_oe[5] bidir_oe[6]
+ bidir_oe[7] bidir_oe[8] bidir_oe[9] bidir_out[0] bidir_out[1] bidir_out[2] bidir_out[3]
+ bidir_out[4] bidir_out[5] bidir_out[6] bidir_out[7] bidir_out[8] bidir_out[9] bidir_pd[0]
+ bidir_pd[1] bidir_pd[2] bidir_pd[3] bidir_pd[4] bidir_pd[5] bidir_pd[6] bidir_pd[7]
+ bidir_pd[8] bidir_pd[9] bidir_pu[0] bidir_pu[1] bidir_pu[2] bidir_pu[3] bidir_pu[4]
+ bidir_pu[5] bidir_pu[6] bidir_pu[7] bidir_pu[8] bidir_pu[9] bidir_sl[0] bidir_sl[1]
+ bidir_sl[2] bidir_sl[3] bidir_sl[4] bidir_sl[5] bidir_sl[6] bidir_sl[7] bidir_sl[8]
+ bidir_sl[9] clk input_in input_pd input_pu rst_n
Xwave_controller_x_inst__3640_ wave_controller_x_inst__3640_/D wave_controller_x_inst__3682_/RN
+ clkload33/I max_cap463/I VDD VDD VSS VSS gf180mcu_fd_sc_mcu7t5v0__dffrnq_1
XFILLER_67_575 VDD VDD VSS VSS gf180mcu_fd_sc_mcu7t5v0__fillcap_4
XTAP_TAPCELL_ROW_4_1_365 VDD VSS gf180mcu_fd_sc_mcu7t5v0__filltie
XTAP_TAPCELL_ROW_68_1004 VDD VSS gf180mcu_fd_sc_mcu7t5v0__filltie
XFILLER_67_597 VDD VDD VSS VSS gf180mcu_fd_sc_mcu7t5v0__fillcap_4
XFILLER_82_523 VDD VDD VSS VSS gf180mcu_fd_sc_mcu7t5v0__fill_2
Xwave_controller_x_inst__3571_ wave_controller_x_inst__3601_/I0 spi_regs_inst__1320_/A1
+ wave_controller_x_inst__3573_/S wave_controller_x_inst__3655_/D VDD VDD VSS VSS
+ gf180mcu_fd_sc_mcu7t5v0__mux2_2
XFILLER_70_718 VDD VDD VSS VSS gf180mcu_fd_sc_mcu7t5v0__fill_1
Xwave_controller_x_inst__2522_ spi_regs_inst__1473_/Q wave_controller_x_inst__2521_/Z
+ wave_controller_x_inst__2528_/B VDD VDD VSS VSS gf180mcu_fd_sc_mcu7t5v0__nor2_1
XTAP_TAPCELL_ROW_81_1215 VDD VSS gf180mcu_fd_sc_mcu7t5v0__filltie
Xwave_controller_x_inst__2453_ wire462/Z max_cap467/Z wave_controller_x_inst__2456_/B
+ VDD VDD VSS VSS gf180mcu_fd_sc_mcu7t5v0__xnor2_1
XFILLER_10_317 VDD VDD VSS VSS gf180mcu_fd_sc_mcu7t5v0__fillcap_32
XFILLER_149_842 VDD VDD VSS VSS gf180mcu_fd_sc_mcu7t5v0__fillcap_64
XFILLER_167_127 VDD VDD VSS VSS gf180mcu_fd_sc_mcu7t5v0__fillcap_8
XFILLER_167_138 VDD VDD VSS VSS gf180mcu_fd_sc_mcu7t5v0__fillcap_32
Xwave_controller_x_inst__2384_ wave_controller_x_inst__3245_/A1 wave_controller_x_inst__2383_/Z
+ wave_controller_x_inst__2384_/Z VDD VDD VSS VSS gf180mcu_fd_sc_mcu7t5v0__or2_1
XFILLER_164_801 VDD VDD VSS VSS gf180mcu_fd_sc_mcu7t5v0__fillcap_4
XFILLER_22_177 VDD VDD VSS VSS gf180mcu_fd_sc_mcu7t5v0__fill_2
XFILLER_22_188 VDD VDD VSS VSS gf180mcu_fd_sc_mcu7t5v0__fillcap_4
XFILLER_108_238 VDD VDD VSS VSS gf180mcu_fd_sc_mcu7t5v0__fillcap_4
Xwave_controller_y_inst__3021_ wave_controller_y_inst__3440_/A1 wave_controller_y_inst__3021_/A2
+ wave_controller_y_inst__3021_/B1 wave_controller_y_inst__3034_/B1 wave_controller_y_inst__3694_/D
+ VDD VDD VSS VSS gf180mcu_fd_sc_mcu7t5v0__aoi22_1
Xwave_controller_x_inst__3005_ wave_controller_x_inst__3719_/Q wave_controller_x_inst__3089_/B
+ wave_controller_x_inst__3089_/A2 wave_controller_x_inst__3005_/Z VDD VDD VSS VSS
+ gf180mcu_fd_sc_mcu7t5v0__and3_1
XFILLER_105_901 VDD VDD VSS VSS gf180mcu_fd_sc_mcu7t5v0__fill_1
XFILLER_105_912 VDD VDD VSS VSS gf180mcu_fd_sc_mcu7t5v0__fillcap_64
XFILLER_117_772 VDD VDD VSS VSS gf180mcu_fd_sc_mcu7t5v0__fill_2
XFILLER_124_709 VDD VDD VSS VSS gf180mcu_fd_sc_mcu7t5v0__fill_2
XTAP_TAPCELL_ROW_42_1_643 VDD VSS gf180mcu_fd_sc_mcu7t5v0__filltie
XTAP_TAPCELL_ROW_79_1177 VDD VSS gf180mcu_fd_sc_mcu7t5v0__filltie
XTAP_TAPCELL_ROW_79_1188 VDD VSS gf180mcu_fd_sc_mcu7t5v0__filltie
XFILLER_2_527 VDD VDD VSS VSS gf180mcu_fd_sc_mcu7t5v0__fillcap_16
XFILLER_85_1154 VDD VDD VSS VSS gf180mcu_fd_sc_mcu7t5v0__fillcap_16
XFILLER_132_753 VDD VDD VSS VSS gf180mcu_fd_sc_mcu7t5v0__fillcap_8
XFILLER_78_807 VDD VDD VSS VSS gf180mcu_fd_sc_mcu7t5v0__fillcap_16
XTAP_TAPCELL_ROW_92_1388 VDD VSS gf180mcu_fd_sc_mcu7t5v0__filltie
XFILLER_104_499 VDD VDD VSS VSS gf180mcu_fd_sc_mcu7t5v0__fillcap_4
XFILLER_132_775 VDD VDD VSS VSS gf180mcu_fd_sc_mcu7t5v0__fillcap_4
XFILLER_89_188 VDD VDD VSS VSS gf180mcu_fd_sc_mcu7t5v0__fillcap_4
XTAP_TAPCELL_ROW_92_1399 VDD VSS gf180mcu_fd_sc_mcu7t5v0__filltie
XFILLER_89_199 VDD VDD VSS VSS gf180mcu_fd_sc_mcu7t5v0__fill_1
XFILLER_133_65 VDD VDD VSS VSS gf180mcu_fd_sc_mcu7t5v0__fill_1
XFILLER_86_862 VDD VDD VSS VSS gf180mcu_fd_sc_mcu7t5v0__fill_2
Xwave_controller_y_inst__2805_ spi_regs_inst__1316_/A1 spi_regs_inst__1312_/B2 wave_controller_y_inst__2805_/S
+ wave_controller_y_inst__2806_/I VDD VDD VSS VSS gf180mcu_fd_sc_mcu7t5v0__mux2_2
XFILLER_58_597 VDD VDD VSS VSS gf180mcu_fd_sc_mcu7t5v0__fillcap_16
XFILLER_73_545 VDD VDD VSS VSS gf180mcu_fd_sc_mcu7t5v0__fillcap_8
XFILLER_26_30 VDD VDD VSS VSS gf180mcu_fd_sc_mcu7t5v0__fillcap_4
XFILLER_73_567 VDD VDD VSS VSS gf180mcu_fd_sc_mcu7t5v0__fill_1
Xwave_controller_y_inst__2736_ wave_controller_y_inst__2736_/I wave_controller_y_inst__2749_/A1
+ VDD VDD VSS VSS gf180mcu_fd_sc_mcu7t5v0__clkinv_1
XTAP_TAPCELL_ROW_56_798 VDD VSS gf180mcu_fd_sc_mcu7t5v0__filltie
Xwave_controller_y_inst__2667_ wave_controller_y_inst__2681_/A2 wave_controller_y_inst__2667_/A2
+ spi_regs_inst_wire28/I VDD VDD VSS VSS gf180mcu_fd_sc_mcu7t5v0__xnor2_1
XFILLER_13_122 VDD VDD VSS VSS gf180mcu_fd_sc_mcu7t5v0__fillcap_16
XFILLER_159_617 VDD VDD VSS VSS gf180mcu_fd_sc_mcu7t5v0__fillcap_8
XTAP_TAPCELL_ROW_140_2190 VDD VSS gf180mcu_fd_sc_mcu7t5v0__filltie
XFILLER_92_1169 VDD VDD VSS VSS gf180mcu_fd_sc_mcu7t5v0__fill_1
Xwave_controller_y_inst__2598_ wave_controller_y_inst__3212_/B wave_controller_y_inst__2597_/Z
+ wave_controller_y_inst__2627_/A1 VDD VDD VSS VSS gf180mcu_fd_sc_mcu7t5v0__nor2_1
XTAP_TAPCELL_ROW_99_1509 VDD VSS gf180mcu_fd_sc_mcu7t5v0__filltie
XFILLER_139_341 VDD VDD VSS VSS gf180mcu_fd_sc_mcu7t5v0__fillcap_8
XFILLER_41_486 VDD VDD VSS VSS gf180mcu_fd_sc_mcu7t5v0__fillcap_4
XFILLER_139_352 VDD VDD VSS VSS gf180mcu_fd_sc_mcu7t5v0__fillcap_8
XFILLER_127_536 VDD VDD VSS VSS gf180mcu_fd_sc_mcu7t5v0__fill_2
XFILLER_166_171 VDD VDD VSS VSS gf180mcu_fd_sc_mcu7t5v0__fillcap_4
XTAP_TAPCELL_ROW_28_1_544 VDD VSS gf180mcu_fd_sc_mcu7t5v0__filltie
Xwave_controller_y_inst__3219_ wave_controller_y_inst__3146_/C wave_controller_y_inst__3222_/A1
+ wave_controller_y_inst__3219_/B wave_controller_y_inst__3219_/C wave_controller_y_inst__3236_/A2
+ VDD VDD VSS VSS gf180mcu_fd_sc_mcu7t5v0__aoi211_1
Xspi_regs_inst__1190_ spi_regs_inst__1190_/A1 spi_regs_inst__1190_/A2 spi_regs_inst__1340_/B1
+ spi_regs_inst__1610_/Q spi_regs_inst__1191_/A4 VDD VDD VSS VSS gf180mcu_fd_sc_mcu7t5v0__aoi22_1
XFILLER_154_355 VDD VDD VSS VSS gf180mcu_fd_sc_mcu7t5v0__fill_1
XFILLER_107_260 VDD VDD VSS VSS gf180mcu_fd_sc_mcu7t5v0__fillcap_4
XFILLER_107_282 VDD VDD VSS VSS gf180mcu_fd_sc_mcu7t5v0__fillcap_4
XFILLER_47_8 VDD VDD VSS VSS gf180mcu_fd_sc_mcu7t5v0__fillcap_16
XFILLER_68_317 VDD VDD VSS VSS gf180mcu_fd_sc_mcu7t5v0__fillcap_8
XTAP_TAPCELL_ROW_147_2300 VDD VSS gf180mcu_fd_sc_mcu7t5v0__filltie
Xsignal_processor_y_inst__140_ signal_processor_y_inst__237_/Q signal_processor_y_inst__140_/A2
+ signal_processor_y_inst__193_/C VDD VDD VSS VSS gf180mcu_fd_sc_mcu7t5v0__xor2_1
XFILLER_150_594 VDD VDD VSS VSS gf180mcu_fd_sc_mcu7t5v0__fill_1
XFILLER_95_158 VDD VDD VSS VSS gf180mcu_fd_sc_mcu7t5v0__fill_2
Xspi_regs_inst__0974_ spi_regs_inst__1499_/Q spi_regs_inst__1195_/B1 spi_regs_inst__1254_/A2
+ spi_regs_inst__0974_/B2 spi_regs_inst__1057_/A1 VDD VDD VSS VSS gf180mcu_fd_sc_mcu7t5v0__aoi22_1
X_83_ analog[2] _83_/Z VDD VDD VSS VSS gf180mcu_fd_sc_mcu7t5v0__buf_1
XFILLER_76_383 VDD VDD VSS VSS gf180mcu_fd_sc_mcu7t5v0__fill_2
XFILLER_92_821 VDD VDD VSS VSS gf180mcu_fd_sc_mcu7t5v0__fill_1
XTAP_TAPCELL_ROW_160_2511 VDD VSS gf180mcu_fd_sc_mcu7t5v0__filltie
XTAP_TAPCELL_ROW_160_2522 VDD VSS gf180mcu_fd_sc_mcu7t5v0__filltie
XFILLER_36_247 VDD VDD VSS VSS gf180mcu_fd_sc_mcu7t5v0__fillcap_64
XFILLER_64_578 VDD VDD VSS VSS gf180mcu_fd_sc_mcu7t5v0__fill_1
XPHY_EDGE_ROW_20_1_Right_19 VDD VSS gf180mcu_fd_sc_mcu7t5v0__endcap
XTAP_TAPCELL_ROW_125_1941 VDD VSS gf180mcu_fd_sc_mcu7t5v0__filltie
XFILLER_51_228 VDD VDD VSS VSS gf180mcu_fd_sc_mcu7t5v0__fillcap_4
XFILLER_83_80 VDD VDD VSS VSS gf180mcu_fd_sc_mcu7t5v0__fill_2
XFILLER_60_762 VDD VDD VSS VSS gf180mcu_fd_sc_mcu7t5v0__fill_2
Xspi_regs_inst__1526_ spi_regs_inst__1526_/D spi_regs_inst__1527_/RN clkbuf_leaf_38_clk/Z
+ spi_regs_inst__1526_/Q VDD VDD VSS VSS gf180mcu_fd_sc_mcu7t5v0__dffrnq_1
XFILLER_165_609 VDD VDD VSS VSS gf180mcu_fd_sc_mcu7t5v0__fillcap_16
XTAP_TAPCELL_ROW_158_2484 VDD VSS gf180mcu_fd_sc_mcu7t5v0__filltie
XFILLER_125_1170 VDD VDD VSS VSS gf180mcu_fd_sc_mcu7t5v0__fillcap_4
XFILLER_146_823 VDD VDD VSS VSS gf180mcu_fd_sc_mcu7t5v0__fillcap_32
Xspi_regs_inst__1457_ spi_regs_inst__1457_/D fanout558/Z clkload7/I spi_regs_inst__1457_/Q
+ VDD VDD VSS VSS gf180mcu_fd_sc_mcu7t5v0__dffsnq_1
XFILLER_145_322 VDD VDD VSS VSS gf180mcu_fd_sc_mcu7t5v0__fillcap_8
XFILLER_69_1116 VDD VDD VSS VSS gf180mcu_fd_sc_mcu7t5v0__fillcap_4
Xspi_regs_inst__1388_ fanout540/Z spi_regs_inst__1439_/I1 spi_regs_inst__1391_/S spi_regs_inst__1463_/D
+ VDD VDD VSS VSS gf180mcu_fd_sc_mcu7t5v0__mux2_2
XFILLER_145_366 VDD VDD VSS VSS gf180mcu_fd_sc_mcu7t5v0__fillcap_8
XFILLER_160_325 VDD VDD VSS VSS gf180mcu_fd_sc_mcu7t5v0__fillcap_8
XFILLER_141_583 VDD VDD VSS VSS gf180mcu_fd_sc_mcu7t5v0__fillcap_8
XTAP_TAPCELL_ROW_74_1096 VDD VSS gf180mcu_fd_sc_mcu7t5v0__filltie
XFILLER_87_648 VDD VDD VSS VSS gf180mcu_fd_sc_mcu7t5v0__fillcap_4
Xwave_controller_x_inst__1953_ wave_controller_x_inst__3043_/A2 spi_regs_inst__1193_/B2
+ wave_controller_x_inst__1962_/A1 VDD VDD VSS VSS gf180mcu_fd_sc_mcu7t5v0__nand2_1
XFILLER_68_873 VDD VDD VSS VSS gf180mcu_fd_sc_mcu7t5v0__fill_2
Xwave_controller_x_inst__1884_ spi_regs_inst__1337_/A1 wave_controller_x_inst__3542_/B2
+ VDD VDD VSS VSS gf180mcu_fd_sc_mcu7t5v0__clkinv_1
XFILLER_27_214 VDD VDD VSS VSS gf180mcu_fd_sc_mcu7t5v0__fill_1
XTAP_TAPCELL_ROW_45_1_669 VDD VSS gf180mcu_fd_sc_mcu7t5v0__filltie
Xwave_controller_x_inst__3623_ wave_controller_x_inst__3623_/D wave_controller_x_inst__3723_/RN
+ clkload28/I spi_regs_inst__1197_/B2 VDD VDD VSS VSS gf180mcu_fd_sc_mcu7t5v0__dffrnq_1
XFILLER_27_236 VDD VDD VSS VSS gf180mcu_fd_sc_mcu7t5v0__fill_2
Xwave_controller_y_inst__3570_ wave_controller_y_inst__3570_/A1 wave_controller_y_inst__3572_/A2
+ wave_controller_y_inst__3601_/I0 VDD VDD VSS VSS gf180mcu_fd_sc_mcu7t5v0__nor2_1
Xwave_controller_x_inst__3554_ wave_controller_x_inst__3557_/A1 wave_controller_x_inst__3554_/A2
+ wave_controller_x_inst__3554_/A3 wave_controller_x_inst__3557_/B1 wave_controller_x_inst__3554_/B2
+ wave_controller_x_inst__3647_/D VDD VDD VSS VSS gf180mcu_fd_sc_mcu7t5v0__oai32_1
XFILLER_103_68 VDD VDD VSS VSS gf180mcu_fd_sc_mcu7t5v0__fill_2
XFILLER_42_217 VDD VDD VSS VSS gf180mcu_fd_sc_mcu7t5v0__fillcap_4
XFILLER_70_537 VDD VDD VSS VSS gf180mcu_fd_sc_mcu7t5v0__fill_1
XFILLER_82_375 VDD VDD VSS VSS gf180mcu_fd_sc_mcu7t5v0__fillcap_8
Xwave_controller_y_inst__2521_ wave_controller_y_inst__2521_/A1 wave_controller_y_inst__3515_/B2
+ wave_controller_y_inst__2534_/A2 wave_controller_y_inst__2521_/Z VDD VDD VSS VSS
+ gf180mcu_fd_sc_mcu7t5v0__xor3_1
Xwave_controller_x_inst__2505_ spi_regs_inst__1259_/B2 wave_controller_x_inst__2511_/A2
+ wave_controller_x_inst__2505_/Z VDD VDD VSS VSS gf180mcu_fd_sc_mcu7t5v0__xor2_1
XFILLER_42_239 VDD VDD VSS VSS gf180mcu_fd_sc_mcu7t5v0__fillcap_4
XTAP_TAPCELL_ROW_53_735 VDD VSS gf180mcu_fd_sc_mcu7t5v0__filltie
XTAP_TAPCELL_ROW_53_746 VDD VSS gf180mcu_fd_sc_mcu7t5v0__filltie
XTAP_TAPCELL_ROW_53_757 VDD VSS gf180mcu_fd_sc_mcu7t5v0__filltie
Xwave_controller_y_inst__2452_ spi_regs_inst__1101_/A1 wave_controller_y_inst__3500_/B2
+ wave_controller_y_inst__2462_/A1 VDD VDD VSS VSS gf180mcu_fd_sc_mcu7t5v0__nand2_1
Xwave_controller_x_inst__3485_ wave_controller_x_inst__3454_/B wave_controller_x_inst__3485_/A2
+ wave_controller_x_inst__3485_/A3 wave_controller_x_inst__3485_/B wave_controller_x_inst__3490_/C
+ VDD VDD VSS VSS gf180mcu_fd_sc_mcu7t5v0__oai31_1
Xwave_controller_x_inst__2436_ wave_controller_x_inst__2436_/A1 wave_controller_x_inst__2436_/A2
+ wave_controller_x_inst__2436_/B wave_controller_x_inst__2449_/B2 VDD VDD VSS VSS
+ gf180mcu_fd_sc_mcu7t5v0__aoi21_1
Xsignal_processor_x_inst__160_ signal_processor_x_inst__231_/Q signal_processor_x_inst__232_/Q
+ signal_processor_x_inst__161_/A4 VDD VDD VSS VSS gf180mcu_fd_sc_mcu7t5v0__nand2_1
XFILLER_50_294 VDD VDD VSS VSS gf180mcu_fd_sc_mcu7t5v0__fillcap_8
Xwave_controller_y_inst__2383_ wave_controller_y_inst__2379_/Z wave_controller_y_inst__2383_/A2
+ wave_controller_y_inst__2383_/Z VDD VDD VSS VSS gf180mcu_fd_sc_mcu7t5v0__xor2_1
Xwave_controller_x_inst__2367_ fanout536/Z wave_controller_x_inst__2363_/Z wave_controller_x_inst__2367_/A3
+ wave_controller_x_inst__2367_/Z VDD VDD VSS VSS gf180mcu_fd_sc_mcu7t5v0__xor3_1
XFILLER_149_672 VDD VDD VSS VSS gf180mcu_fd_sc_mcu7t5v0__fill_2
XFILLER_6_107 VDD VDD VSS VSS gf180mcu_fd_sc_mcu7t5v0__fillcap_64
Xwave_controller_x_inst__2298_ wave_controller_x_inst__2318_/A1 wire454/Z wave_controller_x_inst__2298_/Z
+ VDD VDD VSS VSS gf180mcu_fd_sc_mcu7t5v0__xor2_1
XFILLER_152_804 VDD VDD VSS VSS gf180mcu_fd_sc_mcu7t5v0__fill_1
Xwave_controller_y_inst__3004_ wave_controller_y_inst__3081_/A1 wave_controller_y_inst__3081_/A2
+ wave_controller_y_inst__3004_/B wave_controller_y_inst__3081_/B wave_controller_y_inst__3089_/A2
+ VDD VDD VSS VSS gf180mcu_fd_sc_mcu7t5v0__aoi211_1
XTAP_TAPCELL_ROW_94_1428 VDD VSS gf180mcu_fd_sc_mcu7t5v0__filltie
XFILLER_105_720 VDD VDD VSS VSS gf180mcu_fd_sc_mcu7t5v0__fillcap_8
XFILLER_104_241 VDD VDD VSS VSS gf180mcu_fd_sc_mcu7t5v0__fillcap_4
XFILLER_137_1052 VDD VDD VSS VSS gf180mcu_fd_sc_mcu7t5v0__fillcap_64
XFILLER_120_734 VDD VDD VSS VSS gf180mcu_fd_sc_mcu7t5v0__fill_1
XFILLER_46_501 VDD VDD VSS VSS gf180mcu_fd_sc_mcu7t5v0__fill_1
XFILLER_59_884 VDD VDD VSS VSS gf180mcu_fd_sc_mcu7t5v0__fillcap_8
XFILLER_93_629 VDD VDD VSS VSS gf180mcu_fd_sc_mcu7t5v0__fill_1
XFILLER_18_214 VDD VDD VSS VSS gf180mcu_fd_sc_mcu7t5v0__fillcap_8
XFILLER_58_394 VDD VDD VSS VSS gf180mcu_fd_sc_mcu7t5v0__fillcap_16
XFILLER_18_247 VDD VDD VSS VSS gf180mcu_fd_sc_mcu7t5v0__fillcap_4
XFILLER_46_545 VDD VDD VSS VSS gf180mcu_fd_sc_mcu7t5v0__fillcap_8
XFILLER_74_865 VDD VDD VSS VSS gf180mcu_fd_sc_mcu7t5v0__fillcap_4
XFILLER_61_515 VDD VDD VSS VSS gf180mcu_fd_sc_mcu7t5v0__fillcap_16
Xwave_controller_y_inst__2719_ wave_controller_y_inst__2716_/Z wave_controller_y_inst__2719_/A2
+ wave_controller_y_inst__2719_/Z VDD VDD VSS VSS gf180mcu_fd_sc_mcu7t5v0__xor2_1
Xwave_controller_y_inst__3699_ wave_controller_y_inst__3699_/D wave_controller_y_inst__3699_/RN
+ clkbuf_leaf_46_clk/Z wave_controller_y_inst__3699_/Q VDD VDD VSS VSS gf180mcu_fd_sc_mcu7t5v0__dffrnq_1
XFILLER_109_1154 VDD VDD VSS VSS gf180mcu_fd_sc_mcu7t5v0__fillcap_16
XFILLER_14_464 VDD VDD VSS VSS gf180mcu_fd_sc_mcu7t5v0__fillcap_16
XFILLER_41_272 VDD VDD VSS VSS gf180mcu_fd_sc_mcu7t5v0__fillcap_8
XTAP_TAPCELL_ROW_103_1579 VDD VSS gf180mcu_fd_sc_mcu7t5v0__filltie
XTAP_TAPCELL_ROW_120_1860 VDD VSS gf180mcu_fd_sc_mcu7t5v0__filltie
Xspi_regs_inst__1311_ spi_regs_inst__1311_/A1 spi_regs_inst_wire296/Z spi_regs_inst_wire214/I
+ spi_regs_inst__1311_/B2 spi_regs_inst__1313_/A2 VDD VDD VSS VSS gf180mcu_fd_sc_mcu7t5v0__aoi22_1
XFILLER_128_812 VDD VDD VSS VSS gf180mcu_fd_sc_mcu7t5v0__fill_2
XFILLER_139_193 VDD VDD VSS VSS gf180mcu_fd_sc_mcu7t5v0__fill_1
Xspi_regs_inst__1242_ spi_regs_inst__1242_/A1 spi_regs_inst__1242_/A2 spi_regs_inst__1242_/A3
+ spi_regs_inst__1242_/A4 spi_regs_inst__1243_/A4 VDD VDD VSS VSS gf180mcu_fd_sc_mcu7t5v0__nand4_1
XTAP_TAPCELL_ROW_3_1_353 VDD VSS gf180mcu_fd_sc_mcu7t5v0__filltie
Xspi_regs_inst__1173_ spi_regs_inst__1643_/Q spi_regs_inst__1074_/Z spi_regs_inst__1174_/A3
+ VDD VDD VSS VSS gf180mcu_fd_sc_mcu7t5v0__nor2_1
Xanalog_block_inst_analog_wave_mixer_y_inst__0_ _94_/I analog[1] analog[3] VDD VDD
+ VSS VSS gf180mcu_fd_sc_mcu7t5v0__and2_1
XFILLER_142_325 VDD VDD VSS VSS gf180mcu_fd_sc_mcu7t5v0__fillcap_4
XFILLER_142_369 VDD VDD VSS VSS gf180mcu_fd_sc_mcu7t5v0__fillcap_16
XFILLER_96_401 VDD VDD VSS VSS gf180mcu_fd_sc_mcu7t5v0__fill_2
XFILLER_110_222 VDD VDD VSS VSS gf180mcu_fd_sc_mcu7t5v0__fill_2
XFILLER_150_380 VDD VDD VSS VSS gf180mcu_fd_sc_mcu7t5v0__fillcap_4
XFILLER_96_445 VDD VDD VSS VSS gf180mcu_fd_sc_mcu7t5v0__fill_1
Xsignal_processor_y_inst__123_ signal_processor_y_inst__179_/A1 signal_processor_y_inst__251_/Q
+ signal_processor_y_inst__252_/D VDD VDD VSS VSS gf180mcu_fd_sc_mcu7t5v0__and2_1
XFILLER_110_244 VDD VDD VSS VSS gf180mcu_fd_sc_mcu7t5v0__fill_1
XFILLER_116_1169 VDD VDD VSS VSS gf180mcu_fd_sc_mcu7t5v0__fill_1
XFILLER_96_478 VDD VDD VSS VSS gf180mcu_fd_sc_mcu7t5v0__fill_2
XFILLER_49_394 VDD VDD VSS VSS gf180mcu_fd_sc_mcu7t5v0__fillcap_4
Xspi_regs_inst__0957_ spi_regs_inst__1366_/A1 spi_regs_inst__1628_/Q spi_regs_inst__0995_/A3
+ spi_regs_inst__1032_/A2 VDD VDD VSS VSS gf180mcu_fd_sc_mcu7t5v0__nand3_1
XFILLER_65_898 VDD VDD VSS VSS gf180mcu_fd_sc_mcu7t5v0__fillcap_8
XFILLER_91_150 VDD VDD VSS VSS gf180mcu_fd_sc_mcu7t5v0__fill_2
XFILLER_92_684 VDD VDD VSS VSS gf180mcu_fd_sc_mcu7t5v0__fillcap_4
XTAP_TAPCELL_ROW_41_1_642 VDD VSS gf180mcu_fd_sc_mcu7t5v0__filltie
Xspi_regs_inst__0888_ spi_regs_inst__1622_/Q spi_regs_inst__1379_/I1 spi_regs_inst__0888_/S
+ spi_regs_inst__1622_/D VDD VDD VSS VSS gf180mcu_fd_sc_mcu7t5v0__mux2_2
XFILLER_52_548 VDD VDD VSS VSS gf180mcu_fd_sc_mcu7t5v0__fillcap_4
Xwave_controller_x_inst__3270_ wave_controller_x_inst__3570_/A1 spi_regs_inst__1547_/Q
+ wave_controller_x_inst__3296_/C VDD VDD VSS VSS gf180mcu_fd_sc_mcu7t5v0__nand2_1
Xwave_controller_x_inst__2221_ wave_controller_x_inst__2221_/A1 wave_controller_x_inst__2194_/I
+ wave_controller_x_inst__2221_/B wave_controller_x_inst__2221_/C wave_controller_x_inst_wire184/I
+ VDD VDD VSS VSS gf180mcu_fd_sc_mcu7t5v0__aoi211_1
XFILLER_119_812 VDD VDD VSS VSS gf180mcu_fd_sc_mcu7t5v0__fillcap_4
XFILLER_137_108 VDD VDD VSS VSS gf180mcu_fd_sc_mcu7t5v0__fillcap_8
XFILLER_165_428 VDD VDD VSS VSS gf180mcu_fd_sc_mcu7t5v0__fillcap_16
Xwave_controller_x_inst__2152_ wave_controller_x_inst__3732_/Q wave_controller_x_inst__2152_/A2
+ wave_controller_x_inst__2152_/B wave_controller_x_inst__2756_/A1 VDD VDD VSS VSS
+ gf180mcu_fd_sc_mcu7t5v0__aoi21_1
Xspi_regs_inst__1509_ spi_regs_inst__1509_/D spi_regs_inst__1551_/RN clkload30/I spi_regs_inst__1509_/Q
+ VDD VDD VSS VSS gf180mcu_fd_sc_mcu7t5v0__dffrnq_1
XFILLER_118_366 VDD VDD VSS VSS gf180mcu_fd_sc_mcu7t5v0__fill_1
XFILLER_146_664 VDD VDD VSS VSS gf180mcu_fd_sc_mcu7t5v0__fill_1
Xwave_controller_x_inst__2083_ wave_controller_x_inst__2124_/B wave_controller_x_inst__2090_/A1
+ wave_controller_x_inst__2083_/B wave_controller_x_inst__2117_/A1 VDD VDD VSS VSS
+ gf180mcu_fd_sc_mcu7t5v0__aoi21_1
XTAP_TAPCELL_ROW_76_1125 VDD VSS gf180mcu_fd_sc_mcu7t5v0__filltie
XTAP_TAPCELL_ROW_76_1136 VDD VSS gf180mcu_fd_sc_mcu7t5v0__filltie
XFILLER_160_177 VDD VDD VSS VSS gf180mcu_fd_sc_mcu7t5v0__fill_1
Xwave_controller_x_inst_fanout607 fanout608/Z wave_controller_x_inst__3716_/RN VDD
+ VDD VSS VSS gf180mcu_fd_sc_mcu7t5v0__dlyb_1
XFILLER_114_594 VDD VDD VSS VSS gf180mcu_fd_sc_mcu7t5v0__fill_1
XFILLER_82_1157 VDD VDD VSS VSS gf180mcu_fd_sc_mcu7t5v0__fillcap_8
XFILLER_99_294 VDD VDD VSS VSS gf180mcu_fd_sc_mcu7t5v0__fill_2
Xwave_controller_x_inst_fanout618 fanout619/Z wave_controller_x_inst__3701_/RN VDD
+ VDD VSS VSS gf180mcu_fd_sc_mcu7t5v0__dlyb_1
Xwave_controller_x_inst__2985_ wave_controller_x_inst__2945_/Z wave_controller_x_inst__2985_/A2
+ wave_controller_x_inst__2985_/A3 wave_controller_x_inst__2985_/B wave_controller_x_inst_wire94/I
+ VDD VDD VSS VSS gf180mcu_fd_sc_mcu7t5v0__oai31_1
Xwave_controller_y_inst__1952_ fanout392/Z wave_controller_y_inst__1952_/A2 wave_controller_y_inst__3735_/D
+ VDD VDD VSS VSS gf180mcu_fd_sc_mcu7t5v0__and2_1
Xwave_controller_x_inst__1936_ spi_regs_inst__1513_/Q wave_controller_x_inst__3078_/A1
+ spi_regs_inst__1512_/Q wave_controller_x_inst__3265_/A1 wave_controller_x_inst__1938_/A4
+ VDD VDD VSS VSS gf180mcu_fd_sc_mcu7t5v0__aoi22_1
XFILLER_101_277 VDD VDD VSS VSS gf180mcu_fd_sc_mcu7t5v0__fill_2
XTAP_TAPCELL_ROW_58_827 VDD VSS gf180mcu_fd_sc_mcu7t5v0__filltie
XTAP_TAPCELL_ROW_58_838 VDD VSS gf180mcu_fd_sc_mcu7t5v0__filltie
Xwave_controller_y_inst__1883_ spi_regs_inst__1303_/A1 wave_controller_y_inst__3539_/B2
+ VDD VDD VSS VSS gf180mcu_fd_sc_mcu7t5v0__clkinv_1
XTAP_TAPCELL_ROW_27_1_532 VDD VSS gf180mcu_fd_sc_mcu7t5v0__filltie
Xwave_controller_y_inst__3622_ wave_controller_y_inst__3622_/D wave_controller_y_inst__3739_/RN
+ clkload15/I spi_regs_inst__1160_/A1 VDD VDD VSS VSS gf180mcu_fd_sc_mcu7t5v0__dffrnq_1
Xwave_controller_x_inst__3606_ wave_controller_x_inst__3610_/A1 wave_controller_x_inst__3606_/A2
+ wave_controller_x_inst__3606_/B wave_controller_x_inst__3679_/D VDD VDD VSS VSS
+ gf180mcu_fd_sc_mcu7t5v0__oai21_1
Xwave_controller_x_inst__1867_ wire450/Z wave_controller_x_inst__2730_/B2 VDD VDD
+ VSS VSS gf180mcu_fd_sc_mcu7t5v0__clkinv_1
Xwave_controller_y_inst__3553_ spi_regs_inst__1194_/B2 wave_controller_y_inst__3556_/A2
+ wave_controller_y_inst__3554_/A3 VDD VDD VSS VSS gf180mcu_fd_sc_mcu7t5v0__nor2_1
Xwave_controller_x_inst__1798_ wave_controller_x_inst__3702_/Q wave_controller_x_inst__3560_/A1
+ VDD VDD VSS VSS gf180mcu_fd_sc_mcu7t5v0__clkinv_1
XFILLER_167_1056 VDD VDD VSS VSS gf180mcu_fd_sc_mcu7t5v0__fillcap_8
Xwave_controller_y_inst__2504_ fanout508/Z wave_controller_y_inst__2518_/A3 wave_controller_y_inst__2504_/A3
+ wave_controller_y_inst__2511_/A2 VDD VDD VSS VSS gf180mcu_fd_sc_mcu7t5v0__xnor3_1
Xwave_controller_x_inst__3537_ wave_controller_x_inst__3715_/Q wave_controller_x_inst__3537_/A2
+ wave_controller_x_inst__3539_/A2 VDD VDD VSS VSS gf180mcu_fd_sc_mcu7t5v0__nor2_1
Xwave_controller_y_inst__3484_ spi_regs_inst__1334_/A1 wave_controller_y_inst_wire352/Z
+ wave_controller_y_inst__3485_/A3 VDD VDD VSS VSS gf180mcu_fd_sc_mcu7t5v0__nor2_1
Xwave_controller_x_inst__3468_ wave_controller_x_inst__3468_/I wave_controller_x_inst__3469_/B2
+ VDD VDD VSS VSS gf180mcu_fd_sc_mcu7t5v0__clkinv_1
Xsignal_processor_x_inst__212_ spi_regs_inst__1040_/B2 signal_processor_x_inst__214_/A2
+ signal_processor_x_inst__213_/B VDD VDD VSS VSS gf180mcu_fd_sc_mcu7t5v0__nand2_1
XFILLER_23_272 VDD VDD VSS VSS gf180mcu_fd_sc_mcu7t5v0__fillcap_8
Xwave_controller_y_inst__2435_ wave_controller_y_inst__2435_/A1 wave_controller_y_inst__2435_/A2
+ wave_controller_y_inst__2436_/B VDD VDD VSS VSS gf180mcu_fd_sc_mcu7t5v0__nand2_1
Xwave_controller_x_inst__2419_ fanout534/Z wave_controller_x_inst__2402_/Z wave_controller_x_inst__2419_/B
+ wave_controller_x_inst__2434_/A2 VDD VDD VSS VSS gf180mcu_fd_sc_mcu7t5v0__oai21_1
Xsignal_processor_x_inst__143_ signal_processor_x_inst__108_/I signal_processor_x_inst__195_/B
+ signal_processor_x_inst__187_/A1 VDD VDD VSS VSS gf180mcu_fd_sc_mcu7t5v0__nand2_1
XFILLER_128_119 VDD VDD VSS VSS gf180mcu_fd_sc_mcu7t5v0__fill_2
Xwave_controller_y_inst__2366_ wave_controller_y_inst__2671_/A1 wave_controller_y_inst__2366_/A2
+ wave_controller_y_inst__2389_/A1 VDD VDD VSS VSS gf180mcu_fd_sc_mcu7t5v0__nand2_1
Xwave_controller_x_inst__3399_ wave_controller_x_inst__3399_/A1 wave_controller_x_inst__3341_/B
+ wave_controller_x_inst__3400_/C VDD VDD VSS VSS gf180mcu_fd_sc_mcu7t5v0__xor2_1
XFILLER_128_2 VDD VDD VSS VSS gf180mcu_fd_sc_mcu7t5v0__fillcap_32
XFILLER_7_438 VDD VDD VSS VSS gf180mcu_fd_sc_mcu7t5v0__fillcap_8
XPHY_EDGE_ROW_137_Right_137 VDD VSS gf180mcu_fd_sc_mcu7t5v0__endcap
Xwave_controller_y_inst__2297_ wave_controller_y_inst__2309_/A2 wave_controller_y_inst__2297_/A2
+ spi_regs_inst_wire30/I VDD VDD VSS VSS gf180mcu_fd_sc_mcu7t5v0__xor2_1
XFILLER_109_399 VDD VDD VSS VSS gf180mcu_fd_sc_mcu7t5v0__fillcap_8
XFILLER_87_1046 VDD VDD VSS VSS gf180mcu_fd_sc_mcu7t5v0__fillcap_4
XFILLER_140_807 VDD VDD VSS VSS gf180mcu_fd_sc_mcu7t5v0__fillcap_32
XFILLER_152_667 VDD VDD VSS VSS gf180mcu_fd_sc_mcu7t5v0__fillcap_16
XFILLER_120_520 VDD VDD VSS VSS gf180mcu_fd_sc_mcu7t5v0__fillcap_4
XFILLER_79_957 VDD VDD VSS VSS gf180mcu_fd_sc_mcu7t5v0__fillcap_16
XFILLER_79_979 VDD VDD VSS VSS gf180mcu_fd_sc_mcu7t5v0__fill_1
XFILLER_120_597 VDD VDD VSS VSS gf180mcu_fd_sc_mcu7t5v0__fillcap_8
XFILLER_19_512 VDD VDD VSS VSS gf180mcu_fd_sc_mcu7t5v0__fill_1
XTAP_TAPCELL_ROW_6_1_379 VDD VSS gf180mcu_fd_sc_mcu7t5v0__filltie
Xspi_regs_inst__0811_ spi_regs_inst__1558_/Q spi_regs_inst__1378_/I1 spi_regs_inst__0814_/S
+ spi_regs_inst__1558_/D VDD VDD VSS VSS gf180mcu_fd_sc_mcu7t5v0__mux2_2
XFILLER_74_662 VDD VDD VSS VSS gf180mcu_fd_sc_mcu7t5v0__fill_2
XFILLER_94_1017 VDD VDD VSS VSS gf180mcu_fd_sc_mcu7t5v0__fillcap_64
XTAP_TAPCELL_ROW_105_1608 VDD VSS gf180mcu_fd_sc_mcu7t5v0__filltie
Xspi_regs_inst__0742_ spi_regs_inst__0827_/A1 spi_regs_inst__1652_/Q spi_regs_inst__1437_/A1
+ VDD VDD VSS VSS gf180mcu_fd_sc_mcu7t5v0__nand2_1
XFILLER_70_890 VDD VDD VSS VSS gf180mcu_fd_sc_mcu7t5v0__fillcap_4
XFILLER_9_66 VDD VDD VSS VSS gf180mcu_fd_sc_mcu7t5v0__fillcap_4
XFILLER_9_88 VDD VDD VSS VSS gf180mcu_fd_sc_mcu7t5v0__fillcap_8
XTAP_TAPCELL_ROW_155_2432 VDD VSS gf180mcu_fd_sc_mcu7t5v0__filltie
XPHY_EDGE_ROW_104_Right_104 VDD VSS gf180mcu_fd_sc_mcu7t5v0__endcap
XFILLER_122_1151 VDD VDD VSS VSS gf180mcu_fd_sc_mcu7t5v0__fillcap_4
XFILLER_122_1173 VDD VDD VSS VSS gf180mcu_fd_sc_mcu7t5v0__fill_1
XFILLER_128_664 VDD VDD VSS VSS gf180mcu_fd_sc_mcu7t5v0__fill_1
Xspi_regs_inst__1225_ spi_regs_inst__1225_/A1 spi_regs_inst__1225_/A2 spi_regs_inst__1339_/B1
+ spi_regs_inst_wire100/Z spi_regs_inst__1228_/A2 VDD VDD VSS VSS gf180mcu_fd_sc_mcu7t5v0__aoi22_1
XFILLER_115_303 VDD VDD VSS VSS gf180mcu_fd_sc_mcu7t5v0__fillcap_4
XFILLER_127_174 VDD VDD VSS VSS gf180mcu_fd_sc_mcu7t5v0__fillcap_4
XFILLER_143_623 VDD VDD VSS VSS gf180mcu_fd_sc_mcu7t5v0__fillcap_4
XFILLER_143_656 VDD VDD VSS VSS gf180mcu_fd_sc_mcu7t5v0__fill_1
Xspi_regs_inst__1156_ fanout539/Z spi_regs_inst__1156_/A2 spi_regs_inst__1185_/B1
+ wire450/Z spi_regs_inst__1157_/A4 VDD VDD VSS VSS gf180mcu_fd_sc_mcu7t5v0__aoi22_1
Xspi_regs_inst__1087_ spi_regs_inst_wire30/Z spi_regs_inst_wire297/I spi_regs_inst__1246_/A2
+ spi_regs_inst__1516_/Q spi_regs_inst__1088_/A4 VDD VDD VSS VSS gf180mcu_fd_sc_mcu7t5v0__aoi22_1
XFILLER_97_743 VDD VDD VSS VSS gf180mcu_fd_sc_mcu7t5v0__fill_2
XTAP_TAPCELL_ROW_71_1044 VDD VSS gf180mcu_fd_sc_mcu7t5v0__filltie
XFILLER_69_456 VDD VDD VSS VSS gf180mcu_fd_sc_mcu7t5v0__fill_1
XFILLER_85_916 VDD VDD VSS VSS gf180mcu_fd_sc_mcu7t5v0__fill_2
XTAP_TAPCELL_ROW_71_1055 VDD VSS gf180mcu_fd_sc_mcu7t5v0__filltie
Xwave_controller_x_inst__2770_ wave_controller_x_inst__3557_/B2 wave_controller_x_inst__2902_/B2
+ wave_controller_x_inst__2770_/B wave_controller_x_inst__2897_/A2 VDD VDD VSS VSS
+ gf180mcu_fd_sc_mcu7t5v0__oai21_1
XFILLER_57_629 VDD VDD VSS VSS gf180mcu_fd_sc_mcu7t5v0__fill_1
XFILLER_84_415 VDD VDD VSS VSS gf180mcu_fd_sc_mcu7t5v0__fill_2
XFILLER_93_982 VDD VDD VSS VSS gf180mcu_fd_sc_mcu7t5v0__fillcap_64
XFILLER_25_548 VDD VDD VSS VSS gf180mcu_fd_sc_mcu7t5v0__fillcap_4
XFILLER_53_835 VDD VDD VSS VSS gf180mcu_fd_sc_mcu7t5v0__fill_1
XFILLER_12_209 VDD VDD VSS VSS gf180mcu_fd_sc_mcu7t5v0__fill_1
XFILLER_40_507 VDD VDD VSS VSS gf180mcu_fd_sc_mcu7t5v0__fill_2
Xwave_controller_x_inst__3322_ wave_controller_x_inst__3347_/B wave_controller_x_inst__3321_/Z
+ wave_controller_x_inst__3333_/A2 VDD VDD VSS VSS gf180mcu_fd_sc_mcu7t5v0__nor2_1
XFILLER_20_220 VDD VDD VSS VSS gf180mcu_fd_sc_mcu7t5v0__fill_2
XFILLER_20_231 VDD VDD VSS VSS gf180mcu_fd_sc_mcu7t5v0__fillcap_8
XFILLER_60_18 VDD VDD VSS VSS gf180mcu_fd_sc_mcu7t5v0__fill_1
Xwave_controller_y_inst__2220_ wave_controller_y_inst__2192_/Z wave_controller_y_inst__2203_/Z
+ wave_controller_y_inst__2221_/B VDD VDD VSS VSS gf180mcu_fd_sc_mcu7t5v0__nand2_1
Xwave_controller_x_inst__3253_ wave_controller_x_inst__3193_/Z wave_controller_x_inst__3253_/A2
+ wave_controller_x_inst__3249_/Z wave_controller_x_inst__3256_/A2 VDD VDD VSS VSS
+ gf180mcu_fd_sc_mcu7t5v0__nor3_1
XFILLER_166_737 VDD VDD VSS VSS gf180mcu_fd_sc_mcu7t5v0__fillcap_64
Xwave_controller_x_inst__3184_ wave_controller_x_inst__3340_/A1 spi_regs_inst__1518_/Q
+ wave_controller_x_inst__3184_/Z VDD VDD VSS VSS gf180mcu_fd_sc_mcu7t5v0__xor2_1
Xwave_controller_x_inst__2204_ wave_controller_x_inst__2192_/Z wave_controller_x_inst__2204_/A2
+ wave_controller_x_inst__2204_/B wave_controller_x_inst__2207_/A3 VDD VDD VSS VSS
+ gf180mcu_fd_sc_mcu7t5v0__aoi21_1
XFILLER_165_269 VDD VDD VSS VSS gf180mcu_fd_sc_mcu7t5v0__fill_2
Xwave_controller_y_inst__2151_ wave_controller_y_inst__2148_/Z wave_controller_y_inst__2151_/A2
+ wave_controller_y_inst__3732_/D VDD VDD VSS VSS gf180mcu_fd_sc_mcu7t5v0__xor2_1
Xwave_controller_x_inst__2135_ wave_controller_x_inst__2136_/A1 wave_controller_x_inst__2134_/Z
+ wave_controller_x_inst__3730_/D VDD VDD VSS VSS gf180mcu_fd_sc_mcu7t5v0__xor2_1
XFILLER_107_837 VDD VDD VSS VSS gf180mcu_fd_sc_mcu7t5v0__fill_2
XFILLER_107_848 VDD VDD VSS VSS gf180mcu_fd_sc_mcu7t5v0__fill_2
XFILLER_146_461 VDD VDD VSS VSS gf180mcu_fd_sc_mcu7t5v0__fill_2
XFILLER_4_408 VDD VDD VSS VSS gf180mcu_fd_sc_mcu7t5v0__fill_2
Xwave_controller_y_inst__2082_ wave_controller_y_inst__2124_/B wave_controller_y_inst__2090_/A1
+ wave_controller_y_inst__2083_/B wave_controller_y_inst__2082_/Z VDD VDD VSS VSS
+ gf180mcu_fd_sc_mcu7t5v0__and3_1
Xwave_controller_x_inst__2066_ wave_controller_x_inst__3726_/Q wave_controller_x_inst_wire173/Z
+ wave_controller_x_inst__2153_/A2 wave_controller_x_inst__2067_/I VDD VDD VSS VSS
+ gf180mcu_fd_sc_mcu7t5v0__nand3_1
XFILLER_109_67 VDD VDD VSS VSS gf180mcu_fd_sc_mcu7t5v0__fill_2
XFILLER_122_807 VDD VDD VSS VSS gf180mcu_fd_sc_mcu7t5v0__fillcap_32
XFILLER_134_667 VDD VDD VSS VSS gf180mcu_fd_sc_mcu7t5v0__fillcap_16
XFILLER_121_306 VDD VDD VSS VSS gf180mcu_fd_sc_mcu7t5v0__fillcap_4
XFILLER_161_464 VDD VDD VSS VSS gf180mcu_fd_sc_mcu7t5v0__fillcap_16
XFILLER_79_209 VDD VDD VSS VSS gf180mcu_fd_sc_mcu7t5v0__fill_1
XFILLER_134_1011 VDD VDD VSS VSS gf180mcu_fd_sc_mcu7t5v0__fillcap_4
XFILLER_88_732 VDD VDD VSS VSS gf180mcu_fd_sc_mcu7t5v0__fill_2
Xspi_regs_inst_wire91 spi_regs_inst_wire91/I spi_regs_inst_wire91/Z VDD VDD VSS VSS
+ gf180mcu_fd_sc_mcu7t5v0__buf_2
XFILLER_76_905 VDD VDD VSS VSS gf180mcu_fd_sc_mcu7t5v0__fill_1
XFILLER_88_765 VDD VDD VSS VSS gf180mcu_fd_sc_mcu7t5v0__fill_1
Xwave_controller_y_inst__2984_ wave_controller_y_inst__3712_/Q wave_controller_y_inst__1819_/I
+ fanout517/Z wave_controller_y_inst__3711_/Q wave_controller_y_inst__2985_/B VDD
+ VDD VSS VSS gf180mcu_fd_sc_mcu7t5v0__aoi22_1
Xwave_controller_x_inst_fanout459 spi_regs_inst__1257_/A1 wave_controller_x_inst__2793_/I0
+ VDD VDD VSS VSS gf180mcu_fd_sc_mcu7t5v0__dlyb_1
Xwave_controller_x_inst_fanout448 wave_controller_x_inst__3710_/Q wave_controller_x_inst__1790_/I
+ VDD VDD VSS VSS gf180mcu_fd_sc_mcu7t5v0__dlyb_1
Xwave_controller_x_inst_fanout437 wave_controller_x_inst__2793_/S wave_controller_x_inst__2805_/S
+ VDD VDD VSS VSS gf180mcu_fd_sc_mcu7t5v0__dlyb_1
XFILLER_102_575 VDD VDD VSS VSS gf180mcu_fd_sc_mcu7t5v0__fill_2
XFILLER_102_586 VDD VDD VSS VSS gf180mcu_fd_sc_mcu7t5v0__fillcap_8
XFILLER_102_597 VDD VDD VSS VSS gf180mcu_fd_sc_mcu7t5v0__fill_2
XFILLER_87_264 VDD VDD VSS VSS gf180mcu_fd_sc_mcu7t5v0__fillcap_8
XTAP_TAPCELL_ROW_89_1338 VDD VSS gf180mcu_fd_sc_mcu7t5v0__filltie
Xwave_controller_y_inst__1935_ wave_controller_y_inst__1940_/A1 wave_controller_y_inst__1781_/I
+ wave_controller_y_inst__1937_/A1 wave_controller_y_inst__1783_/I wave_controller_y_inst__1939_/B
+ VDD VDD VSS VSS gf180mcu_fd_sc_mcu7t5v0__aoi22_1
Xwave_controller_x_inst__2968_ wave_controller_x_inst__3704_/Q spi_regs_inst__1473_/Q
+ wave_controller_x_inst__2969_/A2 VDD VDD VSS VSS gf180mcu_fd_sc_mcu7t5v0__nor2_1
XFILLER_47_139 VDD VDD VSS VSS gf180mcu_fd_sc_mcu7t5v0__fill_1
XFILLER_56_640 VDD VDD VSS VSS gf180mcu_fd_sc_mcu7t5v0__fill_2
XTAP_TAPCELL_ROW_89_1349 VDD VSS gf180mcu_fd_sc_mcu7t5v0__filltie
Xwave_controller_x_inst__2899_ wave_controller_x_inst__2897_/Z wave_controller_x_inst__2898_/Z
+ wave_controller_x_inst__2909_/A3 VDD VDD VSS VSS gf180mcu_fd_sc_mcu7t5v0__nor2_1
Xwave_controller_x_inst__1919_ wave_controller_x_inst__1919_/A1 wave_controller_x_inst__1919_/A2
+ wave_controller_x_inst__1919_/B wave_controller_x_inst__1920_/B VDD VDD VSS VSS
+ gf180mcu_fd_sc_mcu7t5v0__oai21_1
XFILLER_16_515 VDD VDD VSS VSS gf180mcu_fd_sc_mcu7t5v0__fill_2
Xwave_controller_y_inst__1866_ spi_regs_inst__1045_/A1 wave_controller_y_inst__2841_/A1
+ VDD VDD VSS VSS gf180mcu_fd_sc_mcu7t5v0__clkinv_1
XFILLER_141_65 VDD VDD VSS VSS gf180mcu_fd_sc_mcu7t5v0__fillcap_4
XFILLER_141_87 VDD VDD VSS VSS gf180mcu_fd_sc_mcu7t5v0__fillcap_4
XFILLER_71_621 VDD VDD VSS VSS gf180mcu_fd_sc_mcu7t5v0__fill_1
XFILLER_71_632 VDD VDD VSS VSS gf180mcu_fd_sc_mcu7t5v0__fillcap_8
XFILLER_83_492 VDD VDD VSS VSS gf180mcu_fd_sc_mcu7t5v0__fillcap_16
Xwave_controller_y_inst__3605_ spi_regs_inst__1109_/A1 wave_controller_y_inst__3606_/A1
+ wave_controller_y_inst__3606_/B VDD VDD VSS VSS gf180mcu_fd_sc_mcu7t5v0__nand2_1
Xwave_controller_y_inst__1797_ wave_controller_y_inst__3703_/Q wave_controller_y_inst__3562_/A1
+ VDD VDD VSS VSS gf180mcu_fd_sc_mcu7t5v0__clkinv_1
Xwave_controller_y_inst__3536_ wave_controller_y_inst__3557_/A1 wave_controller_y_inst__3536_/A2
+ wave_controller_y_inst__3536_/A3 wave_controller_y_inst__3557_/B1 wave_controller_y_inst__3536_/B2
+ wave_controller_y_inst__3641_/D VDD VDD VSS VSS gf180mcu_fd_sc_mcu7t5v0__oai32_1
Xwave_controller_y_inst__3467_ wave_controller_y_inst__3469_/A1 wave_controller_y_inst__3493_/A1
+ wave_controller_y_inst__3467_/B wave_controller_y_inst__3468_/I VDD VDD VSS VSS
+ gf180mcu_fd_sc_mcu7t5v0__oai21_1
XFILLER_34_96 VDD VDD VSS VSS gf180mcu_fd_sc_mcu7t5v0__fillcap_8
XTAP_TAPCELL_ROW_100_1527 VDD VSS gf180mcu_fd_sc_mcu7t5v0__filltie
Xwave_controller_y_inst__2418_ spi_regs_inst__1078_/A1 wave_controller_y_inst__2416_/Z
+ wave_controller_y_inst__2418_/Z VDD VDD VSS VSS gf180mcu_fd_sc_mcu7t5v0__xor2_1
XFILLER_106_1157 VDD VDD VSS VSS gf180mcu_fd_sc_mcu7t5v0__fillcap_16
XFILLER_129_428 VDD VDD VSS VSS gf180mcu_fd_sc_mcu7t5v0__fill_1
XTAP_TAPCELL_ROW_137_2140 VDD VSS gf180mcu_fd_sc_mcu7t5v0__filltie
Xwave_controller_y_inst__3398_ wave_controller_y_inst__3398_/A1 wave_controller_y_inst__3398_/A2
+ wave_controller_y_inst__3400_/B VDD VDD VSS VSS gf180mcu_fd_sc_mcu7t5v0__xnor2_1
Xsignal_processor_x_inst__126_ signal_processor_x_inst__108_/I signal_processor_x_inst__246_/Q
+ signal_processor_x_inst__247_/D VDD VDD VSS VSS gf180mcu_fd_sc_mcu7t5v0__and2_1
XFILLER_137_450 VDD VDD VSS VSS gf180mcu_fd_sc_mcu7t5v0__fillcap_8
XFILLER_156_247 VDD VDD VSS VSS gf180mcu_fd_sc_mcu7t5v0__fillcap_32
Xwave_controller_y_inst__2349_ wave_controller_y_inst__2349_/A1 spi_regs_inst__1275_/B2
+ max_cap426/Z wave_controller_y_inst__2349_/C wave_controller_y_inst__2350_/C VDD
+ VDD VSS VSS gf180mcu_fd_sc_mcu7t5v0__aoi211_1
Xstate_machine_inst__40_ state_machine_inst__40_/D fanout585/Z clkbuf_leaf_13_clk/Z
+ spi_regs_inst__1146_/A1 VDD VDD VSS VSS gf180mcu_fd_sc_mcu7t5v0__dffrnq_1
XFILLER_152_442 VDD VDD VSS VSS gf180mcu_fd_sc_mcu7t5v0__fillcap_8
XTAP_TAPCELL_ROW_150_2351 VDD VSS gf180mcu_fd_sc_mcu7t5v0__filltie
XTAP_TAPCELL_ROW_40_1_630 VDD VSS gf180mcu_fd_sc_mcu7t5v0__filltie
Xspi_regs_inst__1010_ spi_regs_inst__1021_/A1 spi_regs_inst__1016_/A2 spi_regs_inst__1200_/B1
+ VDD VDD VSS VSS gf180mcu_fd_sc_mcu7t5v0__nor2_1
XFILLER_112_317 VDD VDD VSS VSS gf180mcu_fd_sc_mcu7t5v0__fillcap_16
XFILLER_124_155 VDD VDD VSS VSS gf180mcu_fd_sc_mcu7t5v0__fillcap_8
XFILLER_125_678 VDD VDD VSS VSS gf180mcu_fd_sc_mcu7t5v0__fill_2
XFILLER_125_689 VDD VDD VSS VSS gf180mcu_fd_sc_mcu7t5v0__fillcap_8
XFILLER_153_976 VDD VDD VSS VSS gf180mcu_fd_sc_mcu7t5v0__fillcap_4
XFILLER_79_710 VDD VDD VSS VSS gf180mcu_fd_sc_mcu7t5v0__fill_2
XTAP_TAPCELL_ROW_115_1770 VDD VSS gf180mcu_fd_sc_mcu7t5v0__filltie
XTAP_TAPCELL_ROW_115_1781 VDD VSS gf180mcu_fd_sc_mcu7t5v0__filltie
XFILLER_140_648 VDD VDD VSS VSS gf180mcu_fd_sc_mcu7t5v0__fillcap_8
XFILLER_93_212 VDD VDD VSS VSS gf180mcu_fd_sc_mcu7t5v0__fill_2
XFILLER_66_459 VDD VDD VSS VSS gf180mcu_fd_sc_mcu7t5v0__fill_1
XFILLER_75_982 VDD VDD VSS VSS gf180mcu_fd_sc_mcu7t5v0__fillcap_64
XFILLER_34_356 VDD VDD VSS VSS gf180mcu_fd_sc_mcu7t5v0__fill_2
XFILLER_61_142 VDD VDD VSS VSS gf180mcu_fd_sc_mcu7t5v0__fillcap_16
Xspi_regs_inst_load_slew485 spi_regs_inst__1407_/I1 spi_regs_inst__1416_/I0 VDD VDD
+ VSS VSS gf180mcu_fd_sc_mcu7t5v0__buf_4
XFILLER_22_518 VDD VDD VSS VSS gf180mcu_fd_sc_mcu7t5v0__fill_2
Xspi_regs_inst_load_slew496 spi_regs_inst__1377_/I1 spi_regs_inst__1447_/I1 VDD VDD
+ VSS VSS gf180mcu_fd_sc_mcu7t5v0__buf_4
XFILLER_61_197 VDD VDD VSS VSS gf180mcu_fd_sc_mcu7t5v0__fill_1
XTAP_TAPCELL_ROW_60_866 VDD VSS gf180mcu_fd_sc_mcu7t5v0__filltie
Xspi_regs_inst_max_cap192 spi_regs_inst__0870_/S spi_regs_inst__0868_/S VDD VDD VSS
+ VSS gf180mcu_fd_sc_mcu7t5v0__buf_4
XFILLER_148_737 VDD VDD VSS VSS gf180mcu_fd_sc_mcu7t5v0__fill_1
XFILLER_30_551 VDD VDD VSS VSS gf180mcu_fd_sc_mcu7t5v0__fillcap_4
XFILLER_156_792 VDD VDD VSS VSS gf180mcu_fd_sc_mcu7t5v0__fillcap_8
Xspi_regs_inst__1208_ spi_regs_inst__1208_/A1 spi_regs_inst__1354_/B1 spi_regs_inst__1324_/B1
+ spi_regs_inst__1208_/B2 spi_regs_inst__1332_/B1 spi_regs_inst__1473_/Q spi_regs_inst_wire98/I
+ VDD VDD VSS VSS gf180mcu_fd_sc_mcu7t5v0__aoi222_1
Xmax_cap433 max_cap433/I max_cap433/Z VDD VDD VSS VSS gf180mcu_fd_sc_mcu7t5v0__clkbuf_3
XFILLER_104_807 VDD VDD VSS VSS gf180mcu_fd_sc_mcu7t5v0__fillcap_8
XFILLER_118_1017 VDD VDD VSS VSS gf180mcu_fd_sc_mcu7t5v0__fillcap_64
XFILLER_131_615 VDD VDD VSS VSS gf180mcu_fd_sc_mcu7t5v0__fill_2
XFILLER_143_453 VDD VDD VSS VSS gf180mcu_fd_sc_mcu7t5v0__fillcap_4
Xspi_regs_inst__1139_ spi_regs_inst__1139_/A1 spi_regs_inst__1312_/B1 spi_regs_inst_wire231/Z
+ spi_regs_inst__1139_/B2 spi_regs_inst__1142_/A2 VDD VDD VSS VSS gf180mcu_fd_sc_mcu7t5v0__aoi22_1
Xmax_cap466 max_cap466/I max_cap466/Z VDD VDD VSS VSS gf180mcu_fd_sc_mcu7t5v0__clkbuf_3
Xmax_cap455 max_cap455/I max_cap455/Z VDD VDD VSS VSS gf180mcu_fd_sc_mcu7t5v0__buf_3
XFILLER_130_103 VDD VDD VSS VSS gf180mcu_fd_sc_mcu7t5v0__fill_2
XFILLER_131_626 VDD VDD VSS VSS gf180mcu_fd_sc_mcu7t5v0__fillcap_4
XFILLER_112_851 VDD VDD VSS VSS gf180mcu_fd_sc_mcu7t5v0__fillcap_16
XFILLER_69_231 VDD VDD VSS VSS gf180mcu_fd_sc_mcu7t5v0__fill_2
Xwave_controller_x_inst__2822_ wave_controller_x_inst__2822_/A1 wave_controller_x_inst__3446_/A2
+ wave_controller_x_inst__2822_/B wave_controller_x_inst__2837_/A2 VDD VDD VSS VSS
+ gf180mcu_fd_sc_mcu7t5v0__oai21_1
XFILLER_29_106 VDD VDD VSS VSS gf180mcu_fd_sc_mcu7t5v0__fill_1
XFILLER_29_139 VDD VDD VSS VSS gf180mcu_fd_sc_mcu7t5v0__fill_1
XFILLER_69_297 VDD VDD VSS VSS gf180mcu_fd_sc_mcu7t5v0__fill_2
Xwave_controller_x_inst__2753_ spi_regs_inst__1245_/B2 wave_controller_x_inst__2753_/A2
+ wave_controller_x_inst__2753_/A3 spi_regs_inst__1224_/A1 VDD VDD VSS VSS gf180mcu_fd_sc_mcu7t5v0__xor3_1
XTAP_TAPCELL_ROW_68_999 VDD VSS gf180mcu_fd_sc_mcu7t5v0__filltie
Xwave_controller_x_inst__2684_ wave_controller_x_inst__2841_/A1 spi_regs_inst__1038_/A1
+ wave_controller_x_inst__2717_/B1 VDD VDD VSS VSS gf180mcu_fd_sc_mcu7t5v0__nand2_1
XFILLER_65_492 VDD VDD VSS VSS gf180mcu_fd_sc_mcu7t5v0__fillcap_8
XFILLER_25_345 VDD VDD VSS VSS gf180mcu_fd_sc_mcu7t5v0__fillcap_4
XTAP_TAPCELL_ROW_84_1257 VDD VSS gf180mcu_fd_sc_mcu7t5v0__filltie
XTAP_TAPCELL_ROW_84_1268 VDD VSS gf180mcu_fd_sc_mcu7t5v0__filltie
XFILLER_111_68 VDD VDD VSS VSS gf180mcu_fd_sc_mcu7t5v0__fill_2
Xwave_controller_y_inst__3321_ wave_controller_y_inst__3716_/Q spi_regs_inst__1614_/Q
+ wave_controller_y_inst__3321_/Z VDD VDD VSS VSS gf180mcu_fd_sc_mcu7t5v0__xor2_1
XFILLER_40_337 VDD VDD VSS VSS gf180mcu_fd_sc_mcu7t5v0__fill_2
Xwave_controller_x_inst__3305_ wave_controller_x_inst__3305_/A1 spi_regs_inst__1550_/Q
+ wave_controller_x_inst__3305_/B1 wave_controller_x_inst__3305_/B2 wave_controller_x_inst__3310_/A2
+ VDD VDD VSS VSS gf180mcu_fd_sc_mcu7t5v0__aoi22_1
Xwave_controller_y_inst__3252_ wave_controller_y_inst__3252_/A1 wave_controller_y_inst__3252_/A2
+ wave_controller_y_inst__3248_/B wave_controller_y_inst__3195_/Z wave_controller_y_inst__3400_/A1
+ wave_controller_y_inst__3254_/C VDD VDD VSS VSS gf180mcu_fd_sc_mcu7t5v0__oai32_1
Xwave_controller_x_inst__3236_ wave_controller_x_inst__3236_/A1 wave_controller_x_inst__3236_/A2
+ wave_controller_x_inst__3236_/B wave_controller_x_inst__3237_/B VDD VDD VSS VSS
+ gf180mcu_fd_sc_mcu7t5v0__oai21_1
XFILLER_138_236 VDD VDD VSS VSS gf180mcu_fd_sc_mcu7t5v0__fillcap_8
XTAP_TAPCELL_ROW_5_1_367 VDD VSS gf180mcu_fd_sc_mcu7t5v0__filltie
Xwave_controller_y_inst__3183_ wave_controller_y_inst__3189_/A1 spi_regs_inst__1581_/Q
+ wave_controller_y_inst__3190_/A1 VDD VDD VSS VSS gf180mcu_fd_sc_mcu7t5v0__nand2_1
Xwave_controller_y_inst__2203_ wave_controller_y_inst__2223_/B2 max_cap427/Z wave_controller_y_inst__2203_/Z
+ VDD VDD VSS VSS gf180mcu_fd_sc_mcu7t5v0__xor2_1
XFILLER_140_1081 VDD VDD VSS VSS gf180mcu_fd_sc_mcu7t5v0__fillcap_4
Xwave_controller_y_inst__2134_ wave_controller_y_inst__3730_/Q wave_controller_y_inst__2134_/A2
+ wave_controller_y_inst__2134_/Z VDD VDD VSS VSS gf180mcu_fd_sc_mcu7t5v0__xor2_1
Xwave_controller_x_inst__3167_ wave_controller_x_inst__3110_/Z wave_controller_x_inst__3168_/A3
+ wave_controller_x_inst__3198_/A1 VDD VDD VSS VSS gf180mcu_fd_sc_mcu7t5v0__nor2_1
Xwave_controller_x_inst__3098_ wave_controller_x_inst__3098_/A1 wave_controller_x_inst__3101_/A2
+ wave_controller_x_inst__3098_/B wave_controller_x_inst__3098_/C wave_controller_x_inst__3612_/D
+ VDD VDD VSS VSS gf180mcu_fd_sc_mcu7t5v0__aoi211_1
Xwave_controller_x_inst__2118_ wave_controller_x_inst__2124_/A1 wave_controller_x_inst__2124_/A2
+ wave_controller_x_inst__2118_/Z VDD VDD VSS VSS gf180mcu_fd_sc_mcu7t5v0__xor2_1
XFILLER_135_976 VDD VDD VSS VSS gf180mcu_fd_sc_mcu7t5v0__fillcap_4
XFILLER_161_250 VDD VDD VSS VSS gf180mcu_fd_sc_mcu7t5v0__fill_1
Xwave_controller_y_inst__2065_ wave_controller_y_inst__3406_/A2 wave_controller_y_inst__2065_/A2
+ wave_controller_y_inst__2153_/A2 VDD VDD VSS VSS gf180mcu_fd_sc_mcu7t5v0__nand2_1
Xwave_controller_x_inst__2049_ wave_controller_x_inst__2039_/B wave_controller_x_inst__2061_/A1
+ wave_controller_x_inst__2049_/Z VDD VDD VSS VSS gf180mcu_fd_sc_mcu7t5v0__xor2_1
XFILLER_106_177 VDD VDD VSS VSS gf180mcu_fd_sc_mcu7t5v0__fill_1
XFILLER_161_294 VDD VDD VSS VSS gf180mcu_fd_sc_mcu7t5v0__fillcap_8
XFILLER_0_444 VDD VDD VSS VSS gf180mcu_fd_sc_mcu7t5v0__fillcap_32
XFILLER_121_136 VDD VDD VSS VSS gf180mcu_fd_sc_mcu7t5v0__fillcap_4
XFILLER_121_158 VDD VDD VSS VSS gf180mcu_fd_sc_mcu7t5v0__fill_1
XFILLER_96_69 VDD VDD VSS VSS gf180mcu_fd_sc_mcu7t5v0__fillcap_16
XFILLER_29_52 VDD VDD VSS VSS gf180mcu_fd_sc_mcu7t5v0__fill_1
XFILLER_75_212 VDD VDD VSS VSS gf180mcu_fd_sc_mcu7t5v0__fillcap_4
XFILLER_48_448 VDD VDD VSS VSS gf180mcu_fd_sc_mcu7t5v0__fillcap_4
Xwave_controller_y_inst__2967_ wave_controller_y_inst__2961_/Z wave_controller_y_inst__3045_/B
+ wave_controller_y_inst__2967_/B wave_controller_y_inst__3047_/A3 VDD VDD VSS VSS
+ gf180mcu_fd_sc_mcu7t5v0__aoi21_1
XFILLER_57_982 VDD VDD VSS VSS gf180mcu_fd_sc_mcu7t5v0__fillcap_64
XFILLER_76_779 VDD VDD VSS VSS gf180mcu_fd_sc_mcu7t5v0__fill_2
Xwave_controller_y_inst__2898_ wave_controller_y_inst__3189_/A1 wave_controller_y_inst__2898_/A2
+ wave_controller_y_inst__2898_/A3 wave_controller_y_inst__2898_/Z VDD VDD VSS VSS
+ gf180mcu_fd_sc_mcu7t5v0__xor3_1
Xwave_controller_y_inst__1918_ spi_regs_inst__1564_/Q wave_controller_y_inst__3562_/A1
+ spi_regs_inst__1563_/Q wave_controller_y_inst__3279_/A1 wave_controller_y_inst__1919_/A2
+ VDD VDD VSS VSS gf180mcu_fd_sc_mcu7t5v0__oai22_1
XFILLER_28_183 VDD VDD VSS VSS gf180mcu_fd_sc_mcu7t5v0__fill_1
XFILLER_72_941 VDD VDD VSS VSS gf180mcu_fd_sc_mcu7t5v0__fillcap_4
XTAP_TAPCELL_ROW_43_1_656 VDD VSS gf180mcu_fd_sc_mcu7t5v0__filltie
Xwave_controller_y_inst__1849_ spi_regs_inst__1202_/A1 wave_controller_y_inst__2027_/B
+ VDD VDD VSS VSS gf180mcu_fd_sc_mcu7t5v0__clkinv_1
XFILLER_43_142 VDD VDD VSS VSS gf180mcu_fd_sc_mcu7t5v0__fillcap_8
XFILLER_31_326 VDD VDD VSS VSS gf180mcu_fd_sc_mcu7t5v0__fillcap_16
Xspi_regs_inst__1490_ spi_regs_inst__1490_/D fanout615/Z clkbuf_leaf_36_clk/Z fanout505/I
+ VDD VDD VSS VSS gf180mcu_fd_sc_mcu7t5v0__dffrnq_1
Xwave_controller_y_inst__3519_ wave_controller_y_inst__3709_/Q wave_controller_y_inst__3493_/Z
+ wave_controller_y_inst__3521_/A2 VDD VDD VSS VSS gf180mcu_fd_sc_mcu7t5v0__nor2_1
XFILLER_8_511 VDD VDD VSS VSS gf180mcu_fd_sc_mcu7t5v0__fill_1
XFILLER_61_72 VDD VDD VSS VSS gf180mcu_fd_sc_mcu7t5v0__fillcap_4
Xsignal_processor_x_inst__109_ signal_processor_x_inst__248_/Q signal_processor_x_inst__202_/A2
+ VDD VDD VSS VSS gf180mcu_fd_sc_mcu7t5v0__clkinv_1
XFILLER_144_206 VDD VDD VSS VSS gf180mcu_fd_sc_mcu7t5v0__fillcap_4
XFILLER_6_34 VDD VDD VSS VSS gf180mcu_fd_sc_mcu7t5v0__fill_1
XTAP_TAPCELL_ROW_117_1810 VDD VSS gf180mcu_fd_sc_mcu7t5v0__filltie
XFILLER_138_792 VDD VDD VSS VSS gf180mcu_fd_sc_mcu7t5v0__fill_1
Xstate_machine_inst__23_ spi_regs_inst__1079_/B2 spi_regs_inst__1146_/A1 state_machine_inst__27_/B
+ VDD VDD VSS VSS gf180mcu_fd_sc_mcu7t5v0__nor2_1
XFILLER_140_401 VDD VDD VSS VSS gf180mcu_fd_sc_mcu7t5v0__fill_1
XFILLER_152_283 VDD VDD VSS VSS gf180mcu_fd_sc_mcu7t5v0__fillcap_4
XFILLER_3_282 VDD VDD VSS VSS gf180mcu_fd_sc_mcu7t5v0__fillcap_64
XFILLER_100_309 VDD VDD VSS VSS gf180mcu_fd_sc_mcu7t5v0__fillcap_4
XFILLER_121_681 VDD VDD VSS VSS gf180mcu_fd_sc_mcu7t5v0__fill_2
XFILLER_39_404 VDD VDD VSS VSS gf180mcu_fd_sc_mcu7t5v0__fill_2
XFILLER_67_702 VDD VDD VSS VSS gf180mcu_fd_sc_mcu7t5v0__fill_1
XFILLER_79_562 VDD VDD VSS VSS gf180mcu_fd_sc_mcu7t5v0__fillcap_8
XFILLER_39_459 VDD VDD VSS VSS gf180mcu_fd_sc_mcu7t5v0__fillcap_8
XFILLER_55_908 VDD VDD VSS VSS gf180mcu_fd_sc_mcu7t5v0__fill_2
XFILLER_19_150 VDD VDD VSS VSS gf180mcu_fd_sc_mcu7t5v0__fillcap_4
XTAP_TAPCELL_ROW_163_2564 VDD VSS gf180mcu_fd_sc_mcu7t5v0__filltie
XTAP_TAPCELL_ROW_29_1_546 VDD VSS gf180mcu_fd_sc_mcu7t5v0__filltie
XFILLER_47_492 VDD VDD VSS VSS gf180mcu_fd_sc_mcu7t5v0__fillcap_8
XFILLER_82_749 VDD VDD VSS VSS gf180mcu_fd_sc_mcu7t5v0__fill_1
XTAP_TAPCELL_ROW_128_1983 VDD VSS gf180mcu_fd_sc_mcu7t5v0__filltie
XTAP_TAPCELL_ROW_128_1994 VDD VSS gf180mcu_fd_sc_mcu7t5v0__filltie
XTAP_TAPCELL_ROW_65_947 VDD VSS gf180mcu_fd_sc_mcu7t5v0__filltie
XFILLER_19_194 VDD VDD VSS VSS gf180mcu_fd_sc_mcu7t5v0__fillcap_16
XFILLER_62_440 VDD VDD VSS VSS gf180mcu_fd_sc_mcu7t5v0__fillcap_4
XFILLER_62_473 VDD VDD VSS VSS gf180mcu_fd_sc_mcu7t5v0__fill_1
Xwave_controller_x_inst__3021_ wave_controller_x_inst__3440_/A1 wave_controller_x_inst__3021_/A2
+ wave_controller_x_inst__3021_/B1 wave_controller_x_inst_wire60/Z wave_controller_x_inst__3694_/D
+ VDD VDD VSS VSS gf180mcu_fd_sc_mcu7t5v0__aoi22_1
XFILLER_124_1087 VDD VDD VSS VSS gf180mcu_fd_sc_mcu7t5v0__fillcap_64
XFILLER_148_578 VDD VDD VSS VSS gf180mcu_fd_sc_mcu7t5v0__fillcap_16
XFILLER_163_559 VDD VDD VSS VSS gf180mcu_fd_sc_mcu7t5v0__fill_1
XTAP_TAPCELL_ROW_1_1_340 VDD VSS gf180mcu_fd_sc_mcu7t5v0__filltie
XFILLER_117_976 VDD VDD VSS VSS gf180mcu_fd_sc_mcu7t5v0__fillcap_4
XFILLER_104_648 VDD VDD VSS VSS gf180mcu_fd_sc_mcu7t5v0__fill_1
XFILLER_144_795 VDD VDD VSS VSS gf180mcu_fd_sc_mcu7t5v0__fillcap_8
XFILLER_104_659 VDD VDD VSS VSS gf180mcu_fd_sc_mcu7t5v0__fillcap_4
Xwave_controller_x_inst_load_slew63 wave_controller_x_inst__3585_/S wave_controller_x_inst__3591_/S
+ VDD VDD VSS VSS gf180mcu_fd_sc_mcu7t5v0__buf_4
XFILLER_57_212 VDD VDD VSS VSS gf180mcu_fd_sc_mcu7t5v0__fillcap_16
XFILLER_97_381 VDD VDD VSS VSS gf180mcu_fd_sc_mcu7t5v0__fillcap_8
Xwave_controller_y_inst__2821_ spi_regs_inst__1303_/A1 wave_controller_y_inst__2844_/A2
+ wave_controller_y_inst__2822_/B VDD VDD VSS VSS gf180mcu_fd_sc_mcu7t5v0__nand2_1
Xwave_controller_x_inst__2805_ spi_regs_inst__1320_/A1 spi_regs_inst__1311_/B2 wave_controller_x_inst__2805_/S
+ wave_controller_x_inst__2806_/I VDD VDD VSS VSS gf180mcu_fd_sc_mcu7t5v0__mux2_2
XFILLER_57_278 VDD VDD VSS VSS gf180mcu_fd_sc_mcu7t5v0__fill_2
XFILLER_58_779 VDD VDD VSS VSS gf180mcu_fd_sc_mcu7t5v0__fillcap_8
Xwave_controller_y_inst__2752_ wave_controller_y_inst__2749_/B wave_controller_y_inst__2747_/Z
+ wave_controller_y_inst__2752_/B1 wave_controller_y_inst__2752_/B2 wave_controller_y_inst__2752_/C
+ wave_controller_y_inst__2753_/A3 VDD VDD VSS VSS gf180mcu_fd_sc_mcu7t5v0__oai221_1
Xwave_controller_x_inst__2736_ wave_controller_x_inst__2736_/I wave_controller_x_inst__2749_/A1
+ VDD VDD VSS VSS gf180mcu_fd_sc_mcu7t5v0__clkinv_1
XFILLER_122_34 VDD VDD VSS VSS gf180mcu_fd_sc_mcu7t5v0__fill_1
XFILLER_54_941 VDD VDD VSS VSS gf180mcu_fd_sc_mcu7t5v0__fillcap_4
Xwave_controller_y_inst__2683_ wave_controller_y_inst__2677_/Z wave_controller_y_inst__2683_/A2
+ spi_regs_inst_wire27/I VDD VDD VSS VSS gf180mcu_fd_sc_mcu7t5v0__xor2_1
XFILLER_167_6 VDD VDD VSS VSS gf180mcu_fd_sc_mcu7t5v0__fillcap_16
XFILLER_25_142 VDD VDD VSS VSS gf180mcu_fd_sc_mcu7t5v0__fillcap_8
Xwave_controller_x_inst__2667_ wave_controller_x_inst__2681_/A2 wave_controller_x_inst__2667_/A2
+ spi_regs_inst_wire37/I VDD VDD VSS VSS gf180mcu_fd_sc_mcu7t5v0__xnor2_1
Xwave_controller_x_inst__2598_ fanout542/Z wave_controller_x_inst__2597_/Z wave_controller_x_inst__2627_/A1
+ VDD VDD VSS VSS gf180mcu_fd_sc_mcu7t5v0__nor2_1
XFILLER_139_512 VDD VDD VSS VSS gf180mcu_fd_sc_mcu7t5v0__fill_2
Xwave_controller_y_inst__3304_ wave_controller_y_inst__1790_/I wave_controller_y_inst__3304_/A2
+ wave_controller_y_inst__3304_/B wave_controller_y_inst__3305_/B1 VDD VDD VSS VSS
+ gf180mcu_fd_sc_mcu7t5v0__aoi21_1
XFILLER_103_1116 VDD VDD VSS VSS gf180mcu_fd_sc_mcu7t5v0__fillcap_4
XFILLER_142_1165 VDD VDD VSS VSS gf180mcu_fd_sc_mcu7t5v0__fillcap_4
Xwave_controller_y_inst__3235_ fanout505/I wave_controller_y_inst__3235_/A2 wave_controller_y_inst__3235_/B1
+ wave_controller_y_inst__3235_/B2 wave_controller_y_inst__3237_/A3 VDD VDD VSS VSS
+ gf180mcu_fd_sc_mcu7t5v0__aoi22_1
Xwave_controller_x_inst__3219_ wave_controller_x_inst__3146_/C wave_controller_x_inst__3222_/A1
+ wave_controller_x_inst__3219_/B wave_controller_x_inst__3219_/C wave_controller_x_inst__3236_/A2
+ VDD VDD VSS VSS gf180mcu_fd_sc_mcu7t5v0__aoi211_1
XFILLER_110_2 VDD VDD VSS VSS gf180mcu_fd_sc_mcu7t5v0__fillcap_16
Xwave_controller_y_inst__3166_ wave_controller_y_inst__3166_/A1 wave_controller_y_inst__3164_/Z
+ wave_controller_y_inst__3166_/B wave_controller_y_inst__3168_/A3 VDD VDD VSS VSS
+ gf180mcu_fd_sc_mcu7t5v0__aoi21_1
XTAP_TAPCELL_ROW_130_2018 VDD VSS gf180mcu_fd_sc_mcu7t5v0__filltie
XTAP_TAPCELL_ROW_130_2029 VDD VSS gf180mcu_fd_sc_mcu7t5v0__filltie
Xwave_controller_y_inst__3097_ wave_controller_y_inst__3097_/A1 wave_controller_y_inst__3097_/A2
+ wave_controller_y_inst__3101_/A2 VDD VDD VSS VSS gf180mcu_fd_sc_mcu7t5v0__nand2_1
Xwave_controller_y_inst__2117_ wave_controller_y_inst__2117_/A1 wave_controller_y_inst__2117_/A2
+ wave_controller_y_inst__2117_/B wave_controller_y_inst__2124_/A2 VDD VDD VSS VSS
+ gf180mcu_fd_sc_mcu7t5v0__aoi21_1
XFILLER_134_261 VDD VDD VSS VSS gf180mcu_fd_sc_mcu7t5v0__fill_2
Xwave_controller_y_inst__2048_ wave_controller_y_inst__2092_/A1 wave_controller_y_inst_wire358/Z
+ wave_controller_y_inst_wire356/Z wave_controller_y_inst__2095_/C VDD VDD VSS VSS
+ gf180mcu_fd_sc_mcu7t5v0__nor3_1
Xoutput7 _19_/Q bidir_out[0] VDD VDD VSS VSS gf180mcu_fd_sc_mcu7t5v0__buf_1
XFILLER_0_263 VDD VDD VSS VSS gf180mcu_fd_sc_mcu7t5v0__fillcap_8
XFILLER_110_618 VDD VDD VSS VSS gf180mcu_fd_sc_mcu7t5v0__fillcap_32
XFILLER_122_478 VDD VDD VSS VSS gf180mcu_fd_sc_mcu7t5v0__fillcap_4
XFILLER_76_510 VDD VDD VSS VSS gf180mcu_fd_sc_mcu7t5v0__fill_1
XFILLER_0_274 VDD VDD VSS VSS gf180mcu_fd_sc_mcu7t5v0__fillcap_4
XFILLER_103_692 VDD VDD VSS VSS gf180mcu_fd_sc_mcu7t5v0__fillcap_8
Xspi_regs_inst_fanout565 fanout566/Z spi_regs_inst__1610_/RN VDD VDD VSS VSS gf180mcu_fd_sc_mcu7t5v0__dlyb_1
Xspi_regs_inst__0990_ spi_regs_inst__1021_/A1 spi_regs_inst__1032_/A2 spi_regs_inst__1200_/A2
+ VDD VDD VSS VSS gf180mcu_fd_sc_mcu7t5v0__nor2_1
XFILLER_48_267 VDD VDD VSS VSS gf180mcu_fd_sc_mcu7t5v0__fillcap_4
XTAP_TAPCELL_ROW_145_2272 VDD VSS gf180mcu_fd_sc_mcu7t5v0__filltie
XFILLER_91_546 VDD VDD VSS VSS gf180mcu_fd_sc_mcu7t5v0__fillcap_8
XTAP_TAPCELL_ROW_62_906 VDD VSS gf180mcu_fd_sc_mcu7t5v0__filltie
Xspi_regs_inst__1611_ spi_regs_inst__1611_/D fanout566/Z clkbuf_leaf_9_clk/Z spi_regs_inst__1611_/Q
+ VDD VDD VSS VSS gf180mcu_fd_sc_mcu7t5v0__dffrnq_1
Xwave_controller_x_inst_fanout71 wave_controller_x_inst_wire75/I wave_controller_x_inst__2923_/S
+ VDD VDD VSS VSS gf180mcu_fd_sc_mcu7t5v0__dlyb_1
Xspi_regs_inst__1542_ spi_regs_inst__1542_/D fanout615/Z clkbuf_leaf_36_clk/Z spi_regs_inst__1542_/Q
+ VDD VDD VSS VSS gf180mcu_fd_sc_mcu7t5v0__dffrnq_1
XFILLER_60_944 VDD VDD VSS VSS gf180mcu_fd_sc_mcu7t5v0__fill_1
Xspi_regs_inst__1473_ spi_regs_inst__1473_/D fanout619/Z clkload32/I spi_regs_inst__1473_/Q
+ VDD VDD VSS VSS gf180mcu_fd_sc_mcu7t5v0__dffrnq_1
XFILLER_12_370 VDD VDD VSS VSS gf180mcu_fd_sc_mcu7t5v0__fill_1
XFILLER_12_381 VDD VDD VSS VSS gf180mcu_fd_sc_mcu7t5v0__fillcap_4
XFILLER_157_386 VDD VDD VSS VSS gf180mcu_fd_sc_mcu7t5v0__fillcap_8
XFILLER_125_261 VDD VDD VSS VSS gf180mcu_fd_sc_mcu7t5v0__fill_1
XFILLER_125_272 VDD VDD VSS VSS gf180mcu_fd_sc_mcu7t5v0__fill_1
XFILLER_141_710 VDD VDD VSS VSS gf180mcu_fd_sc_mcu7t5v0__fill_1
XFILLER_99_613 VDD VDD VSS VSS gf180mcu_fd_sc_mcu7t5v0__fill_1
XFILLER_125_294 VDD VDD VSS VSS gf180mcu_fd_sc_mcu7t5v0__fill_2
XTAP_TAPCELL_ROW_165_2604 VDD VSS gf180mcu_fd_sc_mcu7t5v0__filltie
XFILLER_101_629 VDD VDD VSS VSS gf180mcu_fd_sc_mcu7t5v0__fill_1
XFILLER_100_117 VDD VDD VSS VSS gf180mcu_fd_sc_mcu7t5v0__fillcap_8
XFILLER_140_297 VDD VDD VSS VSS gf180mcu_fd_sc_mcu7t5v0__fill_1
XFILLER_39_234 VDD VDD VSS VSS gf180mcu_fd_sc_mcu7t5v0__fillcap_16
XFILLER_94_362 VDD VDD VSS VSS gf180mcu_fd_sc_mcu7t5v0__fillcap_4
Xspi_regs_inst_hold692 spi_regs_inst__1458_/Q spi_regs_inst__1459_/D VDD VDD VSS VSS
+ gf180mcu_fd_sc_mcu7t5v0__dlyc_1
XFILLER_27_418 VDD VDD VSS VSS gf180mcu_fd_sc_mcu7t5v0__fill_2
XFILLER_82_513 VDD VDD VSS VSS gf180mcu_fd_sc_mcu7t5v0__fill_1
XFILLER_82_535 VDD VDD VSS VSS gf180mcu_fd_sc_mcu7t5v0__fillcap_4
XTAP_TAPCELL_ROW_68_1005 VDD VSS gf180mcu_fd_sc_mcu7t5v0__filltie
Xwave_controller_x_inst__3570_ wave_controller_x_inst__3570_/A1 wave_controller_x_inst__3572_/A2
+ wave_controller_x_inst__3601_/I0 VDD VDD VSS VSS gf180mcu_fd_sc_mcu7t5v0__nor2_1
XFILLER_54_259 VDD VDD VSS VSS gf180mcu_fd_sc_mcu7t5v0__fill_2
XFILLER_78_1151 VDD VDD VSS VSS gf180mcu_fd_sc_mcu7t5v0__fillcap_4
Xwave_controller_x_inst__2521_ wave_controller_x_inst__2521_/A1 wave_controller_x_inst__3515_/B2
+ wave_controller_x_inst__2534_/A2 wave_controller_x_inst__2521_/Z VDD VDD VSS VSS
+ gf180mcu_fd_sc_mcu7t5v0__xor3_1
XFILLER_35_484 VDD VDD VSS VSS gf180mcu_fd_sc_mcu7t5v0__fillcap_4
XFILLER_63_793 VDD VDD VSS VSS gf180mcu_fd_sc_mcu7t5v0__fillcap_8
XFILLER_78_1173 VDD VDD VSS VSS gf180mcu_fd_sc_mcu7t5v0__fill_1
XTAP_TAPCELL_ROW_81_1216 VDD VSS gf180mcu_fd_sc_mcu7t5v0__filltie
Xwave_controller_x_inst__2452_ wire462/Z wave_controller_x_inst__3500_/B2 wave_controller_x_inst__2462_/A1
+ VDD VDD VSS VSS gf180mcu_fd_sc_mcu7t5v0__nand2_1
XFILLER_165_1154 VDD VDD VSS VSS gf180mcu_fd_sc_mcu7t5v0__fillcap_8
XFILLER_52_19 VDD VDD VSS VSS gf180mcu_fd_sc_mcu7t5v0__fillcap_16
XFILLER_22_156 VDD VDD VSS VSS gf180mcu_fd_sc_mcu7t5v0__fill_1
Xwave_controller_x_inst__2383_ wave_controller_x_inst__2379_/Z wave_controller_x_inst_wire117/Z
+ wave_controller_x_inst__2383_/Z VDD VDD VSS VSS gf180mcu_fd_sc_mcu7t5v0__xor2_1
XPHY_EDGE_ROW_99_Left_266 VDD VSS gf180mcu_fd_sc_mcu7t5v0__endcap
XFILLER_163_301 VDD VDD VSS VSS gf180mcu_fd_sc_mcu7t5v0__fill_1
Xwave_controller_y_inst__3020_ wave_controller_y_inst__3034_/B1 wave_controller_y_inst__3021_/B1
+ wave_controller_y_inst__3022_/A2 VDD VDD VSS VSS gf180mcu_fd_sc_mcu7t5v0__nand2_1
XFILLER_136_548 VDD VDD VSS VSS gf180mcu_fd_sc_mcu7t5v0__fill_1
XFILLER_163_312 VDD VDD VSS VSS gf180mcu_fd_sc_mcu7t5v0__fillcap_16
Xwave_controller_x_inst__3004_ wave_controller_x_inst__3081_/A1 wave_controller_x_inst__3081_/A2
+ wave_controller_x_inst__3004_/B wave_controller_x_inst__3081_/B wave_controller_x_inst__3089_/A2
+ VDD VDD VSS VSS gf180mcu_fd_sc_mcu7t5v0__aoi211_1
XFILLER_117_762 VDD VDD VSS VSS gf180mcu_fd_sc_mcu7t5v0__fillcap_8
XFILLER_163_345 VDD VDD VSS VSS gf180mcu_fd_sc_mcu7t5v0__fillcap_4
XFILLER_2_506 VDD VDD VSS VSS gf180mcu_fd_sc_mcu7t5v0__fillcap_16
XFILLER_85_1122 VDD VDD VSS VSS gf180mcu_fd_sc_mcu7t5v0__fillcap_32
XTAP_TAPCELL_ROW_42_1_644 VDD VSS gf180mcu_fd_sc_mcu7t5v0__filltie
XTAP_TAPCELL_ROW_79_1178 VDD VSS gf180mcu_fd_sc_mcu7t5v0__filltie
XFILLER_104_401 VDD VDD VSS VSS gf180mcu_fd_sc_mcu7t5v0__fillcap_8
XFILLER_117_56 VDD VDD VSS VSS gf180mcu_fd_sc_mcu7t5v0__fillcap_4
XFILLER_117_78 VDD VDD VSS VSS gf180mcu_fd_sc_mcu7t5v0__fillcap_8
XFILLER_89_178 VDD VDD VSS VSS gf180mcu_fd_sc_mcu7t5v0__fillcap_4
XTAP_TAPCELL_ROW_92_1389 VDD VSS gf180mcu_fd_sc_mcu7t5v0__filltie
XFILLER_86_852 VDD VDD VSS VSS gf180mcu_fd_sc_mcu7t5v0__fillcap_4
XFILLER_133_44 VDD VDD VSS VSS gf180mcu_fd_sc_mcu7t5v0__fillcap_4
XFILLER_85_340 VDD VDD VSS VSS gf180mcu_fd_sc_mcu7t5v0__fill_1
XFILLER_86_885 VDD VDD VSS VSS gf180mcu_fd_sc_mcu7t5v0__fillcap_4
XPHY_EDGE_ROW_49_1_Right_48 VDD VSS gf180mcu_fd_sc_mcu7t5v0__endcap
Xwave_controller_y_inst__2804_ wave_controller_y_inst__3568_/A1 wave_controller_y_inst__2791_/Z
+ wave_controller_y_inst__2810_/C VDD VDD VSS VSS gf180mcu_fd_sc_mcu7t5v0__or2_1
XFILLER_133_88 VDD VDD VSS VSS gf180mcu_fd_sc_mcu7t5v0__fillcap_16
XFILLER_85_395 VDD VDD VSS VSS gf180mcu_fd_sc_mcu7t5v0__fillcap_4
XFILLER_73_557 VDD VDD VSS VSS gf180mcu_fd_sc_mcu7t5v0__fill_2
XFILLER_93_59 VDD VDD VSS VSS gf180mcu_fd_sc_mcu7t5v0__fill_2
Xwave_controller_y_inst__2735_ wave_controller_y_inst__2729_/I wave_controller_y_inst__2733_/Z
+ wave_controller_y_inst__2736_/I VDD VDD VSS VSS gf180mcu_fd_sc_mcu7t5v0__xnor2_1
Xwave_controller_x_inst__3699_ wave_controller_x_inst__3699_/D wave_controller_x_inst__3723_/RN
+ clkload28/I wave_controller_x_inst__3699_/Q VDD VDD VSS VSS gf180mcu_fd_sc_mcu7t5v0__dffrnq_1
Xwave_controller_x_inst__2719_ wave_controller_x_inst__2716_/Z wave_controller_x_inst__2719_/A2
+ wave_controller_x_inst__2719_/Z VDD VDD VSS VSS gf180mcu_fd_sc_mcu7t5v0__xor2_1
XTAP_TAPCELL_ROW_56_799 VDD VSS gf180mcu_fd_sc_mcu7t5v0__filltie
Xwave_controller_y_inst__2666_ wave_controller_y_inst__2680_/A1 wave_controller_y_inst__2681_/A1
+ wave_controller_y_inst__2667_/A2 VDD VDD VSS VSS gf180mcu_fd_sc_mcu7t5v0__nand2_1
Xclkbuf_3_6__f_clk clkbuf_0_clk/Z clkbuf_3_6__f_clk/Z VDD VDD VSS VSS gf180mcu_fd_sc_mcu7t5v0__clkbuf_16
XFILLER_158_2 VDD VDD VSS VSS gf180mcu_fd_sc_mcu7t5v0__fillcap_32
XFILLER_41_432 VDD VDD VSS VSS gf180mcu_fd_sc_mcu7t5v0__fillcap_4
XTAP_TAPCELL_ROW_140_2180 VDD VSS gf180mcu_fd_sc_mcu7t5v0__filltie
XTAP_TAPCELL_ROW_140_2191 VDD VSS gf180mcu_fd_sc_mcu7t5v0__filltie
Xwave_controller_y_inst__2597_ wave_controller_y_inst__2595_/Z wave_controller_y_inst__2599_/A3
+ wave_controller_y_inst__2597_/Z VDD VDD VSS VSS gf180mcu_fd_sc_mcu7t5v0__xor2_1
XFILLER_159_629 VDD VDD VSS VSS gf180mcu_fd_sc_mcu7t5v0__fill_1
XFILLER_42_30 VDD VDD VSS VSS gf180mcu_fd_sc_mcu7t5v0__fill_1
XFILLER_139_364 VDD VDD VSS VSS gf180mcu_fd_sc_mcu7t5v0__fill_2
XTAP_TAPCELL_ROW_28_1_545 VDD VSS gf180mcu_fd_sc_mcu7t5v0__filltie
Xwave_controller_y_inst__3218_ wave_controller_y_inst__3218_/A1 wave_controller_y_inst__3147_/B
+ wave_controller_y_inst__3218_/B wave_controller_y_inst__3218_/C wave_controller_y_inst__3236_/A1
+ VDD VDD VSS VSS gf180mcu_fd_sc_mcu7t5v0__aoi211_1
Xwave_controller_y_inst__3149_ wave_controller_y_inst__1792_/I wave_controller_y_inst__3213_/A2
+ wave_controller_y_inst__3149_/B1 wave_controller_y_inst__3149_/B2 wave_controller_y_inst__3149_/C
+ wave_controller_y_inst__3211_/A2 VDD VDD VSS VSS gf180mcu_fd_sc_mcu7t5v0__oai221_1
XFILLER_123_710 VDD VDD VSS VSS gf180mcu_fd_sc_mcu7t5v0__fillcap_4
XFILLER_142_529 VDD VDD VSS VSS gf180mcu_fd_sc_mcu7t5v0__fill_1
XFILLER_154_378 VDD VDD VSS VSS gf180mcu_fd_sc_mcu7t5v0__fill_2
XFILLER_135_592 VDD VDD VSS VSS gf180mcu_fd_sc_mcu7t5v0__fillcap_16
XFILLER_111_916 VDD VDD VSS VSS gf180mcu_fd_sc_mcu7t5v0__fillcap_64
XFILLER_122_242 VDD VDD VSS VSS gf180mcu_fd_sc_mcu7t5v0__fill_2
XFILLER_150_562 VDD VDD VSS VSS gf180mcu_fd_sc_mcu7t5v0__fill_2
XFILLER_150_584 VDD VDD VSS VSS gf180mcu_fd_sc_mcu7t5v0__fillcap_8
XTAP_TAPCELL_ROW_147_2301 VDD VSS gf180mcu_fd_sc_mcu7t5v0__filltie
Xspi_regs_inst_fanout340 spi_regs_inst__0942_/ZN spi_regs_inst__1009_/A1 VDD VDD VSS
+ VSS gf180mcu_fd_sc_mcu7t5v0__dlyb_1
XFILLER_49_554 VDD VDD VSS VSS gf180mcu_fd_sc_mcu7t5v0__fill_1
Xspi_regs_inst__0973_ spi_regs_inst__1029_/A1 spi_regs_inst__0992_/A1 spi_regs_inst__1202_/A2
+ VDD VDD VSS VSS gf180mcu_fd_sc_mcu7t5v0__nor2_1
XTAP_TAPCELL_ROW_160_2512 VDD VSS gf180mcu_fd_sc_mcu7t5v0__filltie
XTAP_TAPCELL_ROW_160_2523 VDD VSS gf180mcu_fd_sc_mcu7t5v0__filltie
XFILLER_149_1116 VDD VDD VSS VSS gf180mcu_fd_sc_mcu7t5v0__fillcap_4
XTAP_TAPCELL_ROW_125_1942 VDD VSS gf180mcu_fd_sc_mcu7t5v0__filltie
XFILLER_32_410 VDD VDD VSS VSS gf180mcu_fd_sc_mcu7t5v0__fillcap_8
XFILLER_44_281 VDD VDD VSS VSS gf180mcu_fd_sc_mcu7t5v0__fill_1
XFILLER_32_454 VDD VDD VSS VSS gf180mcu_fd_sc_mcu7t5v0__fill_1
Xspi_regs_inst__1525_ spi_regs_inst__1525_/D spi_regs_inst__1527_/RN clkload32/I spi_regs_inst__1525_/Q
+ VDD VDD VSS VSS gf180mcu_fd_sc_mcu7t5v0__dffrnq_1
XFILLER_149_139 VDD VDD VSS VSS gf180mcu_fd_sc_mcu7t5v0__fill_1
XFILLER_60_796 VDD VDD VSS VSS gf180mcu_fd_sc_mcu7t5v0__fillcap_8
XTAP_TAPCELL_ROW_158_2485 VDD VSS gf180mcu_fd_sc_mcu7t5v0__filltie
Xspi_regs_inst__1456_ input1/Z fanout558/Z clkload7/I spi_regs_inst__1457_/D VDD VDD
+ VSS VSS gf180mcu_fd_sc_mcu7t5v0__dffsnq_1
XFILLER_121_1046 VDD VDD VSS VSS gf180mcu_fd_sc_mcu7t5v0__fillcap_4
XFILLER_145_334 VDD VDD VSS VSS gf180mcu_fd_sc_mcu7t5v0__fill_2
XFILLER_8_171 VDD VDD VSS VSS gf180mcu_fd_sc_mcu7t5v0__fillcap_4
Xspi_regs_inst__1387_ fanout542/Z spi_regs_inst__1438_/I1 spi_regs_inst__1391_/S spi_regs_inst__1462_/D
+ VDD VDD VSS VSS gf180mcu_fd_sc_mcu7t5v0__mux2_2
XFILLER_105_209 VDD VDD VSS VSS gf180mcu_fd_sc_mcu7t5v0__fill_1
XFILLER_126_581 VDD VDD VSS VSS gf180mcu_fd_sc_mcu7t5v0__fillcap_4
XFILLER_145_378 VDD VDD VSS VSS gf180mcu_fd_sc_mcu7t5v0__fill_1
XFILLER_114_732 VDD VDD VSS VSS gf180mcu_fd_sc_mcu7t5v0__fill_2
XFILLER_126_592 VDD VDD VSS VSS gf180mcu_fd_sc_mcu7t5v0__fill_2
XFILLER_101_404 VDD VDD VSS VSS gf180mcu_fd_sc_mcu7t5v0__fillcap_16
XFILLER_102_938 VDD VDD VSS VSS gf180mcu_fd_sc_mcu7t5v0__fillcap_4
XFILLER_141_551 VDD VDD VSS VSS gf180mcu_fd_sc_mcu7t5v0__fillcap_8
XFILLER_141_562 VDD VDD VSS VSS gf180mcu_fd_sc_mcu7t5v0__fill_1
XTAP_TAPCELL_ROW_74_1097 VDD VSS gf180mcu_fd_sc_mcu7t5v0__filltie
Xwave_controller_x_inst__1952_ fanout400/Z wave_controller_x_inst__1952_/A2 wave_controller_x_inst__3735_/D
+ VDD VDD VSS VSS gf180mcu_fd_sc_mcu7t5v0__and2_1
XFILLER_101_448 VDD VDD VSS VSS gf180mcu_fd_sc_mcu7t5v0__fill_1
XFILLER_113_275 VDD VDD VSS VSS gf180mcu_fd_sc_mcu7t5v0__fillcap_4
XFILLER_141_595 VDD VDD VSS VSS gf180mcu_fd_sc_mcu7t5v0__fill_1
XFILLER_86_137 VDD VDD VSS VSS gf180mcu_fd_sc_mcu7t5v0__fill_1
Xwave_controller_x_inst__1883_ spi_regs_inst__1301_/A1 wave_controller_x_inst__3539_/B2
+ VDD VDD VSS VSS gf180mcu_fd_sc_mcu7t5v0__clkinv_1
Xwave_controller_x_inst__3622_ wave_controller_x_inst__3622_/D wave_controller_x_inst__3723_/RN
+ clkload27/I spi_regs_inst__1134_/A1 VDD VDD VSS VSS gf180mcu_fd_sc_mcu7t5v0__dffrnq_1
Xsignal_processor_y_inst__199_ spi_regs_inst__1100_/A1 signal_processor_y_inst__199_/A2
+ signal_processor_y_inst__200_/A3 VDD VDD VSS VSS gf180mcu_fd_sc_mcu7t5v0__nor2_1
XFILLER_103_36 VDD VDD VSS VSS gf180mcu_fd_sc_mcu7t5v0__fillcap_8
Xwave_controller_x_inst__3553_ spi_regs_inst__1188_/C1 wave_controller_x_inst__3556_/A2
+ wave_controller_x_inst__3554_/A3 VDD VDD VSS VSS gf180mcu_fd_sc_mcu7t5v0__nor2_1
XFILLER_70_516 VDD VDD VSS VSS gf180mcu_fd_sc_mcu7t5v0__fillcap_8
XFILLER_70_527 VDD VDD VSS VSS gf180mcu_fd_sc_mcu7t5v0__fillcap_8
XFILLER_82_365 VDD VDD VSS VSS gf180mcu_fd_sc_mcu7t5v0__fill_1
XPHY_EDGE_ROW_118_Right_118 VDD VSS gf180mcu_fd_sc_mcu7t5v0__endcap
Xwave_controller_y_inst__2520_ wave_controller_y_inst__2556_/A1 wave_controller_y_inst__2519_/Z
+ wave_controller_y_inst__2534_/A2 VDD VDD VSS VSS gf180mcu_fd_sc_mcu7t5v0__nand2_1
Xwave_controller_x_inst__2504_ fanout528/Z wave_controller_x_inst__2518_/A3 wave_controller_x_inst__2504_/A3
+ wave_controller_x_inst__2511_/A2 VDD VDD VSS VSS gf180mcu_fd_sc_mcu7t5v0__xnor3_1
XTAP_TAPCELL_ROW_53_736 VDD VSS gf180mcu_fd_sc_mcu7t5v0__filltie
XTAP_TAPCELL_ROW_53_747 VDD VSS gf180mcu_fd_sc_mcu7t5v0__filltie
XTAP_TAPCELL_ROW_53_758 VDD VSS gf180mcu_fd_sc_mcu7t5v0__filltie
Xwave_controller_y_inst__2451_ wave_controller_y_inst__2451_/A1 spi_regs_inst__1097_/A1
+ wave_controller_y_inst__2464_/A1 VDD VDD VSS VSS gf180mcu_fd_sc_mcu7t5v0__nor2_1
Xwave_controller_x_inst__3484_ spi_regs_inst__1333_/A1 wave_controller_x_inst_wire370/Z
+ wave_controller_x_inst__3485_/A3 VDD VDD VSS VSS gf180mcu_fd_sc_mcu7t5v0__nor2_1
Xwave_controller_x_inst__2435_ wave_controller_x_inst__2435_/A1 wave_controller_x_inst__2435_/A2
+ wave_controller_x_inst__2436_/B VDD VDD VSS VSS gf180mcu_fd_sc_mcu7t5v0__nand2_1
XFILLER_149_640 VDD VDD VSS VSS gf180mcu_fd_sc_mcu7t5v0__fill_2
XFILLER_91_1170 VDD VDD VSS VSS gf180mcu_fd_sc_mcu7t5v0__fillcap_4
Xwave_controller_y_inst__2382_ wave_controller_y_inst_wire120/Z wave_controller_y_inst__2352_/Z
+ wave_controller_y_inst__2363_/Z wave_controller_y_inst__2382_/B wave_controller_y_inst__2383_/A2
+ VDD VDD VSS VSS gf180mcu_fd_sc_mcu7t5v0__oai31_1
Xwave_controller_x_inst__2366_ wave_controller_x_inst__2671_/A1 wave_controller_x_inst__2366_/A2
+ wave_controller_x_inst__2389_/A1 VDD VDD VSS VSS gf180mcu_fd_sc_mcu7t5v0__nand2_1
XFILLER_137_813 VDD VDD VSS VSS gf180mcu_fd_sc_mcu7t5v0__fill_2
Xwave_controller_x_inst__2297_ wave_controller_x_inst__2309_/A2 wave_controller_x_inst__2297_/A2
+ spi_regs_inst_wire39/I VDD VDD VSS VSS gf180mcu_fd_sc_mcu7t5v0__xor2_1
XFILLER_109_559 VDD VDD VSS VSS gf180mcu_fd_sc_mcu7t5v0__fill_1
XFILLER_163_142 VDD VDD VSS VSS gf180mcu_fd_sc_mcu7t5v0__fillcap_64
Xwave_controller_y_inst__3003_ wave_controller_y_inst__3081_/A1 wave_controller_y_inst__3081_/A2
+ wave_controller_y_inst__3082_/A2 VDD VDD VSS VSS gf180mcu_fd_sc_mcu7t5v0__nand2_1
XTAP_TAPCELL_ROW_94_1429 VDD VSS gf180mcu_fd_sc_mcu7t5v0__filltie
XFILLER_151_304 VDD VDD VSS VSS gf180mcu_fd_sc_mcu7t5v0__fillcap_4
XFILLER_88_26 VDD VDD VSS VSS gf180mcu_fd_sc_mcu7t5v0__fill_2
XFILLER_88_37 VDD VDD VSS VSS gf180mcu_fd_sc_mcu7t5v0__fillcap_16
XFILLER_151_348 VDD VDD VSS VSS gf180mcu_fd_sc_mcu7t5v0__fill_2
XFILLER_160_871 VDD VDD VSS VSS gf180mcu_fd_sc_mcu7t5v0__fillcap_4
XFILLER_78_649 VDD VDD VSS VSS gf180mcu_fd_sc_mcu7t5v0__fillcap_4
XFILLER_77_148 VDD VDD VSS VSS gf180mcu_fd_sc_mcu7t5v0__fill_1
XFILLER_101_982 VDD VDD VSS VSS gf180mcu_fd_sc_mcu7t5v0__fillcap_64
XFILLER_58_384 VDD VDD VSS VSS gf180mcu_fd_sc_mcu7t5v0__fill_1
XFILLER_59_896 VDD VDD VSS VSS gf180mcu_fd_sc_mcu7t5v0__fill_1
XFILLER_73_310 VDD VDD VSS VSS gf180mcu_fd_sc_mcu7t5v0__fill_2
XFILLER_92_107 VDD VDD VSS VSS gf180mcu_fd_sc_mcu7t5v0__fillcap_16
XFILLER_100_481 VDD VDD VSS VSS gf180mcu_fd_sc_mcu7t5v0__fill_2
XFILLER_37_63 VDD VDD VSS VSS gf180mcu_fd_sc_mcu7t5v0__fillcap_4
XFILLER_46_535 VDD VDD VSS VSS gf180mcu_fd_sc_mcu7t5v0__fill_2
XFILLER_73_343 VDD VDD VSS VSS gf180mcu_fd_sc_mcu7t5v0__fillcap_4
XFILLER_74_877 VDD VDD VSS VSS gf180mcu_fd_sc_mcu7t5v0__fillcap_16
XFILLER_85_181 VDD VDD VSS VSS gf180mcu_fd_sc_mcu7t5v0__fill_2
XTAP_TAPCELL_ROW_142_2220 VDD VSS gf180mcu_fd_sc_mcu7t5v0__filltie
XFILLER_73_365 VDD VDD VSS VSS gf180mcu_fd_sc_mcu7t5v0__fill_2
XTAP_TAPCELL_ROW_107_1650 VDD VSS gf180mcu_fd_sc_mcu7t5v0__filltie
Xwave_controller_y_inst__2718_ wave_controller_y_inst__2730_/A1 wave_controller_y_inst__2730_/A3
+ wave_controller_y_inst__2719_/A2 VDD VDD VSS VSS gf180mcu_fd_sc_mcu7t5v0__nor2_1
XFILLER_14_410 VDD VDD VSS VSS gf180mcu_fd_sc_mcu7t5v0__fill_1
XFILLER_96_1081 VDD VDD VSS VSS gf180mcu_fd_sc_mcu7t5v0__fillcap_4
Xwave_controller_y_inst__3698_ wave_controller_y_inst__3698_/D wave_controller_y_inst__3699_/RN
+ clkload11/I wave_controller_y_inst__3698_/Q VDD VDD VSS VSS gf180mcu_fd_sc_mcu7t5v0__dffrnq_1
XFILLER_109_1122 VDD VDD VSS VSS gf180mcu_fd_sc_mcu7t5v0__fillcap_32
XFILLER_14_454 VDD VDD VSS VSS gf180mcu_fd_sc_mcu7t5v0__fill_1
XFILLER_53_62 VDD VDD VSS VSS gf180mcu_fd_sc_mcu7t5v0__fillcap_4
XTAP_TAPCELL_ROW_103_1569 VDD VSS gf180mcu_fd_sc_mcu7t5v0__filltie
Xwave_controller_y_inst__2649_ wave_controller_y_inst__2615_/I wave_controller_y_inst__2636_/Z
+ wave_controller_y_inst__2652_/A2 VDD VDD VSS VSS gf180mcu_fd_sc_mcu7t5v0__nor2_1
XFILLER_53_95 VDD VDD VSS VSS gf180mcu_fd_sc_mcu7t5v0__fill_1
XTAP_TAPCELL_ROW_120_1850 VDD VSS gf180mcu_fd_sc_mcu7t5v0__filltie
XTAP_TAPCELL_ROW_120_1861 VDD VSS gf180mcu_fd_sc_mcu7t5v0__filltie
Xspi_regs_inst__1310_ spi_regs_inst__1310_/A1 spi_regs_inst_wire284/Z spi_regs_inst__1346_/B1
+ spi_regs_inst__1310_/B2 spi_regs_inst__1313_/A1 VDD VDD VSS VSS gf180mcu_fd_sc_mcu7t5v0__aoi22_1
XFILLER_139_150 VDD VDD VSS VSS gf180mcu_fd_sc_mcu7t5v0__fill_2
XFILLER_155_632 VDD VDD VSS VSS gf180mcu_fd_sc_mcu7t5v0__fillcap_16
Xspi_regs_inst__1241_ max_cap453/Z spi_regs_inst__1336_/A2 spi_regs_inst__1241_/B1
+ spi_regs_inst__1241_/B2 spi_regs_inst__1242_/A4 VDD VDD VSS VSS gf180mcu_fd_sc_mcu7t5v0__aoi22_1
XFILLER_128_868 VDD VDD VSS VSS gf180mcu_fd_sc_mcu7t5v0__fillcap_4
XTAP_TAPCELL_ROW_3_1_354 VDD VSS gf180mcu_fd_sc_mcu7t5v0__filltie
Xspi_regs_inst__1172_ spi_regs_inst__1133_/Z spi_regs_inst__1172_/A2 spi_regs_inst__1172_/A3
+ spi_regs_inst__1172_/A4 spi_regs_inst__1172_/Z VDD VDD VSS VSS gf180mcu_fd_sc_mcu7t5v0__and4_1
XFILLER_123_562 VDD VDD VSS VSS gf180mcu_fd_sc_mcu7t5v0__fill_2
XFILLER_69_627 VDD VDD VSS VSS gf180mcu_fd_sc_mcu7t5v0__fill_2
XFILLER_97_958 VDD VDD VSS VSS gf180mcu_fd_sc_mcu7t5v0__fillcap_16
Xwave_controller_x_inst_wire170 wave_controller_x_inst_wire170/I wave_controller_x_inst_wire170/Z
+ VDD VDD VSS VSS gf180mcu_fd_sc_mcu7t5v0__buf_1
Xsignal_processor_y_inst__122_ signal_processor_y_inst__179_/A1 signal_processor_y_inst__250_/Q
+ signal_processor_y_inst__251_/D VDD VDD VSS VSS gf180mcu_fd_sc_mcu7t5v0__and2_1
XFILLER_96_457 VDD VDD VSS VSS gf180mcu_fd_sc_mcu7t5v0__fill_2
XFILLER_37_524 VDD VDD VSS VSS gf180mcu_fd_sc_mcu7t5v0__fill_1
XFILLER_49_384 VDD VDD VSS VSS gf180mcu_fd_sc_mcu7t5v0__fill_1
XFILLER_37_546 VDD VDD VSS VSS gf180mcu_fd_sc_mcu7t5v0__fillcap_8
Xspi_regs_inst__0956_ spi_regs_inst__1009_/A1 spi_regs_inst__1023_/A2 spi_regs_inst__1136_/A2
+ VDD VDD VSS VSS gf180mcu_fd_sc_mcu7t5v0__nor2_1
XFILLER_52_505 VDD VDD VSS VSS gf180mcu_fd_sc_mcu7t5v0__fillcap_8
XFILLER_52_527 VDD VDD VSS VSS gf180mcu_fd_sc_mcu7t5v0__fill_1
Xspi_regs_inst__0887_ fanout498/Z spi_regs_inst__1448_/I1 spi_regs_inst__0887_/S spi_regs_inst__1621_/D
+ VDD VDD VSS VSS gf180mcu_fd_sc_mcu7t5v0__mux2_2
XFILLER_64_387 VDD VDD VSS VSS gf180mcu_fd_sc_mcu7t5v0__fillcap_4
XFILLER_64_398 VDD VDD VSS VSS gf180mcu_fd_sc_mcu7t5v0__fill_2
XFILLER_80_847 VDD VDD VSS VSS gf180mcu_fd_sc_mcu7t5v0__fillcap_4
XFILLER_75_1154 VDD VDD VSS VSS gf180mcu_fd_sc_mcu7t5v0__fillcap_16
XFILLER_162_1157 VDD VDD VSS VSS gf180mcu_fd_sc_mcu7t5v0__fillcap_16
Xwave_controller_x_inst__2220_ wave_controller_x_inst__2192_/Z wave_controller_x_inst__2203_/Z
+ wave_controller_x_inst__2221_/B VDD VDD VSS VSS gf180mcu_fd_sc_mcu7t5v0__nand2_1
XFILLER_159_982 VDD VDD VSS VSS gf180mcu_fd_sc_mcu7t5v0__fillcap_64
XFILLER_20_435 VDD VDD VSS VSS gf180mcu_fd_sc_mcu7t5v0__fillcap_16
Xwave_controller_x_inst__2151_ wave_controller_x_inst__2148_/Z wave_controller_x_inst__2151_/A2
+ wave_controller_x_inst__3732_/D VDD VDD VSS VSS gf180mcu_fd_sc_mcu7t5v0__xor2_1
Xspi_regs_inst__1508_ spi_regs_inst__1508_/D spi_regs_inst__1648_/RN clkload29/I spi_regs_inst__1508_/Q
+ VDD VDD VSS VSS gf180mcu_fd_sc_mcu7t5v0__dffrnq_1
XFILLER_9_480 VDD VDD VSS VSS gf180mcu_fd_sc_mcu7t5v0__fill_2
Xspi_regs_inst__1439_ spi_regs_inst__1508_/Q spi_regs_inst__1439_/I1 spi_regs_inst__1441_/S
+ spi_regs_inst__1508_/D VDD VDD VSS VSS gf180mcu_fd_sc_mcu7t5v0__mux2_2
XFILLER_145_142 VDD VDD VSS VSS gf180mcu_fd_sc_mcu7t5v0__fillcap_4
Xwave_controller_x_inst__2082_ wave_controller_x_inst__2124_/B wave_controller_x_inst__2090_/A1
+ wave_controller_x_inst__2083_/B wave_controller_x_inst__2082_/Z VDD VDD VSS VSS
+ gf180mcu_fd_sc_mcu7t5v0__and3_1
XFILLER_134_838 VDD VDD VSS VSS gf180mcu_fd_sc_mcu7t5v0__fillcap_16
XFILLER_160_101 VDD VDD VSS VSS gf180mcu_fd_sc_mcu7t5v0__fillcap_4
XTAP_TAPCELL_ROW_76_1126 VDD VSS gf180mcu_fd_sc_mcu7t5v0__filltie
XTAP_TAPCELL_ROW_76_1137 VDD VSS gf180mcu_fd_sc_mcu7t5v0__filltie
XFILLER_87_402 VDD VDD VSS VSS gf180mcu_fd_sc_mcu7t5v0__fillcap_4
XFILLER_101_212 VDD VDD VSS VSS gf180mcu_fd_sc_mcu7t5v0__fill_2
XFILLER_82_1169 VDD VDD VSS VSS gf180mcu_fd_sc_mcu7t5v0__fill_1
XFILLER_87_446 VDD VDD VSS VSS gf180mcu_fd_sc_mcu7t5v0__fill_1
XFILLER_88_947 VDD VDD VSS VSS gf180mcu_fd_sc_mcu7t5v0__fillcap_64
Xwave_controller_x_inst__2984_ wave_controller_x_inst__3712_/Q wave_controller_x_inst__3244_/B2
+ fanout539/Z wave_controller_x_inst__3711_/Q wave_controller_x_inst__2985_/B VDD
+ VDD VSS VSS gf180mcu_fd_sc_mcu7t5v0__aoi22_1
XFILLER_75_608 VDD VDD VSS VSS gf180mcu_fd_sc_mcu7t5v0__fillcap_4
Xwave_controller_y_inst__1951_ fanout392/Z wave_controller_y_inst__3735_/Q wave_controller_y_inst__3736_/D
+ VDD VDD VSS VSS gf180mcu_fd_sc_mcu7t5v0__and2_1
Xwave_controller_x_inst__1935_ wave_controller_x_inst__1940_/A1 wave_controller_x_inst__1781_/I
+ wave_controller_x_inst__1937_/A1 wave_controller_x_inst__1783_/I wave_controller_x_inst__1939_/B
+ VDD VDD VSS VSS gf180mcu_fd_sc_mcu7t5v0__aoi22_1
XFILLER_114_46 VDD VDD VSS VSS gf180mcu_fd_sc_mcu7t5v0__fillcap_8
XFILLER_56_822 VDD VDD VSS VSS gf180mcu_fd_sc_mcu7t5v0__fillcap_32
XFILLER_74_107 VDD VDD VSS VSS gf180mcu_fd_sc_mcu7t5v0__fillcap_4
XTAP_TAPCELL_ROW_58_828 VDD VSS gf180mcu_fd_sc_mcu7t5v0__filltie
XTAP_TAPCELL_ROW_58_839 VDD VSS gf180mcu_fd_sc_mcu7t5v0__filltie
Xwave_controller_y_inst__1882_ spi_regs_inst__1285_/B2 wave_controller_y_inst__3536_/B2
+ VDD VDD VSS VSS gf180mcu_fd_sc_mcu7t5v0__clkinv_1
Xwave_controller_x_inst__1866_ spi_regs_inst__1060_/A1 wave_controller_x_inst__2841_/A1
+ VDD VDD VSS VSS gf180mcu_fd_sc_mcu7t5v0__clkinv_1
XFILLER_110_790 VDD VDD VSS VSS gf180mcu_fd_sc_mcu7t5v0__fill_2
XTAP_TAPCELL_ROW_27_1_533 VDD VSS gf180mcu_fd_sc_mcu7t5v0__filltie
Xwave_controller_y_inst__3621_ wave_controller_y_inst__3621_/D wave_controller_y_inst__3739_/RN
+ clkload15/I spi_regs_inst__1091_/A1 VDD VDD VSS VSS gf180mcu_fd_sc_mcu7t5v0__dffrnq_1
Xwave_controller_x_inst__3605_ spi_regs_inst__1100_/B2 wave_controller_x_inst__3610_/A1
+ wave_controller_x_inst__3606_/B VDD VDD VSS VSS gf180mcu_fd_sc_mcu7t5v0__nand2_1
Xwave_controller_y_inst__3552_ wave_controller_y_inst__1806_/I wave_controller_y_inst__3555_/A2
+ wave_controller_y_inst__3554_/A2 VDD VDD VSS VSS gf180mcu_fd_sc_mcu7t5v0__nor2_1
Xwave_controller_x_inst__1797_ wave_controller_x_inst__3703_/Q wave_controller_x_inst__3562_/A1
+ VDD VDD VSS VSS gf180mcu_fd_sc_mcu7t5v0__clkinv_1
XFILLER_130_23 VDD VDD VSS VSS gf180mcu_fd_sc_mcu7t5v0__fill_1
XFILLER_130_34 VDD VDD VSS VSS gf180mcu_fd_sc_mcu7t5v0__fill_1
XFILLER_167_1068 VDD VDD VSS VSS gf180mcu_fd_sc_mcu7t5v0__fill_1
XFILLER_82_173 VDD VDD VSS VSS gf180mcu_fd_sc_mcu7t5v0__fill_2
Xwave_controller_y_inst__2503_ fanout507/Z wave_controller_y_inst__2503_/A2 wave_controller_y_inst__2511_/B
+ VDD VDD VSS VSS gf180mcu_fd_sc_mcu7t5v0__nor2_1
Xwave_controller_x_inst__3536_ wave_controller_x_inst__3539_/A1 wave_controller_x_inst__3536_/A2
+ wave_controller_x_inst__3536_/A3 wave_controller_x_inst__3545_/B1 wave_controller_x_inst__3536_/B2
+ wave_controller_x_inst__3641_/D VDD VDD VSS VSS gf180mcu_fd_sc_mcu7t5v0__oai32_1
Xwave_controller_y_inst__3483_ wave_controller_y_inst__3699_/Q wave_controller_y_inst__3483_/A2
+ wave_controller_y_inst__3485_/A2 VDD VDD VSS VSS gf180mcu_fd_sc_mcu7t5v0__nor2_1
Xwave_controller_x_inst__3467_ wave_controller_x_inst__3469_/A1 wave_controller_x_inst__3487_/A2
+ wave_controller_x_inst__3467_/B wave_controller_x_inst__3468_/I VDD VDD VSS VSS
+ gf180mcu_fd_sc_mcu7t5v0__oai21_1
Xsignal_processor_x_inst__211_ signal_processor_x_inst__211_/A1 signal_processor_x_inst__169_/Z
+ signal_processor_x_inst__211_/B signal_processor_x_inst__224_/D VDD VDD VSS VSS
+ gf180mcu_fd_sc_mcu7t5v0__oai21_1
Xwave_controller_y_inst__2434_ wave_controller_y_inst__2418_/Z wave_controller_y_inst__2434_/A2
+ wave_controller_y_inst__2434_/B wave_controller_y_inst__2435_/A2 VDD VDD VSS VSS
+ gf180mcu_fd_sc_mcu7t5v0__oai21_1
Xwave_controller_x_inst__2418_ max_cap451/Z wave_controller_x_inst__2416_/Z wave_controller_x_inst__2418_/Z
+ VDD VDD VSS VSS gf180mcu_fd_sc_mcu7t5v0__xor2_1
Xsignal_processor_x_inst__142_ signal_processor_x_inst__202_/A1 signal_processor_x_inst__199_/A2
+ signal_processor_x_inst__210_/A2 VDD VDD VSS VSS gf180mcu_fd_sc_mcu7t5v0__nor2_1
XFILLER_7_406 VDD VDD VSS VSS gf180mcu_fd_sc_mcu7t5v0__fillcap_4
Xwave_controller_y_inst__2365_ wave_controller_y_inst__2363_/Z wave_controller_y_inst__2367_/A3
+ wave_controller_y_inst__2366_/A2 VDD VDD VSS VSS gf180mcu_fd_sc_mcu7t5v0__xnor2_1
Xwave_controller_x_inst__3398_ wave_controller_x_inst__3398_/A1 wave_controller_x_inst__3398_/A2
+ wave_controller_x_inst__3400_/B VDD VDD VSS VSS gf180mcu_fd_sc_mcu7t5v0__xnor2_1
XFILLER_149_492 VDD VDD VSS VSS gf180mcu_fd_sc_mcu7t5v0__fillcap_8
XFILLER_23_76 VDD VDD VSS VSS gf180mcu_fd_sc_mcu7t5v0__fill_1
Xwave_controller_x_inst__2349_ wave_controller_x_inst__2349_/A1 max_cap452/Z max_cap453/Z
+ wave_controller_x_inst__2349_/C wave_controller_x_inst__2350_/C VDD VDD VSS VSS
+ gf180mcu_fd_sc_mcu7t5v0__aoi211_1
Xwave_controller_y_inst__2296_ wave_controller_y_inst__2311_/A1 wave_controller_y_inst__2296_/A2
+ wave_controller_y_inst__2297_/A2 VDD VDD VSS VSS gf180mcu_fd_sc_mcu7t5v0__nand2_1
XFILLER_137_698 VDD VDD VSS VSS gf180mcu_fd_sc_mcu7t5v0__fill_2
XFILLER_99_69 VDD VDD VSS VSS gf180mcu_fd_sc_mcu7t5v0__fill_1
Xwave_controller_y_inst_fanout520 spi_regs_inst__1478_/Q wave_controller_y_inst__3212_/B
+ VDD VDD VSS VSS gf180mcu_fd_sc_mcu7t5v0__dlyb_1
XFILLER_3_2 VDD VDD VSS VSS gf180mcu_fd_sc_mcu7t5v0__fillcap_64
Xwave_controller_y_inst_fanout553 fanout570/Z wave_controller_y_inst__3717_/RN VDD
+ VDD VSS VSS gf180mcu_fd_sc_mcu7t5v0__dlyb_1
XFILLER_120_510 VDD VDD VSS VSS gf180mcu_fd_sc_mcu7t5v0__fillcap_4
XFILLER_155_86 VDD VDD VSS VSS gf180mcu_fd_sc_mcu7t5v0__fillcap_8
XFILLER_2_177 VDD VDD VSS VSS gf180mcu_fd_sc_mcu7t5v0__fillcap_64
XFILLER_19_502 VDD VDD VSS VSS gf180mcu_fd_sc_mcu7t5v0__fillcap_8
XFILLER_93_438 VDD VDD VSS VSS gf180mcu_fd_sc_mcu7t5v0__fillcap_16
Xspi_regs_inst__0810_ spi_regs_inst__1557_/Q spi_regs_inst__1377_/I1 spi_regs_inst__0813_/S
+ spi_regs_inst__1557_/D VDD VDD VSS VSS gf180mcu_fd_sc_mcu7t5v0__mux2_2
XFILLER_0_36 VDD VDD VSS VSS gf180mcu_fd_sc_mcu7t5v0__fillcap_32
XFILLER_34_505 VDD VDD VSS VSS gf180mcu_fd_sc_mcu7t5v0__fillcap_16
XFILLER_59_1116 VDD VDD VSS VSS gf180mcu_fd_sc_mcu7t5v0__fillcap_4
XFILLER_61_302 VDD VDD VSS VSS gf180mcu_fd_sc_mcu7t5v0__fill_2
XFILLER_62_803 VDD VDD VSS VSS gf180mcu_fd_sc_mcu7t5v0__fill_2
XFILLER_74_685 VDD VDD VSS VSS gf180mcu_fd_sc_mcu7t5v0__fillcap_4
XTAP_TAPCELL_ROW_105_1609 VDD VSS gf180mcu_fd_sc_mcu7t5v0__filltie
Xspi_regs_inst__0741_ spi_regs_inst__1645_/Q spi_regs_inst__1265_/A1 VDD VDD VSS VSS
+ gf180mcu_fd_sc_mcu7t5v0__clkinv_1
XFILLER_34_527 VDD VDD VSS VSS gf180mcu_fd_sc_mcu7t5v0__fill_1
XFILLER_61_335 VDD VDD VSS VSS gf180mcu_fd_sc_mcu7t5v0__fillcap_8
XFILLER_159_278 VDD VDD VSS VSS gf180mcu_fd_sc_mcu7t5v0__fill_2
XTAP_TAPCELL_ROW_155_2433 VDD VSS gf180mcu_fd_sc_mcu7t5v0__filltie
XFILLER_156_941 VDD VDD VSS VSS gf180mcu_fd_sc_mcu7t5v0__fillcap_4
XFILLER_80_71 VDD VDD VSS VSS gf180mcu_fd_sc_mcu7t5v0__fillcap_16
XFILLER_127_142 VDD VDD VSS VSS gf180mcu_fd_sc_mcu7t5v0__fillcap_32
Xspi_regs_inst__1224_ spi_regs_inst__1224_/A1 spi_regs_inst__1224_/A2 spi_regs_inst_wire218/I
+ spi_regs_inst__1224_/B2 spi_regs_inst__1228_/A1 VDD VDD VSS VSS gf180mcu_fd_sc_mcu7t5v0__aoi22_1
XFILLER_10_490 VDD VDD VSS VSS gf180mcu_fd_sc_mcu7t5v0__fillcap_16
XFILLER_6_461 VDD VDD VSS VSS gf180mcu_fd_sc_mcu7t5v0__fill_1
XTAP_TAPCELL_ROW_44_1_658 VDD VSS gf180mcu_fd_sc_mcu7t5v0__filltie
Xspi_regs_inst__1155_ max_cap432/Z spi_regs_inst_wire222/Z spi_regs_inst__1325_/A2
+ spi_regs_inst_wire102/Z spi_regs_inst__1157_/A3 VDD VDD VSS VSS gf180mcu_fd_sc_mcu7t5v0__aoi22_1
Xspi_regs_inst__1086_ spi_regs_inst__1584_/Q spi_regs_inst__1198_/A2 spi_regs_inst__1178_/A2
+ spi_regs_inst__1086_/B2 spi_regs_inst__1088_/A3 VDD VDD VSS VSS gf180mcu_fd_sc_mcu7t5v0__aoi22_1
XFILLER_124_893 VDD VDD VSS VSS gf180mcu_fd_sc_mcu7t5v0__fill_1
XFILLER_130_329 VDD VDD VSS VSS gf180mcu_fd_sc_mcu7t5v0__fillcap_4
XFILLER_36_2 VDD VDD VSS VSS gf180mcu_fd_sc_mcu7t5v0__fillcap_32
XTAP_TAPCELL_ROW_71_1045 VDD VSS gf180mcu_fd_sc_mcu7t5v0__filltie
XFILLER_57_619 VDD VDD VSS VSS gf180mcu_fd_sc_mcu7t5v0__fill_2
XTAP_TAPCELL_ROW_71_1056 VDD VSS gf180mcu_fd_sc_mcu7t5v0__filltie
XFILLER_56_107 VDD VDD VSS VSS gf180mcu_fd_sc_mcu7t5v0__fill_2
XFILLER_96_287 VDD VDD VSS VSS gf180mcu_fd_sc_mcu7t5v0__fillcap_8
XFILLER_49_170 VDD VDD VSS VSS gf180mcu_fd_sc_mcu7t5v0__fill_1
XFILLER_49_192 VDD VDD VSS VSS gf180mcu_fd_sc_mcu7t5v0__fill_1
XFILLER_64_140 VDD VDD VSS VSS gf180mcu_fd_sc_mcu7t5v0__fill_1
XFILLER_65_663 VDD VDD VSS VSS gf180mcu_fd_sc_mcu7t5v0__fill_1
Xspi_regs_inst__0939_ spi_regs_inst__1641_/Q spi_regs_inst__1640_/Q spi_regs_inst__0939_/S
+ spi_regs_inst__1641_/D VDD VDD VSS VSS gf180mcu_fd_sc_mcu7t5v0__mux2_2
XFILLER_52_302 VDD VDD VSS VSS gf180mcu_fd_sc_mcu7t5v0__fillcap_8
Xwave_controller_x_inst__3321_ wave_controller_x_inst__1781_/I spi_regs_inst__1556_/Q
+ wave_controller_x_inst__3321_/Z VDD VDD VSS VSS gf180mcu_fd_sc_mcu7t5v0__xor2_1
XFILLER_100_37 VDD VDD VSS VSS gf180mcu_fd_sc_mcu7t5v0__fill_2
XFILLER_127_1052 VDD VDD VSS VSS gf180mcu_fd_sc_mcu7t5v0__fillcap_64
Xwave_controller_x_inst__3252_ wave_controller_x_inst__3252_/A1 wave_controller_x_inst__3252_/A2
+ wave_controller_x_inst__3248_/B wave_controller_x_inst__3195_/Z fanout532/Z wave_controller_x_inst__3254_/C
+ VDD VDD VSS VSS gf180mcu_fd_sc_mcu7t5v0__oai32_1
Xwave_controller_x_inst__2203_ wave_controller_x_inst__2223_/B2 max_cap458/Z wave_controller_x_inst__2203_/Z
+ VDD VDD VSS VSS gf180mcu_fd_sc_mcu7t5v0__xor2_1
XFILLER_165_204 VDD VDD VSS VSS gf180mcu_fd_sc_mcu7t5v0__fill_1
XFILLER_20_243 VDD VDD VSS VSS gf180mcu_fd_sc_mcu7t5v0__fill_2
Xwave_controller_y_inst__2150_ wave_controller_y_inst__2148_/Z wave_controller_y_inst__2151_/A2
+ wave_controller_y_inst__2152_/B VDD VDD VSS VSS gf180mcu_fd_sc_mcu7t5v0__and2_1
Xwave_controller_x_inst__3183_ wave_controller_x_inst__3340_/A1 spi_regs_inst__1518_/Q
+ wave_controller_x_inst__3190_/A1 VDD VDD VSS VSS gf180mcu_fd_sc_mcu7t5v0__nand2_1
XFILLER_119_632 VDD VDD VSS VSS gf180mcu_fd_sc_mcu7t5v0__fillcap_16
Xwave_controller_x_inst__2134_ wave_controller_x_inst__3730_/Q wave_controller_x_inst__2134_/A2
+ wave_controller_x_inst__2134_/Z VDD VDD VSS VSS gf180mcu_fd_sc_mcu7t5v0__xor2_1
XFILLER_119_676 VDD VDD VSS VSS gf180mcu_fd_sc_mcu7t5v0__fill_1
XFILLER_134_613 VDD VDD VSS VSS gf180mcu_fd_sc_mcu7t5v0__fill_2
Xwave_controller_y_inst__2081_ wave_controller_y_inst__2144_/B wave_controller_y_inst__2081_/A2
+ wave_controller_y_inst__2081_/A3 wave_controller_y_inst__2081_/B wave_controller_y_inst__2083_/B
+ VDD VDD VSS VSS gf180mcu_fd_sc_mcu7t5v0__oai31_1
Xwave_controller_x_inst__2065_ wave_controller_x_inst__3406_/A2 wave_controller_x_inst__2065_/A2
+ wave_controller_x_inst__2754_/A2 VDD VDD VSS VSS gf180mcu_fd_sc_mcu7t5v0__nand2_1
XFILLER_114_381 VDD VDD VSS VSS gf180mcu_fd_sc_mcu7t5v0__fillcap_4
Xspi_regs_inst_wire81 spi_regs_inst_wire81/I spi_regs_inst_wire81/Z VDD VDD VSS VSS
+ gf180mcu_fd_sc_mcu7t5v0__buf_2
XFILLER_87_254 VDD VDD VSS VSS gf180mcu_fd_sc_mcu7t5v0__fill_2
Xwave_controller_y_inst__2983_ wave_controller_y_inst__3711_/Q fanout517/Z wave_controller_y_inst__2983_/B
+ wave_controller_y_inst__3071_/A3 VDD VDD VSS VSS gf180mcu_fd_sc_mcu7t5v0__aoi21_1
Xwave_controller_x_inst_fanout449 wave_controller_x_inst__3708_/Q wave_controller_x_inst__1792_/I
+ VDD VDD VSS VSS gf180mcu_fd_sc_mcu7t5v0__dlyb_1
Xwave_controller_x_inst_fanout438 wave_controller_x_inst__2831_/A2 wave_controller_x_inst__2793_/S
+ VDD VDD VSS VSS gf180mcu_fd_sc_mcu7t5v0__dlyb_1
Xwave_controller_x_inst__2967_ wave_controller_x_inst__2961_/Z wave_controller_x_inst__3045_/B
+ wave_controller_x_inst__2967_/B wave_controller_x_inst__3047_/A3 VDD VDD VSS VSS
+ gf180mcu_fd_sc_mcu7t5v0__aoi21_1
Xspi_regs_inst_wire92 spi_regs_inst_wire92/I spi_regs_inst_wire92/Z VDD VDD VSS VSS
+ gf180mcu_fd_sc_mcu7t5v0__buf_2
Xwave_controller_y_inst__1934_ wave_controller_y_inst__1937_/B1 wave_controller_y_inst__1785_/I
+ wave_controller_y_inst__3713_/Q wave_controller_y_inst__1934_/B2 wave_controller_y_inst__1939_/A1
+ VDD VDD VSS VSS gf180mcu_fd_sc_mcu7t5v0__aoi22_1
Xwave_controller_x_inst__1918_ spi_regs_inst__1501_/Q wave_controller_x_inst__3562_/A1
+ spi_regs_inst__1500_/Q wave_controller_x_inst__3279_/A1 wave_controller_x_inst__1919_/A2
+ VDD VDD VSS VSS gf180mcu_fd_sc_mcu7t5v0__oai22_1
XFILLER_28_321 VDD VDD VSS VSS gf180mcu_fd_sc_mcu7t5v0__fill_1
XFILLER_91_909 VDD VDD VSS VSS gf180mcu_fd_sc_mcu7t5v0__fill_1
XTAP_TAPCELL_ROW_89_1339 VDD VSS gf180mcu_fd_sc_mcu7t5v0__filltie
Xwave_controller_x_inst__2898_ wave_controller_x_inst__3340_/A1 wave_controller_x_inst__2898_/A2
+ wave_controller_x_inst__2898_/A3 wave_controller_x_inst__2898_/Z VDD VDD VSS VSS
+ gf180mcu_fd_sc_mcu7t5v0__xor3_1
Xwave_controller_y_inst__3604_ wave_controller_y_inst__3597_/S wave_controller_y_inst__3604_/A2
+ wave_controller_y_inst__3604_/B wave_controller_y_inst__3678_/D VDD VDD VSS VSS
+ gf180mcu_fd_sc_mcu7t5v0__oai21_1
Xwave_controller_y_inst__1865_ max_cap425/I wave_controller_y_inst__2824_/A1 VDD VDD
+ VSS VSS gf180mcu_fd_sc_mcu7t5v0__clkinv_1
Xwave_controller_x_inst__1849_ spi_regs_inst__1198_/B2 wave_controller_x_inst__2027_/B
+ VDD VDD VSS VSS gf180mcu_fd_sc_mcu7t5v0__clkinv_1
XFILLER_16_527 VDD VDD VSS VSS gf180mcu_fd_sc_mcu7t5v0__fillcap_4
XFILLER_28_398 VDD VDD VSS VSS gf180mcu_fd_sc_mcu7t5v0__fillcap_16
XFILLER_56_685 VDD VDD VSS VSS gf180mcu_fd_sc_mcu7t5v0__fillcap_16
XFILLER_71_644 VDD VDD VSS VSS gf180mcu_fd_sc_mcu7t5v0__fill_2
Xwave_controller_y_inst__1796_ wave_controller_y_inst__3704_/Q wave_controller_y_inst__3564_/A1
+ VDD VDD VSS VSS gf180mcu_fd_sc_mcu7t5v0__clkinv_1
XFILLER_141_99 VDD VDD VSS VSS gf180mcu_fd_sc_mcu7t5v0__fillcap_8
XFILLER_31_508 VDD VDD VSS VSS gf180mcu_fd_sc_mcu7t5v0__fill_1
XFILLER_71_655 VDD VDD VSS VSS gf180mcu_fd_sc_mcu7t5v0__fillcap_16
Xwave_controller_y_inst__3535_ spi_regs_inst__1285_/B2 wave_controller_y_inst__3556_/A2
+ wave_controller_y_inst__3536_/A3 VDD VDD VSS VSS gf180mcu_fd_sc_mcu7t5v0__nor2_1
Xwave_controller_x_inst_max_cap444 wave_controller_x_inst__3717_/Q wave_controller_x_inst__1778_/I
+ VDD VDD VSS VSS gf180mcu_fd_sc_mcu7t5v0__clkbuf_3
Xwave_controller_x_inst__3519_ wave_controller_x_inst__3709_/Q wave_controller_x_inst__3493_/Z
+ wave_controller_x_inst__3521_/A2 VDD VDD VSS VSS gf180mcu_fd_sc_mcu7t5v0__nor2_1
XFILLER_71_688 VDD VDD VSS VSS gf180mcu_fd_sc_mcu7t5v0__fill_1
XFILLER_71_699 VDD VDD VSS VSS gf180mcu_fd_sc_mcu7t5v0__fill_1
Xwave_controller_y_inst__3466_ spi_regs_inst__1270_/A1 wave_controller_y_inst__3493_/A1
+ wave_controller_y_inst__3467_/B VDD VDD VSS VSS gf180mcu_fd_sc_mcu7t5v0__nand2_1
XTAP_TAPCELL_ROW_100_1528 VDD VSS gf180mcu_fd_sc_mcu7t5v0__filltie
Xwave_controller_y_inst__2417_ spi_regs_inst__1078_/A1 wave_controller_y_inst__2416_/Z
+ wave_controller_y_inst__2417_/Z VDD VDD VSS VSS gf180mcu_fd_sc_mcu7t5v0__and2_1
XTAP_TAPCELL_ROW_137_2130 VDD VSS gf180mcu_fd_sc_mcu7t5v0__filltie
XTAP_TAPCELL_ROW_137_2141 VDD VSS gf180mcu_fd_sc_mcu7t5v0__filltie
Xwave_controller_y_inst__3397_ wave_controller_y_inst__3397_/A1 wave_controller_y_inst__3326_/Z
+ wave_controller_y_inst__3401_/B VDD VDD VSS VSS gf180mcu_fd_sc_mcu7t5v0__xor2_1
Xsignal_processor_x_inst__125_ signal_processor_x_inst__128_/A1 signal_processor_x_inst__245_/Q
+ signal_processor_x_inst__246_/D VDD VDD VSS VSS gf180mcu_fd_sc_mcu7t5v0__and2_1
XFILLER_11_276 VDD VDD VSS VSS gf180mcu_fd_sc_mcu7t5v0__fillcap_4
XFILLER_11_298 VDD VDD VSS VSS gf180mcu_fd_sc_mcu7t5v0__fillcap_8
XFILLER_138_941 VDD VDD VSS VSS gf180mcu_fd_sc_mcu7t5v0__fillcap_4
Xwave_controller_y_inst__2348_ wave_controller_y_inst__2322_/Z wave_controller_y_inst__2332_/Z
+ wave_controller_y_inst__2348_/Z VDD VDD VSS VSS gf180mcu_fd_sc_mcu7t5v0__and2_1
XFILLER_109_142 VDD VDD VSS VSS gf180mcu_fd_sc_mcu7t5v0__fillcap_16
XFILLER_166_30 VDD VDD VSS VSS gf180mcu_fd_sc_mcu7t5v0__fillcap_4
Xwave_controller_y_inst__2279_ wave_controller_y_inst__2277_/Z wave_controller_y_inst__2280_/A2
+ wave_controller_y_inst__2311_/A1 VDD VDD VSS VSS gf180mcu_fd_sc_mcu7t5v0__nand2_1
XFILLER_124_134 VDD VDD VSS VSS gf180mcu_fd_sc_mcu7t5v0__fill_1
XTAP_TAPCELL_ROW_150_2352 VDD VSS gf180mcu_fd_sc_mcu7t5v0__filltie
XFILLER_140_616 VDD VDD VSS VSS gf180mcu_fd_sc_mcu7t5v0__fillcap_4
XFILLER_152_454 VDD VDD VSS VSS gf180mcu_fd_sc_mcu7t5v0__fill_1
XTAP_TAPCELL_ROW_115_1771 VDD VSS gf180mcu_fd_sc_mcu7t5v0__filltie
XTAP_TAPCELL_ROW_40_1_631 VDD VSS gf180mcu_fd_sc_mcu7t5v0__filltie
XFILLER_106_882 VDD VDD VSS VSS gf180mcu_fd_sc_mcu7t5v0__fill_2
XFILLER_124_189 VDD VDD VSS VSS gf180mcu_fd_sc_mcu7t5v0__fillcap_4
XFILLER_133_690 VDD VDD VSS VSS gf180mcu_fd_sc_mcu7t5v0__fillcap_8
XTAP_TAPCELL_ROW_115_1782 VDD VSS gf180mcu_fd_sc_mcu7t5v0__filltie
Xwave_controller_y_inst_fanout361 wave_controller_y_inst__2114_/B wave_controller_y_inst__2079_/B
+ VDD VDD VSS VSS gf180mcu_fd_sc_mcu7t5v0__dlyb_1
XFILLER_59_72 VDD VDD VSS VSS gf180mcu_fd_sc_mcu7t5v0__fillcap_4
Xwave_controller_y_inst_fanout394 fanout402/I wave_controller_y_inst__1829_/I VDD
+ VDD VSS VSS gf180mcu_fd_sc_mcu7t5v0__dlyb_1
XFILLER_38_107 VDD VDD VSS VSS gf180mcu_fd_sc_mcu7t5v0__fillcap_8
XFILLER_94_769 VDD VDD VSS VSS gf180mcu_fd_sc_mcu7t5v0__fill_2
XFILLER_46_151 VDD VDD VSS VSS gf180mcu_fd_sc_mcu7t5v0__fillcap_4
XFILLER_81_419 VDD VDD VSS VSS gf180mcu_fd_sc_mcu7t5v0__fill_1
XFILLER_93_257 VDD VDD VSS VSS gf180mcu_fd_sc_mcu7t5v0__fill_2
XFILLER_93_279 VDD VDD VSS VSS gf180mcu_fd_sc_mcu7t5v0__fill_1
XFILLER_46_173 VDD VDD VSS VSS gf180mcu_fd_sc_mcu7t5v0__fill_2
XFILLER_62_699 VDD VDD VSS VSS gf180mcu_fd_sc_mcu7t5v0__fillcap_16
XFILLER_72_1157 VDD VDD VSS VSS gf180mcu_fd_sc_mcu7t5v0__fillcap_16
XPHY_EDGE_ROW_62_Left_229 VDD VSS gf180mcu_fd_sc_mcu7t5v0__endcap
XTAP_TAPCELL_ROW_60_867 VDD VSS gf180mcu_fd_sc_mcu7t5v0__filltie
XFILLER_156_760 VDD VDD VSS VSS gf180mcu_fd_sc_mcu7t5v0__fillcap_32
XFILLER_162_229 VDD VDD VSS VSS gf180mcu_fd_sc_mcu7t5v0__fill_2
Xspi_regs_inst__1207_ spi_regs_inst__1565_/Q spi_regs_inst__1207_/A2 spi_regs_inst__1207_/B1
+ spi_regs_inst__1539_/Q spi_regs_inst_wire242/I spi_regs_inst__1510_/Q spi_regs_inst__1209_/A2
+ VDD VDD VSS VSS gf180mcu_fd_sc_mcu7t5v0__aoi222_1
Xmax_cap423 max_cap423/I max_cap423/Z VDD VDD VSS VSS gf180mcu_fd_sc_mcu7t5v0__clkbuf_3
XFILLER_89_519 VDD VDD VSS VSS gf180mcu_fd_sc_mcu7t5v0__fill_2
Xspi_regs_inst__1138_ max_cap429/Z spi_regs_inst__1353_/A2 spi_regs_inst__1261_/B1
+ spi_regs_inst__1138_/B2 spi_regs_inst__1138_/C spi_regs_inst__1172_/A2 VDD VDD VSS
+ VSS gf180mcu_fd_sc_mcu7t5v0__aoi221_1
Xmax_cap467 max_cap467/I max_cap467/Z VDD VDD VSS VSS gf180mcu_fd_sc_mcu7t5v0__buf_4
XFILLER_143_487 VDD VDD VSS VSS gf180mcu_fd_sc_mcu7t5v0__fill_2
XFILLER_111_340 VDD VDD VSS VSS gf180mcu_fd_sc_mcu7t5v0__fill_1
XPHY_EDGE_ROW_7_1_Right_6 VDD VSS gf180mcu_fd_sc_mcu7t5v0__endcap
Xwave_controller_x_inst__2821_ spi_regs_inst__1301_/A1 wave_controller_x_inst__3446_/A2
+ wave_controller_x_inst__2822_/B VDD VDD VSS VSS gf180mcu_fd_sc_mcu7t5v0__nand2_1
Xspi_regs_inst__1069_ wire456/Z spi_regs_inst__1306_/A2 spi_regs_inst__1176_/A2 spi_regs_inst__1069_/B2
+ spi_regs_inst__1070_/A4 VDD VDD VSS VSS gf180mcu_fd_sc_mcu7t5v0__aoi22_1
XPHY_EDGE_ROW_71_Left_238 VDD VSS gf180mcu_fd_sc_mcu7t5v0__endcap
XFILLER_57_438 VDD VDD VSS VSS gf180mcu_fd_sc_mcu7t5v0__fill_2
XFILLER_85_758 VDD VDD VSS VSS gf180mcu_fd_sc_mcu7t5v0__fillcap_8
Xwave_controller_x_inst__2752_ wave_controller_x_inst__2749_/B wave_controller_x_inst__2747_/Z
+ wave_controller_x_inst__2752_/B1 wave_controller_x_inst_wire36/Z wave_controller_x_inst__2752_/C
+ wave_controller_x_inst__2753_/A3 VDD VDD VSS VSS gf180mcu_fd_sc_mcu7t5v0__oai221_1
Xclkbuf_leaf_49_clk clkbuf_3_2__f_clk/Z clkload14/I VDD VDD VSS VSS gf180mcu_fd_sc_mcu7t5v0__clkbuf_8
XFILLER_72_419 VDD VDD VSS VSS gf180mcu_fd_sc_mcu7t5v0__fill_2
Xwave_controller_x_inst__2683_ wave_controller_x_inst__2677_/Z wave_controller_x_inst__2683_/A2
+ spi_regs_inst__1310_/B2 VDD VDD VSS VSS gf180mcu_fd_sc_mcu7t5v0__xor2_1
XFILLER_53_611 VDD VDD VSS VSS gf180mcu_fd_sc_mcu7t5v0__fill_1
XFILLER_53_622 VDD VDD VSS VSS gf180mcu_fd_sc_mcu7t5v0__fillcap_8
XFILLER_53_666 VDD VDD VSS VSS gf180mcu_fd_sc_mcu7t5v0__fillcap_8
XFILLER_77_1046 VDD VDD VSS VSS gf180mcu_fd_sc_mcu7t5v0__fillcap_4
XTAP_TAPCELL_ROW_84_1258 VDD VSS gf180mcu_fd_sc_mcu7t5v0__filltie
XTAP_TAPCELL_ROW_84_1269 VDD VSS gf180mcu_fd_sc_mcu7t5v0__filltie
Xwave_controller_y_inst__3320_ wave_controller_y_inst__3320_/A1 spi_regs_inst__1613_/Q
+ wave_controller_y_inst__3320_/B wave_controller_y_inst__3332_/B2 VDD VDD VSS VSS
+ gf180mcu_fd_sc_mcu7t5v0__aoi21_1
Xwave_controller_x_inst__3304_ wave_controller_x_inst__1790_/I wave_controller_x_inst__3304_/A2
+ wave_controller_x_inst__3304_/B wave_controller_x_inst__3305_/B1 VDD VDD VSS VSS
+ gf180mcu_fd_sc_mcu7t5v0__aoi21_1
XPHY_EDGE_ROW_80_Left_247 VDD VSS gf180mcu_fd_sc_mcu7t5v0__endcap
XFILLER_139_738 VDD VDD VSS VSS gf180mcu_fd_sc_mcu7t5v0__fillcap_8
XFILLER_166_524 VDD VDD VSS VSS gf180mcu_fd_sc_mcu7t5v0__fill_1
XFILLER_21_552 VDD VDD VSS VSS gf180mcu_fd_sc_mcu7t5v0__fill_2
Xwave_controller_y_inst__3251_ wave_controller_y_inst__3251_/A1 wave_controller_y_inst__3250_/Z
+ wave_controller_y_inst__3254_/B VDD VDD VSS VSS gf180mcu_fd_sc_mcu7t5v0__nand2_1
Xwave_controller_x_inst__3235_ fanout527/Z wave_controller_x_inst__3235_/A2 wave_controller_x_inst__3235_/B1
+ wave_controller_x_inst__3235_/B2 wave_controller_x_inst__3237_/A3 VDD VDD VSS VSS
+ gf180mcu_fd_sc_mcu7t5v0__aoi22_1
XFILLER_53_1090 VDD VDD VSS VSS gf180mcu_fd_sc_mcu7t5v0__fillcap_32
XTAP_TAPCELL_ROW_5_1_368 VDD VSS gf180mcu_fd_sc_mcu7t5v0__filltie
Xwave_controller_y_inst__3182_ wave_controller_y_inst__3004_/B spi_regs_inst__1579_/Q
+ wave_controller_y_inst__3182_/B wave_controller_y_inst__3194_/A2 VDD VDD VSS VSS
+ gf180mcu_fd_sc_mcu7t5v0__aoi21_1
Xwave_controller_y_inst__2202_ wave_controller_y_inst__2202_/A1 wave_controller_y_inst__2202_/A2
+ wave_controller_y_inst__2201_/B spi_regs_inst_wire103/I VDD VDD VSS VSS gf180mcu_fd_sc_mcu7t5v0__xor3_1
Xwave_controller_x_inst__3166_ wave_controller_x_inst__3166_/A1 wave_controller_x_inst__3164_/Z
+ wave_controller_x_inst__3166_/B wave_controller_x_inst__3168_/A3 VDD VDD VSS VSS
+ gf180mcu_fd_sc_mcu7t5v0__aoi21_1
XFILLER_107_613 VDD VDD VSS VSS gf180mcu_fd_sc_mcu7t5v0__fill_2
XFILLER_119_462 VDD VDD VSS VSS gf180mcu_fd_sc_mcu7t5v0__fill_2
Xwave_controller_y_inst__2133_ wave_controller_y_inst__3730_/Q wave_controller_y_inst__2134_/A2
+ wave_controller_y_inst__2136_/B VDD VDD VSS VSS gf180mcu_fd_sc_mcu7t5v0__and2_1
Xwave_controller_x_inst__2117_ wave_controller_x_inst__2117_/A1 wave_controller_x_inst__2117_/A2
+ wave_controller_x_inst__2117_/B wave_controller_x_inst__2124_/A2 VDD VDD VSS VSS
+ gf180mcu_fd_sc_mcu7t5v0__aoi21_1
Xwave_controller_x_inst__3097_ wave_controller_x_inst__3097_/A1 wave_controller_x_inst__3097_/A2
+ wave_controller_x_inst__3101_/A2 VDD VDD VSS VSS gf180mcu_fd_sc_mcu7t5v0__nand2_1
XFILLER_84_1017 VDD VDD VSS VSS gf180mcu_fd_sc_mcu7t5v0__fillcap_64
XTAP_TAPCELL_ROW_132_2060 VDD VSS gf180mcu_fd_sc_mcu7t5v0__filltie
Xwave_controller_y_inst__2064_ wave_controller_y_inst__3098_/B wave_controller_y_inst__3612_/Q
+ fanout499/Z wave_controller_y_inst__2132_/A1 VDD VDD VSS VSS gf180mcu_fd_sc_mcu7t5v0__oai21_1
Xwave_controller_x_inst__2048_ wave_controller_x_inst__2071_/A1 wave_controller_x_inst__2035_/Z
+ wave_controller_x_inst__2073_/A2 wave_controller_x_inst__2095_/C VDD VDD VSS VSS
+ gf180mcu_fd_sc_mcu7t5v0__nor3_1
XFILLER_134_487 VDD VDD VSS VSS gf180mcu_fd_sc_mcu7t5v0__fill_1
XFILLER_134_498 VDD VDD VSS VSS gf180mcu_fd_sc_mcu7t5v0__fill_1
XFILLER_150_947 VDD VDD VSS VSS gf180mcu_fd_sc_mcu7t5v0__fillcap_64
XFILLER_161_273 VDD VDD VSS VSS gf180mcu_fd_sc_mcu7t5v0__fill_2
XFILLER_96_37 VDD VDD VSS VSS gf180mcu_fd_sc_mcu7t5v0__fillcap_32
XFILLER_0_478 VDD VDD VSS VSS gf180mcu_fd_sc_mcu7t5v0__fillcap_16
XFILLER_102_373 VDD VDD VSS VSS gf180mcu_fd_sc_mcu7t5v0__fillcap_8
XFILLER_76_703 VDD VDD VSS VSS gf180mcu_fd_sc_mcu7t5v0__fillcap_32
XTAP_TAPCELL_ROW_110_1690 VDD VSS gf180mcu_fd_sc_mcu7t5v0__filltie
Xwave_controller_y_inst__2966_ wave_controller_y_inst__2960_/I wave_controller_y_inst__2961_/Z
+ wave_controller_y_inst__3045_/B wave_controller_y_inst__2966_/Z VDD VDD VSS VSS
+ gf180mcu_fd_sc_mcu7t5v0__and3_1
XFILLER_112_1151 VDD VDD VSS VSS gf180mcu_fd_sc_mcu7t5v0__fillcap_4
XFILLER_63_419 VDD VDD VSS VSS gf180mcu_fd_sc_mcu7t5v0__fill_1
XFILLER_75_257 VDD VDD VSS VSS gf180mcu_fd_sc_mcu7t5v0__fillcap_16
XFILLER_75_279 VDD VDD VSS VSS gf180mcu_fd_sc_mcu7t5v0__fill_1
Xwave_controller_y_inst__2897_ wave_controller_y_inst__2117_/B wave_controller_y_inst__2897_/A2
+ wave_controller_y_inst__2897_/A3 wave_controller_y_inst__2897_/Z VDD VDD VSS VSS
+ gf180mcu_fd_sc_mcu7t5v0__xor3_1
Xwave_controller_y_inst__1917_ spi_regs_inst__1563_/Q wave_controller_y_inst__3279_/A1
+ spi_regs_inst__1562_/Q wave_controller_y_inst__2797_/C wave_controller_y_inst__1919_/A1
+ VDD VDD VSS VSS gf180mcu_fd_sc_mcu7t5v0__aoi22_1
XFILLER_112_1173 VDD VDD VSS VSS gf180mcu_fd_sc_mcu7t5v0__fill_1
XFILLER_72_920 VDD VDD VSS VSS gf180mcu_fd_sc_mcu7t5v0__fill_1
XTAP_TAPCELL_ROW_43_1_657 VDD VSS gf180mcu_fd_sc_mcu7t5v0__filltie
Xwave_controller_y_inst__1848_ spi_regs_inst__1169_/A1 wave_controller_y_inst__2425_/B2
+ VDD VDD VSS VSS gf180mcu_fd_sc_mcu7t5v0__clkinv_1
XPHY_EDGE_ROW_119_Left_286 VDD VSS gf180mcu_fd_sc_mcu7t5v0__endcap
Xwave_controller_y_inst__3518_ wave_controller_y_inst_wire144/Z wave_controller_y_inst__3518_/A2
+ wave_controller_y_inst__3518_/A3 wave_controller_y_inst__3521_/B1 wave_controller_y_inst__3518_/B2
+ wave_controller_y_inst__3635_/D VDD VDD VSS VSS gf180mcu_fd_sc_mcu7t5v0__oai32_1
Xwave_controller_y_inst__1779_ spi_regs_inst__1557_/Q wave_controller_y_inst__1942_/A2
+ VDD VDD VSS VSS gf180mcu_fd_sc_mcu7t5v0__clkinv_1
XFILLER_157_524 VDD VDD VSS VSS gf180mcu_fd_sc_mcu7t5v0__fillcap_8
Xwave_controller_y_inst__3449_ wave_controller_y_inst__3449_/A1 wave_controller_y_inst__3454_/A2
+ wave_controller_y_inst__3454_/B wave_controller_y_inst__3449_/C wave_controller_y_inst__3450_/B
+ VDD VDD VSS VSS gf180mcu_fd_sc_mcu7t5v0__aoi211_1
XFILLER_61_95 VDD VDD VSS VSS gf180mcu_fd_sc_mcu7t5v0__fill_1
XFILLER_8_523 VDD VDD VSS VSS gf180mcu_fd_sc_mcu7t5v0__fill_2
XFILLER_8_545 VDD VDD VSS VSS gf180mcu_fd_sc_mcu7t5v0__fillcap_8
Xsignal_processor_x_inst__108_ signal_processor_x_inst__108_/I signal_processor_x_inst__202_/A1
+ VDD VDD VSS VSS gf180mcu_fd_sc_mcu7t5v0__clkinv_1
XFILLER_145_719 VDD VDD VSS VSS gf180mcu_fd_sc_mcu7t5v0__fillcap_4
XTAP_TAPCELL_ROW_117_1800 VDD VSS gf180mcu_fd_sc_mcu7t5v0__filltie
XTAP_TAPCELL_ROW_117_1811 VDD VSS gf180mcu_fd_sc_mcu7t5v0__filltie
XFILLER_137_270 VDD VDD VSS VSS gf180mcu_fd_sc_mcu7t5v0__fillcap_8
XFILLER_153_741 VDD VDD VSS VSS gf180mcu_fd_sc_mcu7t5v0__fill_2
XFILLER_153_774 VDD VDD VSS VSS gf180mcu_fd_sc_mcu7t5v0__fill_1
XPHY_EDGE_ROW_128_Left_295 VDD VSS gf180mcu_fd_sc_mcu7t5v0__endcap
Xstate_machine_inst__22_ spi_regs_inst__1079_/B2 spi_regs_inst__1146_/A1 state_machine_inst__22_/Z
+ VDD VDD VSS VSS gf180mcu_fd_sc_mcu7t5v0__and2_1
XFILLER_112_104 VDD VDD VSS VSS gf180mcu_fd_sc_mcu7t5v0__fill_1
XFILLER_125_487 VDD VDD VSS VSS gf180mcu_fd_sc_mcu7t5v0__fill_2
XFILLER_98_327 VDD VDD VSS VSS gf180mcu_fd_sc_mcu7t5v0__fill_1
XFILLER_140_457 VDD VDD VSS VSS gf180mcu_fd_sc_mcu7t5v0__fillcap_16
XFILLER_67_736 VDD VDD VSS VSS gf180mcu_fd_sc_mcu7t5v0__fill_1
XFILLER_67_769 VDD VDD VSS VSS gf180mcu_fd_sc_mcu7t5v0__fill_1
XFILLER_54_419 VDD VDD VSS VSS gf180mcu_fd_sc_mcu7t5v0__fillcap_4
XTAP_TAPCELL_ROW_163_2565 VDD VSS gf180mcu_fd_sc_mcu7t5v0__filltie
XTAP_TAPCELL_ROW_29_1_547 VDD VSS gf180mcu_fd_sc_mcu7t5v0__filltie
XFILLER_19_162 VDD VDD VSS VSS gf180mcu_fd_sc_mcu7t5v0__fillcap_32
XFILLER_81_227 VDD VDD VSS VSS gf180mcu_fd_sc_mcu7t5v0__fillcap_16
XTAP_TAPCELL_ROW_128_1984 VDD VSS gf180mcu_fd_sc_mcu7t5v0__filltie
XTAP_TAPCELL_ROW_128_1995 VDD VSS gf180mcu_fd_sc_mcu7t5v0__filltie
XTAP_TAPCELL_ROW_65_948 VDD VSS gf180mcu_fd_sc_mcu7t5v0__filltie
Xspi_regs_inst_load_slew283 spi_regs_inst__1353_/A2 spi_regs_inst__1316_/A2 VDD VDD
+ VSS VSS gf180mcu_fd_sc_mcu7t5v0__buf_2
XFILLER_124_1011 VDD VDD VSS VSS gf180mcu_fd_sc_mcu7t5v0__fillcap_4
XFILLER_148_524 VDD VDD VSS VSS gf180mcu_fd_sc_mcu7t5v0__fill_1
Xwave_controller_x_inst__3020_ wave_controller_x_inst_wire60/Z wave_controller_x_inst__3021_/B1
+ wave_controller_x_inst__3022_/A2 VDD VDD VSS VSS gf180mcu_fd_sc_mcu7t5v0__nand2_1
XFILLER_129_782 VDD VDD VSS VSS gf180mcu_fd_sc_mcu7t5v0__fillcap_8
XFILLER_163_538 VDD VDD VSS VSS gf180mcu_fd_sc_mcu7t5v0__fillcap_8
XTAP_TAPCELL_ROW_1_1_341 VDD VSS gf180mcu_fd_sc_mcu7t5v0__filltie
XFILLER_116_454 VDD VDD VSS VSS gf180mcu_fd_sc_mcu7t5v0__fill_1
XFILLER_104_616 VDD VDD VSS VSS gf180mcu_fd_sc_mcu7t5v0__fillcap_16
XFILLER_132_947 VDD VDD VSS VSS gf180mcu_fd_sc_mcu7t5v0__fillcap_64
XFILLER_131_446 VDD VDD VSS VSS gf180mcu_fd_sc_mcu7t5v0__fill_2
XFILLER_112_671 VDD VDD VSS VSS gf180mcu_fd_sc_mcu7t5v0__fill_2
XFILLER_131_479 VDD VDD VSS VSS gf180mcu_fd_sc_mcu7t5v0__fill_1
Xwave_controller_y_inst__2820_ wave_controller_y_inst__3712_/Q wave_controller_y_inst__2835_/A2
+ wave_controller_y_inst__2820_/B1 wave_controller_y_inst__2820_/B2 wave_controller_y_inst__2820_/C
+ wave_controller_y_inst__2839_/A1 VDD VDD VSS VSS gf180mcu_fd_sc_mcu7t5v0__aoi221_1
XFILLER_100_833 VDD VDD VSS VSS gf180mcu_fd_sc_mcu7t5v0__fill_2
Xwave_controller_x_inst__2804_ wave_controller_x_inst__3568_/A1 wave_controller_x_inst__2791_/Z
+ wave_controller_x_inst__2810_/C VDD VDD VSS VSS gf180mcu_fd_sc_mcu7t5v0__or2_1
XFILLER_100_877 VDD VDD VSS VSS gf180mcu_fd_sc_mcu7t5v0__fillcap_64
Xwave_controller_y_inst__2751_ wave_controller_y_inst__2736_/I wave_controller_y_inst__2748_/Z
+ wave_controller_y_inst__2752_/B1 VDD VDD VSS VSS gf180mcu_fd_sc_mcu7t5v0__nand2_1
Xwave_controller_x_inst__2735_ wave_controller_x_inst__2729_/I wave_controller_x_inst__2733_/Z
+ wave_controller_x_inst__2736_/I VDD VDD VSS VSS gf180mcu_fd_sc_mcu7t5v0__xnor2_1
XFILLER_45_419 VDD VDD VSS VSS gf180mcu_fd_sc_mcu7t5v0__fill_1
Xwave_controller_y_inst__2682_ wave_controller_y_inst__2677_/Z wave_controller_y_inst__2683_/A2
+ wave_controller_y_inst__2696_/A2 VDD VDD VSS VSS gf180mcu_fd_sc_mcu7t5v0__nand2_1
XFILLER_53_441 VDD VDD VSS VSS gf180mcu_fd_sc_mcu7t5v0__fill_1
XFILLER_81_750 VDD VDD VSS VSS gf180mcu_fd_sc_mcu7t5v0__fill_2
Xwave_controller_x_inst__2666_ wave_controller_x_inst__2680_/A1 wave_controller_x_inst__2681_/A1
+ wave_controller_x_inst__2667_/A2 VDD VDD VSS VSS gf180mcu_fd_sc_mcu7t5v0__nand2_1
XFILLER_25_165 VDD VDD VSS VSS gf180mcu_fd_sc_mcu7t5v0__fillcap_4
Xwave_controller_x_inst__2597_ wave_controller_x_inst__2595_/Z wave_controller_x_inst__2599_/A3
+ wave_controller_x_inst__2597_/Z VDD VDD VSS VSS gf180mcu_fd_sc_mcu7t5v0__xor2_1
XFILLER_15_66 VDD VDD VSS VSS gf180mcu_fd_sc_mcu7t5v0__fillcap_4
XFILLER_40_102 VDD VDD VSS VSS gf180mcu_fd_sc_mcu7t5v0__fill_2
Xwave_controller_y_inst__3303_ wave_controller_y_inst__3303_/A1 wave_controller_y_inst_wire119/Z
+ wave_controller_y_inst__3303_/A3 wave_controller_y_inst__3310_/A1 VDD VDD VSS VSS
+ gf180mcu_fd_sc_mcu7t5v0__nand3_1
XFILLER_90_1087 VDD VDD VSS VSS gf180mcu_fd_sc_mcu7t5v0__fillcap_64
Xwave_controller_y_inst__3234_ wave_controller_y_inst__3374_/B wave_controller_y_inst__3234_/A2
+ wave_controller_y_inst__3234_/B1 wave_controller_y_inst__3234_/B2 wave_controller_y_inst__3235_/B2
+ VDD VDD VSS VSS gf180mcu_fd_sc_mcu7t5v0__oai22_1
Xwave_controller_x_inst__3218_ wave_controller_x_inst__3218_/A1 wave_controller_x_inst__3147_/B
+ wave_controller_x_inst__3218_/B wave_controller_x_inst__3218_/C wave_controller_x_inst__3236_/A1
+ VDD VDD VSS VSS gf180mcu_fd_sc_mcu7t5v0__aoi211_1
XFILLER_166_376 VDD VDD VSS VSS gf180mcu_fd_sc_mcu7t5v0__fillcap_8
XFILLER_108_944 VDD VDD VSS VSS gf180mcu_fd_sc_mcu7t5v0__fill_1
XFILLER_154_527 VDD VDD VSS VSS gf180mcu_fd_sc_mcu7t5v0__fillcap_8
XFILLER_166_387 VDD VDD VSS VSS gf180mcu_fd_sc_mcu7t5v0__fillcap_4
Xwave_controller_y_inst__3165_ wave_controller_y_inst__3166_/A1 wave_controller_y_inst__3164_/Z
+ wave_controller_y_inst__3165_/Z VDD VDD VSS VSS gf180mcu_fd_sc_mcu7t5v0__and2_1
Xwave_controller_x_inst__3149_ wave_controller_x_inst__1792_/I wave_controller_x_inst__3213_/A2
+ wave_controller_x_inst__3149_/B1 wave_controller_x_inst__3149_/B2 wave_controller_x_inst__3149_/C
+ wave_controller_x_inst__3211_/A2 VDD VDD VSS VSS gf180mcu_fd_sc_mcu7t5v0__oai221_1
XFILLER_107_432 VDD VDD VSS VSS gf180mcu_fd_sc_mcu7t5v0__fillcap_4
XTAP_TAPCELL_ROW_130_2019 VDD VSS gf180mcu_fd_sc_mcu7t5v0__filltie
Xwave_controller_y_inst__3096_ wave_controller_y_inst__3096_/A1 wave_controller_y_inst__3096_/A2
+ wave_controller_y_inst__3097_/A2 VDD VDD VSS VSS gf180mcu_fd_sc_mcu7t5v0__nand2_1
Xwave_controller_y_inst__2116_ wave_controller_y_inst__2114_/C wave_controller_y_inst__2116_/A2
+ wave_controller_y_inst__2116_/B1 wave_controller_y_inst__2107_/B wave_controller_y_inst__2116_/C
+ wave_controller_y_inst__2124_/A1 VDD VDD VSS VSS gf180mcu_fd_sc_mcu7t5v0__aoi221_1
XFILLER_107_487 VDD VDD VSS VSS gf180mcu_fd_sc_mcu7t5v0__fill_2
XFILLER_122_402 VDD VDD VSS VSS gf180mcu_fd_sc_mcu7t5v0__fillcap_4
XFILLER_122_413 VDD VDD VSS VSS gf180mcu_fd_sc_mcu7t5v0__fill_2
XFILLER_135_796 VDD VDD VSS VSS gf180mcu_fd_sc_mcu7t5v0__fillcap_4
Xwave_controller_y_inst__2047_ wave_controller_y_inst__2073_/A1 wave_controller_y_inst__2092_/A2
+ wave_controller_y_inst__2061_/A1 VDD VDD VSS VSS gf180mcu_fd_sc_mcu7t5v0__nand2_1
Xoutput8 _20_/Q bidir_out[1] VDD VDD VSS VSS gf180mcu_fd_sc_mcu7t5v0__buf_1
Xoutput10 _88_/Z bidir_out[3] VDD VDD VSS VSS gf180mcu_fd_sc_mcu7t5v0__buf_1
XFILLER_89_850 VDD VDD VSS VSS gf180mcu_fd_sc_mcu7t5v0__fillcap_4
XTAP_TAPCELL_ROW_112_1730 VDD VSS gf180mcu_fd_sc_mcu7t5v0__filltie
XFILLER_0_242 VDD VDD VSS VSS gf180mcu_fd_sc_mcu7t5v0__fill_1
XFILLER_150_799 VDD VDD VSS VSS gf180mcu_fd_sc_mcu7t5v0__fillcap_4
XFILLER_89_861 VDD VDD VSS VSS gf180mcu_fd_sc_mcu7t5v0__fill_2
XFILLER_95_319 VDD VDD VSS VSS gf180mcu_fd_sc_mcu7t5v0__fill_1
XTAP_TAPCELL_ROW_145_2262 VDD VSS gf180mcu_fd_sc_mcu7t5v0__filltie
Xwave_controller_y_inst__2949_ wave_controller_y_inst__1792_/I wave_controller_y_inst__1823_/I
+ wave_controller_y_inst__2976_/B VDD VDD VSS VSS gf180mcu_fd_sc_mcu7t5v0__nand2_1
XTAP_TAPCELL_ROW_145_2273 VDD VSS gf180mcu_fd_sc_mcu7t5v0__filltie
XFILLER_91_558 VDD VDD VSS VSS gf180mcu_fd_sc_mcu7t5v0__fill_2
XTAP_TAPCELL_ROW_25_1_520 VDD VSS gf180mcu_fd_sc_mcu7t5v0__filltie
XTAP_TAPCELL_ROW_62_907 VDD VSS gf180mcu_fd_sc_mcu7t5v0__filltie
Xspi_regs_inst__1610_ spi_regs_inst__1610_/D spi_regs_inst__1610_/RN clkload17/I spi_regs_inst__1610_/Q
+ VDD VDD VSS VSS gf180mcu_fd_sc_mcu7t5v0__dffrnq_1
XFILLER_16_143 VDD VDD VSS VSS gf180mcu_fd_sc_mcu7t5v0__fillcap_16
XFILLER_16_165 VDD VDD VSS VSS gf180mcu_fd_sc_mcu7t5v0__fill_1
XFILLER_44_452 VDD VDD VSS VSS gf180mcu_fd_sc_mcu7t5v0__fill_2
XFILLER_44_463 VDD VDD VSS VSS gf180mcu_fd_sc_mcu7t5v0__fill_1
XFILLER_71_260 VDD VDD VSS VSS gf180mcu_fd_sc_mcu7t5v0__fillcap_8
Xwave_controller_x_inst_fanout72 wave_controller_x_inst_wire75/Z wave_controller_x_inst__3602_/S
+ VDD VDD VSS VSS gf180mcu_fd_sc_mcu7t5v0__dlyb_1
Xspi_regs_inst__1541_ spi_regs_inst__1541_/D fanout619/Z clkbuf_leaf_36_clk/Z spi_regs_inst__1541_/Q
+ VDD VDD VSS VSS gf180mcu_fd_sc_mcu7t5v0__dffrnq_1
XFILLER_108_1017 VDD VDD VSS VSS gf180mcu_fd_sc_mcu7t5v0__fillcap_64
XFILLER_16_198 VDD VDD VSS VSS gf180mcu_fd_sc_mcu7t5v0__fillcap_4
XFILLER_60_934 VDD VDD VSS VSS gf180mcu_fd_sc_mcu7t5v0__fillcap_8
XFILLER_71_282 VDD VDD VSS VSS gf180mcu_fd_sc_mcu7t5v0__fillcap_32
Xspi_regs_inst__1472_ spi_regs_inst__1472_/D fanout619/Z clkload32/I fanout529/I VDD
+ VDD VSS VSS gf180mcu_fd_sc_mcu7t5v0__dffrnq_1
XPHY_EDGE_ROW_59_Right_59 VDD VSS gf180mcu_fd_sc_mcu7t5v0__endcap
XFILLER_117_207 VDD VDD VSS VSS gf180mcu_fd_sc_mcu7t5v0__fill_2
XFILLER_118_708 VDD VDD VSS VSS gf180mcu_fd_sc_mcu7t5v0__fill_2
XFILLER_158_877 VDD VDD VSS VSS gf180mcu_fd_sc_mcu7t5v0__fillcap_64
XFILLER_145_538 VDD VDD VSS VSS gf180mcu_fd_sc_mcu7t5v0__fill_1
XFILLER_157_398 VDD VDD VSS VSS gf180mcu_fd_sc_mcu7t5v0__fillcap_16
XFILLER_8_397 VDD VDD VSS VSS gf180mcu_fd_sc_mcu7t5v0__fillcap_8
XPHY_EDGE_ROW_136_Left_303 VDD VSS gf180mcu_fd_sc_mcu7t5v0__endcap
XFILLER_113_402 VDD VDD VSS VSS gf180mcu_fd_sc_mcu7t5v0__fill_2
XFILLER_114_947 VDD VDD VSS VSS gf180mcu_fd_sc_mcu7t5v0__fillcap_64
XFILLER_158_1151 VDD VDD VSS VSS gf180mcu_fd_sc_mcu7t5v0__fillcap_4
XFILLER_158_1173 VDD VDD VSS VSS gf180mcu_fd_sc_mcu7t5v0__fill_1
XFILLER_100_107 VDD VDD VSS VSS gf180mcu_fd_sc_mcu7t5v0__fillcap_4
XFILLER_97_80 VDD VDD VSS VSS gf180mcu_fd_sc_mcu7t5v0__fillcap_4
XTAP_TAPCELL_ROW_165_2605 VDD VSS gf180mcu_fd_sc_mcu7t5v0__filltie
XFILLER_100_129 VDD VDD VSS VSS gf180mcu_fd_sc_mcu7t5v0__fill_1
XFILLER_95_831 VDD VDD VSS VSS gf180mcu_fd_sc_mcu7t5v0__fill_1
XPHY_EDGE_ROW_68_Right_68 VDD VSS gf180mcu_fd_sc_mcu7t5v0__endcap
XPHY_EDGE_ROW_145_Left_312 VDD VSS gf180mcu_fd_sc_mcu7t5v0__endcap
XFILLER_39_279 VDD VDD VSS VSS gf180mcu_fd_sc_mcu7t5v0__fill_1
XFILLER_94_374 VDD VDD VSS VSS gf180mcu_fd_sc_mcu7t5v0__fill_2
XFILLER_95_897 VDD VDD VSS VSS gf180mcu_fd_sc_mcu7t5v0__fill_2
XTAP_TAPCELL_ROW_68_1006 VDD VSS gf180mcu_fd_sc_mcu7t5v0__filltie
Xwave_controller_x_inst__2520_ wave_controller_x_inst__2556_/A1 wave_controller_x_inst__2519_/Z
+ wave_controller_x_inst__2534_/A2 VDD VDD VSS VSS gf180mcu_fd_sc_mcu7t5v0__nand2_1
XFILLER_130_1081 VDD VDD VSS VSS gf180mcu_fd_sc_mcu7t5v0__fillcap_4
XFILLER_165_1122 VDD VDD VSS VSS gf180mcu_fd_sc_mcu7t5v0__fillcap_32
XFILLER_63_772 VDD VDD VSS VSS gf180mcu_fd_sc_mcu7t5v0__fillcap_16
XTAP_TAPCELL_ROW_81_1206 VDD VSS gf180mcu_fd_sc_mcu7t5v0__filltie
Xwave_controller_x_inst__2451_ wave_controller_x_inst__2451_/A1 max_cap467/I wave_controller_x_inst__2464_/A1
+ VDD VDD VSS VSS gf180mcu_fd_sc_mcu7t5v0__nor2_1
XTAP_TAPCELL_ROW_81_1217 VDD VSS gf180mcu_fd_sc_mcu7t5v0__filltie
Xwave_controller_x_inst__2382_ wave_controller_x_inst_wire121/Z wave_controller_x_inst__2352_/Z
+ wave_controller_x_inst__2363_/Z wave_controller_x_inst__2382_/B wave_controller_x_inst_wire117/I
+ VDD VDD VSS VSS gf180mcu_fd_sc_mcu7t5v0__oai31_1
XPHY_EDGE_ROW_77_Right_77 VDD VSS gf180mcu_fd_sc_mcu7t5v0__endcap
XFILLER_108_207 VDD VDD VSS VSS gf180mcu_fd_sc_mcu7t5v0__fillcap_8
XPHY_EDGE_ROW_154_Left_321 VDD VSS gf180mcu_fd_sc_mcu7t5v0__endcap
XFILLER_136_538 VDD VDD VSS VSS gf180mcu_fd_sc_mcu7t5v0__fill_2
XFILLER_148_387 VDD VDD VSS VSS gf180mcu_fd_sc_mcu7t5v0__fillcap_4
Xwave_controller_x_inst__3003_ wave_controller_x_inst__3081_/A1 wave_controller_x_inst__3081_/A2
+ wave_controller_x_inst__3082_/A2 VDD VDD VSS VSS gf180mcu_fd_sc_mcu7t5v0__nand2_1
XFILLER_151_508 VDD VDD VSS VSS gf180mcu_fd_sc_mcu7t5v0__fillcap_4
XTAP_TAPCELL_ROW_42_1_645 VDD VSS gf180mcu_fd_sc_mcu7t5v0__filltie
XTAP_TAPCELL_ROW_79_1179 VDD VSS gf180mcu_fd_sc_mcu7t5v0__filltie
XTAP_TAPCELL_ROW_96_1460 VDD VSS gf180mcu_fd_sc_mcu7t5v0__filltie
XFILLER_116_262 VDD VDD VSS VSS gf180mcu_fd_sc_mcu7t5v0__fill_2
XFILLER_144_571 VDD VDD VSS VSS gf180mcu_fd_sc_mcu7t5v0__fill_2
XFILLER_89_146 VDD VDD VSS VSS gf180mcu_fd_sc_mcu7t5v0__fillcap_32
XFILLER_131_243 VDD VDD VSS VSS gf180mcu_fd_sc_mcu7t5v0__fillcap_4
XFILLER_131_265 VDD VDD VSS VSS gf180mcu_fd_sc_mcu7t5v0__fillcap_8
XPHY_EDGE_ROW_86_Right_86 VDD VSS gf180mcu_fd_sc_mcu7t5v0__endcap
XPHY_EDGE_ROW_163_Left_330 VDD VSS gf180mcu_fd_sc_mcu7t5v0__endcap
XFILLER_100_663 VDD VDD VSS VSS gf180mcu_fd_sc_mcu7t5v0__fill_2
XFILLER_58_544 VDD VDD VSS VSS gf180mcu_fd_sc_mcu7t5v0__fillcap_8
Xwave_controller_y_inst__2803_ wave_controller_y_inst__3564_/A1 wave_controller_y_inst__2800_/Z
+ wave_controller_y_inst__2808_/A2 VDD VDD VSS VSS gf180mcu_fd_sc_mcu7t5v0__nand2_1
Xsignal_processor_y_inst_fanout388 fanout389/Z signal_processor_y_inst__179_/A1 VDD
+ VDD VSS VSS gf180mcu_fd_sc_mcu7t5v0__dlyb_1
XFILLER_133_78 VDD VDD VSS VSS gf180mcu_fd_sc_mcu7t5v0__fill_2
Xwave_controller_y_inst__2734_ wave_controller_y_inst__2734_/A1 wave_controller_y_inst__2733_/Z
+ wave_controller_y_inst__2749_/B VDD VDD VSS VSS gf180mcu_fd_sc_mcu7t5v0__nand2_1
Xwave_controller_x_inst__3698_ wave_controller_x_inst__3698_/D wave_controller_x_inst__3716_/RN
+ clkload28/I wave_controller_x_inst__3698_/Q VDD VDD VSS VSS gf180mcu_fd_sc_mcu7t5v0__dffrnq_1
Xwave_controller_x_inst__2718_ wave_controller_x_inst__2730_/A1 wave_controller_x_inst__2730_/A3
+ wave_controller_x_inst__2719_/A2 VDD VDD VSS VSS gf180mcu_fd_sc_mcu7t5v0__nor2_1
XFILLER_26_452 VDD VDD VSS VSS gf180mcu_fd_sc_mcu7t5v0__fill_2
Xwave_controller_y_inst__2665_ wave_controller_y_inst__2681_/C wave_controller_y_inst__2710_/A3
+ wave_controller_y_inst__2681_/A2 VDD VDD VSS VSS gf180mcu_fd_sc_mcu7t5v0__nand2_1
Xwave_controller_x_inst__2649_ wave_controller_x_inst__2615_/I wave_controller_x_inst__2636_/Z
+ wave_controller_x_inst__2652_/A2 VDD VDD VSS VSS gf180mcu_fd_sc_mcu7t5v0__nor2_1
XFILLER_159_608 VDD VDD VSS VSS gf180mcu_fd_sc_mcu7t5v0__fill_2
XFILLER_26_98 VDD VDD VSS VSS gf180mcu_fd_sc_mcu7t5v0__fillcap_4
XPHY_EDGE_ROW_95_Right_95 VDD VSS gf180mcu_fd_sc_mcu7t5v0__endcap
XTAP_TAPCELL_ROW_140_2181 VDD VSS gf180mcu_fd_sc_mcu7t5v0__filltie
XTAP_TAPCELL_ROW_140_2192 VDD VSS gf180mcu_fd_sc_mcu7t5v0__filltie
Xwave_controller_y_inst__2596_ wave_controller_y_inst__2580_/Z wave_controller_y_inst__2596_/A2
+ wave_controller_y_inst__2596_/B wave_controller_y_inst__2599_/A3 VDD VDD VSS VSS
+ gf180mcu_fd_sc_mcu7t5v0__aoi21_1
XFILLER_158_107 VDD VDD VSS VSS gf180mcu_fd_sc_mcu7t5v0__fillcap_64
XFILLER_127_538 VDD VDD VSS VSS gf180mcu_fd_sc_mcu7t5v0__fill_1
XFILLER_154_313 VDD VDD VSS VSS gf180mcu_fd_sc_mcu7t5v0__fill_2
XFILLER_155_836 VDD VDD VSS VSS gf180mcu_fd_sc_mcu7t5v0__fillcap_4
Xwave_controller_y_inst__3217_ fanout502/Z wave_controller_y_inst__3215_/Z wave_controller_y_inst__3217_/Z
+ VDD VDD VSS VSS gf180mcu_fd_sc_mcu7t5v0__or2_1
XFILLER_108_752 VDD VDD VSS VSS gf180mcu_fd_sc_mcu7t5v0__fillcap_16
Xwave_controller_y_inst__3148_ wave_controller_y_inst__3149_/B1 wave_controller_y_inst__3149_/B2
+ wave_controller_y_inst__3149_/C wave_controller_y_inst__3213_/A3 VDD VDD VSS VSS
+ gf180mcu_fd_sc_mcu7t5v0__oai21_1
Xwave_controller_y_inst__3079_ wave_controller_y_inst__3079_/A1 wave_controller_y_inst__3079_/A2
+ wave_controller_y_inst__3079_/Z VDD VDD VSS VSS gf180mcu_fd_sc_mcu7t5v0__xor2_1
Xwave_controller_x_inst_wire330 wave_controller_x_inst__2032_/Z wave_controller_x_inst__2058_/C
+ VDD VDD VSS VSS gf180mcu_fd_sc_mcu7t5v0__buf_2
XFILLER_68_308 VDD VDD VSS VSS gf180mcu_fd_sc_mcu7t5v0__fillcap_4
XFILLER_96_606 VDD VDD VSS VSS gf180mcu_fd_sc_mcu7t5v0__fillcap_4
XTAP_TAPCELL_ROW_147_2302 VDD VSS gf180mcu_fd_sc_mcu7t5v0__filltie
XFILLER_49_522 VDD VDD VSS VSS gf180mcu_fd_sc_mcu7t5v0__fillcap_32
XFILLER_95_138 VDD VDD VSS VSS gf180mcu_fd_sc_mcu7t5v0__fill_2
Xspi_regs_inst_fanout341 spi_regs_inst__0940_/ZN spi_regs_inst__1266_/S VDD VDD VSS
+ VSS gf180mcu_fd_sc_mcu7t5v0__dlyb_1
XFILLER_88_190 VDD VDD VSS VSS gf180mcu_fd_sc_mcu7t5v0__fillcap_8
XFILLER_92_801 VDD VDD VSS VSS gf180mcu_fd_sc_mcu7t5v0__fillcap_4
Xspi_regs_inst__0972_ spi_regs_inst__1032_/A1 spi_regs_inst__1022_/A2 spi_regs_inst_wire277/I
+ VDD VDD VSS VSS gf180mcu_fd_sc_mcu7t5v0__nor2_1
XFILLER_114_1087 VDD VDD VSS VSS gf180mcu_fd_sc_mcu7t5v0__fillcap_64
XFILLER_36_205 VDD VDD VSS VSS gf180mcu_fd_sc_mcu7t5v0__fill_2
XTAP_TAPCELL_ROW_160_2513 VDD VSS gf180mcu_fd_sc_mcu7t5v0__filltie
XTAP_TAPCELL_ROW_160_2524 VDD VSS gf180mcu_fd_sc_mcu7t5v0__filltie
XFILLER_91_333 VDD VDD VSS VSS gf180mcu_fd_sc_mcu7t5v0__fill_2
XTAP_TAPCELL_ROW_125_1932 VDD VSS gf180mcu_fd_sc_mcu7t5v0__filltie
XTAP_TAPCELL_ROW_125_1943 VDD VSS gf180mcu_fd_sc_mcu7t5v0__filltie
XFILLER_51_208 VDD VDD VSS VSS gf180mcu_fd_sc_mcu7t5v0__fill_2
XFILLER_32_422 VDD VDD VSS VSS gf180mcu_fd_sc_mcu7t5v0__fill_2
XFILLER_44_271 VDD VDD VSS VSS gf180mcu_fd_sc_mcu7t5v0__fillcap_4
XFILLER_72_580 VDD VDD VSS VSS gf180mcu_fd_sc_mcu7t5v0__fillcap_8
XFILLER_149_118 VDD VDD VSS VSS gf180mcu_fd_sc_mcu7t5v0__fill_2
Xspi_regs_inst__1524_ spi_regs_inst__1524_/D spi_regs_inst__1601_/RN clkbuf_leaf_36_clk/Z
+ spi_regs_inst__1524_/Q VDD VDD VSS VSS gf180mcu_fd_sc_mcu7t5v0__dffrnq_1
XFILLER_32_477 VDD VDD VSS VSS gf180mcu_fd_sc_mcu7t5v0__fillcap_32
XTAP_TAPCELL_ROW_158_2486 VDD VSS gf180mcu_fd_sc_mcu7t5v0__filltie
Xspi_regs_inst__1455_ spi_regs_inst__1459_/Q fanout558/Z clkload8/I spi_regs_inst__1455_/Q
+ VDD VDD VSS VSS gf180mcu_fd_sc_mcu7t5v0__dffrnq_1
XFILLER_158_663 VDD VDD VSS VSS gf180mcu_fd_sc_mcu7t5v0__fill_2
Xspi_regs_inst__1386_ spi_regs_inst__1386_/A1 spi_regs_inst__1437_/A3 spi_regs_inst__1394_/S
+ VDD VDD VSS VSS gf180mcu_fd_sc_mcu7t5v0__nor2_2
XFILLER_66_2 VDD VDD VSS VSS gf180mcu_fd_sc_mcu7t5v0__fillcap_8
XFILLER_160_349 VDD VDD VSS VSS gf180mcu_fd_sc_mcu7t5v0__fill_2
XFILLER_99_422 VDD VDD VSS VSS gf180mcu_fd_sc_mcu7t5v0__fill_2
XFILLER_99_433 VDD VDD VSS VSS gf180mcu_fd_sc_mcu7t5v0__fillcap_16
XFILLER_102_906 VDD VDD VSS VSS gf180mcu_fd_sc_mcu7t5v0__fillcap_32
XFILLER_87_617 VDD VDD VSS VSS gf180mcu_fd_sc_mcu7t5v0__fillcap_8
XFILLER_99_477 VDD VDD VSS VSS gf180mcu_fd_sc_mcu7t5v0__fillcap_8
Xwave_controller_x_inst__1951_ fanout400/Z wave_controller_x_inst__3735_/Q wave_controller_x_inst__3736_/D
+ VDD VDD VSS VSS gf180mcu_fd_sc_mcu7t5v0__and2_1
XFILLER_86_127 VDD VDD VSS VSS gf180mcu_fd_sc_mcu7t5v0__fillcap_8
XTAP_TAPCELL_ROW_74_1098 VDD VSS gf180mcu_fd_sc_mcu7t5v0__filltie
XFILLER_67_352 VDD VDD VSS VSS gf180mcu_fd_sc_mcu7t5v0__fillcap_8
Xwave_controller_x_inst__1882_ spi_regs_inst__1284_/A1 wave_controller_x_inst__3536_/B2
+ VDD VDD VSS VSS gf180mcu_fd_sc_mcu7t5v0__clkinv_1
XFILLER_68_897 VDD VDD VSS VSS gf180mcu_fd_sc_mcu7t5v0__fill_2
XFILLER_95_694 VDD VDD VSS VSS gf180mcu_fd_sc_mcu7t5v0__fillcap_4
Xwave_controller_x_inst__3621_ wave_controller_x_inst__3621_/D wave_controller_x_inst__3736_/RN
+ clkbuf_leaf_22_clk/Z spi_regs_inst__1094_/A1 VDD VDD VSS VSS gf180mcu_fd_sc_mcu7t5v0__dffrnq_1
Xsignal_processor_y_inst__198_ signal_processor_y_inst__215_/A1 signal_processor_y_inst__194_/Z
+ signal_processor_y_inst__198_/B signal_processor_y_inst__217_/D VDD VDD VSS VSS
+ gf180mcu_fd_sc_mcu7t5v0__oai21_1
XFILLER_27_238 VDD VDD VSS VSS gf180mcu_fd_sc_mcu7t5v0__fill_1
XFILLER_55_536 VDD VDD VSS VSS gf180mcu_fd_sc_mcu7t5v0__fill_2
Xwave_controller_x_inst__3552_ wave_controller_x_inst__1806_/I wave_controller_x_inst__3555_/A2
+ wave_controller_x_inst__3554_/A2 VDD VDD VSS VSS gf180mcu_fd_sc_mcu7t5v0__nor2_1
Xwave_controller_x_inst__3483_ wave_controller_x_inst__3699_/Q wave_controller_x_inst__3483_/A2
+ wave_controller_x_inst__3485_/A2 VDD VDD VSS VSS gf180mcu_fd_sc_mcu7t5v0__nor2_1
Xwave_controller_x_inst__2503_ fanout528/Z wave_controller_x_inst__2503_/A2 wave_controller_x_inst__2511_/B
+ VDD VDD VSS VSS gf180mcu_fd_sc_mcu7t5v0__nor2_1
XFILLER_35_282 VDD VDD VSS VSS gf180mcu_fd_sc_mcu7t5v0__fill_2
XTAP_TAPCELL_ROW_53_726 VDD VSS gf180mcu_fd_sc_mcu7t5v0__filltie
XTAP_TAPCELL_ROW_53_737 VDD VSS gf180mcu_fd_sc_mcu7t5v0__filltie
XTAP_TAPCELL_ROW_53_748 VDD VSS gf180mcu_fd_sc_mcu7t5v0__filltie
Xwave_controller_y_inst__2450_ spi_regs_inst__1234_/A1 wave_controller_y_inst__2450_/A2
+ wave_controller_y_inst__2450_/A3 spi_regs_inst__1249_/A1 VDD VDD VSS VSS gf180mcu_fd_sc_mcu7t5v0__xor3_1
Xwave_controller_x_inst__2434_ wave_controller_x_inst__2418_/Z wave_controller_x_inst__2434_/A2
+ wave_controller_x_inst__2434_/B wave_controller_x_inst__2435_/A2 VDD VDD VSS VSS
+ gf180mcu_fd_sc_mcu7t5v0__oai21_1
XTAP_TAPCELL_ROW_53_759 VDD VSS gf180mcu_fd_sc_mcu7t5v0__filltie
XFILLER_50_285 VDD VDD VSS VSS gf180mcu_fd_sc_mcu7t5v0__fill_1
Xwave_controller_y_inst__2381_ spi_regs_inst__1333_/B2 wave_controller_y_inst__2824_/A1
+ wave_controller_y_inst__2381_/B1 spi_regs_inst__1318_/C2 wave_controller_y_inst__2382_/B
+ VDD VDD VSS VSS gf180mcu_fd_sc_mcu7t5v0__aoi22_1
Xwave_controller_x_inst__2365_ wave_controller_x_inst__2363_/Z wave_controller_x_inst__2367_/A3
+ wave_controller_x_inst__2366_/A2 VDD VDD VSS VSS gf180mcu_fd_sc_mcu7t5v0__xnor2_1
Xwave_controller_x_inst__2296_ wave_controller_x_inst__2311_/A1 wave_controller_x_inst__2296_/A2
+ wave_controller_x_inst__2297_/A2 VDD VDD VSS VSS gf180mcu_fd_sc_mcu7t5v0__nand2_1
XTAP_TAPCELL_ROW_98_1500 VDD VSS gf180mcu_fd_sc_mcu7t5v0__filltie
XFILLER_12_34 VDD VDD VSS VSS gf180mcu_fd_sc_mcu7t5v0__fill_1
XFILLER_12_45 VDD VDD VSS VSS gf180mcu_fd_sc_mcu7t5v0__fill_1
XFILLER_136_302 VDD VDD VSS VSS gf180mcu_fd_sc_mcu7t5v0__fill_2
XFILLER_148_184 VDD VDD VSS VSS gf180mcu_fd_sc_mcu7t5v0__fillcap_4
XFILLER_128_34 VDD VDD VSS VSS gf180mcu_fd_sc_mcu7t5v0__fill_1
Xwave_controller_y_inst__3002_ wave_controller_y_inst__3002_/I wave_controller_y_inst__3081_/A2
+ VDD VDD VSS VSS gf180mcu_fd_sc_mcu7t5v0__clkinv_1
XFILLER_136_368 VDD VDD VSS VSS gf180mcu_fd_sc_mcu7t5v0__fillcap_16
XFILLER_117_582 VDD VDD VSS VSS gf180mcu_fd_sc_mcu7t5v0__fillcap_8
XFILLER_132_563 VDD VDD VSS VSS gf180mcu_fd_sc_mcu7t5v0__fill_2
XTAP_TAPCELL_ROW_129_2010 VDD VSS gf180mcu_fd_sc_mcu7t5v0__filltie
XFILLER_59_842 VDD VDD VSS VSS gf180mcu_fd_sc_mcu7t5v0__fill_2
XFILLER_86_683 VDD VDD VSS VSS gf180mcu_fd_sc_mcu7t5v0__fill_2
XFILLER_74_845 VDD VDD VSS VSS gf180mcu_fd_sc_mcu7t5v0__fillcap_4
XTAP_TAPCELL_ROW_142_2221 VDD VSS gf180mcu_fd_sc_mcu7t5v0__filltie
XFILLER_61_506 VDD VDD VSS VSS gf180mcu_fd_sc_mcu7t5v0__fill_1
XTAP_TAPCELL_ROW_107_1640 VDD VSS gf180mcu_fd_sc_mcu7t5v0__filltie
Xwave_controller_y_inst__2717_ wave_controller_y_inst__2844_/A1 wave_controller_y_inst__3548_/B2
+ wave_controller_y_inst__2717_/B1 wave_controller_y_inst__2717_/B2 wave_controller_y_inst__2717_/C
+ wave_controller_y_inst__2730_/A3 VDD VDD VSS VSS gf180mcu_fd_sc_mcu7t5v0__aoi221_1
Xwave_controller_y_inst__3697_ wave_controller_y_inst__3697_/D wave_controller_y_inst__3699_/RN
+ clkload11/I wave_controller_y_inst__3697_/Q VDD VDD VSS VSS gf180mcu_fd_sc_mcu7t5v0__dffrnq_1
Xwave_controller_y_inst__2648_ wave_controller_y_inst__2664_/A1 wave_controller_y_inst__2664_/A2
+ wave_controller_y_inst__2663_/A1 VDD VDD VSS VSS gf180mcu_fd_sc_mcu7t5v0__nand2_1
XFILLER_159_405 VDD VDD VSS VSS gf180mcu_fd_sc_mcu7t5v0__fill_2
XTAP_TAPCELL_ROW_120_1851 VDD VSS gf180mcu_fd_sc_mcu7t5v0__filltie
XTAP_TAPCELL_ROW_120_1862 VDD VSS gf180mcu_fd_sc_mcu7t5v0__filltie
Xwave_controller_y_inst__2579_ wave_controller_y_inst__2616_/C max_cap432/Z wave_controller_y_inst__2596_/B
+ VDD VDD VSS VSS gf180mcu_fd_sc_mcu7t5v0__nor2_1
XFILLER_139_162 VDD VDD VSS VSS gf180mcu_fd_sc_mcu7t5v0__fill_2
XFILLER_139_173 VDD VDD VSS VSS gf180mcu_fd_sc_mcu7t5v0__fill_2
Xspi_regs_inst__1240_ spi_regs_inst__1595_/Q spi_regs_inst__1240_/A2 spi_regs_inst__1322_/A2
+ spi_regs_inst_wire104/Z spi_regs_inst__1242_/A3 VDD VDD VSS VSS gf180mcu_fd_sc_mcu7t5v0__aoi22_1
XTAP_TAPCELL_ROW_3_1_355 VDD VSS gf180mcu_fd_sc_mcu7t5v0__filltie
Xspi_regs_inst__1171_ spi_regs_inst__1171_/A1 spi_regs_inst__1171_/A2 spi_regs_inst__1171_/A3
+ spi_regs_inst__1171_/A4 spi_regs_inst__1172_/A4 VDD VDD VSS VSS gf180mcu_fd_sc_mcu7t5v0__nor4_1
XFILLER_143_828 VDD VDD VSS VSS gf180mcu_fd_sc_mcu7t5v0__fillcap_4
XFILLER_155_688 VDD VDD VSS VSS gf180mcu_fd_sc_mcu7t5v0__fillcap_4
XFILLER_5_142 VDD VDD VSS VSS gf180mcu_fd_sc_mcu7t5v0__fillcap_64
XTAP_TAPCELL_ROW_153_2394 VDD VSS gf180mcu_fd_sc_mcu7t5v0__filltie
XFILLER_68_1151 VDD VDD VSS VSS gf180mcu_fd_sc_mcu7t5v0__fillcap_4
XFILLER_68_1173 VDD VDD VSS VSS gf180mcu_fd_sc_mcu7t5v0__fill_1
XFILLER_155_1154 VDD VDD VSS VSS gf180mcu_fd_sc_mcu7t5v0__fillcap_16
XFILLER_96_403 VDD VDD VSS VSS gf180mcu_fd_sc_mcu7t5v0__fill_1
XFILLER_97_926 VDD VDD VSS VSS gf180mcu_fd_sc_mcu7t5v0__fillcap_32
XFILLER_110_224 VDD VDD VSS VSS gf180mcu_fd_sc_mcu7t5v0__fill_1
Xsignal_processor_y_inst__121_ signal_processor_y_inst__179_/A1 signal_processor_y_inst__249_/Q
+ signal_processor_y_inst__250_/D VDD VDD VSS VSS gf180mcu_fd_sc_mcu7t5v0__and2_1
XFILLER_68_138 VDD VDD VSS VSS gf180mcu_fd_sc_mcu7t5v0__fill_2
Xwave_controller_x_inst_wire182 wave_controller_x_inst_wire182/I wave_controller_x_inst_wire182/Z
+ VDD VDD VSS VSS gf180mcu_fd_sc_mcu7t5v0__clkbuf_1
XFILLER_49_352 VDD VDD VSS VSS gf180mcu_fd_sc_mcu7t5v0__fillcap_32
XFILLER_77_683 VDD VDD VSS VSS gf180mcu_fd_sc_mcu7t5v0__fillcap_4
XFILLER_92_653 VDD VDD VSS VSS gf180mcu_fd_sc_mcu7t5v0__fill_2
Xspi_regs_inst__0955_ spi_regs_inst__1629_/Q spi_regs_inst__1364_/A1 spi_regs_inst__1368_/A1
+ spi_regs_inst__1631_/Q spi_regs_inst__1023_/A2 VDD VDD VSS VSS gf180mcu_fd_sc_mcu7t5v0__nand4_1
XFILLER_52_517 VDD VDD VSS VSS gf180mcu_fd_sc_mcu7t5v0__fill_2
XFILLER_80_804 VDD VDD VSS VSS gf180mcu_fd_sc_mcu7t5v0__fill_1
Xspi_regs_inst__0886_ spi_regs_inst__1620_/Q spi_regs_inst__1447_/I1 spi_regs_inst__0886_/S
+ spi_regs_inst__1620_/D VDD VDD VSS VSS gf180mcu_fd_sc_mcu7t5v0__mux2_2
XFILLER_75_1122 VDD VDD VSS VSS gf180mcu_fd_sc_mcu7t5v0__fillcap_32
XFILLER_32_241 VDD VDD VSS VSS gf180mcu_fd_sc_mcu7t5v0__fillcap_4
XFILLER_20_403 VDD VDD VSS VSS gf180mcu_fd_sc_mcu7t5v0__fillcap_32
XFILLER_60_572 VDD VDD VSS VSS gf180mcu_fd_sc_mcu7t5v0__fill_2
Xspi_regs_inst__1507_ spi_regs_inst__1507_/D spi_regs_inst__1551_/RN clkload30/I spi_regs_inst__1507_/Q
+ VDD VDD VSS VSS gf180mcu_fd_sc_mcu7t5v0__dffrnq_1
XFILLER_165_419 VDD VDD VSS VSS gf180mcu_fd_sc_mcu7t5v0__fill_1
Xwave_controller_x_inst__2150_ wave_controller_x_inst__2148_/Z wave_controller_x_inst__2151_/A2
+ wave_controller_x_inst__2152_/B VDD VDD VSS VSS gf180mcu_fd_sc_mcu7t5v0__and2_1
Xspi_regs_inst__1438_ spi_regs_inst__1507_/Q spi_regs_inst__1438_/I1 spi_regs_inst__1441_/S
+ spi_regs_inst__1507_/D VDD VDD VSS VSS gf180mcu_fd_sc_mcu7t5v0__mux2_2
Xwave_controller_x_inst__2081_ wave_controller_x_inst__2098_/C wave_controller_x_inst__2081_/A2
+ wave_controller_x_inst__2081_/A3 wave_controller_x_inst__2081_/B wave_controller_x_inst__2083_/B
+ VDD VDD VSS VSS gf180mcu_fd_sc_mcu7t5v0__oai31_1
Xspi_regs_inst__1369_ spi_regs_inst__1653_/Q spi_regs_inst__1379_/S spi_regs_inst__1370_/B
+ VDD VDD VSS VSS gf180mcu_fd_sc_mcu7t5v0__nand2_1
XFILLER_106_519 VDD VDD VSS VSS gf180mcu_fd_sc_mcu7t5v0__fillcap_4
XFILLER_118_379 VDD VDD VSS VSS gf180mcu_fd_sc_mcu7t5v0__fillcap_4
XFILLER_146_677 VDD VDD VSS VSS gf180mcu_fd_sc_mcu7t5v0__fillcap_16
XTAP_TAPCELL_ROW_76_1127 VDD VSS gf180mcu_fd_sc_mcu7t5v0__filltie
XTAP_TAPCELL_ROW_76_1138 VDD VSS gf180mcu_fd_sc_mcu7t5v0__filltie
XPHY_EDGE_ROW_151_Right_151 VDD VSS gf180mcu_fd_sc_mcu7t5v0__endcap
XFILLER_141_360 VDD VDD VSS VSS gf180mcu_fd_sc_mcu7t5v0__fillcap_16
XFILLER_99_296 VDD VDD VSS VSS gf180mcu_fd_sc_mcu7t5v0__fill_1
Xwave_controller_y_inst__1950_ fanout392/Z wave_controller_y_inst__3736_/Q wave_controller_y_inst__3737_/D
+ VDD VDD VSS VSS gf180mcu_fd_sc_mcu7t5v0__and2_1
Xwave_controller_x_inst__2983_ wave_controller_x_inst__3711_/Q fanout539/Z wave_controller_x_inst__2983_/B
+ wave_controller_x_inst__3071_/A3 VDD VDD VSS VSS gf180mcu_fd_sc_mcu7t5v0__aoi21_1
XFILLER_141_393 VDD VDD VSS VSS gf180mcu_fd_sc_mcu7t5v0__fillcap_16
Xwave_controller_x_inst__1934_ wave_controller_x_inst__1937_/B1 wave_controller_x_inst__1785_/I
+ wave_controller_x_inst__3713_/Q wave_controller_x_inst__1934_/B2 wave_controller_x_inst__1939_/A1
+ VDD VDD VSS VSS gf180mcu_fd_sc_mcu7t5v0__aoi22_1
XFILLER_101_279 VDD VDD VSS VSS gf180mcu_fd_sc_mcu7t5v0__fill_1
XTAP_TAPCELL_ROW_58_829 VDD VSS gf180mcu_fd_sc_mcu7t5v0__filltie
Xwave_controller_y_inst__1881_ spi_regs_inst__1256_/A1 wave_controller_y_inst__3533_/B2
+ VDD VDD VSS VSS gf180mcu_fd_sc_mcu7t5v0__clkinv_1
Xwave_controller_x_inst__1865_ spi_regs_inst__1336_/A1 wave_controller_x_inst__2824_/A1
+ VDD VDD VSS VSS gf180mcu_fd_sc_mcu7t5v0__clkinv_1
XTAP_TAPCELL_ROW_27_1_534 VDD VSS gf180mcu_fd_sc_mcu7t5v0__filltie
Xwave_controller_y_inst__3620_ wave_controller_y_inst__3620_/D wave_controller_y_inst__3739_/RN
+ clkload16/I spi_regs_inst__1054_/B2 VDD VDD VSS VSS gf180mcu_fd_sc_mcu7t5v0__dffrnq_1
Xwave_controller_x_inst__3604_ wave_controller_x_inst__3610_/A1 wave_controller_x_inst__3604_/A2
+ wave_controller_x_inst__3604_/B wave_controller_x_inst__3678_/D VDD VDD VSS VSS
+ gf180mcu_fd_sc_mcu7t5v0__oai21_1
XFILLER_55_344 VDD VDD VSS VSS gf180mcu_fd_sc_mcu7t5v0__fillcap_4
XFILLER_55_366 VDD VDD VSS VSS gf180mcu_fd_sc_mcu7t5v0__fillcap_16
Xwave_controller_y_inst__3551_ wave_controller_y_inst__3554_/A1 wave_controller_y_inst__3551_/A2
+ wave_controller_y_inst__3551_/A3 wave_controller_y_inst__3554_/B1 wave_controller_y_inst__3551_/B2
+ wave_controller_y_inst__3646_/D VDD VDD VSS VSS gf180mcu_fd_sc_mcu7t5v0__oai32_1
Xwave_controller_x_inst__1796_ wave_controller_x_inst__3704_/Q wave_controller_x_inst__3564_/A1
+ VDD VDD VSS VSS gf180mcu_fd_sc_mcu7t5v0__clkinv_1
XFILLER_70_325 VDD VDD VSS VSS gf180mcu_fd_sc_mcu7t5v0__fillcap_4
XFILLER_82_185 VDD VDD VSS VSS gf180mcu_fd_sc_mcu7t5v0__fill_1
XFILLER_83_697 VDD VDD VSS VSS gf180mcu_fd_sc_mcu7t5v0__fill_2
XTAP_TAPCELL_ROW_35_1_591 VDD VSS gf180mcu_fd_sc_mcu7t5v0__filltie
Xwave_controller_y_inst__2502_ wave_controller_y_inst__2518_/A3 wave_controller_y_inst__2504_/A3
+ wave_controller_y_inst__2503_/A2 VDD VDD VSS VSS gf180mcu_fd_sc_mcu7t5v0__xnor2_1
Xwave_controller_x_inst__3535_ spi_regs_inst__1284_/A1 wave_controller_x_inst__3556_/A2
+ wave_controller_x_inst__3536_/A3 VDD VDD VSS VSS gf180mcu_fd_sc_mcu7t5v0__nor2_1
Xwave_controller_y_inst__3482_ wave_controller_y_inst__3482_/A1 wave_controller_y_inst__3524_/B1
+ wave_controller_y_inst__3482_/B1 wave_controller_y_inst__3482_/B2 wave_controller_y_inst__3626_/D
+ VDD VDD VSS VSS gf180mcu_fd_sc_mcu7t5v0__oai22_1
Xwave_controller_x_inst__3466_ spi_regs_inst__1274_/A1 wave_controller_x_inst__3487_/A2
+ wave_controller_x_inst__3467_/B VDD VDD VSS VSS gf180mcu_fd_sc_mcu7t5v0__nand2_1
Xsignal_processor_x_inst__210_ spi_regs_inst__1189_/B2 signal_processor_x_inst__210_/A2
+ signal_processor_x_inst__211_/B VDD VDD VSS VSS gf180mcu_fd_sc_mcu7t5v0__nand2_1
Xwave_controller_y_inst__2433_ wave_controller_y_inst__2409_/I wave_controller_y_inst__2433_/A2
+ wave_controller_y_inst__2436_/A2 VDD VDD VSS VSS gf180mcu_fd_sc_mcu7t5v0__nor2_1
Xwave_controller_x_inst__3397_ wave_controller_x_inst__3397_/A1 wave_controller_x_inst__3326_/Z
+ wave_controller_x_inst__3401_/B VDD VDD VSS VSS gf180mcu_fd_sc_mcu7t5v0__xor2_1
Xwave_controller_x_inst__2417_ max_cap451/Z wave_controller_x_inst__2416_/Z wave_controller_x_inst__2417_/Z
+ VDD VDD VSS VSS gf180mcu_fd_sc_mcu7t5v0__and2_1
Xsignal_processor_x_inst__141_ signal_processor_x_inst__237_/Q signal_processor_x_inst__141_/A2
+ signal_processor_x_inst__177_/A1 VDD VDD VSS VSS gf180mcu_fd_sc_mcu7t5v0__xnor2_1
Xwave_controller_y_inst__2364_ wave_controller_y_inst_wire120/Z wave_controller_y_inst__2352_/Z
+ wave_controller_y_inst__2364_/B wave_controller_y_inst__2367_/A3 VDD VDD VSS VSS
+ gf180mcu_fd_sc_mcu7t5v0__oai21_1
Xwave_controller_x_inst__2348_ wave_controller_x_inst__2322_/Z wave_controller_x_inst__2332_/Z
+ wave_controller_x_inst__2348_/Z VDD VDD VSS VSS gf180mcu_fd_sc_mcu7t5v0__and2_1
XFILLER_109_302 VDD VDD VSS VSS gf180mcu_fd_sc_mcu7t5v0__fillcap_16
XFILLER_23_66 VDD VDD VSS VSS gf180mcu_fd_sc_mcu7t5v0__fillcap_4
Xwave_controller_y_inst__2295_ wave_controller_y_inst__2313_/C wave_controller_y_inst__2294_/Z
+ wave_controller_y_inst__2309_/A2 VDD VDD VSS VSS gf180mcu_fd_sc_mcu7t5v0__nor2_1
Xwave_controller_x_inst__2279_ wave_controller_x_inst__2277_/Z wave_controller_x_inst__2280_/A2
+ wave_controller_x_inst__2311_/A1 VDD VDD VSS VSS gf180mcu_fd_sc_mcu7t5v0__nand2_1
XFILLER_139_1116 VDD VDD VSS VSS gf180mcu_fd_sc_mcu7t5v0__fillcap_4
XFILLER_152_647 VDD VDD VSS VSS gf180mcu_fd_sc_mcu7t5v0__fill_2
XFILLER_2_101 VDD VDD VSS VSS gf180mcu_fd_sc_mcu7t5v0__fillcap_4
Xwave_controller_y_inst_fanout510 fanout511/Z wave_controller_y_inst__3400_/A1 VDD
+ VDD VSS VSS gf180mcu_fd_sc_mcu7t5v0__dlyb_1
XFILLER_117_390 VDD VDD VSS VSS gf180mcu_fd_sc_mcu7t5v0__fill_1
XFILLER_133_850 VDD VDD VSS VSS gf180mcu_fd_sc_mcu7t5v0__fill_1
XFILLER_155_98 VDD VDD VSS VSS gf180mcu_fd_sc_mcu7t5v0__fill_2
XFILLER_120_555 VDD VDD VSS VSS gf180mcu_fd_sc_mcu7t5v0__fillcap_8
XFILLER_59_650 VDD VDD VSS VSS gf180mcu_fd_sc_mcu7t5v0__fill_1
XFILLER_94_918 VDD VDD VSS VSS gf180mcu_fd_sc_mcu7t5v0__fillcap_16
XFILLER_46_300 VDD VDD VSS VSS gf180mcu_fd_sc_mcu7t5v0__fillcap_8
XFILLER_0_26 VDD VDD VSS VSS gf180mcu_fd_sc_mcu7t5v0__fillcap_8
XFILLER_101_780 VDD VDD VSS VSS gf180mcu_fd_sc_mcu7t5v0__fill_2
XFILLER_46_333 VDD VDD VSS VSS gf180mcu_fd_sc_mcu7t5v0__fillcap_4
XFILLER_111_1046 VDD VDD VSS VSS gf180mcu_fd_sc_mcu7t5v0__fillcap_4
XFILLER_46_366 VDD VDD VSS VSS gf180mcu_fd_sc_mcu7t5v0__fillcap_16
XFILLER_74_664 VDD VDD VSS VSS gf180mcu_fd_sc_mcu7t5v0__fill_1
Xspi_regs_inst__0740_ spi_regs_inst__1634_/Q spi_regs_inst__1376_/A1 VDD VDD VSS VSS
+ gf180mcu_fd_sc_mcu7t5v0__clkinv_1
XFILLER_104_91 VDD VDD VSS VSS gf180mcu_fd_sc_mcu7t5v0__fillcap_8
XPHY_EDGE_ROW_100_Left_267 VDD VSS gf180mcu_fd_sc_mcu7t5v0__endcap
XFILLER_61_347 VDD VDD VSS VSS gf180mcu_fd_sc_mcu7t5v0__fill_2
XFILLER_14_263 VDD VDD VSS VSS gf180mcu_fd_sc_mcu7t5v0__fillcap_8
Xspi_regs_inst_max_cap386 spi_regs_inst__1385_/A2 spi_regs_inst__0818_/A1 VDD VDD
+ VSS VSS gf180mcu_fd_sc_mcu7t5v0__clkbuf_1
XFILLER_147_408 VDD VDD VSS VSS gf180mcu_fd_sc_mcu7t5v0__fillcap_8
XTAP_TAPCELL_ROW_155_2434 VDD VSS gf180mcu_fd_sc_mcu7t5v0__filltie
XFILLER_155_441 VDD VDD VSS VSS gf180mcu_fd_sc_mcu7t5v0__fill_1
Xspi_regs_inst__1223_ spi_regs_inst__1266_/S spi_regs_inst__1221_/Z spi_regs_inst__1223_/A3
+ spi_regs_inst__1223_/B spi_regs_inst__1645_/D VDD VDD VSS VSS gf180mcu_fd_sc_mcu7t5v0__oai31_1
XFILLER_128_699 VDD VDD VSS VSS gf180mcu_fd_sc_mcu7t5v0__fillcap_8
XFILLER_6_451 VDD VDD VSS VSS gf180mcu_fd_sc_mcu7t5v0__fillcap_4
XTAP_TAPCELL_ROW_44_1_659 VDD VSS gf180mcu_fd_sc_mcu7t5v0__filltie
XFILLER_115_349 VDD VDD VSS VSS gf180mcu_fd_sc_mcu7t5v0__fill_1
XFILLER_155_485 VDD VDD VSS VSS gf180mcu_fd_sc_mcu7t5v0__fillcap_4
Xspi_regs_inst__1154_ spi_regs_inst_wire107/Z spi_regs_inst_wire233/Z spi_regs_inst__1178_/A2
+ spi_regs_inst__1154_/B2 spi_regs_inst__1157_/A2 VDD VDD VSS VSS gf180mcu_fd_sc_mcu7t5v0__aoi22_1
XFILLER_142_157 VDD VDD VSS VSS gf180mcu_fd_sc_mcu7t5v0__fillcap_8
XFILLER_143_669 VDD VDD VSS VSS gf180mcu_fd_sc_mcu7t5v0__fill_1
Xspi_regs_inst__1085_ spi_regs_inst__1085_/A1 spi_regs_inst__1180_/B1 spi_regs_inst__1195_/A2
+ spi_regs_inst__1495_/Q spi_regs_inst__1085_/C1 spi_regs_inst__1085_/C2 spi_regs_inst__1088_/A2
+ VDD VDD VSS VSS gf180mcu_fd_sc_mcu7t5v0__aoi222_1
XFILLER_69_469 VDD VDD VSS VSS gf180mcu_fd_sc_mcu7t5v0__fillcap_8
XFILLER_85_907 VDD VDD VSS VSS gf180mcu_fd_sc_mcu7t5v0__fill_2
XTAP_TAPCELL_ROW_71_1046 VDD VSS gf180mcu_fd_sc_mcu7t5v0__filltie
XFILLER_81_1170 VDD VDD VSS VSS gf180mcu_fd_sc_mcu7t5v0__fillcap_4
Xspi_regs_inst__0938_ spi_regs_inst__1640_/Q spi_regs_inst__1639_/Q spi_regs_inst__0939_/S
+ spi_regs_inst__1640_/D VDD VDD VSS VSS gf180mcu_fd_sc_mcu7t5v0__mux2_2
XFILLER_52_314 VDD VDD VSS VSS gf180mcu_fd_sc_mcu7t5v0__fill_1
XFILLER_53_826 VDD VDD VSS VSS gf180mcu_fd_sc_mcu7t5v0__fill_1
XFILLER_53_848 VDD VDD VSS VSS gf180mcu_fd_sc_mcu7t5v0__fill_2
XFILLER_64_185 VDD VDD VSS VSS gf180mcu_fd_sc_mcu7t5v0__fillcap_4
XFILLER_40_509 VDD VDD VSS VSS gf180mcu_fd_sc_mcu7t5v0__fill_1
XFILLER_80_667 VDD VDD VSS VSS gf180mcu_fd_sc_mcu7t5v0__fillcap_4
Xwave_controller_x_inst__3320_ wave_controller_x_inst__3320_/A1 spi_regs_inst__1555_/Q
+ wave_controller_x_inst__3320_/B wave_controller_x_inst__3332_/B2 VDD VDD VSS VSS
+ gf180mcu_fd_sc_mcu7t5v0__aoi21_1
Xspi_regs_inst__0869_ spi_regs_inst__1605_/Q spi_regs_inst__1444_/I1 spi_regs_inst__0870_/S
+ spi_regs_inst__1605_/D VDD VDD VSS VSS gf180mcu_fd_sc_mcu7t5v0__mux2_2
Xwave_controller_x_inst__3251_ wave_controller_x_inst__3251_/A1 wave_controller_x_inst__3250_/Z
+ wave_controller_x_inst__3254_/B VDD VDD VSS VSS gf180mcu_fd_sc_mcu7t5v0__nand2_1
XFILLER_139_909 VDD VDD VSS VSS gf180mcu_fd_sc_mcu7t5v0__fill_1
XFILLER_20_200 VDD VDD VSS VSS gf180mcu_fd_sc_mcu7t5v0__fillcap_8
XFILLER_20_222 VDD VDD VSS VSS gf180mcu_fd_sc_mcu7t5v0__fill_1
Xwave_controller_x_inst__2202_ wave_controller_x_inst__2202_/A1 wave_controller_x_inst__2202_/A2
+ wave_controller_x_inst__2201_/B spi_regs_inst__1213_/A1 VDD VDD VSS VSS gf180mcu_fd_sc_mcu7t5v0__xor3_1
XFILLER_20_255 VDD VDD VSS VSS gf180mcu_fd_sc_mcu7t5v0__fill_2
Xwave_controller_x_inst__3182_ wave_controller_x_inst__3004_/B spi_regs_inst__1516_/Q
+ wave_controller_x_inst__3182_/B wave_controller_x_inst__3194_/A2 VDD VDD VSS VSS
+ gf180mcu_fd_sc_mcu7t5v0__aoi21_1
Xwave_controller_x_inst__2133_ wave_controller_x_inst__3730_/Q wave_controller_x_inst__2134_/A2
+ wave_controller_x_inst__2136_/B VDD VDD VSS VSS gf180mcu_fd_sc_mcu7t5v0__and2_1
XFILLER_107_839 VDD VDD VSS VSS gf180mcu_fd_sc_mcu7t5v0__fill_1
XFILLER_109_36 VDD VDD VSS VSS gf180mcu_fd_sc_mcu7t5v0__fill_1
XFILLER_146_463 VDD VDD VSS VSS gf180mcu_fd_sc_mcu7t5v0__fill_1
Xwave_controller_y_inst__2080_ wave_controller_y_inst__2092_/A2 wave_controller_y_inst__2108_/B
+ wave_controller_y_inst__2080_/B wave_controller_y_inst__2081_/A3 VDD VDD VSS VSS
+ gf180mcu_fd_sc_mcu7t5v0__aoi21_1
Xwave_controller_x_inst__2064_ wave_controller_x_inst__3098_/B wave_controller_x_inst__3612_/Q
+ fanout498/Z wave_controller_x_inst__2132_/A1 VDD VDD VSS VSS gf180mcu_fd_sc_mcu7t5v0__oai21_1
XFILLER_109_69 VDD VDD VSS VSS gf180mcu_fd_sc_mcu7t5v0__fill_1
XFILLER_134_625 VDD VDD VSS VSS gf180mcu_fd_sc_mcu7t5v0__fillcap_8
XFILLER_161_422 VDD VDD VSS VSS gf180mcu_fd_sc_mcu7t5v0__fillcap_8
XFILLER_69_18 VDD VDD VSS VSS gf180mcu_fd_sc_mcu7t5v0__fillcap_8
XFILLER_115_872 VDD VDD VSS VSS gf180mcu_fd_sc_mcu7t5v0__fill_2
XFILLER_161_488 VDD VDD VSS VSS gf180mcu_fd_sc_mcu7t5v0__fill_2
XFILLER_86_1081 VDD VDD VSS VSS gf180mcu_fd_sc_mcu7t5v0__fillcap_4
XFILLER_88_734 VDD VDD VSS VSS gf180mcu_fd_sc_mcu7t5v0__fill_1
XFILLER_88_745 VDD VDD VSS VSS gf180mcu_fd_sc_mcu7t5v0__fillcap_16
Xwave_controller_y_inst__2982_ wave_controller_y_inst__2945_/Z wave_controller_y_inst__2985_/A2
+ wave_controller_y_inst__2985_/A3 wave_controller_y_inst__2983_/B VDD VDD VSS VSS
+ gf180mcu_fd_sc_mcu7t5v0__nor3_1
Xwave_controller_x_inst_fanout439 wave_controller_x_inst__3722_/Q wave_controller_x_inst__2831_/A2
+ VDD VDD VSS VSS gf180mcu_fd_sc_mcu7t5v0__dlyb_1
Xwave_controller_x_inst__2966_ wave_controller_x_inst__2960_/I wave_controller_x_inst__2961_/Z
+ wave_controller_x_inst__3045_/B wave_controller_x_inst__2966_/Z VDD VDD VSS VSS
+ gf180mcu_fd_sc_mcu7t5v0__and3_1
Xwave_controller_y_inst__1933_ spi_regs_inst__1577_/Q wave_controller_y_inst__3080_/A1
+ wave_controller_y_inst__3266_/A1 spi_regs_inst__1574_/Q spi_regs_inst__1573_/Q wave_controller_y_inst__3312_/A1
+ wave_controller_y_inst__1938_/A1 VDD VDD VSS VSS gf180mcu_fd_sc_mcu7t5v0__aoi222_1
Xwave_controller_x_inst__1917_ spi_regs_inst__1500_/Q wave_controller_x_inst__3279_/A1
+ spi_regs_inst__1499_/Q wave_controller_x_inst__2797_/C wave_controller_x_inst__1919_/A1
+ VDD VDD VSS VSS gf180mcu_fd_sc_mcu7t5v0__aoi22_1
XFILLER_102_599 VDD VDD VSS VSS gf180mcu_fd_sc_mcu7t5v0__fill_1
XFILLER_56_642 VDD VDD VSS VSS gf180mcu_fd_sc_mcu7t5v0__fill_1
Xwave_controller_y_inst__1864_ spi_regs_inst__1321_/A1 wave_controller_y_inst__2822_/A1
+ VDD VDD VSS VSS gf180mcu_fd_sc_mcu7t5v0__clkinv_1
Xwave_controller_x_inst__2897_ wave_controller_x_inst__2117_/B wave_controller_x_inst__2897_/A2
+ wave_controller_x_inst__2897_/A3 wave_controller_x_inst__2897_/Z VDD VDD VSS VSS
+ gf180mcu_fd_sc_mcu7t5v0__xor3_1
XFILLER_56_675 VDD VDD VSS VSS gf180mcu_fd_sc_mcu7t5v0__fill_2
XTAP_TAPCELL_ROW_2_1_343 VDD VSS gf180mcu_fd_sc_mcu7t5v0__filltie
Xwave_controller_y_inst__3603_ spi_regs_inst__1033_/C2 wave_controller_y_inst__3597_/S
+ wave_controller_y_inst__3604_/B VDD VDD VSS VSS gf180mcu_fd_sc_mcu7t5v0__nand2_1
Xwave_controller_x_inst__1848_ spi_regs_inst__1148_/B2 wave_controller_x_inst__2425_/B2
+ VDD VDD VSS VSS gf180mcu_fd_sc_mcu7t5v0__clkinv_1
XFILLER_16_517 VDD VDD VSS VSS gf180mcu_fd_sc_mcu7t5v0__fill_1
Xwave_controller_y_inst__1795_ wave_controller_y_inst__3705_/Q wave_controller_y_inst__3290_/A1
+ VDD VDD VSS VSS gf180mcu_fd_sc_mcu7t5v0__clkinv_1
Xwave_controller_x_inst__1779_ spi_regs_inst__1494_/Q wave_controller_x_inst__1942_/A2
+ VDD VDD VSS VSS gf180mcu_fd_sc_mcu7t5v0__clkinv_1
Xwave_controller_y_inst__3534_ wave_controller_y_inst__1785_/I wave_controller_y_inst__3555_/A2
+ wave_controller_y_inst__3536_/A2 VDD VDD VSS VSS gf180mcu_fd_sc_mcu7t5v0__nor2_1
Xwave_controller_x_inst__3518_ wave_controller_x_inst__3530_/A1 wave_controller_x_inst__3518_/A2
+ wave_controller_x_inst__3518_/A3 wave_controller_x_inst__3518_/B1 wave_controller_x_inst__3518_/B2
+ wave_controller_x_inst__3635_/D VDD VDD VSS VSS gf180mcu_fd_sc_mcu7t5v0__oai32_1
XFILLER_24_550 VDD VDD VSS VSS gf180mcu_fd_sc_mcu7t5v0__fillcap_4
XFILLER_34_32 VDD VDD VSS VSS gf180mcu_fd_sc_mcu7t5v0__fill_2
XFILLER_93_1052 VDD VDD VSS VSS gf180mcu_fd_sc_mcu7t5v0__fillcap_64
Xwave_controller_y_inst__3465_ wave_controller_y_inst__3454_/B wave_controller_y_inst__3465_/A2
+ wave_controller_y_inst__3465_/A3 wave_controller_y_inst__3465_/B wave_controller_y_inst__3470_/C
+ VDD VDD VSS VSS gf180mcu_fd_sc_mcu7t5v0__oai31_1
XFILLER_11_200 VDD VDD VSS VSS gf180mcu_fd_sc_mcu7t5v0__fill_2
XFILLER_51_380 VDD VDD VSS VSS gf180mcu_fd_sc_mcu7t5v0__fill_2
XTAP_TAPCELL_ROW_100_1529 VDD VSS gf180mcu_fd_sc_mcu7t5v0__filltie
Xwave_controller_y_inst__2416_ fanout511/Z wave_controller_y_inst__2411_/Z wave_controller_y_inst__2416_/A3
+ wave_controller_y_inst__2416_/Z VDD VDD VSS VSS gf180mcu_fd_sc_mcu7t5v0__xor3_1
Xwave_controller_x_inst__3449_ wave_controller_x_inst__3449_/A1 wave_controller_x_inst__3454_/A2
+ wave_controller_x_inst__3454_/B wave_controller_x_inst__3449_/C wave_controller_x_inst__3450_/B
+ VDD VDD VSS VSS gf180mcu_fd_sc_mcu7t5v0__aoi211_1
XFILLER_129_419 VDD VDD VSS VSS gf180mcu_fd_sc_mcu7t5v0__fill_1
XTAP_TAPCELL_ROW_137_2131 VDD VSS gf180mcu_fd_sc_mcu7t5v0__filltie
XTAP_TAPCELL_ROW_137_2142 VDD VSS gf180mcu_fd_sc_mcu7t5v0__filltie
Xwave_controller_y_inst__3396_ wave_controller_y_inst__3396_/A1 wave_controller_y_inst__3357_/Z
+ wave_controller_y_inst__3396_/A3 wave_controller_y_inst__3396_/B wave_controller_y_inst__3401_/A2
+ VDD VDD VSS VSS gf180mcu_fd_sc_mcu7t5v0__oai31_1
Xsignal_processor_x_inst__124_ signal_processor_x_inst__128_/A1 wave_controller_x_inst__1952_/A2
+ signal_processor_x_inst__245_/D VDD VDD VSS VSS gf180mcu_fd_sc_mcu7t5v0__and2_1
Xwave_controller_y_inst__2347_ wave_controller_y_inst__2373_/A1 wave_controller_y_inst__2397_/A1
+ spi_regs_inst__1229_/A1 VDD VDD VSS VSS gf180mcu_fd_sc_mcu7t5v0__xor2_1
XFILLER_152_400 VDD VDD VSS VSS gf180mcu_fd_sc_mcu7t5v0__fillcap_8
XFILLER_153_912 VDD VDD VSS VSS gf180mcu_fd_sc_mcu7t5v0__fillcap_64
XFILLER_165_772 VDD VDD VSS VSS gf180mcu_fd_sc_mcu7t5v0__fillcap_64
Xwave_controller_y_inst__2278_ wave_controller_y_inst__1825_/I wave_controller_y_inst__2261_/Z
+ wave_controller_y_inst__2278_/B wave_controller_y_inst__2280_/A2 VDD VDD VSS VSS
+ gf180mcu_fd_sc_mcu7t5v0__oai21_1
XFILLER_124_124 VDD VDD VSS VSS gf180mcu_fd_sc_mcu7t5v0__fillcap_8
XFILLER_164_293 VDD VDD VSS VSS gf180mcu_fd_sc_mcu7t5v0__fillcap_4
XFILLER_50_86 VDD VDD VSS VSS gf180mcu_fd_sc_mcu7t5v0__fillcap_8
XTAP_TAPCELL_ROW_150_2353 VDD VSS gf180mcu_fd_sc_mcu7t5v0__filltie
XTAP_TAPCELL_ROW_115_1772 VDD VSS gf180mcu_fd_sc_mcu7t5v0__filltie
XTAP_TAPCELL_ROW_40_1_632 VDD VSS gf180mcu_fd_sc_mcu7t5v0__filltie
XFILLER_106_872 VDD VDD VSS VSS gf180mcu_fd_sc_mcu7t5v0__fill_2
XFILLER_3_487 VDD VDD VSS VSS gf180mcu_fd_sc_mcu7t5v0__fill_2
XFILLER_65_1154 VDD VDD VSS VSS gf180mcu_fd_sc_mcu7t5v0__fillcap_16
XFILLER_79_712 VDD VDD VSS VSS gf180mcu_fd_sc_mcu7t5v0__fill_1
Xwave_controller_y_inst_fanout362 wave_controller_y_inst__1911_/ZN wave_controller_y_inst__3465_/B
+ VDD VDD VSS VSS gf180mcu_fd_sc_mcu7t5v0__dlyb_1
Xwave_controller_y_inst_fanout351 wave_controller_y_inst_wire352/Z wave_controller_y_inst__3454_/A2
+ VDD VDD VSS VSS gf180mcu_fd_sc_mcu7t5v0__dlyb_1
XFILLER_121_842 VDD VDD VSS VSS gf180mcu_fd_sc_mcu7t5v0__fillcap_4
XFILLER_120_374 VDD VDD VSS VSS gf180mcu_fd_sc_mcu7t5v0__fill_2
XFILLER_152_1157 VDD VDD VSS VSS gf180mcu_fd_sc_mcu7t5v0__fillcap_8
XFILLER_94_704 VDD VDD VSS VSS gf180mcu_fd_sc_mcu7t5v0__fillcap_8
XFILLER_94_737 VDD VDD VSS VSS gf180mcu_fd_sc_mcu7t5v0__fillcap_32
XFILLER_93_214 VDD VDD VSS VSS gf180mcu_fd_sc_mcu7t5v0__fill_1
XFILLER_74_450 VDD VDD VSS VSS gf180mcu_fd_sc_mcu7t5v0__fillcap_4
XFILLER_75_72 VDD VDD VSS VSS gf180mcu_fd_sc_mcu7t5v0__fill_2
XFILLER_34_314 VDD VDD VSS VSS gf180mcu_fd_sc_mcu7t5v0__fill_1
XFILLER_62_601 VDD VDD VSS VSS gf180mcu_fd_sc_mcu7t5v0__fill_2
XFILLER_62_667 VDD VDD VSS VSS gf180mcu_fd_sc_mcu7t5v0__fillcap_32
XTAP_TAPCELL_ROW_60_868 VDD VSS gf180mcu_fd_sc_mcu7t5v0__filltie
XFILLER_116_636 VDD VDD VSS VSS gf180mcu_fd_sc_mcu7t5v0__fill_2
XFILLER_155_282 VDD VDD VSS VSS gf180mcu_fd_sc_mcu7t5v0__fill_2
XFILLER_155_293 VDD VDD VSS VSS gf180mcu_fd_sc_mcu7t5v0__fillcap_8
Xspi_regs_inst__1206_ spi_regs_inst__1206_/A1 spi_regs_inst__1206_/A2 spi_regs_inst__1221_/A3
+ VDD VDD VSS VSS gf180mcu_fd_sc_mcu7t5v0__nor2_1
XFILLER_115_157 VDD VDD VSS VSS gf180mcu_fd_sc_mcu7t5v0__fill_2
XFILLER_157_1046 VDD VDD VSS VSS gf180mcu_fd_sc_mcu7t5v0__fillcap_4
Xspi_regs_inst__1137_ spi_regs_inst__1137_/A1 spi_regs_inst__1137_/A2 spi_regs_inst__1137_/A3
+ spi_regs_inst__1138_/C VDD VDD VSS VSS gf180mcu_fd_sc_mcu7t5v0__nand3_1
Xmax_cap457 max_cap457/I max_cap457/Z VDD VDD VSS VSS gf180mcu_fd_sc_mcu7t5v0__buf_3
XFILLER_131_617 VDD VDD VSS VSS gf180mcu_fd_sc_mcu7t5v0__fill_1
XTAP_TAPCELL_ROW_34_1_590 VDD VSS gf180mcu_fd_sc_mcu7t5v0__filltie
Xwave_controller_x_inst__2820_ wave_controller_x_inst__3712_/Q wave_controller_x_inst__2835_/A2
+ wave_controller_x_inst__2820_/B1 wave_controller_x_inst__2820_/B2 wave_controller_x_inst__2820_/C
+ wave_controller_x_inst__2839_/A1 VDD VDD VSS VSS gf180mcu_fd_sc_mcu7t5v0__aoi221_1
Xspi_regs_inst__1068_ spi_regs_inst__1068_/A1 spi_regs_inst_wire296/Z spi_regs_inst_wire228/Z
+ spi_regs_inst__1068_/B2 spi_regs_inst__1070_/A3 VDD VDD VSS VSS gf180mcu_fd_sc_mcu7t5v0__aoi22_1
XFILLER_111_352 VDD VDD VSS VSS gf180mcu_fd_sc_mcu7t5v0__fill_2
XFILLER_85_726 VDD VDD VSS VSS gf180mcu_fd_sc_mcu7t5v0__fillcap_8
XFILLER_69_299 VDD VDD VSS VSS gf180mcu_fd_sc_mcu7t5v0__fill_1
XFILLER_84_225 VDD VDD VSS VSS gf180mcu_fd_sc_mcu7t5v0__fill_1
Xwave_controller_x_inst__2751_ wave_controller_x_inst__2736_/I wave_controller_x_inst__2748_/Z
+ wave_controller_x_inst__2752_/B1 VDD VDD VSS VSS gf180mcu_fd_sc_mcu7t5v0__nand2_1
XFILLER_84_247 VDD VDD VSS VSS gf180mcu_fd_sc_mcu7t5v0__fillcap_8
Xwave_controller_x_inst__2682_ wave_controller_x_inst__2677_/Z wave_controller_x_inst__2683_/A2
+ wave_controller_x_inst__2696_/A2 VDD VDD VSS VSS gf180mcu_fd_sc_mcu7t5v0__nand2_1
XFILLER_53_634 VDD VDD VSS VSS gf180mcu_fd_sc_mcu7t5v0__fillcap_4
XFILLER_93_792 VDD VDD VSS VSS gf180mcu_fd_sc_mcu7t5v0__fillcap_8
XFILLER_164_1017 VDD VDD VSS VSS gf180mcu_fd_sc_mcu7t5v0__fillcap_64
XFILLER_52_111 VDD VDD VSS VSS gf180mcu_fd_sc_mcu7t5v0__fill_1
XFILLER_53_656 VDD VDD VSS VSS gf180mcu_fd_sc_mcu7t5v0__fillcap_4
XFILLER_81_965 VDD VDD VSS VSS gf180mcu_fd_sc_mcu7t5v0__fillcap_8
XTAP_TAPCELL_ROW_84_1259 VDD VSS gf180mcu_fd_sc_mcu7t5v0__filltie
XFILLER_111_48 VDD VDD VSS VSS gf180mcu_fd_sc_mcu7t5v0__fillcap_16
XFILLER_52_177 VDD VDD VSS VSS gf180mcu_fd_sc_mcu7t5v0__fillcap_16
XFILLER_53_678 VDD VDD VSS VSS gf180mcu_fd_sc_mcu7t5v0__fill_2
Xwave_controller_x_inst__3303_ wave_controller_x_inst__3303_/A1 wave_controller_x_inst__3303_/A2
+ wave_controller_x_inst__3303_/A3 wave_controller_x_inst__3310_/A1 VDD VDD VSS VSS
+ gf180mcu_fd_sc_mcu7t5v0__nand3_1
XFILLER_21_520 VDD VDD VSS VSS gf180mcu_fd_sc_mcu7t5v0__fillcap_32
XFILLER_52_199 VDD VDD VSS VSS gf180mcu_fd_sc_mcu7t5v0__fillcap_8
Xwave_controller_y_inst__3250_ wave_controller_y_inst__3184_/Z wave_controller_y_inst__3250_/A2
+ wave_controller_y_inst__3250_/Z VDD VDD VSS VSS gf180mcu_fd_sc_mcu7t5v0__xor2_1
Xwave_controller_y_inst__2201_ wave_controller_y_inst__2201_/A1 wave_controller_y_inst__2201_/A2
+ wave_controller_y_inst__2201_/B wave_controller_y_inst__2213_/A3 VDD VDD VSS VSS
+ gf180mcu_fd_sc_mcu7t5v0__aoi21_1
Xwave_controller_x_inst__3234_ wave_controller_x_inst__3374_/B wave_controller_x_inst__3234_/A2
+ wave_controller_x_inst__3234_/B1 wave_controller_x_inst__3234_/B2 wave_controller_x_inst__3235_/B2
+ VDD VDD VSS VSS gf180mcu_fd_sc_mcu7t5v0__oai22_1
XFILLER_119_430 VDD VDD VSS VSS gf180mcu_fd_sc_mcu7t5v0__fill_2
Xwave_controller_y_inst__3181_ wave_controller_y_inst__1778_/I wave_controller_y_inst__3181_/A2
+ wave_controller_y_inst__3182_/B VDD VDD VSS VSS gf180mcu_fd_sc_mcu7t5v0__nor2_1
Xwave_controller_x_inst__3165_ wave_controller_x_inst__3166_/A1 wave_controller_x_inst__3164_/Z
+ wave_controller_x_inst__3165_/Z VDD VDD VSS VSS gf180mcu_fd_sc_mcu7t5v0__and2_1
XFILLER_105_1170 VDD VDD VSS VSS gf180mcu_fd_sc_mcu7t5v0__fillcap_4
XFILLER_135_912 VDD VDD VSS VSS gf180mcu_fd_sc_mcu7t5v0__fillcap_64
XFILLER_147_772 VDD VDD VSS VSS gf180mcu_fd_sc_mcu7t5v0__fillcap_4
XTAP_TAPCELL_ROW_5_1_369 VDD VSS gf180mcu_fd_sc_mcu7t5v0__filltie
Xwave_controller_y_inst__2132_ wave_controller_y_inst__2132_/A1 wave_controller_y_inst__2132_/A2
+ wave_controller_y_inst__2134_/A2 VDD VDD VSS VSS gf180mcu_fd_sc_mcu7t5v0__nor2_1
Xwave_controller_x_inst__2116_ wave_controller_x_inst__2144_/B wave_controller_x_inst__2116_/A2
+ wave_controller_x_inst__2116_/B1 wave_controller_x_inst__2107_/B wave_controller_x_inst__2116_/C
+ wave_controller_x_inst__2124_/A1 VDD VDD VSS VSS gf180mcu_fd_sc_mcu7t5v0__aoi221_1
XFILLER_107_647 VDD VDD VSS VSS gf180mcu_fd_sc_mcu7t5v0__fill_1
XFILLER_162_731 VDD VDD VSS VSS gf180mcu_fd_sc_mcu7t5v0__fillcap_4
XFILLER_20_34 VDD VDD VSS VSS gf180mcu_fd_sc_mcu7t5v0__fill_1
Xwave_controller_y_inst__2063_ fanout499/Z wave_controller_y_inst__3612_/Q wave_controller_y_inst__2065_/A2
+ VDD VDD VSS VSS gf180mcu_fd_sc_mcu7t5v0__nand2_1
Xwave_controller_x_inst__3096_ wave_controller_x_inst__3096_/A1 wave_controller_x_inst__3096_/A2
+ wave_controller_x_inst__3097_/A2 VDD VDD VSS VSS gf180mcu_fd_sc_mcu7t5v0__nand2_1
XTAP_TAPCELL_ROW_132_2050 VDD VSS gf180mcu_fd_sc_mcu7t5v0__filltie
XTAP_TAPCELL_ROW_132_2061 VDD VSS gf180mcu_fd_sc_mcu7t5v0__filltie
Xwave_controller_x_inst__2047_ wave_controller_x_inst_wire377/Z wave_controller_x_inst__2068_/A2
+ wave_controller_x_inst__2061_/A1 VDD VDD VSS VSS gf180mcu_fd_sc_mcu7t5v0__nand2_1
XFILLER_103_842 VDD VDD VSS VSS gf180mcu_fd_sc_mcu7t5v0__fill_2
XFILLER_103_886 VDD VDD VSS VSS gf180mcu_fd_sc_mcu7t5v0__fillcap_16
XFILLER_130_650 VDD VDD VSS VSS gf180mcu_fd_sc_mcu7t5v0__fill_2
XFILLER_88_575 VDD VDD VSS VSS gf180mcu_fd_sc_mcu7t5v0__fillcap_4
Xwave_controller_y_inst__2965_ wave_controller_y_inst__2965_/A1 wave_controller_y_inst__3043_/A3
+ wave_controller_y_inst__2965_/B wave_controller_y_inst__3045_/B VDD VDD VSS VSS
+ gf180mcu_fd_sc_mcu7t5v0__oai21_1
XFILLER_130_683 VDD VDD VSS VSS gf180mcu_fd_sc_mcu7t5v0__fill_1
XFILLER_75_225 VDD VDD VSS VSS gf180mcu_fd_sc_mcu7t5v0__fillcap_32
XTAP_TAPCELL_ROW_110_1691 VDD VSS gf180mcu_fd_sc_mcu7t5v0__filltie
Xwave_controller_y_inst__1916_ spi_regs_inst__1564_/Q wave_controller_y_inst__3562_/A1
+ wave_controller_y_inst__1919_/B VDD VDD VSS VSS gf180mcu_fd_sc_mcu7t5v0__nand2_1
Xwave_controller_x_inst__2949_ wave_controller_x_inst__1792_/I wave_controller_x_inst__3238_/A1
+ wave_controller_x_inst__2976_/B VDD VDD VSS VSS gf180mcu_fd_sc_mcu7t5v0__nand2_1
XFILLER_28_130 VDD VDD VSS VSS gf180mcu_fd_sc_mcu7t5v0__fill_2
Xwave_controller_y_inst__2896_ wave_controller_y_inst__3010_/B wave_controller_y_inst__2764_/Z
+ wave_controller_y_inst__2896_/B wave_controller_y_inst__2902_/A3 VDD VDD VSS VSS
+ gf180mcu_fd_sc_mcu7t5v0__aoi21_1
XFILLER_28_174 VDD VDD VSS VSS gf180mcu_fd_sc_mcu7t5v0__fill_1
XFILLER_56_483 VDD VDD VSS VSS gf180mcu_fd_sc_mcu7t5v0__fill_2
XFILLER_90_206 VDD VDD VSS VSS gf180mcu_fd_sc_mcu7t5v0__fill_1
XFILLER_91_729 VDD VDD VSS VSS gf180mcu_fd_sc_mcu7t5v0__fillcap_4
Xwave_controller_y_inst__1847_ spi_regs_inst__1099_/A1 wave_controller_y_inst__2399_/A1
+ VDD VDD VSS VSS gf180mcu_fd_sc_mcu7t5v0__clkinv_1
XFILLER_28_196 VDD VDD VSS VSS gf180mcu_fd_sc_mcu7t5v0__fillcap_4
XTAP_TAPCELL_ROW_67_990 VDD VSS gf180mcu_fd_sc_mcu7t5v0__filltie
Xwave_controller_y_inst__1778_ wave_controller_y_inst__1778_/I wave_controller_y_inst__3081_/B
+ VDD VDD VSS VSS gf180mcu_fd_sc_mcu7t5v0__clkinv_1
XFILLER_43_155 VDD VDD VSS VSS gf180mcu_fd_sc_mcu7t5v0__fillcap_16
Xwave_controller_y_inst__3517_ spi_regs_inst__1343_/A1 wave_controller_y_inst__3520_/A2
+ wave_controller_y_inst__3518_/A3 VDD VDD VSS VSS gf180mcu_fd_sc_mcu7t5v0__nor2_1
XFILLER_101_92 VDD VDD VSS VSS gf180mcu_fd_sc_mcu7t5v0__fill_2
XFILLER_61_52 VDD VDD VSS VSS gf180mcu_fd_sc_mcu7t5v0__fillcap_16
Xwave_controller_y_inst__3448_ spi_regs_inst__1190_/A1 wave_controller_y_inst__3454_/A2
+ wave_controller_y_inst__3449_/C VDD VDD VSS VSS gf180mcu_fd_sc_mcu7t5v0__nor2_1
XFILLER_157_536 VDD VDD VSS VSS gf180mcu_fd_sc_mcu7t5v0__fill_2
Xwave_controller_y_inst__3379_ wave_controller_y_inst__3278_/Z wave_controller_y_inst__3377_/B
+ wave_controller_y_inst__3285_/I wave_controller_y_inst__3381_/A2 VDD VDD VSS VSS
+ gf180mcu_fd_sc_mcu7t5v0__nor3_1
XTAP_TAPCELL_ROW_117_1801 VDD VSS gf180mcu_fd_sc_mcu7t5v0__filltie
XTAP_TAPCELL_ROW_117_1812 VDD VSS gf180mcu_fd_sc_mcu7t5v0__filltie
XFILLER_137_282 VDD VDD VSS VSS gf180mcu_fd_sc_mcu7t5v0__fillcap_16
XFILLER_165_591 VDD VDD VSS VSS gf180mcu_fd_sc_mcu7t5v0__fillcap_4
XFILLER_125_433 VDD VDD VSS VSS gf180mcu_fd_sc_mcu7t5v0__fillcap_16
XFILLER_141_904 VDD VDD VSS VSS gf180mcu_fd_sc_mcu7t5v0__fillcap_4
Xstate_machine_inst__21_ spi_regs_inst__1058_/B2 state_machine_inst__26_/A2 spi_regs_inst__1146_/A1
+ state_machine_inst__34_/A1 VDD VDD VSS VSS gf180mcu_fd_sc_mcu7t5v0__nor3_2
XFILLER_98_317 VDD VDD VSS VSS gf180mcu_fd_sc_mcu7t5v0__fillcap_8
XFILLER_117_1052 VDD VDD VSS VSS gf180mcu_fd_sc_mcu7t5v0__fillcap_64
XFILLER_121_661 VDD VDD VSS VSS gf180mcu_fd_sc_mcu7t5v0__fillcap_16
XFILLER_79_553 VDD VDD VSS VSS gf180mcu_fd_sc_mcu7t5v0__fillcap_4
XFILLER_121_683 VDD VDD VSS VSS gf180mcu_fd_sc_mcu7t5v0__fill_1
XFILLER_66_225 VDD VDD VSS VSS gf180mcu_fd_sc_mcu7t5v0__fillcap_4
XFILLER_94_523 VDD VDD VSS VSS gf180mcu_fd_sc_mcu7t5v0__fill_2
XFILLER_66_247 VDD VDD VSS VSS gf180mcu_fd_sc_mcu7t5v0__fillcap_8
XTAP_TAPCELL_ROW_163_2566 VDD VSS gf180mcu_fd_sc_mcu7t5v0__filltie
XTAP_TAPCELL_ROW_29_1_548 VDD VSS gf180mcu_fd_sc_mcu7t5v0__filltie
XFILLER_94_589 VDD VDD VSS VSS gf180mcu_fd_sc_mcu7t5v0__fillcap_4
XTAP_TAPCELL_ROW_128_1985 VDD VSS gf180mcu_fd_sc_mcu7t5v0__filltie
XTAP_TAPCELL_ROW_65_949 VDD VSS gf180mcu_fd_sc_mcu7t5v0__filltie
XFILLER_63_965 VDD VDD VSS VSS gf180mcu_fd_sc_mcu7t5v0__fillcap_8
XTAP_TAPCELL_ROW_128_1996 VDD VSS gf180mcu_fd_sc_mcu7t5v0__filltie
XFILLER_62_486 VDD VDD VSS VSS gf180mcu_fd_sc_mcu7t5v0__fill_1
XFILLER_96_2 VDD VDD VSS VSS gf180mcu_fd_sc_mcu7t5v0__fillcap_8
XFILLER_148_547 VDD VDD VSS VSS gf180mcu_fd_sc_mcu7t5v0__fill_2
XFILLER_30_383 VDD VDD VSS VSS gf180mcu_fd_sc_mcu7t5v0__fill_2
XFILLER_117_912 VDD VDD VSS VSS gf180mcu_fd_sc_mcu7t5v0__fillcap_64
XFILLER_129_772 VDD VDD VSS VSS gf180mcu_fd_sc_mcu7t5v0__fillcap_4
XFILLER_116_422 VDD VDD VSS VSS gf180mcu_fd_sc_mcu7t5v0__fillcap_32
XFILLER_129_794 VDD VDD VSS VSS gf180mcu_fd_sc_mcu7t5v0__fill_1
XTAP_TAPCELL_ROW_1_1_342 VDD VSS gf180mcu_fd_sc_mcu7t5v0__filltie
XFILLER_143_263 VDD VDD VSS VSS gf180mcu_fd_sc_mcu7t5v0__fill_1
XFILLER_89_317 VDD VDD VSS VSS gf180mcu_fd_sc_mcu7t5v0__fill_2
XFILLER_89_328 VDD VDD VSS VSS gf180mcu_fd_sc_mcu7t5v0__fillcap_8
XFILLER_131_469 VDD VDD VSS VSS gf180mcu_fd_sc_mcu7t5v0__fillcap_8
XFILLER_97_361 VDD VDD VSS VSS gf180mcu_fd_sc_mcu7t5v0__fill_1
XPHY_EDGE_ROW_39_1_Right_38 VDD VSS gf180mcu_fd_sc_mcu7t5v0__endcap
Xwave_controller_x_inst__2803_ wave_controller_x_inst__3564_/A1 wave_controller_x_inst__2800_/Z
+ wave_controller_x_inst__2808_/A2 VDD VDD VSS VSS gf180mcu_fd_sc_mcu7t5v0__nand2_1
XFILLER_73_718 VDD VDD VSS VSS gf180mcu_fd_sc_mcu7t5v0__fillcap_4
XFILLER_85_567 VDD VDD VSS VSS gf180mcu_fd_sc_mcu7t5v0__fillcap_16
Xwave_controller_y_inst__2750_ wave_controller_y_inst__2748_/Z wave_controller_y_inst__2750_/A2
+ spi_regs_inst_wire19/I VDD VDD VSS VSS gf180mcu_fd_sc_mcu7t5v0__xor2_1
Xwave_controller_x_inst__2734_ wave_controller_x_inst__2734_/A1 wave_controller_x_inst__2733_/Z
+ wave_controller_x_inst__2749_/B VDD VDD VSS VSS gf180mcu_fd_sc_mcu7t5v0__nand2_1
XFILLER_66_792 VDD VDD VSS VSS gf180mcu_fd_sc_mcu7t5v0__fillcap_8
Xwave_controller_y_inst__2681_ wave_controller_y_inst__2681_/A1 wave_controller_y_inst__2681_/A2
+ wave_controller_y_inst__2681_/B wave_controller_y_inst__2681_/C wave_controller_y_inst__2683_/A2
+ VDD VDD VSS VSS gf180mcu_fd_sc_mcu7t5v0__oai211_1
XFILLER_122_69 VDD VDD VSS VSS gf180mcu_fd_sc_mcu7t5v0__fill_2
XFILLER_38_494 VDD VDD VSS VSS gf180mcu_fd_sc_mcu7t5v0__fillcap_4
XFILLER_53_431 VDD VDD VSS VSS gf180mcu_fd_sc_mcu7t5v0__fillcap_8
Xwave_controller_x_inst__2665_ wave_controller_x_inst__2681_/C wave_controller_x_inst__2710_/A3
+ wave_controller_x_inst__2681_/A2 VDD VDD VSS VSS gf180mcu_fd_sc_mcu7t5v0__nand2_1
Xwave_controller_x_inst__2596_ wave_controller_x_inst__2580_/Z wave_controller_x_inst__2596_/A2
+ wave_controller_x_inst__2596_/B wave_controller_x_inst__2599_/A3 VDD VDD VSS VSS
+ gf180mcu_fd_sc_mcu7t5v0__aoi21_1
XFILLER_13_317 VDD VDD VSS VSS gf180mcu_fd_sc_mcu7t5v0__fillcap_8
XFILLER_80_283 VDD VDD VSS VSS gf180mcu_fd_sc_mcu7t5v0__fillcap_8
XFILLER_90_1011 VDD VDD VSS VSS gf180mcu_fd_sc_mcu7t5v0__fillcap_4
Xwave_controller_y_inst__3302_ wave_controller_y_inst__3364_/A2 wave_controller_y_inst__3301_/Z
+ wave_controller_y_inst__3303_/A3 VDD VDD VSS VSS gf180mcu_fd_sc_mcu7t5v0__nor2_1
XFILLER_40_158 VDD VDD VSS VSS gf180mcu_fd_sc_mcu7t5v0__fillcap_4
XFILLER_166_333 VDD VDD VSS VSS gf180mcu_fd_sc_mcu7t5v0__fillcap_4
Xwave_controller_y_inst__3233_ fanout509/Z wave_controller_y_inst__3233_/A2 wave_controller_y_inst__3233_/B1
+ fanout507/Z wave_controller_y_inst__3233_/C wave_controller_y_inst__3234_/B2 VDD
+ VDD VSS VSS gf180mcu_fd_sc_mcu7t5v0__aoi221_1
Xwave_controller_x_inst__3217_ fanout523/I wave_controller_x_inst__3215_/Z wave_controller_x_inst__3217_/Z
+ VDD VDD VSS VSS gf180mcu_fd_sc_mcu7t5v0__or2_1
XFILLER_5_505 VDD VDD VSS VSS gf180mcu_fd_sc_mcu7t5v0__fillcap_8
Xwave_controller_y_inst__3164_ wave_controller_y_inst__3164_/A1 wave_controller_y_inst__3164_/A2
+ wave_controller_y_inst__3164_/Z VDD VDD VSS VSS gf180mcu_fd_sc_mcu7t5v0__and2_1
XFILLER_107_411 VDD VDD VSS VSS gf180mcu_fd_sc_mcu7t5v0__fillcap_8
XFILLER_107_422 VDD VDD VSS VSS gf180mcu_fd_sc_mcu7t5v0__fill_1
XFILLER_119_282 VDD VDD VSS VSS gf180mcu_fd_sc_mcu7t5v0__fillcap_8
Xwave_controller_y_inst__2115_ wave_controller_y_inst__2072_/B wave_controller_y_inst__2114_/C
+ wave_controller_y_inst__2116_/B1 VDD VDD VSS VSS gf180mcu_fd_sc_mcu7t5v0__nor2_1
Xwave_controller_x_inst__3148_ wave_controller_x_inst__3149_/B1 wave_controller_x_inst__3149_/B2
+ wave_controller_x_inst__3149_/C wave_controller_x_inst__3213_/A3 VDD VDD VSS VSS
+ gf180mcu_fd_sc_mcu7t5v0__oai21_1
XFILLER_147_55 VDD VDD VSS VSS gf180mcu_fd_sc_mcu7t5v0__fillcap_4
XFILLER_147_66 VDD VDD VSS VSS gf180mcu_fd_sc_mcu7t5v0__fillcap_4
Xwave_controller_y_inst__3095_ wave_controller_y_inst__3101_/A1 wave_controller_y_inst__3614_/Q
+ wave_controller_y_inst__3612_/Q wave_controller_y_inst__3096_/A2 VDD VDD VSS VSS
+ gf180mcu_fd_sc_mcu7t5v0__oai21_1
Xwave_controller_x_inst__3079_ wave_controller_x_inst__3079_/A1 wave_controller_x_inst__3079_/A2
+ wave_controller_x_inst__3079_/Z VDD VDD VSS VSS gf180mcu_fd_sc_mcu7t5v0__xor2_1
XTAP_TAPCELL_ROW_112_1720 VDD VSS gf180mcu_fd_sc_mcu7t5v0__filltie
Xwave_controller_y_inst__2046_ wave_controller_y_inst__2108_/B wave_controller_y_inst__2107_/B
+ wave_controller_y_inst__2079_/B wave_controller_y_inst__2080_/B VDD VDD VSS VSS
+ gf180mcu_fd_sc_mcu7t5v0__oai21_1
Xoutput9 _21_/Q bidir_out[2] VDD VDD VSS VSS gf180mcu_fd_sc_mcu7t5v0__buf_1
Xoutput11 _89_/Z bidir_out[4] VDD VDD VSS VSS gf180mcu_fd_sc_mcu7t5v0__buf_1
XFILLER_0_210 VDD VDD VSS VSS gf180mcu_fd_sc_mcu7t5v0__fill_2
XFILLER_0_221 VDD VDD VSS VSS gf180mcu_fd_sc_mcu7t5v0__fillcap_16
XTAP_TAPCELL_ROW_112_1731 VDD VSS gf180mcu_fd_sc_mcu7t5v0__filltie
XFILLER_89_884 VDD VDD VSS VSS gf180mcu_fd_sc_mcu7t5v0__fill_2
XFILLER_62_1157 VDD VDD VSS VSS gf180mcu_fd_sc_mcu7t5v0__fillcap_16
XTAP_TAPCELL_ROW_145_2263 VDD VSS gf180mcu_fd_sc_mcu7t5v0__filltie
Xwave_controller_y_inst__2948_ wave_controller_y_inst__3305_/B2 wave_controller_y_inst__2979_/A2
+ wave_controller_y_inst__2980_/C VDD VDD VSS VSS gf180mcu_fd_sc_mcu7t5v0__nor2_1
XFILLER_64_729 VDD VDD VSS VSS gf180mcu_fd_sc_mcu7t5v0__fillcap_4
XTAP_TAPCELL_ROW_145_2274 VDD VSS gf180mcu_fd_sc_mcu7t5v0__filltie
XFILLER_56_96 VDD VDD VSS VSS gf180mcu_fd_sc_mcu7t5v0__fillcap_4
XTAP_TAPCELL_ROW_25_1_521 VDD VSS gf180mcu_fd_sc_mcu7t5v0__filltie
Xwave_controller_y_inst__2879_ wave_controller_y_inst__2870_/Z wave_controller_y_inst__2879_/A2
+ wave_controller_y_inst__2879_/B wave_controller_y_inst__2881_/A2 VDD VDD VSS VSS
+ gf180mcu_fd_sc_mcu7t5v0__aoi21_1
XTAP_TAPCELL_ROW_62_908 VDD VSS gf180mcu_fd_sc_mcu7t5v0__filltie
Xwave_controller_x_inst_fanout62 wave_controller_x_inst_wire68/I wave_controller_x_inst__3585_/S
+ VDD VDD VSS VSS gf180mcu_fd_sc_mcu7t5v0__dlyb_1
Xspi_regs_inst__1540_ spi_regs_inst__1540_/D fanout587/Z clkload24/I spi_regs_inst__1540_/Q
+ VDD VDD VSS VSS gf180mcu_fd_sc_mcu7t5v0__dffrnq_1
XFILLER_158_801 VDD VDD VSS VSS gf180mcu_fd_sc_mcu7t5v0__fillcap_4
Xspi_regs_inst__1471_ spi_regs_inst__1471_/D spi_regs_inst__1601_/RN clkload32/I fanout530/I
+ VDD VDD VSS VSS gf180mcu_fd_sc_mcu7t5v0__dffrnq_1
XFILLER_157_322 VDD VDD VSS VSS gf180mcu_fd_sc_mcu7t5v0__fill_1
XFILLER_138_591 VDD VDD VSS VSS gf180mcu_fd_sc_mcu7t5v0__fillcap_4
XFILLER_126_797 VDD VDD VSS VSS gf180mcu_fd_sc_mcu7t5v0__fillcap_8
XFILLER_67_1046 VDD VDD VSS VSS gf180mcu_fd_sc_mcu7t5v0__fillcap_4
XFILLER_140_266 VDD VDD VSS VSS gf180mcu_fd_sc_mcu7t5v0__fillcap_16
XTAP_TAPCELL_ROW_165_2606 VDD VSS gf180mcu_fd_sc_mcu7t5v0__filltie
XFILLER_67_534 VDD VDD VSS VSS gf180mcu_fd_sc_mcu7t5v0__fill_2
XFILLER_11_2 VDD VDD VSS VSS gf180mcu_fd_sc_mcu7t5v0__fillcap_64
XFILLER_94_331 VDD VDD VSS VSS gf180mcu_fd_sc_mcu7t5v0__fillcap_4
XTAP_TAPCELL_ROW_68_1007 VDD VSS gf180mcu_fd_sc_mcu7t5v0__filltie
XFILLER_74_1017 VDD VDD VSS VSS gf180mcu_fd_sc_mcu7t5v0__fillcap_64
XTAP_TAPCELL_ROW_81_1207 VDD VSS gf180mcu_fd_sc_mcu7t5v0__filltie
Xwave_controller_x_inst__2450_ spi_regs_inst__1225_/A1 wave_controller_x_inst__2450_/A2
+ wave_controller_x_inst__2450_/A3 spi_regs_inst__1230_/B2 VDD VDD VSS VSS gf180mcu_fd_sc_mcu7t5v0__xor3_1
XTAP_TAPCELL_ROW_81_1218 VDD VSS gf180mcu_fd_sc_mcu7t5v0__filltie
Xwave_controller_x_inst__2381_ spi_regs_inst__1349_/A1 wave_controller_x_inst__2824_/A1
+ wave_controller_x_inst__2381_/B1 spi_regs_inst__1309_/C2 wave_controller_x_inst__2382_/B
+ VDD VDD VSS VSS gf180mcu_fd_sc_mcu7t5v0__aoi22_1
Xwave_controller_x_inst__3002_ wave_controller_x_inst__3002_/I wave_controller_x_inst__3081_/A2
+ VDD VDD VSS VSS gf180mcu_fd_sc_mcu7t5v0__clkinv_1
XFILLER_102_1151 VDD VDD VSS VSS gf180mcu_fd_sc_mcu7t5v0__fillcap_4
XTAP_TAPCELL_ROW_42_1_646 VDD VSS gf180mcu_fd_sc_mcu7t5v0__filltie
XTAP_TAPCELL_ROW_96_1461 VDD VSS gf180mcu_fd_sc_mcu7t5v0__filltie
XFILLER_132_701 VDD VDD VSS VSS gf180mcu_fd_sc_mcu7t5v0__fillcap_16
XFILLER_132_734 VDD VDD VSS VSS gf180mcu_fd_sc_mcu7t5v0__fill_1
XFILLER_144_594 VDD VDD VSS VSS gf180mcu_fd_sc_mcu7t5v0__fill_1
XFILLER_100_620 VDD VDD VSS VSS gf180mcu_fd_sc_mcu7t5v0__fillcap_4
XFILLER_58_556 VDD VDD VSS VSS gf180mcu_fd_sc_mcu7t5v0__fill_2
XFILLER_58_567 VDD VDD VSS VSS gf180mcu_fd_sc_mcu7t5v0__fillcap_4
Xwave_controller_y_inst__2802_ wave_controller_y_inst__2802_/A1 wave_controller_y_inst__2802_/A2
+ wave_controller_y_inst__2802_/B wave_controller_y_inst__2810_/A1 VDD VDD VSS VSS
+ gf180mcu_fd_sc_mcu7t5v0__aoi21_1
Xwave_controller_y_inst__2733_ wave_controller_y_inst__3551_/B2 wave_controller_y_inst__2731_/Z
+ wave_controller_y_inst__2733_/Z VDD VDD VSS VSS gf180mcu_fd_sc_mcu7t5v0__xor2_1
XFILLER_26_22 VDD VDD VSS VSS gf180mcu_fd_sc_mcu7t5v0__fillcap_8
XFILLER_73_559 VDD VDD VSS VSS gf180mcu_fd_sc_mcu7t5v0__fill_1
Xwave_controller_x_inst__3697_ wave_controller_x_inst__3697_/D wave_controller_x_inst__3716_/RN
+ clkload28/I wave_controller_x_inst__3697_/Q VDD VDD VSS VSS gf180mcu_fd_sc_mcu7t5v0__dffrnq_1
Xwave_controller_x_inst__2717_ max_cap451/I wave_controller_x_inst__3548_/B2 wave_controller_x_inst__2717_/B1
+ wave_controller_x_inst_wire113/Z wave_controller_x_inst__2717_/C wave_controller_x_inst__2730_/A3
+ VDD VDD VSS VSS gf180mcu_fd_sc_mcu7t5v0__aoi221_1
Xwave_controller_y_inst__2664_ wave_controller_y_inst__2664_/A1 wave_controller_y_inst__2664_/A2
+ wave_controller_y_inst__2661_/I wave_controller_y_inst__2710_/A3 VDD VDD VSS VSS
+ gf180mcu_fd_sc_mcu7t5v0__nand3_1
Xwave_controller_x_inst__2648_ wave_controller_x_inst__2664_/A1 wave_controller_x_inst__2664_/A2
+ wave_controller_x_inst__2663_/A1 VDD VDD VSS VSS gf180mcu_fd_sc_mcu7t5v0__nand2_1
XTAP_TAPCELL_ROW_140_2182 VDD VSS gf180mcu_fd_sc_mcu7t5v0__filltie
XTAP_TAPCELL_ROW_140_2193 VDD VSS gf180mcu_fd_sc_mcu7t5v0__filltie
Xwave_controller_y_inst__2595_ wave_controller_y_inst__2616_/A1 spi_regs_inst__1216_/B2
+ wave_controller_y_inst__2595_/Z VDD VDD VSS VSS gf180mcu_fd_sc_mcu7t5v0__xor2_1
XFILLER_13_158 VDD VDD VSS VSS gf180mcu_fd_sc_mcu7t5v0__fillcap_8
Xwave_controller_x_inst__2579_ wave_controller_x_inst__2616_/C max_cap464/Z wave_controller_x_inst__2596_/B
+ VDD VDD VSS VSS gf180mcu_fd_sc_mcu7t5v0__nor2_1
XFILLER_139_366 VDD VDD VSS VSS gf180mcu_fd_sc_mcu7t5v0__fill_1
XPHY_EDGE_ROW_165_Right_165 VDD VSS gf180mcu_fd_sc_mcu7t5v0__endcap
Xwave_controller_y_inst__3216_ fanout502/Z wave_controller_y_inst__3215_/Z wave_controller_y_inst__3238_/C
+ VDD VDD VSS VSS gf180mcu_fd_sc_mcu7t5v0__and2_1
XFILLER_5_346 VDD VDD VSS VSS gf180mcu_fd_sc_mcu7t5v0__fillcap_4
Xwave_controller_y_inst__3147_ wave_controller_y_inst__3219_/B wave_controller_y_inst__3218_/B
+ wave_controller_y_inst__3218_/C wave_controller_y_inst__3147_/B wave_controller_y_inst_wire124/I
+ VDD VDD VSS VSS gf180mcu_fd_sc_mcu7t5v0__oai31_1
XFILLER_107_252 VDD VDD VSS VSS gf180mcu_fd_sc_mcu7t5v0__fillcap_8
XFILLER_5_368 VDD VDD VSS VSS gf180mcu_fd_sc_mcu7t5v0__fill_1
Xwave_controller_y_inst__3078_ wave_controller_y_inst__3320_/A1 wave_controller_y_inst__3090_/B1
+ wave_controller_y_inst__3077_/Z wave_controller_y_inst__2762_/I wave_controller_y_inst__3715_/D
+ VDD VDD VSS VSS gf180mcu_fd_sc_mcu7t5v0__oai22_1
XFILLER_150_531 VDD VDD VSS VSS gf180mcu_fd_sc_mcu7t5v0__fill_1
XFILLER_162_380 VDD VDD VSS VSS gf180mcu_fd_sc_mcu7t5v0__fillcap_4
Xwave_controller_y_inst__2029_ spi_regs_inst__1254_/A1 wave_controller_y_inst__2026_/Z
+ spi_regs_inst__1252_/A1 VDD VDD VSS VSS gf180mcu_fd_sc_mcu7t5v0__xor2_1
XFILLER_122_244 VDD VDD VSS VSS gf180mcu_fd_sc_mcu7t5v0__fill_1
XFILLER_150_542 VDD VDD VSS VSS gf180mcu_fd_sc_mcu7t5v0__fillcap_16
XFILLER_1_541 VDD VDD VSS VSS gf180mcu_fd_sc_mcu7t5v0__fillcap_8
XTAP_TAPCELL_ROW_147_2303 VDD VSS gf180mcu_fd_sc_mcu7t5v0__filltie
XFILLER_114_1011 VDD VDD VSS VSS gf180mcu_fd_sc_mcu7t5v0__fillcap_4
XFILLER_150_597 VDD VDD VSS VSS gf180mcu_fd_sc_mcu7t5v0__fillcap_4
Xspi_regs_inst_fanout342 spi_regs_inst__0940_/ZN spi_regs_inst__1362_/A1 VDD VDD VSS
+ VSS gf180mcu_fd_sc_mcu7t5v0__dlyb_1
XFILLER_67_62 VDD VDD VSS VSS gf180mcu_fd_sc_mcu7t5v0__fillcap_8
Xspi_regs_inst__0971_ spi_regs_inst__1366_/A1 spi_regs_inst__1628_/Q spi_regs_inst__1630_/Q
+ spi_regs_inst__1370_/A1 spi_regs_inst__1022_/A2 VDD VDD VSS VSS gf180mcu_fd_sc_mcu7t5v0__nand4_1
XFILLER_36_217 VDD VDD VSS VSS gf180mcu_fd_sc_mcu7t5v0__fillcap_4
XFILLER_76_375 VDD VDD VSS VSS gf180mcu_fd_sc_mcu7t5v0__fillcap_8
XTAP_TAPCELL_ROW_160_2514 VDD VSS gf180mcu_fd_sc_mcu7t5v0__filltie
XTAP_TAPCELL_ROW_160_2525 VDD VSS gf180mcu_fd_sc_mcu7t5v0__filltie
XFILLER_91_323 VDD VDD VSS VSS gf180mcu_fd_sc_mcu7t5v0__fill_2
XTAP_TAPCELL_ROW_125_1933 VDD VSS gf180mcu_fd_sc_mcu7t5v0__filltie
XFILLER_83_61 VDD VDD VSS VSS gf180mcu_fd_sc_mcu7t5v0__fillcap_8
XTAP_TAPCELL_ROW_125_1944 VDD VSS gf180mcu_fd_sc_mcu7t5v0__filltie
XFILLER_17_475 VDD VDD VSS VSS gf180mcu_fd_sc_mcu7t5v0__fillcap_4
XFILLER_60_732 VDD VDD VSS VSS gf180mcu_fd_sc_mcu7t5v0__fill_2
XFILLER_72_592 VDD VDD VSS VSS gf180mcu_fd_sc_mcu7t5v0__fill_2
XFILLER_83_72 VDD VDD VSS VSS gf180mcu_fd_sc_mcu7t5v0__fillcap_8
XTAP_TAPCELL_ROW_55_790 VDD VSS gf180mcu_fd_sc_mcu7t5v0__filltie
Xspi_regs_inst__1523_ spi_regs_inst__1523_/D fanout619/Z clkload32/I spi_regs_inst__1523_/Q
+ VDD VDD VSS VSS gf180mcu_fd_sc_mcu7t5v0__dffrnq_1
XTAP_TAPCELL_ROW_158_2476 VDD VSS gf180mcu_fd_sc_mcu7t5v0__filltie
Xspi_regs_inst__1454_ spi_regs_inst__1454_/D fanout584/Z clkbuf_leaf_13_clk/Z spi_regs_inst__1454_/Q
+ VDD VDD VSS VSS gf180mcu_fd_sc_mcu7t5v0__dffrnq_1
XTAP_TAPCELL_ROW_158_2487 VDD VSS gf180mcu_fd_sc_mcu7t5v0__filltie
XPHY_EDGE_ROW_132_Right_132 VDD VSS gf180mcu_fd_sc_mcu7t5v0__endcap
Xspi_regs_inst__1385_ spi_regs_inst__1454_/Q spi_regs_inst__1385_/A2 spi_regs_inst__1437_/A3
+ VDD VDD VSS VSS gf180mcu_fd_sc_mcu7t5v0__nand2_1
XFILLER_157_196 VDD VDD VSS VSS gf180mcu_fd_sc_mcu7t5v0__fill_1
XFILLER_160_317 VDD VDD VSS VSS gf180mcu_fd_sc_mcu7t5v0__fill_2
XFILLER_114_734 VDD VDD VSS VSS gf180mcu_fd_sc_mcu7t5v0__fill_1
XFILLER_126_594 VDD VDD VSS VSS gf180mcu_fd_sc_mcu7t5v0__fill_1
Xwave_controller_x_inst__1950_ fanout400/Z wave_controller_x_inst__3736_/Q wave_controller_x_inst__3737_/D
+ VDD VDD VSS VSS gf180mcu_fd_sc_mcu7t5v0__and2_1
XFILLER_113_299 VDD VDD VSS VSS gf180mcu_fd_sc_mcu7t5v0__fill_2
XFILLER_87_629 VDD VDD VSS VSS gf180mcu_fd_sc_mcu7t5v0__fill_1
XFILLER_99_489 VDD VDD VSS VSS gf180mcu_fd_sc_mcu7t5v0__fill_1
XTAP_TAPCELL_ROW_74_1099 VDD VSS gf180mcu_fd_sc_mcu7t5v0__filltie
XTAP_TAPCELL_ROW_91_1380 VDD VSS gf180mcu_fd_sc_mcu7t5v0__filltie
Xwave_controller_x_inst__3620_ wave_controller_x_inst__3620_/D wave_controller_x_inst__3736_/RN
+ clkbuf_leaf_22_clk/Z spi_regs_inst__1050_/B2 VDD VDD VSS VSS gf180mcu_fd_sc_mcu7t5v0__dffrnq_1
Xwave_controller_x_inst__1881_ max_cap463/I wave_controller_x_inst__3533_/B2 VDD VDD
+ VSS VSS gf180mcu_fd_sc_mcu7t5v0__clkinv_1
Xsignal_processor_y_inst__197_ _91_/I signal_processor_y_inst__212_/A2 signal_processor_y_inst__198_/B
+ VDD VDD VSS VSS gf180mcu_fd_sc_mcu7t5v0__nand2_1
XFILLER_27_206 VDD VDD VSS VSS gf180mcu_fd_sc_mcu7t5v0__fillcap_4
XFILLER_55_504 VDD VDD VSS VSS gf180mcu_fd_sc_mcu7t5v0__fillcap_32
XFILLER_80_1087 VDD VDD VSS VSS gf180mcu_fd_sc_mcu7t5v0__fillcap_64
XFILLER_82_301 VDD VDD VSS VSS gf180mcu_fd_sc_mcu7t5v0__fillcap_8
XFILLER_94_194 VDD VDD VSS VSS gf180mcu_fd_sc_mcu7t5v0__fillcap_4
Xwave_controller_x_inst__3551_ wave_controller_x_inst__3557_/A1 wave_controller_x_inst__3551_/A2
+ wave_controller_x_inst__3551_/A3 wave_controller_x_inst__3557_/B1 wave_controller_x_inst__3551_/B2
+ wave_controller_x_inst__3646_/D VDD VDD VSS VSS gf180mcu_fd_sc_mcu7t5v0__oai32_1
XFILLER_42_209 VDD VDD VSS VSS gf180mcu_fd_sc_mcu7t5v0__fillcap_8
Xwave_controller_x_inst__3482_ wave_controller_x_inst__3482_/A1 wave_controller_x_inst__3545_/B1
+ wave_controller_x_inst__3482_/B1 wave_controller_x_inst__3482_/B2 wave_controller_x_inst__3626_/D
+ VDD VDD VSS VSS gf180mcu_fd_sc_mcu7t5v0__oai22_1
Xwave_controller_x_inst__2502_ wave_controller_x_inst__2518_/A3 wave_controller_x_inst__2504_/A3
+ wave_controller_x_inst__2503_/A2 VDD VDD VSS VSS gf180mcu_fd_sc_mcu7t5v0__xnor2_1
XTAP_TAPCELL_ROW_53_727 VDD VSS gf180mcu_fd_sc_mcu7t5v0__filltie
XTAP_TAPCELL_ROW_53_738 VDD VSS gf180mcu_fd_sc_mcu7t5v0__filltie
XTAP_TAPCELL_ROW_53_749 VDD VSS gf180mcu_fd_sc_mcu7t5v0__filltie
Xwave_controller_x_inst__2433_ wave_controller_x_inst__2409_/I wave_controller_x_inst__2433_/A2
+ wave_controller_x_inst__2436_/A2 VDD VDD VSS VSS gf180mcu_fd_sc_mcu7t5v0__nor2_1
XFILLER_50_231 VDD VDD VSS VSS gf180mcu_fd_sc_mcu7t5v0__fillcap_8
Xwave_controller_y_inst__2380_ wave_controller_y_inst__2380_/A1 max_cap425/Z spi_regs_inst__1321_/A1
+ wave_controller_y_inst__2381_/B1 VDD VDD VSS VSS gf180mcu_fd_sc_mcu7t5v0__aoi21_1
Xwave_controller_x_inst__2364_ wave_controller_x_inst_wire121/Z wave_controller_x_inst__2352_/Z
+ wave_controller_x_inst__2364_/B wave_controller_x_inst__2367_/A3 VDD VDD VSS VSS
+ gf180mcu_fd_sc_mcu7t5v0__oai21_1
XFILLER_137_815 VDD VDD VSS VSS gf180mcu_fd_sc_mcu7t5v0__fill_1
XFILLER_149_664 VDD VDD VSS VSS gf180mcu_fd_sc_mcu7t5v0__fillcap_8
Xwave_controller_x_inst__2295_ wave_controller_x_inst__2313_/C wave_controller_x_inst__2294_/Z
+ wave_controller_x_inst__2309_/A2 VDD VDD VSS VSS gf180mcu_fd_sc_mcu7t5v0__nor2_1
XTAP_TAPCELL_ROW_98_1501 VDD VSS gf180mcu_fd_sc_mcu7t5v0__filltie
XFILLER_152_807 VDD VDD VSS VSS gf180mcu_fd_sc_mcu7t5v0__fillcap_64
XFILLER_164_667 VDD VDD VSS VSS gf180mcu_fd_sc_mcu7t5v0__fillcap_64
Xwave_controller_y_inst__3001_ wave_controller_y_inst__3001_/A1 wave_controller_y_inst__2992_/I
+ wave_controller_y_inst__3001_/A3 wave_controller_y_inst__3001_/B wave_controller_y_inst__3002_/I
+ VDD VDD VSS VSS gf180mcu_fd_sc_mcu7t5v0__oai31_1
XFILLER_88_28 VDD VDD VSS VSS gf180mcu_fd_sc_mcu7t5v0__fill_1
XFILLER_117_594 VDD VDD VSS VSS gf180mcu_fd_sc_mcu7t5v0__fill_1
XFILLER_132_520 VDD VDD VSS VSS gf180mcu_fd_sc_mcu7t5v0__fillcap_4
XFILLER_104_255 VDD VDD VSS VSS gf180mcu_fd_sc_mcu7t5v0__fillcap_4
XFILLER_105_767 VDD VDD VSS VSS gf180mcu_fd_sc_mcu7t5v0__fill_2
XFILLER_2_349 VDD VDD VSS VSS gf180mcu_fd_sc_mcu7t5v0__fillcap_16
XFILLER_120_726 VDD VDD VSS VSS gf180mcu_fd_sc_mcu7t5v0__fillcap_8
XTAP_TAPCELL_ROW_129_2000 VDD VSS gf180mcu_fd_sc_mcu7t5v0__filltie
XTAP_TAPCELL_ROW_129_2011 VDD VSS gf180mcu_fd_sc_mcu7t5v0__filltie
Xfanout620 wire628/Z fanout620/Z VDD VDD VSS VSS gf180mcu_fd_sc_mcu7t5v0__dlyb_1
XFILLER_104_299 VDD VDD VSS VSS gf180mcu_fd_sc_mcu7t5v0__fill_1
XFILLER_58_331 VDD VDD VSS VSS gf180mcu_fd_sc_mcu7t5v0__fillcap_8
XFILLER_77_139 VDD VDD VSS VSS gf180mcu_fd_sc_mcu7t5v0__fill_1
XFILLER_74_802 VDD VDD VSS VSS gf180mcu_fd_sc_mcu7t5v0__fill_2
XFILLER_74_857 VDD VDD VSS VSS gf180mcu_fd_sc_mcu7t5v0__fillcap_8
XTAP_TAPCELL_ROW_142_2222 VDD VSS gf180mcu_fd_sc_mcu7t5v0__filltie
XFILLER_73_367 VDD VDD VSS VSS gf180mcu_fd_sc_mcu7t5v0__fill_1
XTAP_TAPCELL_ROW_107_1641 VDD VSS gf180mcu_fd_sc_mcu7t5v0__filltie
Xwave_controller_y_inst__2716_ spi_regs_inst__1150_/A1 spi_regs_inst__1138_/B2 wave_controller_y_inst__2716_/Z
+ VDD VDD VSS VSS gf180mcu_fd_sc_mcu7t5v0__xor2_1
Xwave_controller_y_inst__3696_ wave_controller_y_inst__3696_/D wave_controller_y_inst__3696_/RN
+ clkload11/I wave_controller_y_inst__3696_/Q VDD VDD VSS VSS gf180mcu_fd_sc_mcu7t5v0__dffrnq_1
XFILLER_148_1151 VDD VDD VSS VSS gf180mcu_fd_sc_mcu7t5v0__fillcap_4
XFILLER_163_2 VDD VDD VSS VSS gf180mcu_fd_sc_mcu7t5v0__fillcap_64
Xwave_controller_y_inst__2647_ wave_controller_y_inst__2713_/A1 wave_controller_y_inst__2646_/B
+ spi_regs_inst__1238_/A1 VDD VDD VSS VSS gf180mcu_fd_sc_mcu7t5v0__xnor2_1
XTAP_TAPCELL_ROW_120_1852 VDD VSS gf180mcu_fd_sc_mcu7t5v0__filltie
XTAP_TAPCELL_ROW_120_1863 VDD VSS gf180mcu_fd_sc_mcu7t5v0__filltie
Xwave_controller_y_inst__2578_ wave_controller_y_inst__2607_/A1 wave_controller_y_inst__2578_/A2
+ spi_regs_inst_wire76/I VDD VDD VSS VSS gf180mcu_fd_sc_mcu7t5v0__xor2_1
XTAP_TAPCELL_ROW_3_1_356 VDD VSS gf180mcu_fd_sc_mcu7t5v0__filltie
Xspi_regs_inst__1170_ spi_regs_inst__1170_/A1 spi_regs_inst__1170_/A2 spi_regs_inst__1170_/A3
+ spi_regs_inst__1170_/A4 spi_regs_inst__1171_/A4 VDD VDD VSS VSS gf180mcu_fd_sc_mcu7t5v0__nand4_1
XFILLER_142_317 VDD VDD VSS VSS gf180mcu_fd_sc_mcu7t5v0__fillcap_8
XFILLER_143_818 VDD VDD VSS VSS gf180mcu_fd_sc_mcu7t5v0__fillcap_4
XFILLER_154_177 VDD VDD VSS VSS gf180mcu_fd_sc_mcu7t5v0__fillcap_16
XTAP_TAPCELL_ROW_153_2395 VDD VSS gf180mcu_fd_sc_mcu7t5v0__filltie
XFILLER_120_1081 VDD VDD VSS VSS gf180mcu_fd_sc_mcu7t5v0__fillcap_4
XFILLER_123_553 VDD VDD VSS VSS gf180mcu_fd_sc_mcu7t5v0__fillcap_4
XFILLER_155_1122 VDD VDD VSS VSS gf180mcu_fd_sc_mcu7t5v0__fillcap_32
XFILLER_69_629 VDD VDD VSS VSS gf180mcu_fd_sc_mcu7t5v0__fill_1
XFILLER_78_94 VDD VDD VSS VSS gf180mcu_fd_sc_mcu7t5v0__fillcap_8
XFILLER_96_437 VDD VDD VSS VSS gf180mcu_fd_sc_mcu7t5v0__fillcap_8
Xsignal_processor_y_inst__120_ fanout389/Z wave_controller_y_inst__3615_/Q signal_processor_y_inst__249_/D
+ VDD VDD VSS VSS gf180mcu_fd_sc_mcu7t5v0__and2_1
XFILLER_110_247 VDD VDD VSS VSS gf180mcu_fd_sc_mcu7t5v0__fill_2
XFILLER_96_459 VDD VDD VSS VSS gf180mcu_fd_sc_mcu7t5v0__fill_1
Xwave_controller_x_inst_wire183 wave_controller_x_inst_wire183/I wave_controller_x_inst_wire183/Z
+ VDD VDD VSS VSS gf180mcu_fd_sc_mcu7t5v0__buf_1
XFILLER_64_312 VDD VDD VSS VSS gf180mcu_fd_sc_mcu7t5v0__fill_2
XFILLER_65_846 VDD VDD VSS VSS gf180mcu_fd_sc_mcu7t5v0__fill_1
Xspi_regs_inst__0954_ spi_regs_inst__1032_/A1 spi_regs_inst__1019_/A1 spi_regs_inst__1292_/A2
+ VDD VDD VSS VSS gf180mcu_fd_sc_mcu7t5v0__nor2_1
XFILLER_92_676 VDD VDD VSS VSS gf180mcu_fd_sc_mcu7t5v0__fillcap_8
Xspi_regs_inst__0885_ spi_regs_inst__1619_/Q spi_regs_inst__1451_/I1 spi_regs_inst__0885_/S
+ spi_regs_inst__1619_/D VDD VDD VSS VSS gf180mcu_fd_sc_mcu7t5v0__mux2_2
XFILLER_91_186 VDD VDD VSS VSS gf180mcu_fd_sc_mcu7t5v0__fillcap_16
XFILLER_32_220 VDD VDD VSS VSS gf180mcu_fd_sc_mcu7t5v0__fillcap_4
Xspi_regs_inst__1506_ spi_regs_inst__1506_/D spi_regs_inst__1527_/RN clkload30/I spi_regs_inst__1506_/Q
+ VDD VDD VSS VSS gf180mcu_fd_sc_mcu7t5v0__dffrnq_1
XFILLER_119_804 VDD VDD VSS VSS gf180mcu_fd_sc_mcu7t5v0__fillcap_8
XFILLER_118_314 VDD VDD VSS VSS gf180mcu_fd_sc_mcu7t5v0__fill_1
XFILLER_119_826 VDD VDD VSS VSS gf180mcu_fd_sc_mcu7t5v0__fill_2
XFILLER_119_837 VDD VDD VSS VSS gf180mcu_fd_sc_mcu7t5v0__fill_2
XPHY_EDGE_ROW_48_1_Right_47 VDD VSS gf180mcu_fd_sc_mcu7t5v0__endcap
Xwave_controller_x_inst__2080_ wave_controller_x_inst__2125_/A2 wave_controller_x_inst__2092_/C
+ wave_controller_x_inst__2080_/B wave_controller_x_inst__2081_/A3 VDD VDD VSS VSS
+ gf180mcu_fd_sc_mcu7t5v0__aoi21_1
Xspi_regs_inst__1437_ spi_regs_inst__1437_/A1 spi_regs_inst__1437_/A2 spi_regs_inst__1437_/A3
+ spi_regs_inst_wire202/I VDD VDD VSS VSS gf180mcu_fd_sc_mcu7t5v0__nor3_2
XFILLER_134_807 VDD VDD VSS VSS gf180mcu_fd_sc_mcu7t5v0__fillcap_8
Xspi_regs_inst__1368_ spi_regs_inst__1368_/A1 spi_regs_inst__1379_/S spi_regs_inst__1368_/B
+ spi_regs_inst__1652_/D VDD VDD VSS VSS gf180mcu_fd_sc_mcu7t5v0__oai21_1
XFILLER_133_306 VDD VDD VSS VSS gf180mcu_fd_sc_mcu7t5v0__fill_1
XFILLER_146_667 VDD VDD VSS VSS gf180mcu_fd_sc_mcu7t5v0__fillcap_4
XTAP_TAPCELL_ROW_76_1128 VDD VSS gf180mcu_fd_sc_mcu7t5v0__filltie
XTAP_TAPCELL_ROW_76_1139 VDD VSS gf180mcu_fd_sc_mcu7t5v0__filltie
XFILLER_126_380 VDD VDD VSS VSS gf180mcu_fd_sc_mcu7t5v0__fillcap_4
Xspi_regs_inst__1299_ spi_regs_inst__1648_/Q spi_regs_inst__1362_/A1 spi_regs_inst__1330_/B
+ VDD VDD VSS VSS gf180mcu_fd_sc_mcu7t5v0__nand2_1
XFILLER_114_597 VDD VDD VSS VSS gf180mcu_fd_sc_mcu7t5v0__fillcap_16
Xwave_controller_x_inst__2982_ wave_controller_x_inst__2945_/Z wave_controller_x_inst__2985_/A2
+ wave_controller_x_inst__2985_/A3 wave_controller_x_inst__2983_/B VDD VDD VSS VSS
+ gf180mcu_fd_sc_mcu7t5v0__nor3_1
XFILLER_59_139 VDD VDD VSS VSS gf180mcu_fd_sc_mcu7t5v0__fill_1
Xwave_controller_x_inst__1933_ spi_regs_inst__1514_/Q wave_controller_x_inst__3080_/A1
+ wave_controller_x_inst__3266_/A1 spi_regs_inst__1511_/Q spi_regs_inst__1510_/Q wave_controller_x_inst__3312_/A1
+ wave_controller_x_inst__1938_/A1 VDD VDD VSS VSS gf180mcu_fd_sc_mcu7t5v0__aoi222_1
XFILLER_68_662 VDD VDD VSS VSS gf180mcu_fd_sc_mcu7t5v0__fill_2
Xwave_controller_y_inst__1880_ spi_regs_inst__1216_/B2 wave_controller_y_inst__3530_/B2
+ VDD VDD VSS VSS gf180mcu_fd_sc_mcu7t5v0__clkinv_1
Xwave_controller_x_inst__1864_ spi_regs_inst__1306_/A1 wave_controller_x_inst__2822_/A1
+ VDD VDD VSS VSS gf180mcu_fd_sc_mcu7t5v0__clkinv_1
Xsignal_processor_y_inst__249_ signal_processor_y_inst__249_/D signal_processor_y_inst__253_/RN
+ clkbuf_leaf_0_clk/Z signal_processor_y_inst__249_/Q VDD VDD VSS VSS gf180mcu_fd_sc_mcu7t5v0__dffrnq_1
XFILLER_110_792 VDD VDD VSS VSS gf180mcu_fd_sc_mcu7t5v0__fill_1
XFILLER_83_632 VDD VDD VSS VSS gf180mcu_fd_sc_mcu7t5v0__fillcap_16
XFILLER_95_492 VDD VDD VSS VSS gf180mcu_fd_sc_mcu7t5v0__fill_2
XTAP_TAPCELL_ROW_27_1_535 VDD VSS gf180mcu_fd_sc_mcu7t5v0__filltie
Xwave_controller_x_inst__3603_ spi_regs_inst__1068_/B2 wave_controller_x_inst__3602_/S
+ wave_controller_x_inst__3604_/B VDD VDD VSS VSS gf180mcu_fd_sc_mcu7t5v0__nand2_1
XFILLER_82_131 VDD VDD VSS VSS gf180mcu_fd_sc_mcu7t5v0__fillcap_4
Xwave_controller_y_inst__3550_ spi_regs_inst__1138_/B2 wave_controller_y_inst__3556_/A2
+ wave_controller_y_inst__3551_/A3 VDD VDD VSS VSS gf180mcu_fd_sc_mcu7t5v0__nor2_1
Xwave_controller_x_inst__3534_ wave_controller_x_inst__3714_/Q wave_controller_x_inst__3555_/A2
+ wave_controller_x_inst__3536_/A2 VDD VDD VSS VSS gf180mcu_fd_sc_mcu7t5v0__nor2_1
Xwave_controller_x_inst__1795_ wave_controller_x_inst__3705_/Q wave_controller_x_inst__3290_/A1
+ VDD VDD VSS VSS gf180mcu_fd_sc_mcu7t5v0__clkinv_1
XFILLER_71_838 VDD VDD VSS VSS gf180mcu_fd_sc_mcu7t5v0__fill_2
XTAP_TAPCELL_ROW_35_1_592 VDD VSS gf180mcu_fd_sc_mcu7t5v0__filltie
Xwave_controller_y_inst__2501_ wave_controller_y_inst__2501_/A1 wave_controller_y_inst__2501_/A2
+ wave_controller_y_inst__2501_/B wave_controller_y_inst__2504_/A3 VDD VDD VSS VSS
+ gf180mcu_fd_sc_mcu7t5v0__oai21_1
Xwave_controller_y_inst__3481_ wave_controller_y_inst__3485_/B wave_controller_y_inst__3478_/I
+ wave_controller_y_inst__3491_/B wave_controller_y_inst__3482_/B2 VDD VDD VSS VSS
+ gf180mcu_fd_sc_mcu7t5v0__oai21_1
XFILLER_90_18 VDD VDD VSS VSS gf180mcu_fd_sc_mcu7t5v0__fillcap_4
Xwave_controller_y_inst__2432_ wave_controller_y_inst__2432_/I wave_controller_y_inst__2446_/A1
+ VDD VDD VSS VSS gf180mcu_fd_sc_mcu7t5v0__clkinv_1
Xwave_controller_x_inst__3465_ wave_controller_x_inst__3454_/B wave_controller_x_inst__3465_/A2
+ wave_controller_x_inst__3465_/A3 wave_controller_x_inst__3465_/B wave_controller_x_inst__3470_/C
+ VDD VDD VSS VSS gf180mcu_fd_sc_mcu7t5v0__oai31_1
XFILLER_11_415 VDD VDD VSS VSS gf180mcu_fd_sc_mcu7t5v0__fill_1
Xwave_controller_x_inst__3396_ wave_controller_x_inst__3396_/A1 wave_controller_x_inst__3357_/Z
+ wave_controller_x_inst__3396_/A3 wave_controller_x_inst__3396_/B wave_controller_x_inst__3401_/A2
+ VDD VDD VSS VSS gf180mcu_fd_sc_mcu7t5v0__oai31_1
Xwave_controller_x_inst__2416_ fanout532/Z wave_controller_x_inst__2411_/Z wave_controller_x_inst__2416_/A3
+ wave_controller_x_inst__2416_/Z VDD VDD VSS VSS gf180mcu_fd_sc_mcu7t5v0__xor3_1
Xsignal_processor_x_inst__140_ signal_processor_x_inst__237_/Q signal_processor_x_inst__140_/A2
+ signal_processor_x_inst__193_/C VDD VDD VSS VSS gf180mcu_fd_sc_mcu7t5v0__xor2_1
XTAP_TAPCELL_ROW_102_1560 VDD VSS gf180mcu_fd_sc_mcu7t5v0__filltie
Xwave_controller_y_inst__2363_ spi_regs_inst__1333_/B2 max_cap425/Z wave_controller_y_inst__2363_/Z
+ VDD VDD VSS VSS gf180mcu_fd_sc_mcu7t5v0__xor2_1
Xwave_controller_x_inst__2347_ wave_controller_x_inst__2373_/A1 wave_controller_x_inst_wire78/Z
+ spi_regs_inst__1247_/B2 VDD VDD VSS VSS gf180mcu_fd_sc_mcu7t5v0__xor2_1
XFILLER_7_419 VDD VDD VSS VSS gf180mcu_fd_sc_mcu7t5v0__fill_1
Xwave_controller_y_inst__2294_ wave_controller_y_inst__2294_/A1 wave_controller_y_inst__2294_/A2
+ wave_controller_y_inst__2293_/B wave_controller_y_inst__2294_/Z VDD VDD VSS VSS
+ gf180mcu_fd_sc_mcu7t5v0__and3_1
XFILLER_139_67 VDD VDD VSS VSS gf180mcu_fd_sc_mcu7t5v0__fill_2
Xwave_controller_x_inst__2278_ fanout524/Z wave_controller_x_inst__2261_/Z wave_controller_x_inst__2278_/B
+ wave_controller_x_inst__2280_/A2 VDD VDD VSS VSS gf180mcu_fd_sc_mcu7t5v0__oai21_1
XFILLER_104_1087 VDD VDD VSS VSS gf180mcu_fd_sc_mcu7t5v0__fillcap_64
XFILLER_125_829 VDD VDD VSS VSS gf180mcu_fd_sc_mcu7t5v0__fillcap_4
XFILLER_165_976 VDD VDD VSS VSS gf180mcu_fd_sc_mcu7t5v0__fillcap_4
XFILLER_99_49 VDD VDD VSS VSS gf180mcu_fd_sc_mcu7t5v0__fillcap_16
XFILLER_118_881 VDD VDD VSS VSS gf180mcu_fd_sc_mcu7t5v0__fill_1
XFILLER_124_317 VDD VDD VSS VSS gf180mcu_fd_sc_mcu7t5v0__fill_2
XFILLER_136_177 VDD VDD VSS VSS gf180mcu_fd_sc_mcu7t5v0__fill_2
XFILLER_151_114 VDD VDD VSS VSS gf180mcu_fd_sc_mcu7t5v0__fill_2
XFILLER_155_22 VDD VDD VSS VSS gf180mcu_fd_sc_mcu7t5v0__fill_2
Xwave_controller_y_inst_fanout500 fanout501/Z wave_controller_y_inst__1823_/I VDD
+ VDD VSS VSS gf180mcu_fd_sc_mcu7t5v0__dlyb_1
XFILLER_151_147 VDD VDD VSS VSS gf180mcu_fd_sc_mcu7t5v0__fill_1
XFILLER_132_372 VDD VDD VSS VSS gf180mcu_fd_sc_mcu7t5v0__fill_1
XFILLER_133_895 VDD VDD VSS VSS gf180mcu_fd_sc_mcu7t5v0__fill_2
Xwave_controller_y_inst_fanout577 fanout580/Z wave_controller_y_inst__3708_/RN VDD
+ VDD VSS VSS gf180mcu_fd_sc_mcu7t5v0__dlyb_1
XFILLER_132_383 VDD VDD VSS VSS gf180mcu_fd_sc_mcu7t5v0__fill_2
XFILLER_48_31 VDD VDD VSS VSS gf180mcu_fd_sc_mcu7t5v0__fillcap_4
XFILLER_120_567 VDD VDD VSS VSS gf180mcu_fd_sc_mcu7t5v0__fill_1
XFILLER_120_589 VDD VDD VSS VSS gf180mcu_fd_sc_mcu7t5v0__fill_2
XFILLER_87_982 VDD VDD VSS VSS gf180mcu_fd_sc_mcu7t5v0__fillcap_64
XFILLER_46_312 VDD VDD VSS VSS gf180mcu_fd_sc_mcu7t5v0__fill_2
XFILLER_100_291 VDD VDD VSS VSS gf180mcu_fd_sc_mcu7t5v0__fill_1
XFILLER_73_131 VDD VDD VSS VSS gf180mcu_fd_sc_mcu7t5v0__fillcap_8
XFILLER_61_304 VDD VDD VSS VSS gf180mcu_fd_sc_mcu7t5v0__fill_1
XFILLER_62_849 VDD VDD VSS VSS gf180mcu_fd_sc_mcu7t5v0__fillcap_16
Xspi_regs_inst_max_cap310 spi_regs_inst__0797_/S spi_regs_inst__0795_/S VDD VDD VSS
+ VSS gf180mcu_fd_sc_mcu7t5v0__buf_3
XFILLER_64_96 VDD VDD VSS VSS gf180mcu_fd_sc_mcu7t5v0__fillcap_8
Xwave_controller_y_inst__3679_ wave_controller_y_inst__3679_/D load_slew576/Z clkbuf_leaf_41_clk/Z
+ spi_regs_inst__1109_/A1 VDD VDD VSS VSS gf180mcu_fd_sc_mcu7t5v0__dffrnq_1
XFILLER_42_551 VDD VDD VSS VSS gf180mcu_fd_sc_mcu7t5v0__fillcap_4
Xspi_regs_inst_max_cap387 spi_regs_inst__0798_/A3 spi_regs_inst__1385_/A2 VDD VDD
+ VSS VSS gf180mcu_fd_sc_mcu7t5v0__clkbuf_1
XFILLER_161_1170 VDD VDD VSS VSS gf180mcu_fd_sc_mcu7t5v0__fillcap_4
XTAP_TAPCELL_ROW_155_2435 VDD VSS gf180mcu_fd_sc_mcu7t5v0__filltie
XFILLER_127_111 VDD VDD VSS VSS gf180mcu_fd_sc_mcu7t5v0__fillcap_16
XFILLER_80_95 VDD VDD VSS VSS gf180mcu_fd_sc_mcu7t5v0__fillcap_4
Xspi_regs_inst__1222_ spi_regs_inst__1644_/Q spi_regs_inst__1074_/Z spi_regs_inst__1223_/A3
+ VDD VDD VSS VSS gf180mcu_fd_sc_mcu7t5v0__nor2_1
XFILLER_116_807 VDD VDD VSS VSS gf180mcu_fd_sc_mcu7t5v0__fillcap_8
XFILLER_128_667 VDD VDD VSS VSS gf180mcu_fd_sc_mcu7t5v0__fillcap_32
Xspi_regs_inst__1153_ spi_regs_inst__1153_/A1 spi_regs_inst__1153_/A2 spi_regs_inst__1153_/A3
+ spi_regs_inst__1172_/A3 VDD VDD VSS VSS gf180mcu_fd_sc_mcu7t5v0__nor3_1
XFILLER_143_648 VDD VDD VSS VSS gf180mcu_fd_sc_mcu7t5v0__fillcap_8
XFILLER_142_147 VDD VDD VSS VSS gf180mcu_fd_sc_mcu7t5v0__fill_2
XFILLER_97_702 VDD VDD VSS VSS gf180mcu_fd_sc_mcu7t5v0__fillcap_4
Xspi_regs_inst__1084_ spi_regs_inst__1084_/A1 spi_regs_inst__1084_/A2 spi_regs_inst__1113_/A1
+ VDD VDD VSS VSS gf180mcu_fd_sc_mcu7t5v0__nand2_1
XFILLER_111_501 VDD VDD VSS VSS gf180mcu_fd_sc_mcu7t5v0__fill_2
XFILLER_123_372 VDD VDD VSS VSS gf180mcu_fd_sc_mcu7t5v0__fill_2
XFILLER_124_873 VDD VDD VSS VSS gf180mcu_fd_sc_mcu7t5v0__fill_2
XFILLER_111_556 VDD VDD VSS VSS gf180mcu_fd_sc_mcu7t5v0__fillcap_4
XFILLER_96_234 VDD VDD VSS VSS gf180mcu_fd_sc_mcu7t5v0__fill_1
XTAP_TAPCELL_ROW_71_1047 VDD VSS gf180mcu_fd_sc_mcu7t5v0__filltie
XFILLER_49_183 VDD VDD VSS VSS gf180mcu_fd_sc_mcu7t5v0__fill_2
XFILLER_65_632 VDD VDD VSS VSS gf180mcu_fd_sc_mcu7t5v0__fillcap_4
XFILLER_77_492 VDD VDD VSS VSS gf180mcu_fd_sc_mcu7t5v0__fillcap_16
Xspi_regs_inst__0937_ spi_regs_inst__1639_/Q spi_regs_inst__1638_/Q spi_regs_inst__0937_/S
+ spi_regs_inst__1639_/D VDD VDD VSS VSS gf180mcu_fd_sc_mcu7t5v0__mux2_2
XFILLER_65_698 VDD VDD VSS VSS gf180mcu_fd_sc_mcu7t5v0__fill_2
XFILLER_80_657 VDD VDD VSS VSS gf180mcu_fd_sc_mcu7t5v0__fillcap_8
XTAP_TAPCELL_ROW_86_1290 VDD VSS gf180mcu_fd_sc_mcu7t5v0__filltie
Xspi_regs_inst__0868_ spi_regs_inst__1604_/Q spi_regs_inst__1443_/I1 spi_regs_inst__0868_/S
+ spi_regs_inst__1604_/D VDD VDD VSS VSS gf180mcu_fd_sc_mcu7t5v0__mux2_2
XFILLER_100_17 VDD VDD VSS VSS gf180mcu_fd_sc_mcu7t5v0__fillcap_4
XFILLER_166_1081 VDD VDD VSS VSS gf180mcu_fd_sc_mcu7t5v0__fillcap_4
XFILLER_61_860 VDD VDD VSS VSS gf180mcu_fd_sc_mcu7t5v0__fillcap_8
Xwave_controller_x_inst__3250_ wave_controller_x_inst__3184_/Z wave_controller_x_inst__3250_/A2
+ wave_controller_x_inst__3250_/Z VDD VDD VSS VSS gf180mcu_fd_sc_mcu7t5v0__xor2_1
Xspi_regs_inst__0799_ spi_regs_inst__1438_/I1 spi_regs_inst__1549_/Q spi_regs_inst__0803_/S
+ spi_regs_inst__1549_/D VDD VDD VSS VSS gf180mcu_fd_sc_mcu7t5v0__mux2_2
XFILLER_100_39 VDD VDD VSS VSS gf180mcu_fd_sc_mcu7t5v0__fill_1
Xwave_controller_x_inst__2201_ wave_controller_x_inst__2201_/A1 wave_controller_x_inst__2201_/A2
+ wave_controller_x_inst__2201_/B wave_controller_x_inst__2213_/A3 VDD VDD VSS VSS
+ gf180mcu_fd_sc_mcu7t5v0__aoi21_1
Xwave_controller_x_inst__3181_ wave_controller_x_inst__1778_/I wave_controller_x_inst__3181_/A2
+ wave_controller_x_inst__3182_/B VDD VDD VSS VSS gf180mcu_fd_sc_mcu7t5v0__nor2_1
XFILLER_119_623 VDD VDD VSS VSS gf180mcu_fd_sc_mcu7t5v0__fillcap_4
XFILLER_119_656 VDD VDD VSS VSS gf180mcu_fd_sc_mcu7t5v0__fill_1
XFILLER_146_431 VDD VDD VSS VSS gf180mcu_fd_sc_mcu7t5v0__fill_2
Xwave_controller_x_inst__2132_ wave_controller_x_inst__2132_/A1 wave_controller_x_inst__2132_/A2
+ wave_controller_x_inst__2134_/A2 VDD VDD VSS VSS gf180mcu_fd_sc_mcu7t5v0__nor2_1
XFILLER_118_155 VDD VDD VSS VSS gf180mcu_fd_sc_mcu7t5v0__fillcap_8
XFILLER_134_615 VDD VDD VSS VSS gf180mcu_fd_sc_mcu7t5v0__fill_1
XFILLER_147_976 VDD VDD VSS VSS gf180mcu_fd_sc_mcu7t5v0__fillcap_4
Xwave_controller_x_inst__2063_ fanout498/Z wave_controller_x_inst__3612_/Q wave_controller_x_inst__2065_/A2
+ VDD VDD VSS VSS gf180mcu_fd_sc_mcu7t5v0__nand2_1
XFILLER_118_177 VDD VDD VSS VSS gf180mcu_fd_sc_mcu7t5v0__fillcap_16
XFILLER_133_114 VDD VDD VSS VSS gf180mcu_fd_sc_mcu7t5v0__fill_2
XFILLER_133_136 VDD VDD VSS VSS gf180mcu_fd_sc_mcu7t5v0__fillcap_4
XFILLER_88_713 VDD VDD VSS VSS gf180mcu_fd_sc_mcu7t5v0__fill_2
Xspi_regs_inst_wire476 spi_regs_inst__1661_/Q spi_regs_inst_wire476/Z VDD VDD VSS
+ VSS gf180mcu_fd_sc_mcu7t5v0__buf_3
Xwave_controller_y_inst__2981_ wave_controller_y_inst__1790_/I wave_controller_y_inst__1821_/I
+ wave_controller_y_inst__2981_/B wave_controller_y_inst__3068_/A3 VDD VDD VSS VSS
+ gf180mcu_fd_sc_mcu7t5v0__oai21_1
Xwave_controller_x_inst__2965_ wave_controller_x_inst__2965_/A1 wave_controller_x_inst__3043_/A3
+ wave_controller_x_inst__2965_/B wave_controller_x_inst__3045_/B VDD VDD VSS VSS
+ gf180mcu_fd_sc_mcu7t5v0__oai21_1
Xspi_regs_inst_wire487 spi_regs_inst_wire487/I spi_regs_inst_wire487/Z VDD VDD VSS
+ VSS gf180mcu_fd_sc_mcu7t5v0__buf_4
XFILLER_69_982 VDD VDD VSS VSS gf180mcu_fd_sc_mcu7t5v0__fillcap_64
XFILLER_85_18 VDD VDD VSS VSS gf180mcu_fd_sc_mcu7t5v0__fillcap_8
Xwave_controller_y_inst__1932_ wave_controller_y_inst__1932_/A1 wave_controller_y_inst__1932_/A2
+ wave_controller_y_inst__1941_/A1 VDD VDD VSS VSS gf180mcu_fd_sc_mcu7t5v0__nor2_1
Xwave_controller_x_inst__1916_ spi_regs_inst__1501_/Q wave_controller_x_inst__3562_/A1
+ wave_controller_x_inst__1919_/B VDD VDD VSS VSS gf180mcu_fd_sc_mcu7t5v0__nand2_1
XFILLER_18_34 VDD VDD VSS VSS gf180mcu_fd_sc_mcu7t5v0__fill_1
XFILLER_56_621 VDD VDD VSS VSS gf180mcu_fd_sc_mcu7t5v0__fill_1
XFILLER_56_632 VDD VDD VSS VSS gf180mcu_fd_sc_mcu7t5v0__fillcap_8
XFILLER_84_941 VDD VDD VSS VSS gf180mcu_fd_sc_mcu7t5v0__fillcap_4
Xwave_controller_y_inst__1863_ spi_regs_inst__1275_/B2 wave_controller_y_inst__2831_/A1
+ VDD VDD VSS VSS gf180mcu_fd_sc_mcu7t5v0__clkinv_1
Xwave_controller_x_inst__2896_ wave_controller_x_inst__2910_/B wave_controller_x_inst__2764_/Z
+ wave_controller_x_inst__2896_/B wave_controller_x_inst__2902_/A3 VDD VDD VSS VSS
+ gf180mcu_fd_sc_mcu7t5v0__aoi21_1
XFILLER_16_507 VDD VDD VSS VSS gf180mcu_fd_sc_mcu7t5v0__fillcap_8
XFILLER_28_356 VDD VDD VSS VSS gf180mcu_fd_sc_mcu7t5v0__fillcap_8
XFILLER_55_142 VDD VDD VSS VSS gf180mcu_fd_sc_mcu7t5v0__fillcap_8
XTAP_TAPCELL_ROW_2_1_344 VDD VSS gf180mcu_fd_sc_mcu7t5v0__filltie
Xwave_controller_y_inst__3602_ wave_controller_y_inst__3602_/I0 spi_regs_inst__1354_/A1
+ wave_controller_y_inst__3602_/S wave_controller_y_inst__3677_/D VDD VDD VSS VSS
+ gf180mcu_fd_sc_mcu7t5v0__mux2_2
Xwave_controller_x_inst__1847_ spi_regs_inst__1108_/B2 wave_controller_x_inst__2399_/A1
+ VDD VDD VSS VSS gf180mcu_fd_sc_mcu7t5v0__clkinv_1
XFILLER_71_602 VDD VDD VSS VSS gf180mcu_fd_sc_mcu7t5v0__fill_2
XFILLER_83_484 VDD VDD VSS VSS gf180mcu_fd_sc_mcu7t5v0__fillcap_4
XTAP_TAPCELL_ROW_104_1600 VDD VSS gf180mcu_fd_sc_mcu7t5v0__filltie
Xwave_controller_y_inst__1794_ wave_controller_y_inst__3706_/Q wave_controller_y_inst__3568_/A1
+ VDD VDD VSS VSS gf180mcu_fd_sc_mcu7t5v0__clkinv_1
Xwave_controller_x_inst__1778_ wave_controller_x_inst__1778_/I wave_controller_x_inst__3081_/B
+ VDD VDD VSS VSS gf180mcu_fd_sc_mcu7t5v0__clkinv_1
XFILLER_58_1151 VDD VDD VSS VSS gf180mcu_fd_sc_mcu7t5v0__fillcap_4
Xwave_controller_y_inst__3533_ wave_controller_y_inst__3557_/A1 wave_controller_y_inst__3533_/A2
+ wave_controller_y_inst__3533_/A3 wave_controller_y_inst__3557_/B1 wave_controller_y_inst__3533_/B2
+ wave_controller_y_inst__3640_/D VDD VDD VSS VSS gf180mcu_fd_sc_mcu7t5v0__oai32_1
Xwave_controller_x_inst__3517_ spi_regs_inst__1332_/A1 wave_controller_x_inst__3538_/A2
+ wave_controller_x_inst__3518_/A3 VDD VDD VSS VSS gf180mcu_fd_sc_mcu7t5v0__nor2_1
XFILLER_58_1173 VDD VDD VSS VSS gf180mcu_fd_sc_mcu7t5v0__fill_1
Xwave_controller_y_inst__3464_ spi_regs_inst__1270_/A1 wave_controller_y_inst_wire352/Z
+ wave_controller_y_inst__3465_/A3 VDD VDD VSS VSS gf180mcu_fd_sc_mcu7t5v0__nor2_1
Xwave_controller_x_inst__3448_ spi_regs_inst__1197_/B2 wave_controller_x_inst__3454_/A2
+ wave_controller_x_inst__3449_/C VDD VDD VSS VSS gf180mcu_fd_sc_mcu7t5v0__nor2_1
XFILLER_11_212 VDD VDD VSS VSS gf180mcu_fd_sc_mcu7t5v0__fillcap_64
XFILLER_145_1154 VDD VDD VSS VSS gf180mcu_fd_sc_mcu7t5v0__fillcap_16
XTAP_TAPCELL_ROW_100_1519 VDD VSS gf180mcu_fd_sc_mcu7t5v0__filltie
Xwave_controller_y_inst__2415_ fanout511/Z wave_controller_y_inst__2414_/Z wave_controller_y_inst__2430_/A1
+ VDD VDD VSS VSS gf180mcu_fd_sc_mcu7t5v0__nor2_1
Xsignal_processor_x_inst__123_ signal_processor_x_inst__108_/I signal_processor_x_inst__251_/Q
+ signal_processor_x_inst__252_/D VDD VDD VSS VSS gf180mcu_fd_sc_mcu7t5v0__and2_1
XTAP_TAPCELL_ROW_137_2132 VDD VSS gf180mcu_fd_sc_mcu7t5v0__filltie
XTAP_TAPCELL_ROW_137_2143 VDD VSS gf180mcu_fd_sc_mcu7t5v0__filltie
Xwave_controller_y_inst__3395_ wave_controller_y_inst__3395_/A1 wave_controller_y_inst__3395_/A2
+ wave_controller_y_inst__3395_/B wave_controller_y_inst__3396_/A3 VDD VDD VSS VSS
+ gf180mcu_fd_sc_mcu7t5v0__aoi21_1
Xwave_controller_x_inst__3379_ wave_controller_x_inst__3278_/Z wave_controller_x_inst__3377_/B
+ wave_controller_x_inst__3285_/I wave_controller_x_inst__3381_/A2 VDD VDD VSS VSS
+ gf180mcu_fd_sc_mcu7t5v0__nor3_1
XFILLER_126_2 VDD VDD VSS VSS gf180mcu_fd_sc_mcu7t5v0__fillcap_4
Xwave_controller_y_inst__2346_ wave_controller_y_inst__2346_/A1 wave_controller_y_inst__2346_/A2
+ wave_controller_y_inst__2346_/B wave_controller_y_inst__2397_/A1 VDD VDD VSS VSS
+ gf180mcu_fd_sc_mcu7t5v0__aoi21_1
Xwave_controller_y_inst__2277_ spi_regs_inst__1034_/A1 wave_controller_y_inst__2275_/Z
+ wave_controller_y_inst__2277_/Z VDD VDD VSS VSS gf180mcu_fd_sc_mcu7t5v0__xor2_1
XFILLER_3_400 VDD VDD VSS VSS gf180mcu_fd_sc_mcu7t5v0__fillcap_4
XFILLER_50_98 VDD VDD VSS VSS gf180mcu_fd_sc_mcu7t5v0__fill_2
XTAP_TAPCELL_ROW_150_2354 VDD VSS gf180mcu_fd_sc_mcu7t5v0__filltie
XFILLER_106_851 VDD VDD VSS VSS gf180mcu_fd_sc_mcu7t5v0__fillcap_8
XTAP_TAPCELL_ROW_40_1_633 VDD VSS gf180mcu_fd_sc_mcu7t5v0__filltie
XFILLER_106_884 VDD VDD VSS VSS gf180mcu_fd_sc_mcu7t5v0__fill_1
XFILLER_152_489 VDD VDD VSS VSS gf180mcu_fd_sc_mcu7t5v0__fillcap_16
XFILLER_65_1122 VDD VDD VSS VSS gf180mcu_fd_sc_mcu7t5v0__fillcap_32
XFILLER_79_702 VDD VDD VSS VSS gf180mcu_fd_sc_mcu7t5v0__fillcap_8
XTAP_TAPCELL_ROW_115_1773 VDD VSS gf180mcu_fd_sc_mcu7t5v0__filltie
Xwave_controller_y_inst_fanout363 wave_controller_y_inst__1911_/ZN wave_controller_y_inst__3485_/B
+ VDD VDD VSS VSS gf180mcu_fd_sc_mcu7t5v0__dlyb_1
XFILLER_59_63 VDD VDD VSS VSS gf180mcu_fd_sc_mcu7t5v0__fill_1
XFILLER_79_746 VDD VDD VSS VSS gf180mcu_fd_sc_mcu7t5v0__fill_2
XFILLER_152_1169 VDD VDD VSS VSS gf180mcu_fd_sc_mcu7t5v0__fill_1
XFILLER_59_96 VDD VDD VSS VSS gf180mcu_fd_sc_mcu7t5v0__fillcap_16
XFILLER_94_716 VDD VDD VSS VSS gf180mcu_fd_sc_mcu7t5v0__fill_2
XFILLER_59_492 VDD VDD VSS VSS gf180mcu_fd_sc_mcu7t5v0__fillcap_32
XFILLER_19_345 VDD VDD VSS VSS gf180mcu_fd_sc_mcu7t5v0__fillcap_4
XFILLER_75_952 VDD VDD VSS VSS gf180mcu_fd_sc_mcu7t5v0__fillcap_16
XFILLER_74_473 VDD VDD VSS VSS gf180mcu_fd_sc_mcu7t5v0__fillcap_4
XFILLER_46_197 VDD VDD VSS VSS gf180mcu_fd_sc_mcu7t5v0__fill_2
XFILLER_15_540 VDD VDD VSS VSS gf180mcu_fd_sc_mcu7t5v0__fillcap_8
XFILLER_61_167 VDD VDD VSS VSS gf180mcu_fd_sc_mcu7t5v0__fillcap_16
XFILLER_91_72 VDD VDD VSS VSS gf180mcu_fd_sc_mcu7t5v0__fillcap_16
XFILLER_30_543 VDD VDD VSS VSS gf180mcu_fd_sc_mcu7t5v0__fillcap_8
XTAP_TAPCELL_ROW_60_869 VDD VSS gf180mcu_fd_sc_mcu7t5v0__filltie
XFILLER_128_431 VDD VDD VSS VSS gf180mcu_fd_sc_mcu7t5v0__fillcap_4
XFILLER_129_976 VDD VDD VSS VSS gf180mcu_fd_sc_mcu7t5v0__fillcap_4
XFILLER_162_209 VDD VDD VSS VSS gf180mcu_fd_sc_mcu7t5v0__fill_2
XTAP_TAPCELL_ROW_26_1_523 VDD VSS gf180mcu_fd_sc_mcu7t5v0__filltie
Xspi_regs_inst__1205_ spi_regs_inst__1205_/A1 spi_regs_inst__1205_/A2 spi_regs_inst__1205_/A3
+ spi_regs_inst__1205_/A4 spi_regs_inst__1206_/A2 VDD VDD VSS VSS gf180mcu_fd_sc_mcu7t5v0__nand4_1
Xmax_cap425 max_cap425/I max_cap425/Z VDD VDD VSS VSS gf180mcu_fd_sc_mcu7t5v0__buf_3
Xspi_regs_inst__1136_ spi_regs_inst__1517_/Q spi_regs_inst__1136_/A2 spi_regs_inst__1200_/A2
+ spi_regs_inst_wire29/Z spi_regs_inst__1137_/A3 VDD VDD VSS VSS gf180mcu_fd_sc_mcu7t5v0__aoi22_1
Xmax_cap458 max_cap458/I max_cap458/Z VDD VDD VSS VSS gf180mcu_fd_sc_mcu7t5v0__buf_4
XFILLER_143_489 VDD VDD VSS VSS gf180mcu_fd_sc_mcu7t5v0__fill_1
XFILLER_41_2 VDD VDD VSS VSS gf180mcu_fd_sc_mcu7t5v0__fillcap_8
Xspi_regs_inst__1067_ spi_regs_inst__1067_/A1 spi_regs_inst__1067_/A2 spi_regs_inst__1067_/A3
+ spi_regs_inst__1067_/A4 spi_regs_inst__1071_/A3 VDD VDD VSS VSS gf180mcu_fd_sc_mcu7t5v0__nand4_1
XFILLER_124_681 VDD VDD VSS VSS gf180mcu_fd_sc_mcu7t5v0__fill_1
XFILLER_97_543 VDD VDD VSS VSS gf180mcu_fd_sc_mcu7t5v0__fillcap_16
XFILLER_57_407 VDD VDD VSS VSS gf180mcu_fd_sc_mcu7t5v0__fill_2
Xwave_controller_x_inst__2750_ wave_controller_x_inst__2748_/Z wave_controller_x_inst__2750_/A2
+ spi_regs_inst__1189_/A1 VDD VDD VSS VSS gf180mcu_fd_sc_mcu7t5v0__xor2_1
XFILLER_37_142 VDD VDD VSS VSS gf180mcu_fd_sc_mcu7t5v0__fill_2
XFILLER_84_259 VDD VDD VSS VSS gf180mcu_fd_sc_mcu7t5v0__fill_2
XTAP_TAPCELL_ROW_88_1330 VDD VSS gf180mcu_fd_sc_mcu7t5v0__filltie
Xwave_controller_x_inst__2681_ wave_controller_x_inst__2681_/A1 wave_controller_x_inst__2681_/A2
+ wave_controller_x_inst__2681_/B wave_controller_x_inst__2681_/C wave_controller_x_inst__2683_/A2
+ VDD VDD VSS VSS gf180mcu_fd_sc_mcu7t5v0__oai211_1
XFILLER_37_153 VDD VDD VSS VSS gf180mcu_fd_sc_mcu7t5v0__fillcap_4
XFILLER_65_462 VDD VDD VSS VSS gf180mcu_fd_sc_mcu7t5v0__fill_1
XFILLER_81_922 VDD VDD VSS VSS gf180mcu_fd_sc_mcu7t5v0__fillcap_4
XFILLER_129_1116 VDD VDD VSS VSS gf180mcu_fd_sc_mcu7t5v0__fillcap_4
XFILLER_80_454 VDD VDD VSS VSS gf180mcu_fd_sc_mcu7t5v0__fill_1
XFILLER_81_977 VDD VDD VSS VSS gf180mcu_fd_sc_mcu7t5v0__fill_2
Xwave_controller_x_inst__3302_ wave_controller_x_inst__3364_/A2 wave_controller_x_inst__3301_/Z
+ wave_controller_x_inst__3303_/A3 VDD VDD VSS VSS gf180mcu_fd_sc_mcu7t5v0__nor2_1
XFILLER_21_554 VDD VDD VSS VSS gf180mcu_fd_sc_mcu7t5v0__fill_1
Xwave_controller_y_inst__2200_ wave_controller_y_inst__2201_/A1 wave_controller_y_inst__2201_/A2
+ wave_controller_y_inst__2201_/B wave_controller_y_inst__2213_/B VDD VDD VSS VSS
+ gf180mcu_fd_sc_mcu7t5v0__nand3_1
Xwave_controller_x_inst__3233_ fanout530/I wave_controller_x_inst__3233_/A2 wave_controller_x_inst__3233_/B1
+ fanout529/Z wave_controller_x_inst__3233_/C wave_controller_x_inst__3234_/B2 VDD
+ VDD VSS VSS gf180mcu_fd_sc_mcu7t5v0__aoi221_1
Xwave_controller_y_inst__3180_ wave_controller_y_inst__3004_/B spi_regs_inst__1579_/Q
+ spi_regs_inst__1578_/Q wave_controller_y_inst__3181_/A2 VDD VDD VSS VSS gf180mcu_fd_sc_mcu7t5v0__oai21_1
Xwave_controller_x_inst__3164_ wave_controller_x_inst__3164_/A1 wave_controller_x_inst__3164_/A2
+ wave_controller_x_inst__3164_/Z VDD VDD VSS VSS gf180mcu_fd_sc_mcu7t5v0__and2_1
XFILLER_119_442 VDD VDD VSS VSS gf180mcu_fd_sc_mcu7t5v0__fillcap_8
XFILLER_119_464 VDD VDD VSS VSS gf180mcu_fd_sc_mcu7t5v0__fill_1
Xwave_controller_y_inst__2131_ wave_controller_y_inst__2145_/I1 wave_controller_y_inst__2131_/A2
+ wave_controller_y_inst__2132_/A2 VDD VDD VSS VSS gf180mcu_fd_sc_mcu7t5v0__xnor2_1
Xwave_controller_x_inst__2115_ wave_controller_x_inst__2072_/B wave_controller_x_inst__2144_/B
+ wave_controller_x_inst__2116_/B1 VDD VDD VSS VSS gf180mcu_fd_sc_mcu7t5v0__nor2_1
XFILLER_101_1046 VDD VDD VSS VSS gf180mcu_fd_sc_mcu7t5v0__fillcap_4
XFILLER_106_103 VDD VDD VSS VSS gf180mcu_fd_sc_mcu7t5v0__fill_2
XFILLER_134_412 VDD VDD VSS VSS gf180mcu_fd_sc_mcu7t5v0__fill_1
Xwave_controller_y_inst__2062_ wave_controller_y_inst__2144_/B wave_controller_y_inst__2062_/A2
+ wave_controller_y_inst__2062_/A3 wave_controller_y_inst__2062_/B1 wave_controller_y_inst__2062_/B2
+ wave_controller_y_inst_wire156/I VDD VDD VSS VSS gf180mcu_fd_sc_mcu7t5v0__oai32_1
Xwave_controller_x_inst__3095_ wave_controller_x_inst__3101_/A1 wave_controller_x_inst__3614_/Q
+ wave_controller_x_inst__3612_/Q wave_controller_x_inst__3096_/A2 VDD VDD VSS VSS
+ gf180mcu_fd_sc_mcu7t5v0__oai21_1
XTAP_TAPCELL_ROW_132_2051 VDD VSS gf180mcu_fd_sc_mcu7t5v0__filltie
XTAP_TAPCELL_ROW_132_2062 VDD VSS gf180mcu_fd_sc_mcu7t5v0__filltie
Xwave_controller_x_inst__2046_ wave_controller_x_inst__2125_/C wave_controller_x_inst__2107_/B
+ wave_controller_x_inst__2114_/B wave_controller_x_inst__2080_/B VDD VDD VSS VSS
+ gf180mcu_fd_sc_mcu7t5v0__oai21_1
XFILLER_103_810 VDD VDD VSS VSS gf180mcu_fd_sc_mcu7t5v0__fill_1
XFILLER_161_264 VDD VDD VSS VSS gf180mcu_fd_sc_mcu7t5v0__fill_2
Xspi_regs_inst_wire251 spi_regs_inst_wire251/I spi_regs_inst_wire251/Z VDD VDD VSS
+ VSS gf180mcu_fd_sc_mcu7t5v0__buf_2
Xspi_regs_inst_wire240 spi_regs_inst_wire241/Z spi_regs_inst_wire240/Z VDD VDD VSS
+ VSS gf180mcu_fd_sc_mcu7t5v0__buf_2
Xspi_regs_inst_wire284 spi_regs_inst_wire284/I spi_regs_inst_wire284/Z VDD VDD VSS
+ VSS gf180mcu_fd_sc_mcu7t5v0__buf_2
XFILLER_88_554 VDD VDD VSS VSS gf180mcu_fd_sc_mcu7t5v0__fillcap_4
Xwave_controller_y_inst__2964_ wave_controller_y_inst__3701_/Q spi_regs_inst__1486_/Q
+ wave_controller_y_inst__3043_/A3 VDD VDD VSS VSS gf180mcu_fd_sc_mcu7t5v0__nand2_1
XFILLER_152_45 VDD VDD VSS VSS gf180mcu_fd_sc_mcu7t5v0__fill_2
XFILLER_75_204 VDD VDD VSS VSS gf180mcu_fd_sc_mcu7t5v0__fillcap_4
XTAP_TAPCELL_ROW_110_1692 VDD VSS gf180mcu_fd_sc_mcu7t5v0__filltie
Xwave_controller_y_inst__1915_ wave_controller_y_inst__1915_/A1 wave_controller_y_inst__3718_/Q
+ wave_controller_y_inst__1778_/I wave_controller_y_inst__1942_/A2 wave_controller_y_inst__1943_/C1
+ VDD VDD VSS VSS gf180mcu_fd_sc_mcu7t5v0__aoi22_1
Xwave_controller_x_inst__2948_ wave_controller_x_inst__3305_/B2 wave_controller_x_inst__2979_/A2
+ wave_controller_x_inst__2980_/C VDD VDD VSS VSS gf180mcu_fd_sc_mcu7t5v0__nor2_1
XFILLER_57_952 VDD VDD VSS VSS gf180mcu_fd_sc_mcu7t5v0__fillcap_16
Xwave_controller_y_inst__2895_ wave_controller_y_inst__3010_/B wave_controller_y_inst__2764_/Z
+ wave_controller_y_inst__2933_/A1 wave_controller_y_inst__3700_/Q wave_controller_y_inst__2895_/C
+ wave_controller_y_inst__2902_/A2 VDD VDD VSS VSS gf180mcu_fd_sc_mcu7t5v0__aoi221_1
Xwave_controller_x_inst__2879_ wave_controller_x_inst__2870_/Z wave_controller_x_inst__2879_/A2
+ wave_controller_x_inst__2879_/B wave_controller_x_inst__2881_/A2 VDD VDD VSS VSS
+ gf180mcu_fd_sc_mcu7t5v0__aoi21_1
XTAP_TAPCELL_ROW_67_980 VDD VSS gf180mcu_fd_sc_mcu7t5v0__filltie
Xwave_controller_y_inst__1846_ spi_regs_inst__0974_/B2 wave_controller_y_inst__2379_/A1
+ VDD VDD VSS VSS gf180mcu_fd_sc_mcu7t5v0__clkinv_1
XFILLER_43_112 VDD VDD VSS VSS gf180mcu_fd_sc_mcu7t5v0__fillcap_16
XFILLER_71_410 VDD VDD VSS VSS gf180mcu_fd_sc_mcu7t5v0__fillcap_8
Xwave_controller_y_inst__1777_ wave_controller_y_inst__3718_/Q wave_controller_y_inst__3004_/B
+ VDD VDD VSS VSS gf180mcu_fd_sc_mcu7t5v0__clkinv_1
XFILLER_45_87 VDD VDD VSS VSS gf180mcu_fd_sc_mcu7t5v0__fillcap_4
Xwave_controller_y_inst__3516_ wave_controller_y_inst__3708_/Q wave_controller_y_inst__3493_/Z
+ wave_controller_y_inst__3518_/A2 VDD VDD VSS VSS gf180mcu_fd_sc_mcu7t5v0__nor2_1
XFILLER_12_510 VDD VDD VSS VSS gf180mcu_fd_sc_mcu7t5v0__fill_1
XFILLER_101_82 VDD VDD VSS VSS gf180mcu_fd_sc_mcu7t5v0__fillcap_4
Xwave_controller_y_inst__3447_ wave_controller_y_inst__3695_/Q wave_controller_y_inst__3451_/A2
+ wave_controller_y_inst__3447_/S wave_controller_y_inst__3447_/Z VDD VDD VSS VSS
+ gf180mcu_fd_sc_mcu7t5v0__mux2_2
XFILLER_157_559 VDD VDD VSS VSS gf180mcu_fd_sc_mcu7t5v0__fill_1
XFILLER_71_1170 VDD VDD VSS VSS gf180mcu_fd_sc_mcu7t5v0__fillcap_4
Xwave_controller_y_inst__3378_ wave_controller_y_inst__3701_/Q wave_controller_y_inst__3378_/A2
+ fanout509/Z wave_controller_y_inst__3283_/B wave_controller_y_inst__3378_/C wave_controller_y_inst__3382_/A2
+ VDD VDD VSS VSS gf180mcu_fd_sc_mcu7t5v0__aoi221_1
XTAP_TAPCELL_ROW_117_1802 VDD VSS gf180mcu_fd_sc_mcu7t5v0__filltie
XTAP_TAPCELL_ROW_117_1813 VDD VSS gf180mcu_fd_sc_mcu7t5v0__filltie
Xwave_controller_y_inst__2329_ wave_controller_y_inst__2345_/C wave_controller_y_inst__2328_/Z
+ wave_controller_y_inst__2331_/A1 VDD VDD VSS VSS gf180mcu_fd_sc_mcu7t5v0__nand2_1
XFILLER_137_261 VDD VDD VSS VSS gf180mcu_fd_sc_mcu7t5v0__fill_1
XFILLER_138_784 VDD VDD VSS VSS gf180mcu_fd_sc_mcu7t5v0__fillcap_8
XFILLER_6_37 VDD VDD VSS VSS gf180mcu_fd_sc_mcu7t5v0__fillcap_64
Xstate_machine_inst__20_ fanout498/Z state_machine_inst__29_/B2 VDD VDD VSS VSS gf180mcu_fd_sc_mcu7t5v0__clkinv_1
XFILLER_125_489 VDD VDD VSS VSS gf180mcu_fd_sc_mcu7t5v0__fill_1
XFILLER_152_275 VDD VDD VSS VSS gf180mcu_fd_sc_mcu7t5v0__fillcap_8
XFILLER_153_798 VDD VDD VSS VSS gf180mcu_fd_sc_mcu7t5v0__fillcap_32
XFILLER_94_535 VDD VDD VSS VSS gf180mcu_fd_sc_mcu7t5v0__fill_2
XFILLER_19_131 VDD VDD VSS VSS gf180mcu_fd_sc_mcu7t5v0__fillcap_8
XFILLER_66_259 VDD VDD VSS VSS gf180mcu_fd_sc_mcu7t5v0__fill_1
XFILLER_94_557 VDD VDD VSS VSS gf180mcu_fd_sc_mcu7t5v0__fillcap_4
XTAP_TAPCELL_ROW_163_2567 VDD VSS gf180mcu_fd_sc_mcu7t5v0__filltie
XTAP_TAPCELL_ROW_29_1_549 VDD VSS gf180mcu_fd_sc_mcu7t5v0__filltie
XFILLER_19_142 VDD VDD VSS VSS gf180mcu_fd_sc_mcu7t5v0__fillcap_8
XFILLER_47_473 VDD VDD VSS VSS gf180mcu_fd_sc_mcu7t5v0__fillcap_16
XFILLER_81_207 VDD VDD VSS VSS gf180mcu_fd_sc_mcu7t5v0__fill_2
XTAP_TAPCELL_ROW_128_1986 VDD VSS gf180mcu_fd_sc_mcu7t5v0__filltie
XFILLER_62_432 VDD VDD VSS VSS gf180mcu_fd_sc_mcu7t5v0__fillcap_8
XFILLER_63_933 VDD VDD VSS VSS gf180mcu_fd_sc_mcu7t5v0__fillcap_32
XTAP_TAPCELL_ROW_128_1997 VDD VSS gf180mcu_fd_sc_mcu7t5v0__filltie
XFILLER_62_465 VDD VDD VSS VSS gf180mcu_fd_sc_mcu7t5v0__fillcap_8
XFILLER_63_977 VDD VDD VSS VSS gf180mcu_fd_sc_mcu7t5v0__fill_2
XFILLER_90_752 VDD VDD VSS VSS gf180mcu_fd_sc_mcu7t5v0__fillcap_16
XFILLER_76_1081 VDD VDD VSS VSS gf180mcu_fd_sc_mcu7t5v0__fillcap_4
XFILLER_30_362 VDD VDD VSS VSS gf180mcu_fd_sc_mcu7t5v0__fillcap_4
XFILLER_135_209 VDD VDD VSS VSS gf180mcu_fd_sc_mcu7t5v0__fill_1
XFILLER_103_139 VDD VDD VSS VSS gf180mcu_fd_sc_mcu7t5v0__fill_1
XFILLER_131_448 VDD VDD VSS VSS gf180mcu_fd_sc_mcu7t5v0__fill_1
XFILLER_83_1052 VDD VDD VSS VSS gf180mcu_fd_sc_mcu7t5v0__fillcap_64
Xspi_regs_inst__1119_ spi_regs_inst__1119_/A1 spi_regs_inst__1169_/B1 spi_regs_inst__1200_/B1
+ spi_regs_inst__1119_/B2 spi_regs_inst__1120_/A4 VDD VDD VSS VSS gf180mcu_fd_sc_mcu7t5v0__aoi22_1
XFILLER_98_885 VDD VDD VSS VSS gf180mcu_fd_sc_mcu7t5v0__fill_2
Xwave_controller_x_inst_load_slew66 wave_controller_x_inst__3573_/S wave_controller_x_inst__3569_/S
+ VDD VDD VSS VSS gf180mcu_fd_sc_mcu7t5v0__buf_4
Xwave_controller_x_inst__2802_ wave_controller_x_inst__2802_/A1 wave_controller_x_inst__2802_/A2
+ wave_controller_x_inst__2802_/B wave_controller_x_inst__2810_/A1 VDD VDD VSS VSS
+ gf180mcu_fd_sc_mcu7t5v0__aoi21_1
XFILLER_57_204 VDD VDD VSS VSS gf180mcu_fd_sc_mcu7t5v0__fillcap_4
Xwave_controller_x_inst__2733_ wave_controller_x_inst__3551_/B2 wave_controller_x_inst__2731_/Z
+ wave_controller_x_inst__2733_/Z VDD VDD VSS VSS gf180mcu_fd_sc_mcu7t5v0__xor2_1
XFILLER_38_451 VDD VDD VSS VSS gf180mcu_fd_sc_mcu7t5v0__fillcap_4
Xwave_controller_y_inst__2680_ wave_controller_y_inst__2680_/A1 wave_controller_y_inst__2680_/A2
+ wave_controller_y_inst__2681_/C wave_controller_y_inst__2712_/A1 VDD VDD VSS VSS
+ gf180mcu_fd_sc_mcu7t5v0__oai21_1
Xwave_controller_x_inst__2664_ wave_controller_x_inst__2664_/A1 wave_controller_x_inst__2664_/A2
+ wave_controller_x_inst__2661_/I wave_controller_x_inst__2710_/A3 VDD VDD VSS VSS
+ gf180mcu_fd_sc_mcu7t5v0__nand3_1
XFILLER_38_484 VDD VDD VSS VSS gf180mcu_fd_sc_mcu7t5v0__fillcap_4
XFILLER_53_410 VDD VDD VSS VSS gf180mcu_fd_sc_mcu7t5v0__fillcap_8
XFILLER_80_240 VDD VDD VSS VSS gf180mcu_fd_sc_mcu7t5v0__fillcap_4
XFILLER_80_251 VDD VDD VSS VSS gf180mcu_fd_sc_mcu7t5v0__fill_1
XPHY_EDGE_ROW_146_Right_146 VDD VSS gf180mcu_fd_sc_mcu7t5v0__endcap
Xwave_controller_x_inst__2595_ wave_controller_x_inst__2616_/A1 spi_regs_inst__1186_/B2
+ wave_controller_x_inst__2595_/Z VDD VDD VSS VSS gf180mcu_fd_sc_mcu7t5v0__xor2_1
XFILLER_40_104 VDD VDD VSS VSS gf180mcu_fd_sc_mcu7t5v0__fill_1
XFILLER_40_115 VDD VDD VSS VSS gf180mcu_fd_sc_mcu7t5v0__fillcap_4
Xwave_controller_y_inst__3301_ wave_controller_y_inst__1790_/I spi_regs_inst__1608_/Q
+ wave_controller_y_inst__3301_/Z VDD VDD VSS VSS gf180mcu_fd_sc_mcu7t5v0__xor2_1
XFILLER_166_301 VDD VDD VSS VSS gf180mcu_fd_sc_mcu7t5v0__fillcap_8
XFILLER_55_1154 VDD VDD VSS VSS gf180mcu_fd_sc_mcu7t5v0__fillcap_16
XFILLER_142_1157 VDD VDD VSS VSS gf180mcu_fd_sc_mcu7t5v0__fillcap_8
Xwave_controller_y_inst__3232_ wave_controller_y_inst__2797_/C spi_regs_inst__1583_/Q
+ wave_controller_y_inst__3232_/B1 wave_controller_y_inst__3232_/B2 wave_controller_y_inst__3232_/C
+ wave_controller_y_inst__3233_/C VDD VDD VSS VSS gf180mcu_fd_sc_mcu7t5v0__aoi221_1
Xwave_controller_x_inst__3216_ fanout523/Z wave_controller_x_inst__3215_/Z wave_controller_x_inst__3238_/C
+ VDD VDD VSS VSS gf180mcu_fd_sc_mcu7t5v0__and2_1
Xwave_controller_y_inst__3163_ wave_controller_y_inst__3312_/A1 spi_regs_inst__1594_/Q
+ spi_regs_inst__1593_/Q wave_controller_y_inst__3163_/C wave_controller_y_inst__3164_/A2
+ VDD VDD VSS VSS gf180mcu_fd_sc_mcu7t5v0__oai211_1
XFILLER_126_209 VDD VDD VSS VSS gf180mcu_fd_sc_mcu7t5v0__fillcap_16
Xwave_controller_y_inst__2114_ wave_controller_y_inst__2114_/A1 wave_controller_y_inst__2114_/A2
+ wave_controller_y_inst__2114_/B wave_controller_y_inst__2114_/C wave_controller_y_inst__2116_/C
+ VDD VDD VSS VSS gf180mcu_fd_sc_mcu7t5v0__aoi211_1
Xwave_controller_x_inst__3147_ wave_controller_x_inst__3219_/B wave_controller_x_inst__3218_/B
+ wave_controller_x_inst__3218_/C wave_controller_x_inst__3147_/B wave_controller_x_inst__3215_/A3
+ VDD VDD VSS VSS gf180mcu_fd_sc_mcu7t5v0__oai31_1
XFILLER_119_294 VDD VDD VSS VSS gf180mcu_fd_sc_mcu7t5v0__fill_2
XFILLER_135_732 VDD VDD VSS VSS gf180mcu_fd_sc_mcu7t5v0__fill_1
XFILLER_135_754 VDD VDD VSS VSS gf180mcu_fd_sc_mcu7t5v0__fillcap_16
Xwave_controller_y_inst__3094_ wave_controller_y_inst__2117_/B wave_controller_y_inst__3094_/A2
+ wave_controller_y_inst__3612_/Q wave_controller_y_inst__3098_/A1 VDD VDD VSS VSS
+ gf180mcu_fd_sc_mcu7t5v0__oai21_1
Xwave_controller_x_inst__3078_ wave_controller_x_inst__3078_/A1 wave_controller_x_inst__3090_/B1
+ wave_controller_x_inst__3077_/Z wave_controller_x_inst__2762_/I wave_controller_x_inst__3715_/D
+ VDD VDD VSS VSS gf180mcu_fd_sc_mcu7t5v0__oai22_1
XFILLER_107_489 VDD VDD VSS VSS gf180mcu_fd_sc_mcu7t5v0__fill_1
XFILLER_162_573 VDD VDD VSS VSS gf180mcu_fd_sc_mcu7t5v0__fillcap_16
Xwave_controller_y_inst__2045_ wave_controller_y_inst__2125_/A2 wave_controller_y_inst__2125_/B
+ wave_controller_y_inst__2138_/A1 VDD VDD VSS VSS gf180mcu_fd_sc_mcu7t5v0__nand2_1
Xwave_controller_x_inst__2029_ spi_regs_inst__1252_/B2 wave_controller_x_inst__2026_/Z
+ spi_regs_inst__1251_/B2 VDD VDD VSS VSS gf180mcu_fd_sc_mcu7t5v0__xor2_1
Xoutput12 _90_/Z bidir_out[5] VDD VDD VSS VSS gf180mcu_fd_sc_mcu7t5v0__buf_1
XTAP_TAPCELL_ROW_112_1721 VDD VSS gf180mcu_fd_sc_mcu7t5v0__filltie
XTAP_TAPCELL_ROW_112_1732 VDD VSS gf180mcu_fd_sc_mcu7t5v0__filltie
XFILLER_103_673 VDD VDD VSS VSS gf180mcu_fd_sc_mcu7t5v0__fillcap_4
XFILLER_131_982 VDD VDD VSS VSS gf180mcu_fd_sc_mcu7t5v0__fillcap_64
XFILLER_163_66 VDD VDD VSS VSS gf180mcu_fd_sc_mcu7t5v0__fillcap_4
XFILLER_76_535 VDD VDD VSS VSS gf180mcu_fd_sc_mcu7t5v0__fillcap_4
XFILLER_88_373 VDD VDD VSS VSS gf180mcu_fd_sc_mcu7t5v0__fillcap_4
XPHY_EDGE_ROW_9_1_Left_176 VDD VSS gf180mcu_fd_sc_mcu7t5v0__endcap
XFILLER_0_299 VDD VDD VSS VSS gf180mcu_fd_sc_mcu7t5v0__fillcap_4
XFILLER_48_259 VDD VDD VSS VSS gf180mcu_fd_sc_mcu7t5v0__fillcap_8
XFILLER_64_708 VDD VDD VSS VSS gf180mcu_fd_sc_mcu7t5v0__fillcap_4
Xwave_controller_y_inst__2947_ wave_controller_y_inst__1790_/I wave_controller_y_inst__1821_/I
+ wave_controller_y_inst__3068_/A2 VDD VDD VSS VSS gf180mcu_fd_sc_mcu7t5v0__nand2_1
XFILLER_57_760 VDD VDD VSS VSS gf180mcu_fd_sc_mcu7t5v0__fillcap_4
XTAP_TAPCELL_ROW_145_2264 VDD VSS gf180mcu_fd_sc_mcu7t5v0__filltie
XTAP_TAPCELL_ROW_145_2275 VDD VSS gf180mcu_fd_sc_mcu7t5v0__filltie
Xwave_controller_y_inst__2878_ wave_controller_y_inst__2878_/A1 wave_controller_y_inst__2878_/A2
+ wave_controller_y_inst__2887_/A1 VDD VDD VSS VSS gf180mcu_fd_sc_mcu7t5v0__nand2_1
XFILLER_16_101 VDD VDD VSS VSS gf180mcu_fd_sc_mcu7t5v0__fillcap_4
XFILLER_72_741 VDD VDD VSS VSS gf180mcu_fd_sc_mcu7t5v0__fill_2
XTAP_TAPCELL_ROW_25_1_522 VDD VSS gf180mcu_fd_sc_mcu7t5v0__filltie
Xwave_controller_y_inst__1829_ wave_controller_y_inst__1829_/I wave_controller_y_inst__3572_/A2
+ VDD VDD VSS VSS gf180mcu_fd_sc_mcu7t5v0__clkinv_1
XFILLER_44_454 VDD VDD VSS VSS gf180mcu_fd_sc_mcu7t5v0__fill_1
XPHY_EDGE_ROW_113_Right_113 VDD VSS gf180mcu_fd_sc_mcu7t5v0__endcap
XFILLER_147_1046 VDD VDD VSS VSS gf180mcu_fd_sc_mcu7t5v0__fillcap_4
XFILLER_44_498 VDD VDD VSS VSS gf180mcu_fd_sc_mcu7t5v0__fillcap_8
XFILLER_60_947 VDD VDD VSS VSS gf180mcu_fd_sc_mcu7t5v0__fillcap_64
XFILLER_72_785 VDD VDD VSS VSS gf180mcu_fd_sc_mcu7t5v0__fill_2
Xwave_controller_x_inst_fanout74 wave_controller_x_inst_wire75/Z wave_controller_x_inst__3610_/A1
+ VDD VDD VSS VSS gf180mcu_fd_sc_mcu7t5v0__dlyb_1
XFILLER_72_85 VDD VDD VSS VSS gf180mcu_fd_sc_mcu7t5v0__fillcap_4
Xspi_regs_inst__1470_ spi_regs_inst__1470_/D spi_regs_inst__1601_/RN clkbuf_leaf_36_clk/Z
+ spi_regs_inst__1470_/Q VDD VDD VSS VSS gf180mcu_fd_sc_mcu7t5v0__dffrnq_1
XFILLER_8_311 VDD VDD VSS VSS gf180mcu_fd_sc_mcu7t5v0__fillcap_4
XFILLER_12_395 VDD VDD VSS VSS gf180mcu_fd_sc_mcu7t5v0__fillcap_32
XFILLER_157_345 VDD VDD VSS VSS gf180mcu_fd_sc_mcu7t5v0__fillcap_4
XFILLER_157_356 VDD VDD VSS VSS gf180mcu_fd_sc_mcu7t5v0__fillcap_16
XFILLER_117_209 VDD VDD VSS VSS gf180mcu_fd_sc_mcu7t5v0__fill_1
XFILLER_126_721 VDD VDD VSS VSS gf180mcu_fd_sc_mcu7t5v0__fill_2
XFILLER_126_732 VDD VDD VSS VSS gf180mcu_fd_sc_mcu7t5v0__fill_2
XFILLER_113_404 VDD VDD VSS VSS gf180mcu_fd_sc_mcu7t5v0__fill_1
XFILLER_141_702 VDD VDD VSS VSS gf180mcu_fd_sc_mcu7t5v0__fillcap_8
XFILLER_153_562 VDD VDD VSS VSS gf180mcu_fd_sc_mcu7t5v0__fillcap_4
XFILLER_99_627 VDD VDD VSS VSS gf180mcu_fd_sc_mcu7t5v0__fill_2
XFILLER_154_1017 VDD VDD VSS VSS gf180mcu_fd_sc_mcu7t5v0__fillcap_64
XTAP_TAPCELL_ROW_165_2607 VDD VSS gf180mcu_fd_sc_mcu7t5v0__filltie
XFILLER_140_289 VDD VDD VSS VSS gf180mcu_fd_sc_mcu7t5v0__fillcap_8
XFILLER_121_492 VDD VDD VSS VSS gf180mcu_fd_sc_mcu7t5v0__fill_2
XFILLER_55_719 VDD VDD VSS VSS gf180mcu_fd_sc_mcu7t5v0__fillcap_4
XFILLER_67_579 VDD VDD VSS VSS gf180mcu_fd_sc_mcu7t5v0__fill_2
XFILLER_82_527 VDD VDD VSS VSS gf180mcu_fd_sc_mcu7t5v0__fillcap_8
XFILLER_94_376 VDD VDD VSS VSS gf180mcu_fd_sc_mcu7t5v0__fill_1
XFILLER_95_899 VDD VDD VSS VSS gf180mcu_fd_sc_mcu7t5v0__fill_1
XTAP_TAPCELL_ROW_4_1_358 VDD VSS gf180mcu_fd_sc_mcu7t5v0__filltie
XPHY_EDGE_ROW_59_Left_226 VDD VSS gf180mcu_fd_sc_mcu7t5v0__endcap
XFILLER_22_115 VDD VDD VSS VSS gf180mcu_fd_sc_mcu7t5v0__fillcap_16
XFILLER_90_593 VDD VDD VSS VSS gf180mcu_fd_sc_mcu7t5v0__fill_2
XTAP_TAPCELL_ROW_81_1208 VDD VSS gf180mcu_fd_sc_mcu7t5v0__filltie
XTAP_TAPCELL_ROW_81_1219 VDD VSS gf180mcu_fd_sc_mcu7t5v0__filltie
Xwave_controller_x_inst__2380_ wave_controller_x_inst__2380_/A1 spi_regs_inst__1336_/A1
+ spi_regs_inst__1306_/A1 wave_controller_x_inst__2381_/B1 VDD VDD VSS VSS gf180mcu_fd_sc_mcu7t5v0__aoi21_1
XFILLER_149_813 VDD VDD VSS VSS gf180mcu_fd_sc_mcu7t5v0__fillcap_16
XFILLER_50_457 VDD VDD VSS VSS gf180mcu_fd_sc_mcu7t5v0__fillcap_4
Xspi_regs_inst__1599_ spi_regs_inst__1599_/D spi_regs_inst__1601_/RN clkbuf_leaf_36_clk/Z
+ spi_regs_inst__1599_/Q VDD VDD VSS VSS gf180mcu_fd_sc_mcu7t5v0__dffrnq_1
XFILLER_30_170 VDD VDD VSS VSS gf180mcu_fd_sc_mcu7t5v0__fill_1
Xwave_controller_x_inst__3001_ wave_controller_x_inst__3001_/A1 wave_controller_x_inst__2992_/I
+ wave_controller_x_inst__3001_/A3 wave_controller_x_inst__3001_/B wave_controller_x_inst__3002_/I
+ VDD VDD VSS VSS gf180mcu_fd_sc_mcu7t5v0__oai31_1
XFILLER_129_570 VDD VDD VSS VSS gf180mcu_fd_sc_mcu7t5v0__fill_2
XFILLER_136_518 VDD VDD VSS VSS gf180mcu_fd_sc_mcu7t5v0__fillcap_4
XTAP_TAPCELL_ROW_96_1462 VDD VSS gf180mcu_fd_sc_mcu7t5v0__filltie
XFILLER_116_264 VDD VDD VSS VSS gf180mcu_fd_sc_mcu7t5v0__fill_1
XFILLER_144_551 VDD VDD VSS VSS gf180mcu_fd_sc_mcu7t5v0__fill_2
XPHY_EDGE_ROW_68_Left_235 VDD VSS gf180mcu_fd_sc_mcu7t5v0__endcap
XTAP_TAPCELL_ROW_42_1_647 VDD VSS gf180mcu_fd_sc_mcu7t5v0__filltie
XFILLER_117_48 VDD VDD VSS VSS gf180mcu_fd_sc_mcu7t5v0__fillcap_8
XFILLER_132_779 VDD VDD VSS VSS gf180mcu_fd_sc_mcu7t5v0__fill_2
XFILLER_113_982 VDD VDD VSS VSS gf180mcu_fd_sc_mcu7t5v0__fillcap_64
XFILLER_98_671 VDD VDD VSS VSS gf180mcu_fd_sc_mcu7t5v0__fill_2
XFILLER_133_36 VDD VDD VSS VSS gf180mcu_fd_sc_mcu7t5v0__fillcap_8
XFILLER_58_535 VDD VDD VSS VSS gf180mcu_fd_sc_mcu7t5v0__fill_2
XFILLER_86_877 VDD VDD VSS VSS gf180mcu_fd_sc_mcu7t5v0__fillcap_8
Xwave_controller_y_inst__2801_ wave_controller_y_inst__3562_/A1 wave_controller_y_inst__2798_/Z
+ wave_controller_y_inst__2800_/Z wave_controller_y_inst__3564_/A1 wave_controller_y_inst__2802_/B
+ VDD VDD VSS VSS gf180mcu_fd_sc_mcu7t5v0__oai22_1
XFILLER_93_18 VDD VDD VSS VSS gf180mcu_fd_sc_mcu7t5v0__fill_2
Xwave_controller_y_inst__2732_ spi_regs_inst__1138_/B2 wave_controller_y_inst__2731_/Z
+ wave_controller_y_inst__2748_/A2 VDD VDD VSS VSS gf180mcu_fd_sc_mcu7t5v0__nor2_1
Xwave_controller_x_inst__2716_ wire450/Z spi_regs_inst__1169_/B2 wave_controller_x_inst__2716_/Z
+ VDD VDD VSS VSS gf180mcu_fd_sc_mcu7t5v0__xor2_1
XPHY_EDGE_ROW_77_Left_244 VDD VSS gf180mcu_fd_sc_mcu7t5v0__endcap
Xwave_controller_x_inst__3696_ wave_controller_x_inst__3696_/D wave_controller_x_inst__3715_/RN
+ clkload28/I wave_controller_x_inst__3696_/Q VDD VDD VSS VSS gf180mcu_fd_sc_mcu7t5v0__dffrnq_1
XFILLER_26_34 VDD VDD VSS VSS gf180mcu_fd_sc_mcu7t5v0__fill_1
XFILLER_26_454 VDD VDD VSS VSS gf180mcu_fd_sc_mcu7t5v0__fill_1
Xwave_controller_y_inst__2663_ wave_controller_y_inst__2663_/A1 wave_controller_y_inst__2663_/A2
+ wave_controller_y_inst__2680_/A2 VDD VDD VSS VSS gf180mcu_fd_sc_mcu7t5v0__nor2_1
Xwave_controller_x_inst__2647_ wave_controller_x_inst__2713_/A1 wave_controller_x_inst__2646_/B
+ spi_regs_inst__1241_/B2 VDD VDD VSS VSS gf180mcu_fd_sc_mcu7t5v0__xnor2_1
XTAP_TAPCELL_ROW_140_2183 VDD VSS gf180mcu_fd_sc_mcu7t5v0__filltie
Xwave_controller_y_inst__2594_ wave_controller_y_inst__2594_/A1 wave_controller_y_inst__2594_/A2
+ spi_regs_inst__1095_/B2 VDD VDD VSS VSS gf180mcu_fd_sc_mcu7t5v0__xor2_1
Xwave_controller_x_inst__2578_ wave_controller_x_inst__2607_/A1 wave_controller_x_inst__2578_/A2
+ spi_regs_inst_wire77/I VDD VDD VSS VSS gf180mcu_fd_sc_mcu7t5v0__xor2_1
XFILLER_53_295 VDD VDD VSS VSS gf180mcu_fd_sc_mcu7t5v0__fillcap_4
XTAP_TAPCELL_ROW_140_2194 VDD VSS gf180mcu_fd_sc_mcu7t5v0__filltie
XFILLER_107_1052 VDD VDD VSS VSS gf180mcu_fd_sc_mcu7t5v0__fillcap_64
Xwave_controller_y_inst__3215_ wave_controller_y_inst__3570_/A1 spi_regs_inst__1589_/Q
+ wave_controller_y_inst_wire124/Z wave_controller_y_inst__3215_/Z VDD VDD VSS VSS
+ gf180mcu_fd_sc_mcu7t5v0__xor3_1
XPHY_EDGE_ROW_86_Left_253 VDD VSS gf180mcu_fd_sc_mcu7t5v0__endcap
Xwave_controller_y_inst__3146_ wave_controller_y_inst__3146_/A1 wave_controller_y_inst__3225_/A1
+ wave_controller_y_inst__3146_/B wave_controller_y_inst__3146_/C wave_controller_y_inst__3222_/A1
+ VDD VDD VSS VSS gf180mcu_fd_sc_mcu7t5v0__oai211_1
XFILLER_123_702 VDD VDD VSS VSS gf180mcu_fd_sc_mcu7t5v0__fillcap_8
XFILLER_135_540 VDD VDD VSS VSS gf180mcu_fd_sc_mcu7t5v0__fill_1
XFILLER_135_562 VDD VDD VSS VSS gf180mcu_fd_sc_mcu7t5v0__fillcap_16
Xwave_controller_y_inst__3077_ wave_controller_y_inst__2942_/Z wave_controller_y_inst__3077_/A2
+ wave_controller_y_inst__3077_/Z VDD VDD VSS VSS gf180mcu_fd_sc_mcu7t5v0__xor2_1
XFILLER_107_286 VDD VDD VSS VSS gf180mcu_fd_sc_mcu7t5v0__fill_1
XPHY_EDGE_ROW_49_1_Left_216 VDD VSS gf180mcu_fd_sc_mcu7t5v0__endcap
Xwave_controller_y_inst__2028_ wave_controller_y_inst__2026_/Z wave_controller_y_inst__2028_/A2
+ spi_regs_inst__1217_/A1 VDD VDD VSS VSS gf180mcu_fd_sc_mcu7t5v0__or2_1
XFILLER_123_768 VDD VDD VSS VSS gf180mcu_fd_sc_mcu7t5v0__fill_2
XFILLER_1_553 VDD VDD VSS VSS gf180mcu_fd_sc_mcu7t5v0__fill_2
XTAP_TAPCELL_ROW_147_2304 VDD VSS gf180mcu_fd_sc_mcu7t5v0__filltie
Xspi_regs_inst_fanout343 spi_regs_inst__1028_/A1 spi_regs_inst__1029_/A1 VDD VDD VSS
+ VSS gf180mcu_fd_sc_mcu7t5v0__dlyb_1
XFILLER_103_492 VDD VDD VSS VSS gf180mcu_fd_sc_mcu7t5v0__fillcap_8
XFILLER_77_866 VDD VDD VSS VSS gf180mcu_fd_sc_mcu7t5v0__fill_1
XFILLER_88_181 VDD VDD VSS VSS gf180mcu_fd_sc_mcu7t5v0__fill_1
Xspi_regs_inst__0970_ spi_regs_inst__1019_/A2 spi_regs_inst__1031_/A2 spi_regs_inst__1194_/A2
+ VDD VDD VSS VSS gf180mcu_fd_sc_mcu7t5v0__nor2_1
XPHY_EDGE_ROW_95_Left_262 VDD VSS gf180mcu_fd_sc_mcu7t5v0__endcap
XTAP_TAPCELL_ROW_160_2515 VDD VSS gf180mcu_fd_sc_mcu7t5v0__filltie
XFILLER_64_527 VDD VDD VSS VSS gf180mcu_fd_sc_mcu7t5v0__fill_2
XFILLER_76_387 VDD VDD VSS VSS gf180mcu_fd_sc_mcu7t5v0__fillcap_16
XTAP_TAPCELL_ROW_125_1934 VDD VSS gf180mcu_fd_sc_mcu7t5v0__filltie
XFILLER_91_346 VDD VDD VSS VSS gf180mcu_fd_sc_mcu7t5v0__fillcap_4
XTAP_TAPCELL_ROW_125_1945 VDD VSS gf180mcu_fd_sc_mcu7t5v0__filltie
XFILLER_32_424 VDD VDD VSS VSS gf180mcu_fd_sc_mcu7t5v0__fill_1
XTAP_TAPCELL_ROW_55_780 VDD VSS gf180mcu_fd_sc_mcu7t5v0__filltie
XFILLER_32_457 VDD VDD VSS VSS gf180mcu_fd_sc_mcu7t5v0__fill_1
XTAP_TAPCELL_ROW_55_791 VDD VSS gf180mcu_fd_sc_mcu7t5v0__filltie
Xspi_regs_inst__1522_ spi_regs_inst__1522_/D fanout619/Z clkload32/I spi_regs_inst__1522_/Q
+ VDD VDD VSS VSS gf180mcu_fd_sc_mcu7t5v0__dffrnq_1
XTAP_TAPCELL_ROW_158_2477 VDD VSS gf180mcu_fd_sc_mcu7t5v0__filltie
Xspi_regs_inst__1453_ spi_regs_inst__1453_/D fanout558/Z clkload7/I _87_/I VDD VDD
+ VSS VSS gf180mcu_fd_sc_mcu7t5v0__dffrnq_1
XFILLER_157_142 VDD VDD VSS VSS gf180mcu_fd_sc_mcu7t5v0__fillcap_16
XFILLER_80_6 VDD VDD VSS VSS gf180mcu_fd_sc_mcu7t5v0__fillcap_8
XTAP_TAPCELL_ROW_158_2488 VDD VSS gf180mcu_fd_sc_mcu7t5v0__filltie
XFILLER_158_676 VDD VDD VSS VSS gf180mcu_fd_sc_mcu7t5v0__fillcap_32
XFILLER_160_1087 VDD VDD VSS VSS gf180mcu_fd_sc_mcu7t5v0__fillcap_64
Xspi_regs_inst__1384_ spi_regs_inst__1641_/Q spi_regs_inst__1412_/I1 spi_regs_inst__1384_/S
+ spi_regs_inst__1664_/D VDD VDD VSS VSS gf180mcu_fd_sc_mcu7t5v0__mux2_2
XFILLER_145_348 VDD VDD VSS VSS gf180mcu_fd_sc_mcu7t5v0__fill_2
XFILLER_154_871 VDD VDD VSS VSS gf180mcu_fd_sc_mcu7t5v0__fillcap_4
XTAP_TAPCELL_ROW_78_1170 VDD VSS gf180mcu_fd_sc_mcu7t5v0__filltie
XFILLER_99_424 VDD VDD VSS VSS gf180mcu_fd_sc_mcu7t5v0__fill_1
XFILLER_4_391 VDD VDD VSS VSS gf180mcu_fd_sc_mcu7t5v0__fillcap_8
XFILLER_80_1011 VDD VDD VSS VSS gf180mcu_fd_sc_mcu7t5v0__fillcap_4
XFILLER_86_107 VDD VDD VSS VSS gf180mcu_fd_sc_mcu7t5v0__fill_1
XTAP_TAPCELL_ROW_91_1381 VDD VSS gf180mcu_fd_sc_mcu7t5v0__filltie
Xwave_controller_x_inst__1880_ spi_regs_inst__1186_/B2 wave_controller_x_inst__3530_/B2
+ VDD VDD VSS VSS gf180mcu_fd_sc_mcu7t5v0__clkinv_1
XFILLER_95_641 VDD VDD VSS VSS gf180mcu_fd_sc_mcu7t5v0__fillcap_4
Xsignal_processor_y_inst__196_ signal_processor_y_inst__202_/A1 signal_processor_y_inst__196_/A2
+ signal_processor_y_inst__200_/A2 signal_processor_y_inst__196_/B1 signal_processor_y_inst__215_/A1
+ signal_processor_y_inst__216_/D VDD VDD VSS VSS gf180mcu_fd_sc_mcu7t5v0__oai32_1
XFILLER_68_877 VDD VDD VSS VSS gf180mcu_fd_sc_mcu7t5v0__fillcap_16
XFILLER_68_899 VDD VDD VSS VSS gf180mcu_fd_sc_mcu7t5v0__fill_1
Xwave_controller_y_inst_max_cap109 wave_controller_y_inst__2510_/A3 wave_controller_y_inst__2543_/A2
+ VDD VDD VSS VSS gf180mcu_fd_sc_mcu7t5v0__clkbuf_1
XFILLER_67_398 VDD VDD VSS VSS gf180mcu_fd_sc_mcu7t5v0__fillcap_16
XFILLER_82_313 VDD VDD VSS VSS gf180mcu_fd_sc_mcu7t5v0__fill_2
XFILLER_83_858 VDD VDD VSS VSS gf180mcu_fd_sc_mcu7t5v0__fillcap_4
XFILLER_94_173 VDD VDD VSS VSS gf180mcu_fd_sc_mcu7t5v0__fill_2
Xwave_controller_x_inst__3550_ spi_regs_inst__1169_/B2 wave_controller_x_inst__3556_/A2
+ wave_controller_x_inst__3551_/A3 VDD VDD VSS VSS gf180mcu_fd_sc_mcu7t5v0__nor2_1
XFILLER_35_240 VDD VDD VSS VSS gf180mcu_fd_sc_mcu7t5v0__fillcap_4
Xwave_controller_x_inst__3481_ wave_controller_x_inst__3485_/B wave_controller_x_inst__3478_/I
+ wave_controller_x_inst__3496_/B wave_controller_x_inst__3482_/B2 VDD VDD VSS VSS
+ gf180mcu_fd_sc_mcu7t5v0__oai21_1
Xwave_controller_x_inst__2501_ wave_controller_x_inst__2501_/A1 wave_controller_x_inst__2501_/A2
+ wave_controller_x_inst__2501_/B wave_controller_x_inst__2504_/A3 VDD VDD VSS VSS
+ gf180mcu_fd_sc_mcu7t5v0__oai21_1
XFILLER_23_413 VDD VDD VSS VSS gf180mcu_fd_sc_mcu7t5v0__fill_1
XTAP_TAPCELL_ROW_53_728 VDD VSS gf180mcu_fd_sc_mcu7t5v0__filltie
XTAP_TAPCELL_ROW_53_739 VDD VSS gf180mcu_fd_sc_mcu7t5v0__filltie
Xwave_controller_x_inst__2432_ wave_controller_x_inst__2432_/I wave_controller_x_inst__2446_/A1
+ VDD VDD VSS VSS gf180mcu_fd_sc_mcu7t5v0__clkinv_1
XFILLER_23_446 VDD VDD VSS VSS gf180mcu_fd_sc_mcu7t5v0__fill_2
XFILLER_10_107 VDD VDD VSS VSS gf180mcu_fd_sc_mcu7t5v0__fillcap_4
XFILLER_149_632 VDD VDD VSS VSS gf180mcu_fd_sc_mcu7t5v0__fillcap_8
XFILLER_50_243 VDD VDD VSS VSS gf180mcu_fd_sc_mcu7t5v0__fill_2
Xwave_controller_x_inst__2363_ spi_regs_inst__1349_/A1 spi_regs_inst__1336_/A1 wave_controller_x_inst__2363_/Z
+ VDD VDD VSS VSS gf180mcu_fd_sc_mcu7t5v0__xor2_1
Xwave_controller_x_inst__2294_ wave_controller_x_inst__2294_/A1 wave_controller_x_inst__2294_/A2
+ wave_controller_x_inst__2293_/B wave_controller_x_inst__2294_/Z VDD VDD VSS VSS
+ gf180mcu_fd_sc_mcu7t5v0__and3_1
XTAP_TAPCELL_ROW_98_1502 VDD VSS gf180mcu_fd_sc_mcu7t5v0__filltie
XFILLER_148_164 VDD VDD VSS VSS gf180mcu_fd_sc_mcu7t5v0__fill_2
XFILLER_149_698 VDD VDD VSS VSS gf180mcu_fd_sc_mcu7t5v0__fill_2
Xclkbuf_leaf_30_clk clkload0/I clkload34/I VDD VDD VSS VSS gf180mcu_fd_sc_mcu7t5v0__clkbuf_8
Xwave_controller_y_inst__3000_ wave_controller_y_inst__3000_/A1 wave_controller_y_inst_wire93/Z
+ wave_controller_y_inst__3000_/A3 wave_controller_y_inst__3081_/A1 VDD VDD VSS VSS
+ gf180mcu_fd_sc_mcu7t5v0__nand3_1
XFILLER_105_702 VDD VDD VSS VSS gf180mcu_fd_sc_mcu7t5v0__fill_2
XTAP_TAPCELL_ROW_24_1_510 VDD VSS gf180mcu_fd_sc_mcu7t5v0__filltie
XFILLER_2_317 VDD VDD VSS VSS gf180mcu_fd_sc_mcu7t5v0__fillcap_32
XTAP_TAPCELL_ROW_129_2001 VDD VSS gf180mcu_fd_sc_mcu7t5v0__filltie
XTAP_TAPCELL_ROW_129_2012 VDD VSS gf180mcu_fd_sc_mcu7t5v0__filltie
XFILLER_58_343 VDD VDD VSS VSS gf180mcu_fd_sc_mcu7t5v0__fill_2
XFILLER_86_685 VDD VDD VSS VSS gf180mcu_fd_sc_mcu7t5v0__fill_1
XFILLER_100_473 VDD VDD VSS VSS gf180mcu_fd_sc_mcu7t5v0__fillcap_8
XFILLER_160_34 VDD VDD VSS VSS gf180mcu_fd_sc_mcu7t5v0__fill_1
XFILLER_46_527 VDD VDD VSS VSS gf180mcu_fd_sc_mcu7t5v0__fillcap_8
XFILLER_58_387 VDD VDD VSS VSS gf180mcu_fd_sc_mcu7t5v0__fill_2
XFILLER_73_335 VDD VDD VSS VSS gf180mcu_fd_sc_mcu7t5v0__fillcap_8
XTAP_TAPCELL_ROW_142_2212 VDD VSS gf180mcu_fd_sc_mcu7t5v0__filltie
XTAP_TAPCELL_ROW_142_2223 VDD VSS gf180mcu_fd_sc_mcu7t5v0__filltie
XFILLER_37_88 VDD VDD VSS VSS gf180mcu_fd_sc_mcu7t5v0__fillcap_4
XTAP_TAPCELL_ROW_107_1642 VDD VSS gf180mcu_fd_sc_mcu7t5v0__filltie
Xwave_controller_y_inst__2715_ wave_controller_y_inst__2737_/A1 wave_controller_y_inst__2714_/Z
+ spi_regs_inst_wire20/I VDD VDD VSS VSS gf180mcu_fd_sc_mcu7t5v0__xor2_1
Xwave_controller_y_inst__3695_ wave_controller_y_inst__3695_/D wave_controller_y_inst__3695_/RN
+ clkload16/I wave_controller_y_inst__3695_/Q VDD VDD VSS VSS gf180mcu_fd_sc_mcu7t5v0__dffrnq_1
Xwave_controller_x_inst__3679_ wave_controller_x_inst__3679_/D wave_controller_x_inst__3712_/RN
+ clkbuf_leaf_31_clk/Z spi_regs_inst__1100_/B2 VDD VDD VSS VSS gf180mcu_fd_sc_mcu7t5v0__dffrnq_1
Xwave_controller_y_inst__2646_ wave_controller_y_inst__2646_/A1 wave_controller_y_inst__2646_/A2
+ wave_controller_y_inst__2646_/B wave_controller_y_inst__2681_/A1 VDD VDD VSS VSS
+ gf180mcu_fd_sc_mcu7t5v0__oai21_1
XFILLER_159_407 VDD VDD VSS VSS gf180mcu_fd_sc_mcu7t5v0__fill_1
XFILLER_159_418 VDD VDD VSS VSS gf180mcu_fd_sc_mcu7t5v0__fill_2
XFILLER_57_1046 VDD VDD VSS VSS gf180mcu_fd_sc_mcu7t5v0__fillcap_4
XFILLER_53_87 VDD VDD VSS VSS gf180mcu_fd_sc_mcu7t5v0__fill_2
XTAP_TAPCELL_ROW_120_1853 VDD VSS gf180mcu_fd_sc_mcu7t5v0__filltie
XTAP_TAPCELL_ROW_120_1864 VDD VSS gf180mcu_fd_sc_mcu7t5v0__filltie
Xwave_controller_y_inst__2577_ wave_controller_y_inst__2607_/A1 wave_controller_y_inst__2578_/A2
+ wave_controller_y_inst__2593_/A2 VDD VDD VSS VSS gf180mcu_fd_sc_mcu7t5v0__nand2_1
XFILLER_139_120 VDD VDD VSS VSS gf180mcu_fd_sc_mcu7t5v0__fillcap_4
XFILLER_41_298 VDD VDD VSS VSS gf180mcu_fd_sc_mcu7t5v0__fill_2
XFILLER_139_142 VDD VDD VSS VSS gf180mcu_fd_sc_mcu7t5v0__fillcap_8
XFILLER_139_164 VDD VDD VSS VSS gf180mcu_fd_sc_mcu7t5v0__fill_1
XFILLER_139_175 VDD VDD VSS VSS gf180mcu_fd_sc_mcu7t5v0__fill_1
XFILLER_155_602 VDD VDD VSS VSS gf180mcu_fd_sc_mcu7t5v0__fillcap_4
Xclkbuf_leaf_21_clk clkbuf_3_5__f_clk/Z clkload26/I VDD VDD VSS VSS gf180mcu_fd_sc_mcu7t5v0__clkbuf_8
XFILLER_127_348 VDD VDD VSS VSS gf180mcu_fd_sc_mcu7t5v0__fill_2
XTAP_TAPCELL_ROW_3_1_357 VDD VSS gf180mcu_fd_sc_mcu7t5v0__filltie
XFILLER_108_551 VDD VDD VSS VSS gf180mcu_fd_sc_mcu7t5v0__fill_2
XFILLER_155_668 VDD VDD VSS VSS gf180mcu_fd_sc_mcu7t5v0__fill_2
XTAP_TAPCELL_ROW_153_2396 VDD VSS gf180mcu_fd_sc_mcu7t5v0__filltie
Xwave_controller_y_inst__3129_ wave_controller_y_inst__3279_/A1 spi_regs_inst__1584_/Q
+ wave_controller_y_inst__3129_/Z VDD VDD VSS VSS gf180mcu_fd_sc_mcu7t5v0__and2_1
XFILLER_123_510 VDD VDD VSS VSS gf180mcu_fd_sc_mcu7t5v0__fill_1
XFILLER_142_329 VDD VDD VSS VSS gf180mcu_fd_sc_mcu7t5v0__fill_1
XFILLER_150_340 VDD VDD VSS VSS gf180mcu_fd_sc_mcu7t5v0__fillcap_4
XFILLER_64_1017 VDD VDD VSS VSS gf180mcu_fd_sc_mcu7t5v0__fillcap_64
XFILLER_68_107 VDD VDD VSS VSS gf180mcu_fd_sc_mcu7t5v0__fillcap_16
XFILLER_69_619 VDD VDD VSS VSS gf180mcu_fd_sc_mcu7t5v0__fill_2
XFILLER_150_384 VDD VDD VSS VSS gf180mcu_fd_sc_mcu7t5v0__fill_1
Xwave_controller_x_inst_wire184 wave_controller_x_inst_wire184/I wave_controller_x_inst_wire184/Z
+ VDD VDD VSS VSS gf180mcu_fd_sc_mcu7t5v0__clkbuf_1
Xwave_controller_x_inst_wire173 wave_controller_x_inst_wire173/I wave_controller_x_inst_wire173/Z
+ VDD VDD VSS VSS gf180mcu_fd_sc_mcu7t5v0__dlyb_1
Xspi_regs_inst__0953_ spi_regs_inst__0918_/Z spi_regs_inst__1008_/A3 spi_regs_inst__1019_/A1
+ VDD VDD VSS VSS gf180mcu_fd_sc_mcu7t5v0__nand2_1
XFILLER_76_173 VDD VDD VSS VSS gf180mcu_fd_sc_mcu7t5v0__fill_2
XFILLER_77_696 VDD VDD VSS VSS gf180mcu_fd_sc_mcu7t5v0__fillcap_4
XFILLER_92_655 VDD VDD VSS VSS gf180mcu_fd_sc_mcu7t5v0__fill_1
Xspi_regs_inst__0884_ spi_regs_inst__1618_/Q spi_regs_inst__1380_/I1 spi_regs_inst__0884_/S
+ spi_regs_inst__1618_/D VDD VDD VSS VSS gf180mcu_fd_sc_mcu7t5v0__mux2_2
XFILLER_52_519 VDD VDD VSS VSS gf180mcu_fd_sc_mcu7t5v0__fill_1
XFILLER_92_688 VDD VDD VSS VSS gf180mcu_fd_sc_mcu7t5v0__fill_2
XFILLER_17_295 VDD VDD VSS VSS gf180mcu_fd_sc_mcu7t5v0__fillcap_4
XFILLER_60_552 VDD VDD VSS VSS gf180mcu_fd_sc_mcu7t5v0__fillcap_16
XFILLER_60_574 VDD VDD VSS VSS gf180mcu_fd_sc_mcu7t5v0__fill_1
Xspi_regs_inst__1505_ spi_regs_inst__1505_/D spi_regs_inst__1605_/RN clkbuf_leaf_38_clk/Z
+ spi_regs_inst__1505_/Q VDD VDD VSS VSS gf180mcu_fd_sc_mcu7t5v0__dffrnq_1
XFILLER_119_816 VDD VDD VSS VSS gf180mcu_fd_sc_mcu7t5v0__fill_2
XFILLER_158_451 VDD VDD VSS VSS gf180mcu_fd_sc_mcu7t5v0__fillcap_4
Xspi_regs_inst__1436_ spi_regs_inst__1506_/Q spi_regs_inst__1445_/I1 spi_regs_inst__1436_/S
+ spi_regs_inst__1506_/D VDD VDD VSS VSS gf180mcu_fd_sc_mcu7t5v0__mux2_2
Xclkbuf_leaf_12_clk clkbuf_3_4__f_clk/Z clkload22/I VDD VDD VSS VSS gf180mcu_fd_sc_mcu7t5v0__clkbuf_8
Xspi_regs_inst__1367_ spi_regs_inst__1652_/Q spi_regs_inst__1379_/S spi_regs_inst__1368_/B
+ VDD VDD VSS VSS gf180mcu_fd_sc_mcu7t5v0__nand2_1
XFILLER_161_605 VDD VDD VSS VSS gf180mcu_fd_sc_mcu7t5v0__fillcap_16
XTAP_TAPCELL_ROW_76_1129 VDD VSS gf180mcu_fd_sc_mcu7t5v0__filltie
XTAP_TAPCELL_ROW_93_1410 VDD VSS gf180mcu_fd_sc_mcu7t5v0__filltie
Xspi_regs_inst__1298_ spi_regs_inst__1362_/A1 spi_regs_inst__1296_/Z spi_regs_inst__1298_/A3
+ spi_regs_inst__1298_/B spi_regs_inst__1647_/D VDD VDD VSS VSS gf180mcu_fd_sc_mcu7t5v0__oai31_1
Xwave_controller_x_inst__2981_ wave_controller_x_inst__1790_/I wave_controller_x_inst__2981_/A2
+ wave_controller_x_inst__2981_/B wave_controller_x_inst__3068_/A3 VDD VDD VSS VSS
+ gf180mcu_fd_sc_mcu7t5v0__oai21_1
Xwave_controller_x_inst__1932_ wave_controller_x_inst__1932_/A1 wave_controller_x_inst__1932_/A2
+ wave_controller_x_inst__1941_/A1 VDD VDD VSS VSS gf180mcu_fd_sc_mcu7t5v0__nor2_1
XFILLER_141_384 VDD VDD VSS VSS gf180mcu_fd_sc_mcu7t5v0__fill_2
XFILLER_68_630 VDD VDD VSS VSS gf180mcu_fd_sc_mcu7t5v0__fillcap_16
Xsignal_processor_y_inst__248_ signal_processor_y_inst__248_/D signal_processor_y_inst__253_/RN
+ clkbuf_leaf_0_clk/Z signal_processor_y_inst__248_/Q VDD VDD VSS VSS gf180mcu_fd_sc_mcu7t5v0__dffrnq_1
XFILLER_56_803 VDD VDD VSS VSS gf180mcu_fd_sc_mcu7t5v0__fill_2
Xwave_controller_x_inst__1863_ max_cap452/Z wave_controller_x_inst__2831_/A1 VDD VDD
+ VSS VSS gf180mcu_fd_sc_mcu7t5v0__clkinv_1
XFILLER_28_527 VDD VDD VSS VSS gf180mcu_fd_sc_mcu7t5v0__fillcap_8
XFILLER_67_173 VDD VDD VSS VSS gf180mcu_fd_sc_mcu7t5v0__fill_2
Xwave_controller_x_inst__3602_ wave_controller_x_inst__3602_/I0 spi_regs_inst__1343_/B2
+ wave_controller_x_inst__3602_/S wave_controller_x_inst__3677_/D VDD VDD VSS VSS
+ gf180mcu_fd_sc_mcu7t5v0__mux2_2
Xwave_controller_x_inst__1794_ wave_controller_x_inst__3706_/Q wave_controller_x_inst__3568_/A1
+ VDD VDD VSS VSS gf180mcu_fd_sc_mcu7t5v0__clkinv_1
Xsignal_processor_y_inst__179_ signal_processor_y_inst__179_/A1 signal_processor_y_inst__239_/Q
+ signal_processor_y_inst__203_/A1 signal_processor_y_inst__181_/B VDD VDD VSS VSS
+ gf180mcu_fd_sc_mcu7t5v0__nand3_1
XTAP_TAPCELL_ROW_27_1_536 VDD VSS gf180mcu_fd_sc_mcu7t5v0__filltie
Xwave_controller_x_inst__3533_ wave_controller_x_inst__3539_/A1 wave_controller_x_inst__3533_/A2
+ wave_controller_x_inst__3533_/A3 wave_controller_x_inst__3545_/B1 wave_controller_x_inst__3533_/B2
+ wave_controller_x_inst__3640_/D VDD VDD VSS VSS gf180mcu_fd_sc_mcu7t5v0__oai32_1
XFILLER_43_519 VDD VDD VSS VSS gf180mcu_fd_sc_mcu7t5v0__fill_2
XFILLER_83_699 VDD VDD VSS VSS gf180mcu_fd_sc_mcu7t5v0__fill_1
Xwave_controller_y_inst__2500_ max_cap427/I spi_regs_inst__1275_/A1 wave_controller_y_inst__2518_/A3
+ VDD VDD VSS VSS gf180mcu_fd_sc_mcu7t5v0__xnor2_1
Xwave_controller_y_inst__3480_ wave_controller_y_inst__3490_/A1 wave_controller_y_inst__3478_/I
+ wave_controller_y_inst__3480_/B wave_controller_y_inst__3480_/C wave_controller_y_inst__3482_/B1
+ VDD VDD VSS VSS gf180mcu_fd_sc_mcu7t5v0__aoi211_1
XFILLER_130_37 VDD VDD VSS VSS gf180mcu_fd_sc_mcu7t5v0__fillcap_4
XFILLER_51_541 VDD VDD VSS VSS gf180mcu_fd_sc_mcu7t5v0__fillcap_8
XFILLER_82_198 VDD VDD VSS VSS gf180mcu_fd_sc_mcu7t5v0__fillcap_4
XTAP_TAPCELL_ROW_35_1_593 VDD VSS gf180mcu_fd_sc_mcu7t5v0__filltie
Xwave_controller_y_inst__2431_ wave_controller_y_inst__2431_/A1 wave_controller_y_inst__2430_/B
+ wave_controller_y_inst__2432_/I VDD VDD VSS VSS gf180mcu_fd_sc_mcu7t5v0__xnor2_1
Xwave_controller_x_inst__3464_ spi_regs_inst__1274_/A1 wave_controller_x_inst_wire370/Z
+ wave_controller_x_inst__3465_/A3 VDD VDD VSS VSS gf180mcu_fd_sc_mcu7t5v0__nor2_1
Xwave_controller_x_inst__3395_ wave_controller_x_inst__3395_/A1 wave_controller_x_inst__3395_/A2
+ wave_controller_x_inst__3395_/B wave_controller_x_inst__3396_/A3 VDD VDD VSS VSS
+ gf180mcu_fd_sc_mcu7t5v0__aoi21_1
Xwave_controller_x_inst__2415_ wave_controller_x_inst__2939_/A2 wave_controller_x_inst__2414_/Z
+ wave_controller_x_inst__2430_/A1 VDD VDD VSS VSS gf180mcu_fd_sc_mcu7t5v0__nor2_1
XTAP_TAPCELL_ROW_102_1561 VDD VSS gf180mcu_fd_sc_mcu7t5v0__filltie
Xwave_controller_y_inst__2362_ wave_controller_y_inst__2373_/A2 wave_controller_y_inst__2362_/A2
+ spi_regs_inst__1285_/A1 VDD VDD VSS VSS gf180mcu_fd_sc_mcu7t5v0__xnor2_1
Xwave_controller_x_inst__2346_ wave_controller_x_inst__2346_/A1 wave_controller_x_inst__2346_/A2
+ wave_controller_x_inst__2346_/B wave_controller_x_inst_wire78/I VDD VDD VSS VSS
+ gf180mcu_fd_sc_mcu7t5v0__aoi21_1
XFILLER_104_1011 VDD VDD VSS VSS gf180mcu_fd_sc_mcu7t5v0__fillcap_4
Xwave_controller_y_inst__2293_ wave_controller_y_inst__2294_/A1 wave_controller_y_inst__2294_/A2
+ wave_controller_y_inst__2293_/B wave_controller_y_inst__2313_/C VDD VDD VSS VSS
+ gf180mcu_fd_sc_mcu7t5v0__aoi21_1
Xwave_controller_x_inst__2277_ wire456/Z wave_controller_x_inst__2275_/Z wave_controller_x_inst__2277_/Z
+ VDD VDD VSS VSS gf180mcu_fd_sc_mcu7t5v0__xor2_1
XFILLER_124_307 VDD VDD VSS VSS gf180mcu_fd_sc_mcu7t5v0__fillcap_8
XFILLER_152_649 VDD VDD VSS VSS gf180mcu_fd_sc_mcu7t5v0__fill_1
Xwave_controller_y_inst_fanout512 spi_regs_inst__1484_/Q wave_controller_y_inst__1816_/I
+ VDD VDD VSS VSS gf180mcu_fd_sc_mcu7t5v0__dlyb_1
XFILLER_145_690 VDD VDD VSS VSS gf180mcu_fd_sc_mcu7t5v0__fill_1
XFILLER_155_67 VDD VDD VSS VSS gf180mcu_fd_sc_mcu7t5v0__fill_2
XFILLER_79_906 VDD VDD VSS VSS gf180mcu_fd_sc_mcu7t5v0__fillcap_4
XFILLER_160_660 VDD VDD VSS VSS gf180mcu_fd_sc_mcu7t5v0__fillcap_4
XFILLER_79_928 VDD VDD VSS VSS gf180mcu_fd_sc_mcu7t5v0__fillcap_4
Xwave_controller_y_inst_fanout567 fanout569/Z wave_controller_y_inst__3689_/RN VDD
+ VDD VSS VSS gf180mcu_fd_sc_mcu7t5v0__dlyb_1
XFILLER_120_524 VDD VDD VSS VSS gf180mcu_fd_sc_mcu7t5v0__fill_1
XFILLER_132_395 VDD VDD VSS VSS gf180mcu_fd_sc_mcu7t5v0__fill_2
XFILLER_78_438 VDD VDD VSS VSS gf180mcu_fd_sc_mcu7t5v0__fill_1
XPHY_EDGE_ROW_2_1_Right_1 VDD VSS gf180mcu_fd_sc_mcu7t5v0__endcap
XTAP_TAPCELL_ROW_57_820 VDD VSS gf180mcu_fd_sc_mcu7t5v0__filltie
XFILLER_104_71 VDD VDD VSS VSS gf180mcu_fd_sc_mcu7t5v0__fillcap_8
XFILLER_98_1157 VDD VDD VSS VSS gf180mcu_fd_sc_mcu7t5v0__fillcap_16
XFILLER_62_839 VDD VDD VSS VSS gf180mcu_fd_sc_mcu7t5v0__fillcap_4
XFILLER_64_53 VDD VDD VSS VSS gf180mcu_fd_sc_mcu7t5v0__fill_1
XFILLER_74_677 VDD VDD VSS VSS gf180mcu_fd_sc_mcu7t5v0__fillcap_8
Xspi_regs_inst_max_cap300 spi_regs_inst__0931_/B1 spi_regs_inst__1252_/A2 VDD VDD
+ VSS VSS gf180mcu_fd_sc_mcu7t5v0__buf_2
XFILLER_61_349 VDD VDD VSS VSS gf180mcu_fd_sc_mcu7t5v0__fill_1
Xwave_controller_y_inst__3678_ wave_controller_y_inst__3678_/D load_slew576/Z clkbuf_leaf_41_clk/Z
+ spi_regs_inst__1033_/C2 VDD VDD VSS VSS gf180mcu_fd_sc_mcu7t5v0__dffrnq_1
XFILLER_14_243 VDD VDD VSS VSS gf180mcu_fd_sc_mcu7t5v0__fill_2
XFILLER_159_226 VDD VDD VSS VSS gf180mcu_fd_sc_mcu7t5v0__fillcap_16
Xwave_controller_y_inst__2629_ wave_controller_y_inst__2601_/Z wave_controller_y_inst__2631_/A2
+ wave_controller_y_inst__2629_/B wave_controller_y_inst__2630_/A2 VDD VDD VSS VSS
+ gf180mcu_fd_sc_mcu7t5v0__aoi21_1
XFILLER_70_894 VDD VDD VSS VSS gf180mcu_fd_sc_mcu7t5v0__fill_1
XTAP_TAPCELL_ROW_155_2436 VDD VSS gf180mcu_fd_sc_mcu7t5v0__filltie
XFILLER_10_471 VDD VDD VSS VSS gf180mcu_fd_sc_mcu7t5v0__fillcap_8
XFILLER_155_410 VDD VDD VSS VSS gf180mcu_fd_sc_mcu7t5v0__fillcap_8
XFILLER_70_1087 VDD VDD VSS VSS gf180mcu_fd_sc_mcu7t5v0__fillcap_64
Xspi_regs_inst__1221_ spi_regs_inst__1221_/A1 spi_regs_inst_wire17/Z spi_regs_inst__1221_/A3
+ spi_regs_inst__1221_/A4 spi_regs_inst__1221_/Z VDD VDD VSS VSS gf180mcu_fd_sc_mcu7t5v0__and4_1
Xsignal_processor_x_inst__199_ spi_regs_inst__1044_/C2 signal_processor_x_inst__199_/A2
+ signal_processor_x_inst__200_/A3 VDD VDD VSS VSS gf180mcu_fd_sc_mcu7t5v0__nor2_1
XFILLER_115_307 VDD VDD VSS VSS gf180mcu_fd_sc_mcu7t5v0__fill_1
Xspi_regs_inst__1152_ spi_regs_inst__1152_/A1 spi_regs_inst__1152_/A2 spi_regs_inst__1152_/A3
+ spi_regs_inst__1152_/A4 spi_regs_inst__1153_/A3 VDD VDD VSS VSS gf180mcu_fd_sc_mcu7t5v0__nand4_1
XFILLER_115_329 VDD VDD VSS VSS gf180mcu_fd_sc_mcu7t5v0__fillcap_4
XFILLER_127_178 VDD VDD VSS VSS gf180mcu_fd_sc_mcu7t5v0__fill_1
XFILLER_127_189 VDD VDD VSS VSS gf180mcu_fd_sc_mcu7t5v0__fillcap_16
XFILLER_143_627 VDD VDD VSS VSS gf180mcu_fd_sc_mcu7t5v0__fill_2
XFILLER_155_476 VDD VDD VSS VSS gf180mcu_fd_sc_mcu7t5v0__fill_1
XFILLER_124_852 VDD VDD VSS VSS gf180mcu_fd_sc_mcu7t5v0__fillcap_16
XFILLER_136_690 VDD VDD VSS VSS gf180mcu_fd_sc_mcu7t5v0__fill_2
XFILLER_89_72 VDD VDD VSS VSS gf180mcu_fd_sc_mcu7t5v0__fillcap_4
XFILLER_89_83 VDD VDD VSS VSS gf180mcu_fd_sc_mcu7t5v0__fill_2
Xspi_regs_inst__1083_ spi_regs_inst__1083_/A1 spi_regs_inst_wire247/Z spi_regs_inst_wire227/Z
+ spi_regs_inst__1083_/B2 spi_regs_inst__1357_/B spi_regs_inst__1084_/A2 VDD VDD VSS
+ VSS gf180mcu_fd_sc_mcu7t5v0__aoi221_1
XFILLER_111_546 VDD VDD VSS VSS gf180mcu_fd_sc_mcu7t5v0__fill_1
XFILLER_150_181 VDD VDD VSS VSS gf180mcu_fd_sc_mcu7t5v0__fill_1
XFILLER_85_909 VDD VDD VSS VSS gf180mcu_fd_sc_mcu7t5v0__fill_1
XTAP_TAPCELL_ROW_71_1048 VDD VSS gf180mcu_fd_sc_mcu7t5v0__filltie
Xclkbuf_leaf_1_clk clkbuf_leaf_3_clk/I clkload1/I VDD VDD VSS VSS gf180mcu_fd_sc_mcu7t5v0__clkbuf_8
XFILLER_37_302 VDD VDD VSS VSS gf180mcu_fd_sc_mcu7t5v0__fillcap_16
XFILLER_93_920 VDD VDD VSS VSS gf180mcu_fd_sc_mcu7t5v0__fill_1
XFILLER_37_346 VDD VDD VSS VSS gf180mcu_fd_sc_mcu7t5v0__fillcap_4
Xspi_regs_inst__0936_ spi_regs_inst__1638_/Q spi_regs_inst__1637_/Q spi_regs_inst__0937_/S
+ spi_regs_inst__1638_/D VDD VDD VSS VSS gf180mcu_fd_sc_mcu7t5v0__mux2_2
XFILLER_92_485 VDD VDD VSS VSS gf180mcu_fd_sc_mcu7t5v0__fill_2
Xspi_regs_inst__0867_ spi_regs_inst__1603_/Q spi_regs_inst__1391_/I1 spi_regs_inst__0870_/S
+ spi_regs_inst__1603_/D VDD VDD VSS VSS gf180mcu_fd_sc_mcu7t5v0__mux2_2
XTAP_TAPCELL_ROW_86_1291 VDD VSS gf180mcu_fd_sc_mcu7t5v0__filltie
Xspi_regs_inst__0798_ spi_regs_inst__1653_/Q spi_regs_inst__1652_/Q spi_regs_inst__0798_/A3
+ spi_regs_inst__0808_/A3 spi_regs_inst__0806_/S VDD VDD VSS VSS gf180mcu_fd_sc_mcu7t5v0__nand4_2
Xwave_controller_x_inst__3180_ wave_controller_x_inst__3004_/B spi_regs_inst__1516_/Q
+ spi_regs_inst__1515_/Q wave_controller_x_inst__3181_/A2 VDD VDD VSS VSS gf180mcu_fd_sc_mcu7t5v0__oai21_1
Xwave_controller_x_inst__2200_ wave_controller_x_inst__2201_/A1 wave_controller_x_inst__2201_/A2
+ wave_controller_x_inst__2201_/B wave_controller_x_inst__2213_/B VDD VDD VSS VSS
+ gf180mcu_fd_sc_mcu7t5v0__nand3_1
XFILLER_20_257 VDD VDD VSS VSS gf180mcu_fd_sc_mcu7t5v0__fill_1
Xwave_controller_x_inst__2131_ wave_controller_x_inst__2145_/I1 wave_controller_x_inst__2131_/A2
+ wave_controller_x_inst__2132_/A2 VDD VDD VSS VSS gf180mcu_fd_sc_mcu7t5v0__xnor2_1
XFILLER_118_101 VDD VDD VSS VSS gf180mcu_fd_sc_mcu7t5v0__fillcap_4
Xspi_regs_inst__1419_ spi_regs_inst__1443_/I1 fanout504/Z spi_regs_inst__1419_/S spi_regs_inst__1491_/D
+ VDD VDD VSS VSS gf180mcu_fd_sc_mcu7t5v0__mux2_2
XFILLER_146_454 VDD VDD VSS VSS gf180mcu_fd_sc_mcu7t5v0__fill_1
Xwave_controller_x_inst__2062_ wave_controller_x_inst__2098_/C wave_controller_x_inst__2062_/A2
+ wave_controller_x_inst__2062_/A3 wave_controller_x_inst__2062_/B1 wave_controller_x_inst__2062_/B2
+ wave_controller_x_inst_wire173/I VDD VDD VSS VSS gf180mcu_fd_sc_mcu7t5v0__oai32_1
XFILLER_118_167 VDD VDD VSS VSS gf180mcu_fd_sc_mcu7t5v0__fillcap_8
XFILLER_133_104 VDD VDD VSS VSS gf180mcu_fd_sc_mcu7t5v0__fill_1
XFILLER_162_947 VDD VDD VSS VSS gf180mcu_fd_sc_mcu7t5v0__fillcap_64
XFILLER_138_1151 VDD VDD VSS VSS gf180mcu_fd_sc_mcu7t5v0__fillcap_4
XFILLER_138_1173 VDD VDD VSS VSS gf180mcu_fd_sc_mcu7t5v0__fill_1
XFILLER_88_703 VDD VDD VSS VSS gf180mcu_fd_sc_mcu7t5v0__fill_2
XFILLER_102_535 VDD VDD VSS VSS gf180mcu_fd_sc_mcu7t5v0__fill_2
XFILLER_114_373 VDD VDD VSS VSS gf180mcu_fd_sc_mcu7t5v0__fillcap_8
Xwave_controller_y_inst__2980_ wave_controller_y_inst__1790_/I wave_controller_y_inst__1821_/I
+ wave_controller_y_inst__3061_/A1 wave_controller_y_inst__2977_/Z wave_controller_y_inst__2980_/C
+ wave_controller_y_inst__2985_/A3 VDD VDD VSS VSS gf180mcu_fd_sc_mcu7t5v0__aoi221_1
Xwave_controller_x_inst__2964_ wave_controller_x_inst__3701_/Q wave_controller_x_inst__3231_/B
+ wave_controller_x_inst__3043_/A3 VDD VDD VSS VSS gf180mcu_fd_sc_mcu7t5v0__nand2_1
XFILLER_141_192 VDD VDD VSS VSS gf180mcu_fd_sc_mcu7t5v0__fill_2
XFILLER_87_246 VDD VDD VSS VSS gf180mcu_fd_sc_mcu7t5v0__fillcap_8
Xwave_controller_y_inst__1931_ spi_regs_inst__1573_/Q wave_controller_y_inst__3312_/A1
+ spi_regs_inst__1572_/Q wave_controller_y_inst__3163_/C wave_controller_y_inst__1932_/A2
+ VDD VDD VSS VSS gf180mcu_fd_sc_mcu7t5v0__oai22_1
Xwave_controller_x_inst__2895_ wave_controller_x_inst__2910_/B wave_controller_x_inst__2764_/Z
+ wave_controller_x_inst__2933_/A1 wave_controller_x_inst__3700_/Q wave_controller_x_inst__2895_/C
+ wave_controller_x_inst__2902_/A2 VDD VDD VSS VSS gf180mcu_fd_sc_mcu7t5v0__aoi221_1
Xwave_controller_x_inst__1915_ wave_controller_x_inst__1915_/A1 wave_controller_x_inst__3718_/Q
+ wave_controller_x_inst__1778_/I wave_controller_x_inst__1942_/A2 wave_controller_x_inst__1943_/C1
+ VDD VDD VSS VSS gf180mcu_fd_sc_mcu7t5v0__aoi22_1
XFILLER_68_471 VDD VDD VSS VSS gf180mcu_fd_sc_mcu7t5v0__fillcap_8
Xwave_controller_y_inst__1862_ max_cap426/I wave_controller_y_inst__2829_/A1 VDD VDD
+ VSS VSS gf180mcu_fd_sc_mcu7t5v0__clkinv_1
Xwave_controller_x_inst__1846_ spi_regs_inst__1052_/B2 wave_controller_x_inst__2379_/A1
+ VDD VDD VSS VSS gf180mcu_fd_sc_mcu7t5v0__clkinv_1
XFILLER_141_36 VDD VDD VSS VSS gf180mcu_fd_sc_mcu7t5v0__fill_2
XFILLER_83_430 VDD VDD VSS VSS gf180mcu_fd_sc_mcu7t5v0__fillcap_4
XTAP_TAPCELL_ROW_2_1_345 VDD VSS gf180mcu_fd_sc_mcu7t5v0__filltie
Xwave_controller_y_inst__3601_ wave_controller_y_inst__3601_/I0 spi_regs_inst__1315_/A1
+ wave_controller_y_inst__3602_/S wave_controller_y_inst__3676_/D VDD VDD VSS VSS
+ gf180mcu_fd_sc_mcu7t5v0__mux2_2
XFILLER_141_69 VDD VDD VSS VSS gf180mcu_fd_sc_mcu7t5v0__fill_1
XFILLER_28_368 VDD VDD VSS VSS gf180mcu_fd_sc_mcu7t5v0__fillcap_16
XFILLER_55_176 VDD VDD VSS VSS gf180mcu_fd_sc_mcu7t5v0__fillcap_4
XFILLER_70_102 VDD VDD VSS VSS gf180mcu_fd_sc_mcu7t5v0__fill_2
Xwave_controller_y_inst__3532_ spi_regs_inst__1256_/A1 wave_controller_y_inst__3556_/A2
+ wave_controller_y_inst__3533_/A3 VDD VDD VSS VSS gf180mcu_fd_sc_mcu7t5v0__nor2_1
Xwave_controller_y_inst__1793_ wave_controller_y_inst__3707_/Q wave_controller_y_inst__3570_/A1
+ VDD VDD VSS VSS gf180mcu_fd_sc_mcu7t5v0__clkinv_1
Xwave_controller_x_inst__1777_ wave_controller_x_inst__3718_/Q wave_controller_x_inst__3004_/B
+ VDD VDD VSS VSS gf180mcu_fd_sc_mcu7t5v0__clkinv_1
XFILLER_110_1081 VDD VDD VSS VSS gf180mcu_fd_sc_mcu7t5v0__fillcap_4
XFILLER_43_338 VDD VDD VSS VSS gf180mcu_fd_sc_mcu7t5v0__fillcap_4
XTAP_TAPCELL_ROW_104_1601 VDD VSS gf180mcu_fd_sc_mcu7t5v0__filltie
Xwave_controller_x_inst__3516_ wave_controller_x_inst__3708_/Q wave_controller_x_inst__3537_/A2
+ wave_controller_x_inst__3518_/A2 VDD VDD VSS VSS gf180mcu_fd_sc_mcu7t5v0__nor2_1
XFILLER_145_1122 VDD VDD VSS VSS gf180mcu_fd_sc_mcu7t5v0__fillcap_32
XFILLER_34_34 VDD VDD VSS VSS gf180mcu_fd_sc_mcu7t5v0__fill_1
Xwave_controller_y_inst__3463_ wave_controller_y_inst__3697_/Q wave_controller_y_inst__3483_/A2
+ wave_controller_y_inst__3465_/A2 VDD VDD VSS VSS gf180mcu_fd_sc_mcu7t5v0__nor2_1
Xwave_controller_x_inst__3447_ wave_controller_x_inst__3695_/Q wave_controller_x_inst__3451_/A2
+ wave_controller_x_inst__3447_/S wave_controller_x_inst__3447_/Z VDD VDD VSS VSS
+ gf180mcu_fd_sc_mcu7t5v0__mux2_2
XFILLER_51_371 VDD VDD VSS VSS gf180mcu_fd_sc_mcu7t5v0__fill_1
XFILLER_51_382 VDD VDD VSS VSS gf180mcu_fd_sc_mcu7t5v0__fill_1
Xwave_controller_y_inst__2414_ wave_controller_y_inst__2411_/Z wave_controller_y_inst__2416_/A3
+ wave_controller_y_inst__2414_/Z VDD VDD VSS VSS gf180mcu_fd_sc_mcu7t5v0__xor2_1
Xwave_controller_y_inst__3394_ fanout513/Z wave_controller_y_inst__3354_/Z wave_controller_y_inst__3394_/A3
+ wave_controller_y_inst__3394_/B1 wave_controller_y_inst__1818_/I wave_controller_y_inst__3395_/B
+ VDD VDD VSS VSS gf180mcu_fd_sc_mcu7t5v0__oai32_1
Xsignal_processor_x_inst__122_ signal_processor_x_inst__128_/A1 signal_processor_x_inst__250_/Q
+ signal_processor_x_inst__251_/D VDD VDD VSS VSS gf180mcu_fd_sc_mcu7t5v0__and2_1
XTAP_TAPCELL_ROW_137_2133 VDD VSS gf180mcu_fd_sc_mcu7t5v0__filltie
Xwave_controller_y_inst__2345_ wave_controller_y_inst__2345_/A1 wave_controller_y_inst__2345_/A2
+ wave_controller_y_inst__2345_/B wave_controller_y_inst__2345_/C wave_controller_y_inst__2346_/B
+ VDD VDD VSS VSS gf180mcu_fd_sc_mcu7t5v0__oai211_1
Xwave_controller_x_inst__3378_ wave_controller_x_inst__3701_/Q wave_controller_x_inst__3378_/A2
+ fanout530/Z wave_controller_x_inst__3283_/B wave_controller_x_inst__3378_/C wave_controller_x_inst__3382_/A2
+ VDD VDD VSS VSS gf180mcu_fd_sc_mcu7t5v0__aoi221_1
XFILLER_156_229 VDD VDD VSS VSS gf180mcu_fd_sc_mcu7t5v0__fill_2
XFILLER_7_206 VDD VDD VSS VSS gf180mcu_fd_sc_mcu7t5v0__fillcap_4
XTAP_TAPCELL_ROW_137_2144 VDD VSS gf180mcu_fd_sc_mcu7t5v0__filltie
Xwave_controller_x_inst__2329_ wave_controller_x_inst__2345_/C wave_controller_x_inst__2328_/Z
+ wave_controller_x_inst__2331_/A1 VDD VDD VSS VSS gf180mcu_fd_sc_mcu7t5v0__nand2_1
Xclkload0 clkload0/I clkload0/Z VDD VDD VSS VSS gf180mcu_fd_sc_mcu7t5v0__clkbuf_8
Xwave_controller_y_inst__2276_ spi_regs_inst__1034_/A1 wave_controller_y_inst__2275_/Z
+ wave_controller_y_inst__2294_/A2 VDD VDD VSS VSS gf180mcu_fd_sc_mcu7t5v0__nand2_1
XTAP_TAPCELL_ROW_150_2344 VDD VSS gf180mcu_fd_sc_mcu7t5v0__filltie
XFILLER_124_148 VDD VDD VSS VSS gf180mcu_fd_sc_mcu7t5v0__fill_1
XFILLER_152_457 VDD VDD VSS VSS gf180mcu_fd_sc_mcu7t5v0__fillcap_32
XTAP_TAPCELL_ROW_150_2355 VDD VSS gf180mcu_fd_sc_mcu7t5v0__filltie
XTAP_TAPCELL_ROW_40_1_634 VDD VSS gf180mcu_fd_sc_mcu7t5v0__filltie
Xwave_controller_y_inst_fanout320 wave_controller_y_inst_wire323/Z wave_controller_y_inst__2917_/A2
+ VDD VDD VSS VSS gf180mcu_fd_sc_mcu7t5v0__dlyb_1
XFILLER_105_340 VDD VDD VSS VSS gf180mcu_fd_sc_mcu7t5v0__fill_1
XFILLER_106_874 VDD VDD VSS VSS gf180mcu_fd_sc_mcu7t5v0__fill_1
XFILLER_1_2 VDD VDD VSS VSS gf180mcu_fd_sc_mcu7t5v0__fillcap_64
XTAP_TAPCELL_ROW_115_1774 VDD VSS gf180mcu_fd_sc_mcu7t5v0__filltie
Xwave_controller_y_inst_fanout353 wave_controller_y_inst__2125_/C wave_controller_y_inst__2108_/B
+ VDD VDD VSS VSS gf180mcu_fd_sc_mcu7t5v0__dlyb_1
XFILLER_121_833 VDD VDD VSS VSS gf180mcu_fd_sc_mcu7t5v0__fillcap_4
XFILLER_133_682 VDD VDD VSS VSS gf180mcu_fd_sc_mcu7t5v0__fill_2
XFILLER_3_489 VDD VDD VSS VSS gf180mcu_fd_sc_mcu7t5v0__fill_1
XFILLER_67_909 VDD VDD VSS VSS gf180mcu_fd_sc_mcu7t5v0__fill_1
Xwave_controller_y_inst_fanout364 wave_controller_y_inst__3340_/A1 wave_controller_y_inst__3189_/A1
+ VDD VDD VSS VSS gf180mcu_fd_sc_mcu7t5v0__dlyb_1
XFILLER_120_376 VDD VDD VSS VSS gf180mcu_fd_sc_mcu7t5v0__fill_1
XFILLER_75_52 VDD VDD VSS VSS gf180mcu_fd_sc_mcu7t5v0__fill_2
XFILLER_93_249 VDD VDD VSS VSS gf180mcu_fd_sc_mcu7t5v0__fillcap_8
XFILLER_19_379 VDD VDD VSS VSS gf180mcu_fd_sc_mcu7t5v0__fill_1
XFILLER_46_165 VDD VDD VSS VSS gf180mcu_fd_sc_mcu7t5v0__fillcap_8
XFILLER_62_625 VDD VDD VSS VSS gf180mcu_fd_sc_mcu7t5v0__fillcap_4
XFILLER_62_658 VDD VDD VSS VSS gf180mcu_fd_sc_mcu7t5v0__fillcap_4
XFILLER_131_80 VDD VDD VSS VSS gf180mcu_fd_sc_mcu7t5v0__fill_2
XFILLER_15_552 VDD VDD VSS VSS gf180mcu_fd_sc_mcu7t5v0__fill_2
Xspi_regs_inst_load_slew489 spi_regs_inst__1406_/I1 spi_regs_inst__1439_/I1 VDD VDD
+ VSS VSS gf180mcu_fd_sc_mcu7t5v0__buf_4
Xspi_regs_inst_load_slew478 spi_regs_inst__1380_/I1 spi_regs_inst__1408_/I1 VDD VDD
+ VSS VSS gf180mcu_fd_sc_mcu7t5v0__buf_4
XTAP_TAPCELL_ROW_60_859 VDD VSS gf180mcu_fd_sc_mcu7t5v0__filltie
XFILLER_156_730 VDD VDD VSS VSS gf180mcu_fd_sc_mcu7t5v0__fillcap_4
XFILLER_128_454 VDD VDD VSS VSS gf180mcu_fd_sc_mcu7t5v0__fill_1
Xspi_regs_inst__1204_ spi_regs_inst__1531_/Q spi_regs_inst__1348_/B1 spi_regs_inst__1234_/A2
+ spi_regs_inst__1204_/B2 spi_regs_inst__1205_/A4 VDD VDD VSS VSS gf180mcu_fd_sc_mcu7t5v0__aoi22_1
XFILLER_116_638 VDD VDD VSS VSS gf180mcu_fd_sc_mcu7t5v0__fill_1
XFILLER_128_498 VDD VDD VSS VSS gf180mcu_fd_sc_mcu7t5v0__fillcap_4
XFILLER_144_947 VDD VDD VSS VSS gf180mcu_fd_sc_mcu7t5v0__fillcap_64
XFILLER_155_284 VDD VDD VSS VSS gf180mcu_fd_sc_mcu7t5v0__fill_1
XTAP_TAPCELL_ROW_26_1_524 VDD VSS gf180mcu_fd_sc_mcu7t5v0__filltie
Xmax_cap426 max_cap426/I max_cap426/Z VDD VDD VSS VSS gf180mcu_fd_sc_mcu7t5v0__buf_4
XFILLER_143_457 VDD VDD VSS VSS gf180mcu_fd_sc_mcu7t5v0__fill_1
Xspi_regs_inst__1135_ spi_regs_inst__1564_/Q spi_regs_inst__1135_/A2 spi_regs_inst__1200_/B1
+ spi_regs_inst__1135_/B2 spi_regs_inst__1137_/A2 VDD VDD VSS VSS gf180mcu_fd_sc_mcu7t5v0__aoi22_1
XFILLER_112_811 VDD VDD VSS VSS gf180mcu_fd_sc_mcu7t5v0__fill_2
XFILLER_115_159 VDD VDD VSS VSS gf180mcu_fd_sc_mcu7t5v0__fill_1
XFILLER_143_479 VDD VDD VSS VSS gf180mcu_fd_sc_mcu7t5v0__fillcap_8
XFILLER_69_202 VDD VDD VSS VSS gf180mcu_fd_sc_mcu7t5v0__fillcap_8
Xspi_regs_inst__1066_ fanout542/Z spi_regs_inst__1156_/A2 spi_regs_inst__1257_/B1
+ spi_regs_inst_wire20/Z spi_regs_inst__1067_/A4 VDD VDD VSS VSS gf180mcu_fd_sc_mcu7t5v0__aoi22_1
XFILLER_130_129 VDD VDD VSS VSS gf180mcu_fd_sc_mcu7t5v0__fillcap_4
XFILLER_34_2 VDD VDD VSS VSS gf180mcu_fd_sc_mcu7t5v0__fillcap_16
XFILLER_97_533 VDD VDD VSS VSS gf180mcu_fd_sc_mcu7t5v0__fill_1
XPHY_EDGE_ROW_29_1_Right_28 VDD VSS gf180mcu_fd_sc_mcu7t5v0__endcap
XFILLER_111_354 VDD VDD VSS VSS gf180mcu_fd_sc_mcu7t5v0__fill_1
XFILLER_111_365 VDD VDD VSS VSS gf180mcu_fd_sc_mcu7t5v0__fillcap_8
XPHY_EDGE_ROW_127_Right_127 VDD VSS gf180mcu_fd_sc_mcu7t5v0__endcap
XTAP_TAPCELL_ROW_88_1331 VDD VSS gf180mcu_fd_sc_mcu7t5v0__filltie
Xwave_controller_x_inst__2680_ wave_controller_x_inst__2680_/A1 wave_controller_x_inst__2680_/A2
+ wave_controller_x_inst__2681_/C wave_controller_x_inst__2712_/A1 VDD VDD VSS VSS
+ gf180mcu_fd_sc_mcu7t5v0__oai21_1
XFILLER_65_452 VDD VDD VSS VSS gf180mcu_fd_sc_mcu7t5v0__fill_1
XFILLER_93_761 VDD VDD VSS VSS gf180mcu_fd_sc_mcu7t5v0__fillcap_8
XFILLER_93_772 VDD VDD VSS VSS gf180mcu_fd_sc_mcu7t5v0__fillcap_4
Xspi_regs_inst__0919_ spi_regs_inst__0909_/Z spi_regs_inst__0918_/Z spi_regs_inst__1013_/A1
+ VDD VDD VSS VSS gf180mcu_fd_sc_mcu7t5v0__nand2_1
XFILLER_25_349 VDD VDD VSS VSS gf180mcu_fd_sc_mcu7t5v0__fill_1
XFILLER_52_102 VDD VDD VSS VSS gf180mcu_fd_sc_mcu7t5v0__fill_2
XFILLER_65_485 VDD VDD VSS VSS gf180mcu_fd_sc_mcu7t5v0__fillcap_4
XFILLER_80_411 VDD VDD VSS VSS gf180mcu_fd_sc_mcu7t5v0__fill_2
XFILLER_52_146 VDD VDD VSS VSS gf180mcu_fd_sc_mcu7t5v0__fillcap_4
Xwave_controller_x_inst__3301_ wave_controller_x_inst__1790_/I spi_regs_inst__1550_/Q
+ wave_controller_x_inst__3301_/Z VDD VDD VSS VSS gf180mcu_fd_sc_mcu7t5v0__xor2_1
Xwave_controller_x_inst__3232_ wave_controller_x_inst__2797_/C spi_regs_inst__1520_/Q
+ wave_controller_x_inst__3232_/B1 wave_controller_x_inst__3232_/B2 wave_controller_x_inst__3232_/C
+ wave_controller_x_inst__3233_/C VDD VDD VSS VSS gf180mcu_fd_sc_mcu7t5v0__aoi221_1
XFILLER_33_393 VDD VDD VSS VSS gf180mcu_fd_sc_mcu7t5v0__fillcap_4
XFILLER_166_527 VDD VDD VSS VSS gf180mcu_fd_sc_mcu7t5v0__fillcap_16
Xwave_controller_x_inst__3163_ wave_controller_x_inst__3312_/A1 spi_regs_inst__1531_/Q
+ spi_regs_inst__1530_/Q wave_controller_x_inst__3163_/C wave_controller_x_inst__3164_/A2
+ VDD VDD VSS VSS gf180mcu_fd_sc_mcu7t5v0__oai211_1
Xwave_controller_y_inst__2130_ wave_controller_y_inst__2130_/A1 wave_controller_y_inst__2130_/A2
+ wave_controller_y_inst__2130_/B wave_controller_y_inst__2131_/A2 VDD VDD VSS VSS
+ gf180mcu_fd_sc_mcu7t5v0__oai21_1
Xwave_controller_x_inst__3094_ wave_controller_x_inst__2117_/B wave_controller_x_inst__3094_/A2
+ wave_controller_x_inst__3612_/Q wave_controller_x_inst__3098_/A1 VDD VDD VSS VSS
+ gf180mcu_fd_sc_mcu7t5v0__oai21_1
Xwave_controller_x_inst__2114_ wave_controller_x_inst__2114_/A1 wave_controller_x_inst__2114_/A2
+ wave_controller_x_inst__2114_/B wave_controller_x_inst__2144_/B wave_controller_x_inst__2116_/C
+ VDD VDD VSS VSS gf180mcu_fd_sc_mcu7t5v0__aoi211_1
XFILLER_134_402 VDD VDD VSS VSS gf180mcu_fd_sc_mcu7t5v0__fill_1
XFILLER_147_796 VDD VDD VSS VSS gf180mcu_fd_sc_mcu7t5v0__fill_2
Xwave_controller_y_inst__2061_ wave_controller_y_inst__2061_/A1 wave_controller_y_inst__2074_/A3
+ wave_controller_y_inst__2079_/B wave_controller_y_inst__2108_/B wave_controller_y_inst__2062_/A3
+ VDD VDD VSS VSS gf180mcu_fd_sc_mcu7t5v0__aoi211_1
Xwave_controller_x_inst__2045_ wave_controller_x_inst__2125_/A2 wave_controller_x_inst__2125_/B
+ wave_controller_x_inst__2138_/A1 VDD VDD VSS VSS gf180mcu_fd_sc_mcu7t5v0__nand2_1
XTAP_TAPCELL_ROW_132_2052 VDD VSS gf180mcu_fd_sc_mcu7t5v0__filltie
XTAP_TAPCELL_ROW_132_2063 VDD VSS gf180mcu_fd_sc_mcu7t5v0__filltie
XFILLER_20_69 VDD VDD VSS VSS gf180mcu_fd_sc_mcu7t5v0__fill_2
Xspi_regs_inst_wire252 spi_regs_inst_wire252/I spi_regs_inst_wire252/Z VDD VDD VSS
+ VSS gf180mcu_fd_sc_mcu7t5v0__buf_2
Xspi_regs_inst_wire241 spi_regs_inst_wire241/I spi_regs_inst_wire241/Z VDD VDD VSS
+ VSS gf180mcu_fd_sc_mcu7t5v0__buf_2
XFILLER_102_310 VDD VDD VSS VSS gf180mcu_fd_sc_mcu7t5v0__fillcap_4
XFILLER_103_844 VDD VDD VSS VSS gf180mcu_fd_sc_mcu7t5v0__fill_1
Xspi_regs_inst_wire263 spi_regs_inst_wire263/I spi_regs_inst_wire263/Z VDD VDD VSS
+ VSS gf180mcu_fd_sc_mcu7t5v0__buf_2
XFILLER_130_652 VDD VDD VSS VSS gf180mcu_fd_sc_mcu7t5v0__fill_1
Xwave_controller_y_inst__2963_ wave_controller_y_inst__3702_/Q fanout509/I wave_controller_y_inst__2965_/A1
+ VDD VDD VSS VSS gf180mcu_fd_sc_mcu7t5v0__nor2_1
Xspi_regs_inst_wire296 spi_regs_inst_wire297/Z spi_regs_inst_wire296/Z VDD VDD VSS
+ VSS gf180mcu_fd_sc_mcu7t5v0__buf_2
XFILLER_102_387 VDD VDD VSS VSS gf180mcu_fd_sc_mcu7t5v0__fillcap_4
XFILLER_130_696 VDD VDD VSS VSS gf180mcu_fd_sc_mcu7t5v0__fillcap_16
XFILLER_48_419 VDD VDD VSS VSS gf180mcu_fd_sc_mcu7t5v0__fill_2
XFILLER_57_920 VDD VDD VSS VSS gf180mcu_fd_sc_mcu7t5v0__fillcap_32
XFILLER_75_216 VDD VDD VSS VSS gf180mcu_fd_sc_mcu7t5v0__fill_1
XTAP_TAPCELL_ROW_110_1693 VDD VSS gf180mcu_fd_sc_mcu7t5v0__filltie
Xwave_controller_y_inst__1914_ spi_regs_inst__1559_/Q wave_controller_y_inst__3189_/C
+ wave_controller_y_inst__3189_/A1 spi_regs_inst__1560_/Q wave_controller_y_inst__1944_/A1
+ VDD VDD VSS VSS gf180mcu_fd_sc_mcu7t5v0__oai22_1
Xwave_controller_x_inst__2947_ wave_controller_x_inst__1790_/I wave_controller_x_inst__2981_/A2
+ wave_controller_x_inst__3068_/A2 VDD VDD VSS VSS gf180mcu_fd_sc_mcu7t5v0__nand2_1
XFILLER_151_1170 VDD VDD VSS VSS gf180mcu_fd_sc_mcu7t5v0__fillcap_4
Xwave_controller_y_inst__2894_ wave_controller_y_inst__3407_/B wave_controller_y_inst__3454_/A2
+ wave_controller_y_inst__2933_/A1 VDD VDD VSS VSS gf180mcu_fd_sc_mcu7t5v0__nor2_1
Xwave_controller_x_inst__2878_ wave_controller_x_inst__2878_/A1 wave_controller_x_inst__2878_/A2
+ wave_controller_x_inst__2887_/A1 VDD VDD VSS VSS gf180mcu_fd_sc_mcu7t5v0__nand2_1
XFILLER_72_912 VDD VDD VSS VSS gf180mcu_fd_sc_mcu7t5v0__fillcap_8
XFILLER_95_1116 VDD VDD VSS VSS gf180mcu_fd_sc_mcu7t5v0__fillcap_4
Xwave_controller_y_inst__1845_ spi_regs_inst__1333_/B2 wave_controller_y_inst__2380_/A1
+ VDD VDD VSS VSS gf180mcu_fd_sc_mcu7t5v0__clkinv_1
Xwave_controller_x_inst__1829_ fanout400/Z wave_controller_x_inst__3572_/A2 VDD VDD
+ VSS VSS gf180mcu_fd_sc_mcu7t5v0__clkinv_1
XFILLER_16_349 VDD VDD VSS VSS gf180mcu_fd_sc_mcu7t5v0__fillcap_16
XFILLER_56_485 VDD VDD VSS VSS gf180mcu_fd_sc_mcu7t5v0__fill_1
XFILLER_83_282 VDD VDD VSS VSS gf180mcu_fd_sc_mcu7t5v0__fillcap_4
XTAP_TAPCELL_ROW_67_981 VDD VSS gf180mcu_fd_sc_mcu7t5v0__filltie
Xwave_controller_y_inst__1776_ spi_regs_inst__1558_/Q wave_controller_y_inst__1915_/A1
+ VDD VDD VSS VSS gf180mcu_fd_sc_mcu7t5v0__clkinv_1
XFILLER_71_455 VDD VDD VSS VSS gf180mcu_fd_sc_mcu7t5v0__fill_1
Xwave_controller_y_inst__3515_ wave_controller_y_inst_wire144/Z wave_controller_y_inst__3515_/A2
+ wave_controller_y_inst__3515_/A3 wave_controller_y_inst_wire139/Z wave_controller_y_inst__3515_/B2
+ wave_controller_y_inst__3634_/D VDD VDD VSS VSS gf180mcu_fd_sc_mcu7t5v0__oai32_1
Xwave_controller_y_inst__3446_ wave_controller_y_inst__3489_/C wave_controller_y_inst__1902_/I
+ wave_controller_y_inst__3419_/B wave_controller_y_inst__3450_/A1 VDD VDD VSS VSS
+ gf180mcu_fd_sc_mcu7t5v0__nand3_1
XFILLER_101_94 VDD VDD VSS VSS gf180mcu_fd_sc_mcu7t5v0__fill_1
XFILLER_12_522 VDD VDD VSS VSS gf180mcu_fd_sc_mcu7t5v0__fill_2
XFILLER_157_538 VDD VDD VSS VSS gf180mcu_fd_sc_mcu7t5v0__fill_1
XFILLER_61_76 VDD VDD VSS VSS gf180mcu_fd_sc_mcu7t5v0__fill_1
Xwave_controller_y_inst__3377_ fanout509/Z wave_controller_y_inst__3282_/B wave_controller_y_inst__3377_/B
+ wave_controller_y_inst__3382_/A1 VDD VDD VSS VSS gf180mcu_fd_sc_mcu7t5v0__aoi21_1
XTAP_TAPCELL_ROW_117_1803 VDD VSS gf180mcu_fd_sc_mcu7t5v0__filltie
XTAP_TAPCELL_ROW_117_1814 VDD VSS gf180mcu_fd_sc_mcu7t5v0__filltie
Xwave_controller_y_inst__2328_ wave_controller_y_inst__2328_/A1 wave_controller_y_inst__2303_/Z
+ wave_controller_y_inst__2327_/B wave_controller_y_inst__2328_/Z VDD VDD VSS VSS
+ gf180mcu_fd_sc_mcu7t5v0__or3_1
XFILLER_126_947 VDD VDD VSS VSS gf180mcu_fd_sc_mcu7t5v0__fillcap_64
Xwave_controller_y_inst__2259_ wave_controller_y_inst__2259_/A1 wave_controller_y_inst__2259_/A2
+ wave_controller_y_inst__2259_/B1 wave_controller_y_inst__2259_/B2 wave_controller_y_inst__2259_/C
+ wave_controller_y_inst_wire153/I VDD VDD VSS VSS gf180mcu_fd_sc_mcu7t5v0__oai221_1
XFILLER_153_766 VDD VDD VSS VSS gf180mcu_fd_sc_mcu7t5v0__fillcap_4
XFILLER_112_107 VDD VDD VSS VSS gf180mcu_fd_sc_mcu7t5v0__fillcap_4
XFILLER_152_243 VDD VDD VSS VSS gf180mcu_fd_sc_mcu7t5v0__fill_2
XFILLER_152_287 VDD VDD VSS VSS gf180mcu_fd_sc_mcu7t5v0__fill_2
XFILLER_126_91 VDD VDD VSS VSS gf180mcu_fd_sc_mcu7t5v0__fillcap_4
XFILLER_156_1081 VDD VDD VSS VSS gf180mcu_fd_sc_mcu7t5v0__fillcap_4
XFILLER_86_84 VDD VDD VSS VSS gf180mcu_fd_sc_mcu7t5v0__fill_2
XFILLER_86_95 VDD VDD VSS VSS gf180mcu_fd_sc_mcu7t5v0__fillcap_4
XFILLER_94_547 VDD VDD VSS VSS gf180mcu_fd_sc_mcu7t5v0__fill_2
XTAP_TAPCELL_ROW_163_2568 VDD VSS gf180mcu_fd_sc_mcu7t5v0__filltie
XFILLER_19_154 VDD VDD VSS VSS gf180mcu_fd_sc_mcu7t5v0__fill_2
XFILLER_63_912 VDD VDD VSS VSS gf180mcu_fd_sc_mcu7t5v0__fillcap_4
XFILLER_75_772 VDD VDD VSS VSS gf180mcu_fd_sc_mcu7t5v0__fillcap_4
XFILLER_142_90 VDD VDD VSS VSS gf180mcu_fd_sc_mcu7t5v0__fill_2
XFILLER_90_731 VDD VDD VSS VSS gf180mcu_fd_sc_mcu7t5v0__fillcap_4
XTAP_TAPCELL_ROW_128_1987 VDD VSS gf180mcu_fd_sc_mcu7t5v0__filltie
XFILLER_34_157 VDD VDD VSS VSS gf180mcu_fd_sc_mcu7t5v0__fillcap_4
XFILLER_62_444 VDD VDD VSS VSS gf180mcu_fd_sc_mcu7t5v0__fill_2
XFILLER_62_499 VDD VDD VSS VSS gf180mcu_fd_sc_mcu7t5v0__fill_2
XTAP_TAPCELL_ROW_83_1250 VDD VSS gf180mcu_fd_sc_mcu7t5v0__filltie
XFILLER_163_1052 VDD VDD VSS VSS gf180mcu_fd_sc_mcu7t5v0__fillcap_64
XPHY_EDGE_ROW_106_Left_273 VDD VSS gf180mcu_fd_sc_mcu7t5v0__endcap
XFILLER_129_763 VDD VDD VSS VSS gf180mcu_fd_sc_mcu7t5v0__fill_1
XFILLER_144_711 VDD VDD VSS VSS gf180mcu_fd_sc_mcu7t5v0__fill_1
XFILLER_128_295 VDD VDD VSS VSS gf180mcu_fd_sc_mcu7t5v0__fillcap_16
XFILLER_132_939 VDD VDD VSS VSS gf180mcu_fd_sc_mcu7t5v0__fillcap_4
Xspi_regs_inst__1118_ spi_regs_inst__1118_/A1 spi_regs_inst__1118_/A2 spi_regs_inst__1118_/A3
+ spi_regs_inst__1118_/A4 spi_regs_inst__1123_/A2 VDD VDD VSS VSS gf180mcu_fd_sc_mcu7t5v0__nand4_1
XFILLER_131_438 VDD VDD VSS VSS gf180mcu_fd_sc_mcu7t5v0__fillcap_8
XFILLER_98_831 VDD VDD VSS VSS gf180mcu_fd_sc_mcu7t5v0__fill_2
XPHY_EDGE_ROW_115_Left_282 VDD VSS gf180mcu_fd_sc_mcu7t5v0__endcap
XFILLER_100_803 VDD VDD VSS VSS gf180mcu_fd_sc_mcu7t5v0__fill_2
XFILLER_135_1154 VDD VDD VSS VSS gf180mcu_fd_sc_mcu7t5v0__fillcap_16
Xwave_controller_x_inst__2801_ wave_controller_x_inst__3562_/A1 wave_controller_x_inst__2798_/Z
+ wave_controller_x_inst__2800_/Z wave_controller_x_inst__3564_/A1 wave_controller_x_inst__2802_/B
+ VDD VDD VSS VSS gf180mcu_fd_sc_mcu7t5v0__oai22_1
Xspi_regs_inst__1049_ spi_regs_inst__1049_/A1 spi_regs_inst__1049_/A2 spi_regs_inst__1049_/A3
+ spi_regs_inst__1049_/A4 spi_regs_inst__1049_/Z VDD VDD VSS VSS gf180mcu_fd_sc_mcu7t5v0__and4_1
XFILLER_100_825 VDD VDD VSS VSS gf180mcu_fd_sc_mcu7t5v0__fillcap_8
XFILLER_111_162 VDD VDD VSS VSS gf180mcu_fd_sc_mcu7t5v0__fill_1
XFILLER_100_847 VDD VDD VSS VSS gf180mcu_fd_sc_mcu7t5v0__fillcap_16
Xwave_controller_x_inst__2732_ spi_regs_inst__1169_/B2 wave_controller_x_inst__2731_/Z
+ wave_controller_x_inst__2748_/A2 VDD VDD VSS VSS gf180mcu_fd_sc_mcu7t5v0__nor2_1
Xwave_controller_x_inst__2663_ wave_controller_x_inst__2663_/A1 wave_controller_x_inst__2663_/A2
+ wave_controller_x_inst__2680_/A2 VDD VDD VSS VSS gf180mcu_fd_sc_mcu7t5v0__nor2_1
XFILLER_53_422 VDD VDD VSS VSS gf180mcu_fd_sc_mcu7t5v0__fill_1
XFILLER_53_444 VDD VDD VSS VSS gf180mcu_fd_sc_mcu7t5v0__fillcap_32
XTAP_TAPCELL_ROW_64_940 VDD VSS gf180mcu_fd_sc_mcu7t5v0__filltie
Xwave_controller_x_inst__2594_ wave_controller_x_inst__2594_/A1 wave_controller_x_inst__2594_/A2
+ spi_regs_inst__1080_/B2 VDD VDD VSS VSS gf180mcu_fd_sc_mcu7t5v0__xor2_1
XFILLER_13_308 VDD VDD VSS VSS gf180mcu_fd_sc_mcu7t5v0__fill_1
XFILLER_55_1122 VDD VDD VSS VSS gf180mcu_fd_sc_mcu7t5v0__fillcap_32
XFILLER_81_797 VDD VDD VSS VSS gf180mcu_fd_sc_mcu7t5v0__fill_2
XPHY_EDGE_ROW_124_Left_291 VDD VSS gf180mcu_fd_sc_mcu7t5v0__endcap
Xwave_controller_y_inst__3300_ wave_controller_y_inst__3305_/B2 spi_regs_inst__1607_/Q
+ wave_controller_y_inst__3297_/Z wave_controller_y_inst__3299_/I wave_controller_y_inst__3363_/A1
+ VDD VDD VSS VSS gf180mcu_fd_sc_mcu7t5v0__aoi22_1
XFILLER_166_313 VDD VDD VSS VSS gf180mcu_fd_sc_mcu7t5v0__fill_2
XFILLER_21_341 VDD VDD VSS VSS gf180mcu_fd_sc_mcu7t5v0__fillcap_8
XFILLER_21_352 VDD VDD VSS VSS gf180mcu_fd_sc_mcu7t5v0__fillcap_4
Xwave_controller_y_inst__3231_ wave_controller_y_inst__3701_/Q wave_controller_y_inst__3231_/A2
+ spi_regs_inst__1486_/Q wave_controller_y_inst__3232_/C VDD VDD VSS VSS gf180mcu_fd_sc_mcu7t5v0__aoi21_1
Xwave_controller_x_inst__3215_ wave_controller_x_inst__3570_/A1 spi_regs_inst__1526_/Q
+ wave_controller_x_inst__3215_/A3 wave_controller_x_inst__3215_/Z VDD VDD VSS VSS
+ gf180mcu_fd_sc_mcu7t5v0__xor3_1
XFILLER_142_1169 VDD VDD VSS VSS gf180mcu_fd_sc_mcu7t5v0__fill_1
Xwave_controller_y_inst__3162_ wave_controller_y_inst__3154_/Z wave_controller_y_inst__3205_/A2
+ wave_controller_y_inst__3162_/B wave_controller_y_inst__3166_/A1 VDD VDD VSS VSS
+ gf180mcu_fd_sc_mcu7t5v0__oai21_1
Xwave_controller_x_inst__3146_ wave_controller_x_inst__3146_/A1 wave_controller_x_inst__3225_/A1
+ wave_controller_x_inst__3146_/B wave_controller_x_inst__3146_/C wave_controller_x_inst__3222_/A1
+ VDD VDD VSS VSS gf180mcu_fd_sc_mcu7t5v0__oai211_1
XFILLER_108_914 VDD VDD VSS VSS gf180mcu_fd_sc_mcu7t5v0__fillcap_16
XFILLER_31_68 VDD VDD VSS VSS gf180mcu_fd_sc_mcu7t5v0__fill_2
Xwave_controller_y_inst__2113_ wave_controller_y_inst__2092_/B wave_controller_y_inst__2130_/A1
+ wave_controller_y_inst__2114_/A2 VDD VDD VSS VSS gf180mcu_fd_sc_mcu7t5v0__nor2_1
XFILLER_108_947 VDD VDD VSS VSS gf180mcu_fd_sc_mcu7t5v0__fillcap_64
Xwave_controller_y_inst__3093_ wave_controller_y_inst__3096_/A1 wave_controller_y_inst__3097_/A1
+ wave_controller_y_inst__3100_/B fanout499/Z wave_controller_y_inst__3611_/D VDD
+ VDD VSS VSS gf180mcu_fd_sc_mcu7t5v0__oai211_1
Xwave_controller_x_inst__3077_ wave_controller_x_inst__2942_/Z wave_controller_x_inst__3077_/A2
+ wave_controller_x_inst__3077_/Z VDD VDD VSS VSS gf180mcu_fd_sc_mcu7t5v0__xor2_1
XFILLER_107_479 VDD VDD VSS VSS gf180mcu_fd_sc_mcu7t5v0__fillcap_8
XFILLER_135_788 VDD VDD VSS VSS gf180mcu_fd_sc_mcu7t5v0__fillcap_8
Xwave_controller_y_inst__2044_ wave_controller_y_inst_wire358/Z wave_controller_y_inst_wire356/Z
+ wave_controller_y_inst__2107_/B VDD VDD VSS VSS gf180mcu_fd_sc_mcu7t5v0__nor2_1
Xwave_controller_x_inst__2028_ wave_controller_x_inst__2026_/Z wave_controller_x_inst__2028_/A2
+ spi_regs_inst__1203_/A1 VDD VDD VSS VSS gf180mcu_fd_sc_mcu7t5v0__or2_1
Xoutput13 _91_/Z bidir_out[6] VDD VDD VSS VSS gf180mcu_fd_sc_mcu7t5v0__buf_1
XFILLER_0_212 VDD VDD VSS VSS gf180mcu_fd_sc_mcu7t5v0__fill_1
XFILLER_122_438 VDD VDD VSS VSS gf180mcu_fd_sc_mcu7t5v0__fill_2
XFILLER_89_842 VDD VDD VSS VSS gf180mcu_fd_sc_mcu7t5v0__fillcap_8
XTAP_TAPCELL_ROW_112_1722 VDD VSS gf180mcu_fd_sc_mcu7t5v0__filltie
XTAP_TAPCELL_ROW_112_1733 VDD VSS gf180mcu_fd_sc_mcu7t5v0__filltie
XFILLER_0_278 VDD VDD VSS VSS gf180mcu_fd_sc_mcu7t5v0__fill_1
XFILLER_89_886 VDD VDD VSS VSS gf180mcu_fd_sc_mcu7t5v0__fill_1
XFILLER_102_173 VDD VDD VSS VSS gf180mcu_fd_sc_mcu7t5v0__fill_2
XFILLER_56_21 VDD VDD VSS VSS gf180mcu_fd_sc_mcu7t5v0__fill_2
XFILLER_76_558 VDD VDD VSS VSS gf180mcu_fd_sc_mcu7t5v0__fillcap_16
Xwave_controller_y_inst__2946_ wave_controller_y_inst__1790_/I wave_controller_y_inst__1821_/I
+ wave_controller_y_inst__2985_/A2 VDD VDD VSS VSS gf180mcu_fd_sc_mcu7t5v0__nor2_1
XFILLER_56_54 VDD VDD VSS VSS gf180mcu_fd_sc_mcu7t5v0__fill_1
XFILLER_57_772 VDD VDD VSS VSS gf180mcu_fd_sc_mcu7t5v0__fillcap_32
XTAP_TAPCELL_ROW_145_2265 VDD VSS gf180mcu_fd_sc_mcu7t5v0__filltie
XTAP_TAPCELL_ROW_145_2276 VDD VSS gf180mcu_fd_sc_mcu7t5v0__filltie
Xwave_controller_y_inst__2877_ wave_controller_y_inst__2881_/B wave_controller_y_inst__2880_/A3
+ wave_controller_y_inst__2878_/A2 VDD VDD VSS VSS gf180mcu_fd_sc_mcu7t5v0__nand2_1
XFILLER_44_400 VDD VDD VSS VSS gf180mcu_fd_sc_mcu7t5v0__fillcap_16
XFILLER_72_731 VDD VDD VSS VSS gf180mcu_fd_sc_mcu7t5v0__fillcap_4
Xwave_controller_y_inst__1828_ spi_regs_inst__1486_/Q wave_controller_y_inst__3376_/B
+ VDD VDD VSS VSS gf180mcu_fd_sc_mcu7t5v0__clkinv_1
Xwave_controller_x_inst_fanout64 wave_controller_x_inst_wire68/I wave_controller_x_inst__3588_/S
+ VDD VDD VSS VSS gf180mcu_fd_sc_mcu7t5v0__dlyb_1
XTAP_TAPCELL_ROW_33_1_580 VDD VSS gf180mcu_fd_sc_mcu7t5v0__filltie
XFILLER_157_302 VDD VDD VSS VSS gf180mcu_fd_sc_mcu7t5v0__fill_2
Xwave_controller_y_inst__3429_ wave_controller_y_inst__3429_/I wave_controller_y_inst__3430_/B2
+ VDD VDD VSS VSS gf180mcu_fd_sc_mcu7t5v0__clkinv_1
Xclkbuf_3_1__f_clk clkbuf_0_clk/Z clkbuf_leaf_8_clk/I VDD VDD VSS VSS gf180mcu_fd_sc_mcu7t5v0__clkbuf_16
XFILLER_119_1116 VDD VDD VSS VSS gf180mcu_fd_sc_mcu7t5v0__fillcap_4
XFILLER_4_551 VDD VDD VSS VSS gf180mcu_fd_sc_mcu7t5v0__fillcap_4
XFILLER_141_747 VDD VDD VSS VSS gf180mcu_fd_sc_mcu7t5v0__fill_2
XFILLER_79_352 VDD VDD VSS VSS gf180mcu_fd_sc_mcu7t5v0__fillcap_16
XFILLER_97_72 VDD VDD VSS VSS gf180mcu_fd_sc_mcu7t5v0__fill_2
XTAP_TAPCELL_ROW_4_1_359 VDD VSS gf180mcu_fd_sc_mcu7t5v0__filltie
XFILLER_35_422 VDD VDD VSS VSS gf180mcu_fd_sc_mcu7t5v0__fill_2
XFILLER_47_282 VDD VDD VSS VSS gf180mcu_fd_sc_mcu7t5v0__fillcap_8
XFILLER_75_591 VDD VDD VSS VSS gf180mcu_fd_sc_mcu7t5v0__fill_1
XFILLER_82_539 VDD VDD VSS VSS gf180mcu_fd_sc_mcu7t5v0__fill_2
XFILLER_35_488 VDD VDD VSS VSS gf180mcu_fd_sc_mcu7t5v0__fill_2
XFILLER_50_403 VDD VDD VSS VSS gf180mcu_fd_sc_mcu7t5v0__fill_2
XTAP_TAPCELL_ROW_81_1209 VDD VSS gf180mcu_fd_sc_mcu7t5v0__filltie
XFILLER_22_138 VDD VDD VSS VSS gf180mcu_fd_sc_mcu7t5v0__fillcap_16
Xspi_regs_inst__1598_ spi_regs_inst__1598_/D fanout564/Z clkbuf_leaf_9_clk/Z spi_regs_inst__1598_/Q
+ VDD VDD VSS VSS gf180mcu_fd_sc_mcu7t5v0__dffrnq_1
XFILLER_30_160 VDD VDD VSS VSS gf180mcu_fd_sc_mcu7t5v0__fillcap_8
Xwave_controller_x_inst__3000_ wave_controller_x_inst__3000_/A1 wave_controller_x_inst_wire94/Z
+ wave_controller_x_inst__3000_/A3 wave_controller_x_inst__3081_/A1 VDD VDD VSS VSS
+ gf180mcu_fd_sc_mcu7t5v0__nand3_1
XFILLER_163_349 VDD VDD VSS VSS gf180mcu_fd_sc_mcu7t5v0__fill_1
XFILLER_116_243 VDD VDD VSS VSS gf180mcu_fd_sc_mcu7t5v0__fill_2
XFILLER_144_563 VDD VDD VSS VSS gf180mcu_fd_sc_mcu7t5v0__fillcap_8
XTAP_TAPCELL_ROW_42_1_648 VDD VSS gf180mcu_fd_sc_mcu7t5v0__filltie
XTAP_TAPCELL_ROW_96_1463 VDD VSS gf180mcu_fd_sc_mcu7t5v0__filltie
XFILLER_104_427 VDD VDD VSS VSS gf180mcu_fd_sc_mcu7t5v0__fillcap_16
XFILLER_86_823 VDD VDD VSS VSS gf180mcu_fd_sc_mcu7t5v0__fillcap_4
Xwave_controller_y_inst__2800_ spi_regs_inst__1218_/A1 spi_regs_inst__1183_/A1 wave_controller_y_inst__2800_/S
+ wave_controller_y_inst__2800_/Z VDD VDD VSS VSS gf180mcu_fd_sc_mcu7t5v0__mux2_2
XFILLER_133_48 VDD VDD VSS VSS gf180mcu_fd_sc_mcu7t5v0__fill_1
XFILLER_58_558 VDD VDD VSS VSS gf180mcu_fd_sc_mcu7t5v0__fill_1
XFILLER_86_856 VDD VDD VSS VSS gf180mcu_fd_sc_mcu7t5v0__fill_1
XFILLER_45_208 VDD VDD VSS VSS gf180mcu_fd_sc_mcu7t5v0__fill_2
XFILLER_61_1170 VDD VDD VSS VSS gf180mcu_fd_sc_mcu7t5v0__fillcap_4
XFILLER_86_889 VDD VDD VSS VSS gf180mcu_fd_sc_mcu7t5v0__fill_2
XPHY_EDGE_ROW_55_Right_55 VDD VSS gf180mcu_fd_sc_mcu7t5v0__endcap
Xwave_controller_y_inst__2731_ spi_regs_inst__1204_/B2 wave_controller_y_inst__3554_/B2
+ wave_controller_y_inst__2741_/B wave_controller_y_inst__2731_/Z VDD VDD VSS VSS
+ gf180mcu_fd_sc_mcu7t5v0__xor3_1
Xwave_controller_x_inst__2715_ wave_controller_x_inst__2737_/A1 wave_controller_x_inst__2714_/Z
+ spi_regs_inst__1041_/B2 VDD VDD VSS VSS gf180mcu_fd_sc_mcu7t5v0__xor2_1
Xwave_controller_y_inst__2662_ wave_controller_y_inst__2663_/A1 wave_controller_y_inst__2663_/A2
+ wave_controller_y_inst__2681_/C VDD VDD VSS VSS gf180mcu_fd_sc_mcu7t5v0__nand2_1
Xwave_controller_x_inst__3695_ wave_controller_x_inst__3695_/D wave_controller_x_inst__3723_/RN
+ clkload28/I wave_controller_x_inst__3695_/Q VDD VDD VSS VSS gf180mcu_fd_sc_mcu7t5v0__dffrnq_1
Xwave_controller_x_inst__2646_ wave_controller_x_inst_wire85/Z wave_controller_x_inst__2646_/A2
+ wave_controller_x_inst__2646_/B wave_controller_x_inst__2681_/A1 VDD VDD VSS VSS
+ gf180mcu_fd_sc_mcu7t5v0__oai21_1
XTAP_TAPCELL_ROW_140_2184 VDD VSS gf180mcu_fd_sc_mcu7t5v0__filltie
Xwave_controller_y_inst__2593_ wave_controller_y_inst__2608_/A1 wave_controller_y_inst__2593_/A2
+ wave_controller_y_inst__2594_/A2 VDD VDD VSS VSS gf180mcu_fd_sc_mcu7t5v0__nand2_1
Xwave_controller_x_inst__2577_ wave_controller_x_inst__2607_/A1 wave_controller_x_inst__2578_/A2
+ wave_controller_x_inst__2593_/A2 VDD VDD VSS VSS gf180mcu_fd_sc_mcu7t5v0__nand2_1
XFILLER_13_138 VDD VDD VSS VSS gf180mcu_fd_sc_mcu7t5v0__fill_2
XFILLER_41_436 VDD VDD VSS VSS gf180mcu_fd_sc_mcu7t5v0__fill_2
XTAP_TAPCELL_ROW_140_2195 VDD VSS gf180mcu_fd_sc_mcu7t5v0__filltie
XFILLER_158_34 VDD VDD VSS VSS gf180mcu_fd_sc_mcu7t5v0__fill_1
XPHY_EDGE_ROW_64_Right_64 VDD VSS gf180mcu_fd_sc_mcu7t5v0__endcap
Xwave_controller_y_inst__3214_ wave_controller_y_inst__1823_/I wave_controller_y_inst__3213_/Z
+ wave_controller_y_inst__3240_/A1 VDD VDD VSS VSS gf180mcu_fd_sc_mcu7t5v0__nor2_1
XFILLER_154_305 VDD VDD VSS VSS gf180mcu_fd_sc_mcu7t5v0__fillcap_8
XFILLER_21_182 VDD VDD VSS VSS gf180mcu_fd_sc_mcu7t5v0__fill_2
XTAP_TAPCELL_ROW_28_1_538 VDD VSS gf180mcu_fd_sc_mcu7t5v0__filltie
XFILLER_154_349 VDD VDD VSS VSS gf180mcu_fd_sc_mcu7t5v0__fillcap_4
Xwave_controller_y_inst__3145_ wave_controller_y_inst__3126_/I wave_controller_y_inst__3221_/A2
+ wave_controller_y_inst__3145_/B wave_controller_y_inst__3218_/C VDD VDD VSS VSS
+ gf180mcu_fd_sc_mcu7t5v0__aoi21_1
Xwave_controller_x_inst__3129_ wave_controller_x_inst__3279_/A1 spi_regs_inst__1521_/Q
+ wave_controller_x_inst__3129_/Z VDD VDD VSS VSS gf180mcu_fd_sc_mcu7t5v0__and2_1
Xwave_controller_y_inst__3076_ wave_controller_y_inst__3265_/A1 wave_controller_y_inst__3090_/B1
+ wave_controller_y_inst__3076_/B1 wave_controller_y_inst__2762_/I wave_controller_y_inst__3714_/D
+ VDD VDD VSS VSS gf180mcu_fd_sc_mcu7t5v0__oai22_1
XFILLER_123_714 VDD VDD VSS VSS gf180mcu_fd_sc_mcu7t5v0__fill_2
Xwave_controller_y_inst__2027_ wave_controller_y_inst__2425_/B2 wave_controller_y_inst_wire31/Z
+ wave_controller_y_inst__2027_/B wave_controller_y_inst__2028_/A2 VDD VDD VSS VSS
+ gf180mcu_fd_sc_mcu7t5v0__aoi21_1
XTAP_TAPCELL_ROW_147_2305 VDD VSS gf180mcu_fd_sc_mcu7t5v0__filltie
Xwave_controller_x_inst_wire333 wave_controller_x_inst__3407_/B wave_controller_x_inst_wire333/Z
+ VDD VDD VSS VSS gf180mcu_fd_sc_mcu7t5v0__buf_4
XFILLER_66_1081 VDD VDD VSS VSS gf180mcu_fd_sc_mcu7t5v0__fillcap_4
Xwave_controller_x_inst_wire377 wave_controller_x_inst__2033_/Z wave_controller_x_inst_wire377/Z
+ VDD VDD VSS VSS gf180mcu_fd_sc_mcu7t5v0__clkbuf_2
Xspi_regs_inst_fanout344 spi_regs_inst__0929_/ZN spi_regs_inst__1028_/A1 VDD VDD VSS
+ VSS gf180mcu_fd_sc_mcu7t5v0__dlyb_1
XFILLER_76_333 VDD VDD VSS VSS gf180mcu_fd_sc_mcu7t5v0__fillcap_8
XPHY_EDGE_ROW_73_Right_73 VDD VSS gf180mcu_fd_sc_mcu7t5v0__endcap
XFILLER_92_815 VDD VDD VSS VSS gf180mcu_fd_sc_mcu7t5v0__fillcap_4
XTAP_TAPCELL_ROW_160_2516 VDD VSS gf180mcu_fd_sc_mcu7t5v0__filltie
Xwave_controller_y_inst__2929_ wave_controller_y_inst__3591_/I0 spi_regs_inst__1202_/A1
+ wave_controller_y_inst__2929_/S wave_controller_y_inst__3689_/D VDD VDD VSS VSS
+ gf180mcu_fd_sc_mcu7t5v0__mux2_2
XFILLER_17_400 VDD VDD VSS VSS gf180mcu_fd_sc_mcu7t5v0__fillcap_16
XFILLER_29_282 VDD VDD VSS VSS gf180mcu_fd_sc_mcu7t5v0__fill_1
XFILLER_91_325 VDD VDD VSS VSS gf180mcu_fd_sc_mcu7t5v0__fill_1
XFILLER_92_848 VDD VDD VSS VSS gf180mcu_fd_sc_mcu7t5v0__fillcap_4
XFILLER_92_859 VDD VDD VSS VSS gf180mcu_fd_sc_mcu7t5v0__fillcap_4
XFILLER_91_369 VDD VDD VSS VSS gf180mcu_fd_sc_mcu7t5v0__fillcap_8
XTAP_TAPCELL_ROW_125_1935 VDD VSS gf180mcu_fd_sc_mcu7t5v0__filltie
XTAP_TAPCELL_ROW_125_1946 VDD VSS gf180mcu_fd_sc_mcu7t5v0__filltie
XFILLER_44_263 VDD VDD VSS VSS gf180mcu_fd_sc_mcu7t5v0__fillcap_8
Xspi_regs_inst__1521_ spi_regs_inst__1521_/D spi_regs_inst__1601_/RN clkbuf_leaf_36_clk/Z
+ spi_regs_inst__1521_/Q VDD VDD VSS VSS gf180mcu_fd_sc_mcu7t5v0__dffrnq_1
XFILLER_60_734 VDD VDD VSS VSS gf180mcu_fd_sc_mcu7t5v0__fill_1
XFILLER_72_594 VDD VDD VSS VSS gf180mcu_fd_sc_mcu7t5v0__fill_1
XTAP_TAPCELL_ROW_55_781 VDD VSS gf180mcu_fd_sc_mcu7t5v0__filltie
XTAP_TAPCELL_ROW_55_792 VDD VSS gf180mcu_fd_sc_mcu7t5v0__filltie
XFILLER_160_1011 VDD VDD VSS VSS gf180mcu_fd_sc_mcu7t5v0__fillcap_4
XFILLER_32_469 VDD VDD VSS VSS gf180mcu_fd_sc_mcu7t5v0__fill_2
XFILLER_73_1052 VDD VDD VSS VSS gf180mcu_fd_sc_mcu7t5v0__fillcap_64
XPHY_EDGE_ROW_38_1_Right_37 VDD VSS gf180mcu_fd_sc_mcu7t5v0__endcap
XPHY_EDGE_ROW_82_Right_82 VDD VSS gf180mcu_fd_sc_mcu7t5v0__endcap
Xspi_regs_inst__1452_ spi_regs_inst__1452_/D fanout584/Z clkbuf_leaf_14_clk/Z _08_/I
+ VDD VDD VSS VSS gf180mcu_fd_sc_mcu7t5v0__dffrnq_1
XTAP_TAPCELL_ROW_158_2478 VDD VSS gf180mcu_fd_sc_mcu7t5v0__filltie
XTAP_TAPCELL_ROW_158_2489 VDD VSS gf180mcu_fd_sc_mcu7t5v0__filltie
Xspi_regs_inst__1383_ spi_regs_inst__1640_/Q spi_regs_inst__1411_/I1 spi_regs_inst__1384_/S
+ spi_regs_inst__1663_/D VDD VDD VSS VSS gf180mcu_fd_sc_mcu7t5v0__mux2_2
XFILLER_118_519 VDD VDD VSS VSS gf180mcu_fd_sc_mcu7t5v0__fillcap_4
XFILLER_126_552 VDD VDD VSS VSS gf180mcu_fd_sc_mcu7t5v0__fill_1
XTAP_TAPCELL_ROW_78_1160 VDD VSS gf180mcu_fd_sc_mcu7t5v0__filltie
XTAP_TAPCELL_ROW_78_1171 VDD VSS gf180mcu_fd_sc_mcu7t5v0__filltie
XFILLER_126_585 VDD VDD VSS VSS gf180mcu_fd_sc_mcu7t5v0__fill_1
XFILLER_153_371 VDD VDD VSS VSS gf180mcu_fd_sc_mcu7t5v0__fillcap_16
XFILLER_4_381 VDD VDD VSS VSS gf180mcu_fd_sc_mcu7t5v0__fillcap_4
XFILLER_113_279 VDD VDD VSS VSS gf180mcu_fd_sc_mcu7t5v0__fill_1
XFILLER_68_823 VDD VDD VSS VSS gf180mcu_fd_sc_mcu7t5v0__fill_2
XPHY_EDGE_ROW_91_Right_91 VDD VSS gf180mcu_fd_sc_mcu7t5v0__endcap
XTAP_TAPCELL_ROW_91_1371 VDD VSS gf180mcu_fd_sc_mcu7t5v0__filltie
XTAP_TAPCELL_ROW_91_1382 VDD VSS gf180mcu_fd_sc_mcu7t5v0__filltie
Xsignal_processor_y_inst__195_ signal_processor_y_inst__196_/B1 signal_processor_y_inst__195_/A2
+ signal_processor_y_inst__195_/B signal_processor_y_inst__200_/A2 VDD VDD VSS VSS
+ gf180mcu_fd_sc_mcu7t5v0__aoi21_1
XFILLER_132_1157 VDD VDD VSS VSS gf180mcu_fd_sc_mcu7t5v0__fillcap_16
XFILLER_82_325 VDD VDD VSS VSS gf180mcu_fd_sc_mcu7t5v0__fillcap_4
XFILLER_82_347 VDD VDD VSS VSS gf180mcu_fd_sc_mcu7t5v0__fill_2
Xwave_controller_x_inst__3480_ wave_controller_x_inst__3490_/A1 wave_controller_x_inst__3478_/I
+ wave_controller_x_inst__3480_/B wave_controller_x_inst__3480_/C wave_controller_x_inst__3482_/B1
+ VDD VDD VSS VSS gf180mcu_fd_sc_mcu7t5v0__aoi211_1
Xwave_controller_x_inst__2500_ max_cap458/I spi_regs_inst__1286_/B2 wave_controller_x_inst__2518_/A3
+ VDD VDD VSS VSS gf180mcu_fd_sc_mcu7t5v0__xnor2_1
XFILLER_35_274 VDD VDD VSS VSS gf180mcu_fd_sc_mcu7t5v0__fillcap_4
XTAP_TAPCELL_ROW_53_729 VDD VSS gf180mcu_fd_sc_mcu7t5v0__filltie
Xwave_controller_x_inst__2431_ wave_controller_x_inst__2431_/A1 wave_controller_x_inst__2430_/B
+ wave_controller_x_inst__2432_/I VDD VDD VSS VSS gf180mcu_fd_sc_mcu7t5v0__xnor2_1
Xwave_controller_x_inst__2362_ wave_controller_x_inst__2373_/A2 wave_controller_x_inst__2362_/A2
+ spi_regs_inst__1289_/B2 VDD VDD VSS VSS gf180mcu_fd_sc_mcu7t5v0__xnor2_1
Xwave_controller_x_inst__2293_ wave_controller_x_inst__2294_/A1 wave_controller_x_inst__2294_/A2
+ wave_controller_x_inst__2293_/B wave_controller_x_inst__2313_/C VDD VDD VSS VSS
+ gf180mcu_fd_sc_mcu7t5v0__aoi21_1
XFILLER_109_508 VDD VDD VSS VSS gf180mcu_fd_sc_mcu7t5v0__fillcap_4
XFILLER_128_37 VDD VDD VSS VSS gf180mcu_fd_sc_mcu7t5v0__fillcap_16
XFILLER_12_37 VDD VDD VSS VSS gf180mcu_fd_sc_mcu7t5v0__fillcap_8
XFILLER_164_647 VDD VDD VSS VSS gf180mcu_fd_sc_mcu7t5v0__fillcap_16
XFILLER_117_552 VDD VDD VSS VSS gf180mcu_fd_sc_mcu7t5v0__fillcap_8
XFILLER_151_308 VDD VDD VSS VSS gf180mcu_fd_sc_mcu7t5v0__fill_2
XTAP_TAPCELL_ROW_24_1_511 VDD VSS gf180mcu_fd_sc_mcu7t5v0__filltie
XFILLER_105_769 VDD VDD VSS VSS gf180mcu_fd_sc_mcu7t5v0__fill_1
XFILLER_137_1046 VDD VDD VSS VSS gf180mcu_fd_sc_mcu7t5v0__fillcap_4
XFILLER_132_577 VDD VDD VSS VSS gf180mcu_fd_sc_mcu7t5v0__fill_2
XTAP_TAPCELL_ROW_129_2002 VDD VSS gf180mcu_fd_sc_mcu7t5v0__filltie
XTAP_TAPCELL_ROW_129_2013 VDD VSS gf180mcu_fd_sc_mcu7t5v0__filltie
XFILLER_144_58 VDD VDD VSS VSS gf180mcu_fd_sc_mcu7t5v0__fillcap_32
XFILLER_74_804 VDD VDD VSS VSS gf180mcu_fd_sc_mcu7t5v0__fill_1
XFILLER_74_815 VDD VDD VSS VSS gf180mcu_fd_sc_mcu7t5v0__fill_2
Xsignal_processor_y_inst_fanout199 signal_processor_y_inst__214_/A2 signal_processor_y_inst__212_/A2
+ VDD VDD VSS VSS gf180mcu_fd_sc_mcu7t5v0__dlyb_1
XFILLER_37_67 VDD VDD VSS VSS gf180mcu_fd_sc_mcu7t5v0__fill_2
XFILLER_74_837 VDD VDD VSS VSS gf180mcu_fd_sc_mcu7t5v0__fillcap_8
XTAP_TAPCELL_ROW_142_2213 VDD VSS gf180mcu_fd_sc_mcu7t5v0__filltie
XTAP_TAPCELL_ROW_142_2224 VDD VSS gf180mcu_fd_sc_mcu7t5v0__filltie
XFILLER_73_347 VDD VDD VSS VSS gf180mcu_fd_sc_mcu7t5v0__fill_2
XTAP_TAPCELL_ROW_107_1643 VDD VSS gf180mcu_fd_sc_mcu7t5v0__filltie
Xwave_controller_y_inst__2714_ wave_controller_y_inst__2711_/Z wave_controller_y_inst__2713_/B
+ wave_controller_y_inst__2714_/Z VDD VDD VSS VSS gf180mcu_fd_sc_mcu7t5v0__and2_1
Xwave_controller_y_inst__3694_ wave_controller_y_inst__3694_/D wave_controller_y_inst__3695_/RN
+ clkload16/I wave_controller_y_inst__3694_/Q VDD VDD VSS VSS gf180mcu_fd_sc_mcu7t5v0__dffrnq_1
Xwave_controller_x_inst__3678_ wave_controller_x_inst__3678_/D wave_controller_x_inst__3710_/RN
+ clkbuf_leaf_31_clk/Z spi_regs_inst__1068_/B2 VDD VDD VSS VSS gf180mcu_fd_sc_mcu7t5v0__dffrnq_1
Xwave_controller_y_inst__2645_ wave_controller_y_inst__2642_/Z wave_controller_y_inst__2679_/A2
+ wave_controller_y_inst__2646_/B VDD VDD VSS VSS gf180mcu_fd_sc_mcu7t5v0__xor2_1
Xwave_controller_x_inst__2629_ wave_controller_x_inst__2601_/Z wave_controller_x_inst__2631_/A2
+ wave_controller_x_inst__2629_/B wave_controller_x_inst__2630_/A2 VDD VDD VSS VSS
+ gf180mcu_fd_sc_mcu7t5v0__aoi21_1
XFILLER_144_1017 VDD VDD VSS VSS gf180mcu_fd_sc_mcu7t5v0__fillcap_64
XFILLER_14_436 VDD VDD VSS VSS gf180mcu_fd_sc_mcu7t5v0__fill_2
XFILLER_26_296 VDD VDD VSS VSS gf180mcu_fd_sc_mcu7t5v0__fill_2
Xwave_controller_y_inst__2576_ wave_controller_y_inst__2576_/I wave_controller_y_inst__2578_/A2
+ VDD VDD VSS VSS gf180mcu_fd_sc_mcu7t5v0__clkinv_1
XFILLER_53_66 VDD VDD VSS VSS gf180mcu_fd_sc_mcu7t5v0__fill_2
XTAP_TAPCELL_ROW_120_1854 VDD VSS gf180mcu_fd_sc_mcu7t5v0__filltie
XTAP_TAPCELL_ROW_120_1865 VDD VSS gf180mcu_fd_sc_mcu7t5v0__filltie
XFILLER_22_491 VDD VDD VSS VSS gf180mcu_fd_sc_mcu7t5v0__fill_2
XFILLER_127_338 VDD VDD VSS VSS gf180mcu_fd_sc_mcu7t5v0__fillcap_4
XFILLER_155_625 VDD VDD VSS VSS gf180mcu_fd_sc_mcu7t5v0__fillcap_4
XFILLER_155_658 VDD VDD VSS VSS gf180mcu_fd_sc_mcu7t5v0__fill_2
XTAP_TAPCELL_ROW_153_2397 VDD VSS gf180mcu_fd_sc_mcu7t5v0__filltie
Xwave_controller_y_inst__3128_ wave_controller_y_inst__3128_/I wave_controller_y_inst__3224_/A1
+ VDD VDD VSS VSS gf180mcu_fd_sc_mcu7t5v0__clkinv_1
XFILLER_108_563 VDD VDD VSS VSS gf180mcu_fd_sc_mcu7t5v0__fillcap_16
XFILLER_123_533 VDD VDD VSS VSS gf180mcu_fd_sc_mcu7t5v0__fillcap_4
XFILLER_151_842 VDD VDD VSS VSS gf180mcu_fd_sc_mcu7t5v0__fillcap_64
Xwave_controller_y_inst__3059_ wave_controller_y_inst__3572_/A1 wave_controller_y_inst__3059_/A2
+ wave_controller_y_inst__3058_/Z wave_controller_y_inst_wire147/Z wave_controller_y_inst__3708_/D
+ VDD VDD VSS VSS gf180mcu_fd_sc_mcu7t5v0__oai22_1
XFILLER_103_290 VDD VDD VSS VSS gf180mcu_fd_sc_mcu7t5v0__fillcap_4
XFILLER_134_80 VDD VDD VSS VSS gf180mcu_fd_sc_mcu7t5v0__fill_1
XFILLER_77_675 VDD VDD VSS VSS gf180mcu_fd_sc_mcu7t5v0__fillcap_8
XFILLER_92_601 VDD VDD VSS VSS gf180mcu_fd_sc_mcu7t5v0__fill_2
Xspi_regs_inst_fanout174 spi_regs_inst__1379_/S spi_regs_inst__1384_/S VDD VDD VSS
+ VSS gf180mcu_fd_sc_mcu7t5v0__dlyb_1
Xspi_regs_inst__0952_ spi_regs_inst__1031_/A1 spi_regs_inst__1030_/A2 spi_regs_inst__1260_/A2
+ VDD VDD VSS VSS gf180mcu_fd_sc_mcu7t5v0__nor2_1
XFILLER_64_314 VDD VDD VSS VSS gf180mcu_fd_sc_mcu7t5v0__fill_1
XFILLER_76_185 VDD VDD VSS VSS gf180mcu_fd_sc_mcu7t5v0__fillcap_16
XFILLER_94_84 VDD VDD VSS VSS gf180mcu_fd_sc_mcu7t5v0__fillcap_16
Xspi_regs_inst__0883_ spi_regs_inst__1617_/Q spi_regs_inst__0883_/I1 spi_regs_inst__0884_/S
+ spi_regs_inst__1617_/D VDD VDD VSS VSS gf180mcu_fd_sc_mcu7t5v0__mux2_2
XFILLER_73_881 VDD VDD VSS VSS gf180mcu_fd_sc_mcu7t5v0__fillcap_16
XTAP_TAPCELL_ROW_41_1_636 VDD VSS gf180mcu_fd_sc_mcu7t5v0__filltie
XFILLER_32_233 VDD VDD VSS VSS gf180mcu_fd_sc_mcu7t5v0__fillcap_8
Xspi_regs_inst__1504_ spi_regs_inst__1504_/D spi_regs_inst__1527_/RN clkbuf_leaf_38_clk/Z
+ spi_regs_inst__1504_/Q VDD VDD VSS VSS gf180mcu_fd_sc_mcu7t5v0__dffrnq_1
XFILLER_60_597 VDD VDD VSS VSS gf180mcu_fd_sc_mcu7t5v0__fill_2
Xspi_regs_inst__1435_ spi_regs_inst__1505_/Q spi_regs_inst__1444_/I1 spi_regs_inst__1435_/S
+ spi_regs_inst__1505_/D VDD VDD VSS VSS gf180mcu_fd_sc_mcu7t5v0__mux2_2
XFILLER_119_828 VDD VDD VSS VSS gf180mcu_fd_sc_mcu7t5v0__fill_1
XFILLER_119_839 VDD VDD VSS VSS gf180mcu_fd_sc_mcu7t5v0__fill_1
XFILLER_145_124 VDD VDD VSS VSS gf180mcu_fd_sc_mcu7t5v0__fill_1
Xspi_regs_inst__1366_ spi_regs_inst__1366_/A1 spi_regs_inst__1384_/S spi_regs_inst__1366_/B
+ spi_regs_inst__1651_/D VDD VDD VSS VSS gf180mcu_fd_sc_mcu7t5v0__oai21_1
XFILLER_145_146 VDD VDD VSS VSS gf180mcu_fd_sc_mcu7t5v0__fill_2
Xspi_regs_inst__1297_ spi_regs_inst__1646_/Q spi_regs_inst__1074_/Z spi_regs_inst__1298_/A3
+ VDD VDD VSS VSS gf180mcu_fd_sc_mcu7t5v0__nor2_1
XFILLER_133_319 VDD VDD VSS VSS gf180mcu_fd_sc_mcu7t5v0__fillcap_8
XTAP_TAPCELL_ROW_93_1411 VDD VSS gf180mcu_fd_sc_mcu7t5v0__filltie
XFILLER_153_190 VDD VDD VSS VSS gf180mcu_fd_sc_mcu7t5v0__fillcap_8
Xwave_controller_x_inst__2980_ wave_controller_x_inst__1790_/I wave_controller_x_inst__2981_/A2
+ wave_controller_x_inst__3061_/A1 wave_controller_x_inst__2977_/Z wave_controller_x_inst__2980_/C
+ wave_controller_x_inst__2985_/A3 VDD VDD VSS VSS gf180mcu_fd_sc_mcu7t5v0__aoi221_1
XFILLER_101_205 VDD VDD VSS VSS gf180mcu_fd_sc_mcu7t5v0__fill_1
XFILLER_114_577 VDD VDD VSS VSS gf180mcu_fd_sc_mcu7t5v0__fill_2
XFILLER_87_406 VDD VDD VSS VSS gf180mcu_fd_sc_mcu7t5v0__fill_2
Xwave_controller_x_inst__1931_ spi_regs_inst__1510_/Q wave_controller_x_inst__3312_/A1
+ spi_regs_inst__1509_/Q wave_controller_x_inst__3163_/C wave_controller_x_inst__1932_/A2
+ VDD VDD VSS VSS gf180mcu_fd_sc_mcu7t5v0__oai22_1
Xsignal_processor_y_inst__247_ signal_processor_y_inst__247_/D signal_processor_y_inst__253_/RN
+ clkbuf_leaf_0_clk/Z signal_processor_y_inst__247_/Q VDD VDD VSS VSS gf180mcu_fd_sc_mcu7t5v0__dffrnq_1
XFILLER_68_664 VDD VDD VSS VSS gf180mcu_fd_sc_mcu7t5v0__fill_1
XFILLER_68_675 VDD VDD VSS VSS gf180mcu_fd_sc_mcu7t5v0__fillcap_4
Xwave_controller_x_inst__1862_ max_cap453/Z wave_controller_x_inst__2829_/A1 VDD VDD
+ VSS VSS gf180mcu_fd_sc_mcu7t5v0__clkinv_1
XFILLER_110_783 VDD VDD VSS VSS gf180mcu_fd_sc_mcu7t5v0__fill_1
XFILLER_83_612 VDD VDD VSS VSS gf180mcu_fd_sc_mcu7t5v0__fill_2
XFILLER_95_461 VDD VDD VSS VSS gf180mcu_fd_sc_mcu7t5v0__fillcap_4
XFILLER_95_494 VDD VDD VSS VSS gf180mcu_fd_sc_mcu7t5v0__fill_1
Xwave_controller_x_inst__3601_ wave_controller_x_inst__3601_/I0 spi_regs_inst__1320_/B2
+ wave_controller_x_inst__3601_/S wave_controller_x_inst__3676_/D VDD VDD VSS VSS
+ gf180mcu_fd_sc_mcu7t5v0__mux2_2
Xwave_controller_x_inst__1793_ wave_controller_x_inst__3707_/Q wave_controller_x_inst__3570_/A1
+ VDD VDD VSS VSS gf180mcu_fd_sc_mcu7t5v0__clkinv_1
Xsignal_processor_y_inst__178_ signal_processor_y_inst__187_/A1 signal_processor_y_inst__146_/Z
+ signal_processor_y_inst__238_/D VDD VDD VSS VSS gf180mcu_fd_sc_mcu7t5v0__nor2_1
XFILLER_167_1017 VDD VDD VSS VSS gf180mcu_fd_sc_mcu7t5v0__fill_2
XFILLER_83_656 VDD VDD VSS VSS gf180mcu_fd_sc_mcu7t5v0__fill_2
XTAP_TAPCELL_ROW_27_1_537 VDD VSS gf180mcu_fd_sc_mcu7t5v0__filltie
Xwave_controller_x_inst__3532_ max_cap463/I wave_controller_x_inst__3556_/A2 wave_controller_x_inst__3533_/A3
+ VDD VDD VSS VSS gf180mcu_fd_sc_mcu7t5v0__nor2_1
XFILLER_64_881 VDD VDD VSS VSS gf180mcu_fd_sc_mcu7t5v0__fill_1
XFILLER_70_317 VDD VDD VSS VSS gf180mcu_fd_sc_mcu7t5v0__fillcap_8
XFILLER_82_177 VDD VDD VSS VSS gf180mcu_fd_sc_mcu7t5v0__fillcap_8
XTAP_TAPCELL_ROW_35_1_594 VDD VSS gf180mcu_fd_sc_mcu7t5v0__filltie
Xwave_controller_y_inst__2430_ wave_controller_y_inst__2430_/A1 wave_controller_y_inst__2417_/Z
+ wave_controller_y_inst__2430_/B wave_controller_y_inst__2446_/B VDD VDD VSS VSS
+ gf180mcu_fd_sc_mcu7t5v0__oai21_1
Xwave_controller_x_inst__3463_ wave_controller_x_inst__3697_/Q wave_controller_x_inst__3483_/A2
+ wave_controller_x_inst__3465_/A2 VDD VDD VSS VSS gf180mcu_fd_sc_mcu7t5v0__nor2_1
XFILLER_51_553 VDD VDD VSS VSS gf180mcu_fd_sc_mcu7t5v0__fill_2
Xwave_controller_x_inst__3394_ fanout535/I wave_controller_x_inst__3354_/Z wave_controller_x_inst__3394_/A3
+ wave_controller_x_inst__3394_/B1 fanout536/I wave_controller_x_inst__3395_/B VDD
+ VDD VSS VSS gf180mcu_fd_sc_mcu7t5v0__oai32_1
Xwave_controller_x_inst__2414_ wave_controller_x_inst__2411_/Z wave_controller_x_inst__2416_/A3
+ wave_controller_x_inst__2414_/Z VDD VDD VSS VSS gf180mcu_fd_sc_mcu7t5v0__xor2_1
XTAP_TAPCELL_ROW_102_1562 VDD VSS gf180mcu_fd_sc_mcu7t5v0__filltie
Xwave_controller_y_inst__2361_ wave_controller_y_inst__2373_/A1 wave_controller_y_inst__2397_/A1
+ wave_controller_y_inst__2361_/B wave_controller_y_inst__2362_/A2 VDD VDD VSS VSS
+ gf180mcu_fd_sc_mcu7t5v0__oai21_1
Xwave_controller_x_inst__2345_ wave_controller_x_inst__2345_/A1 wave_controller_x_inst__2345_/A2
+ wave_controller_x_inst__2345_/B wave_controller_x_inst__2345_/C wave_controller_x_inst__2346_/B
+ VDD VDD VSS VSS gf180mcu_fd_sc_mcu7t5v0__oai211_1
XFILLER_165_912 VDD VDD VSS VSS gf180mcu_fd_sc_mcu7t5v0__fillcap_64
Xwave_controller_y_inst__2292_ wave_controller_y_inst__1823_/I wave_controller_y_inst__2815_/A1
+ wave_controller_y_inst__2292_/A3 wave_controller_y_inst__2293_/B VDD VDD VSS VSS
+ gf180mcu_fd_sc_mcu7t5v0__xor3_1
XFILLER_109_338 VDD VDD VSS VSS gf180mcu_fd_sc_mcu7t5v0__fill_1
XFILLER_139_69 VDD VDD VSS VSS gf180mcu_fd_sc_mcu7t5v0__fill_1
Xwave_controller_x_inst__2276_ wire456/Z wave_controller_x_inst__2275_/Z wave_controller_x_inst__2294_/A2
+ VDD VDD VSS VSS gf180mcu_fd_sc_mcu7t5v0__nand2_1
XFILLER_136_157 VDD VDD VSS VSS gf180mcu_fd_sc_mcu7t5v0__fillcap_16
XFILLER_133_820 VDD VDD VSS VSS gf180mcu_fd_sc_mcu7t5v0__fill_1
XFILLER_136_179 VDD VDD VSS VSS gf180mcu_fd_sc_mcu7t5v0__fill_1
XFILLER_155_24 VDD VDD VSS VSS gf180mcu_fd_sc_mcu7t5v0__fill_1
XFILLER_133_842 VDD VDD VSS VSS gf180mcu_fd_sc_mcu7t5v0__fillcap_8
XFILLER_144_190 VDD VDD VSS VSS gf180mcu_fd_sc_mcu7t5v0__fill_2
XFILLER_120_514 VDD VDD VSS VSS gf180mcu_fd_sc_mcu7t5v0__fill_2
XFILLER_133_897 VDD VDD VSS VSS gf180mcu_fd_sc_mcu7t5v0__fill_1
XFILLER_87_973 VDD VDD VSS VSS gf180mcu_fd_sc_mcu7t5v0__fillcap_4
XFILLER_101_772 VDD VDD VSS VSS gf180mcu_fd_sc_mcu7t5v0__fillcap_8
XFILLER_46_314 VDD VDD VSS VSS gf180mcu_fd_sc_mcu7t5v0__fill_1
XFILLER_59_697 VDD VDD VSS VSS gf180mcu_fd_sc_mcu7t5v0__fill_2
XTAP_TAPCELL_ROW_57_810 VDD VSS gf180mcu_fd_sc_mcu7t5v0__filltie
XTAP_TAPCELL_ROW_57_821 VDD VSS gf180mcu_fd_sc_mcu7t5v0__filltie
XFILLER_104_50 VDD VDD VSS VSS gf180mcu_fd_sc_mcu7t5v0__fillcap_4
XFILLER_150_1087 VDD VDD VSS VSS gf180mcu_fd_sc_mcu7t5v0__fillcap_64
XFILLER_58_185 VDD VDD VSS VSS gf180mcu_fd_sc_mcu7t5v0__fillcap_16
XFILLER_62_807 VDD VDD VSS VSS gf180mcu_fd_sc_mcu7t5v0__fillcap_32
XFILLER_64_32 VDD VDD VSS VSS gf180mcu_fd_sc_mcu7t5v0__fill_2
XFILLER_74_689 VDD VDD VSS VSS gf180mcu_fd_sc_mcu7t5v0__fill_2
Xspi_regs_inst_max_cap312 spi_regs_inst__0888_/S spi_regs_inst__0887_/S VDD VDD VSS
+ VSS gf180mcu_fd_sc_mcu7t5v0__clkbuf_1
XFILLER_14_211 VDD VDD VSS VSS gf180mcu_fd_sc_mcu7t5v0__fillcap_32
XFILLER_55_892 VDD VDD VSS VSS gf180mcu_fd_sc_mcu7t5v0__fillcap_16
Xwave_controller_y_inst__3677_ wave_controller_y_inst__3677_/D fanout580/Z clkload21/I
+ spi_regs_inst__1354_/A1 VDD VDD VSS VSS gf180mcu_fd_sc_mcu7t5v0__dffrnq_1
Xwave_controller_y_inst__2628_ wave_controller_y_inst__2634_/C wave_controller_y_inst__2627_/Z
+ wave_controller_y_inst__2630_/A1 VDD VDD VSS VSS gf180mcu_fd_sc_mcu7t5v0__nand2_1
XFILLER_70_1011 VDD VDD VSS VSS gf180mcu_fd_sc_mcu7t5v0__fillcap_4
Xwave_controller_y_inst__2559_ spi_regs_inst__1343_/A1 wave_controller_y_inst__2558_/Z
+ wave_controller_y_inst__2573_/B VDD VDD VSS VSS gf180mcu_fd_sc_mcu7t5v0__nand2_1
XTAP_TAPCELL_ROW_155_2437 VDD VSS gf180mcu_fd_sc_mcu7t5v0__filltie
XFILLER_155_422 VDD VDD VSS VSS gf180mcu_fd_sc_mcu7t5v0__fill_2
XFILLER_155_433 VDD VDD VSS VSS gf180mcu_fd_sc_mcu7t5v0__fillcap_8
XFILLER_167_260 VDD VDD VSS VSS gf180mcu_fd_sc_mcu7t5v0__fillcap_8
XFILLER_6_410 VDD VDD VSS VSS gf180mcu_fd_sc_mcu7t5v0__fill_2
Xspi_regs_inst__1220_ spi_regs_inst__1220_/A1 spi_regs_inst__1220_/A2 spi_regs_inst__1220_/A3
+ spi_regs_inst__1220_/A4 spi_regs_inst__1221_/A4 VDD VDD VSS VSS gf180mcu_fd_sc_mcu7t5v0__nor4_1
Xsignal_processor_x_inst__198_ signal_processor_x_inst__215_/A1 signal_processor_x_inst__194_/Z
+ signal_processor_x_inst__198_/B signal_processor_x_inst__217_/D VDD VDD VSS VSS
+ gf180mcu_fd_sc_mcu7t5v0__oai21_1
XFILLER_10_483 VDD VDD VSS VSS gf180mcu_fd_sc_mcu7t5v0__fill_1
XFILLER_13_80 VDD VDD VSS VSS gf180mcu_fd_sc_mcu7t5v0__fill_2
XFILLER_6_443 VDD VDD VSS VSS gf180mcu_fd_sc_mcu7t5v0__fillcap_8
Xspi_regs_inst__1151_ _10_/A2 spi_regs_inst_wire263/Z spi_regs_inst__1151_/B1 spi_regs_inst__1522_/Q
+ spi_regs_inst__1152_/A4 VDD VDD VSS VSS gf180mcu_fd_sc_mcu7t5v0__aoi22_1
XPHY_EDGE_ROW_108_Right_108 VDD VSS gf180mcu_fd_sc_mcu7t5v0__endcap
XFILLER_108_382 VDD VDD VSS VSS gf180mcu_fd_sc_mcu7t5v0__fill_2
Xspi_regs_inst__1082_ spi_regs_inst__1550_/Q spi_regs_inst__1304_/A2 spi_regs_inst_wire242/Z
+ spi_regs_inst__1508_/Q spi_regs_inst_wire286/Z spi_regs_inst__1600_/Q spi_regs_inst__1084_/A1
+ VDD VDD VSS VSS gf180mcu_fd_sc_mcu7t5v0__aoi222_1
XFILLER_123_352 VDD VDD VSS VSS gf180mcu_fd_sc_mcu7t5v0__fillcap_16
XFILLER_151_661 VDD VDD VSS VSS gf180mcu_fd_sc_mcu7t5v0__fillcap_16
XFILLER_123_374 VDD VDD VSS VSS gf180mcu_fd_sc_mcu7t5v0__fill_1
XFILLER_150_160 VDD VDD VSS VSS gf180mcu_fd_sc_mcu7t5v0__fill_1
XTAP_TAPCELL_ROW_71_1049 VDD VSS gf180mcu_fd_sc_mcu7t5v0__filltie
XFILLER_49_130 VDD VDD VSS VSS gf180mcu_fd_sc_mcu7t5v0__fillcap_4
XFILLER_96_247 VDD VDD VSS VSS gf180mcu_fd_sc_mcu7t5v0__fillcap_4
XFILLER_49_185 VDD VDD VSS VSS gf180mcu_fd_sc_mcu7t5v0__fill_1
Xspi_regs_inst__0935_ spi_regs_inst__1637_/Q spi_regs_inst__1636_/Q spi_regs_inst__0939_/S
+ spi_regs_inst__1637_/D VDD VDD VSS VSS gf180mcu_fd_sc_mcu7t5v0__mux2_2
XFILLER_18_550 VDD VDD VSS VSS gf180mcu_fd_sc_mcu7t5v0__fill_1
XFILLER_52_317 VDD VDD VSS VSS gf180mcu_fd_sc_mcu7t5v0__fillcap_16
XFILLER_53_818 VDD VDD VSS VSS gf180mcu_fd_sc_mcu7t5v0__fillcap_8
XFILLER_64_177 VDD VDD VSS VSS gf180mcu_fd_sc_mcu7t5v0__fillcap_8
Xspi_regs_inst__0866_ spi_regs_inst__1602_/Q spi_regs_inst_wire480/Z spi_regs_inst__0870_/S
+ spi_regs_inst__1602_/D VDD VDD VSS VSS gf180mcu_fd_sc_mcu7t5v0__mux2_2
XFILLER_33_520 VDD VDD VSS VSS gf180mcu_fd_sc_mcu7t5v0__fill_1
XFILLER_61_873 VDD VDD VSS VSS gf180mcu_fd_sc_mcu7t5v0__fillcap_8
XTAP_TAPCELL_ROW_86_1292 VDD VSS gf180mcu_fd_sc_mcu7t5v0__filltie
Xspi_regs_inst__0797_ spi_regs_inst__1548_/Q spi_regs_inst__1412_/I1 spi_regs_inst__0797_/S
+ spi_regs_inst__1548_/D VDD VDD VSS VSS gf180mcu_fd_sc_mcu7t5v0__mux2_2
XFILLER_147_912 VDD VDD VSS VSS gf180mcu_fd_sc_mcu7t5v0__fillcap_64
XFILLER_159_772 VDD VDD VSS VSS gf180mcu_fd_sc_mcu7t5v0__fillcap_64
XFILLER_20_247 VDD VDD VSS VSS gf180mcu_fd_sc_mcu7t5v0__fillcap_8
Xwave_controller_x_inst__2130_ wave_controller_x_inst__2130_/A1 wave_controller_x_inst__2130_/A2
+ wave_controller_x_inst__2130_/B wave_controller_x_inst__2131_/A2 VDD VDD VSS VSS
+ gf180mcu_fd_sc_mcu7t5v0__oai21_1
Xspi_regs_inst__1418_ spi_regs_inst_wire476/Z fanout505/Z spi_regs_inst__1419_/S spi_regs_inst__1490_/D
+ VDD VDD VSS VSS gf180mcu_fd_sc_mcu7t5v0__mux2_2
Xwave_controller_x_inst__2061_ wave_controller_x_inst__2061_/A1 wave_controller_x_inst__2074_/A3
+ wave_controller_x_inst__2114_/B wave_controller_x_inst__2125_/C wave_controller_x_inst__2062_/A3
+ VDD VDD VSS VSS gf180mcu_fd_sc_mcu7t5v0__aoi211_1
Xspi_regs_inst__1349_ spi_regs_inst__1349_/A1 spi_regs_inst_wire228/I spi_regs_inst_wire222/Z
+ max_cap431/Z spi_regs_inst__1351_/A3 VDD VDD VSS VSS gf180mcu_fd_sc_mcu7t5v0__aoi22_1
XFILLER_115_820 VDD VDD VSS VSS gf180mcu_fd_sc_mcu7t5v0__fill_1
XFILLER_146_477 VDD VDD VSS VSS gf180mcu_fd_sc_mcu7t5v0__fillcap_16
Xspi_regs_inst_wire30 spi_regs_inst_wire30/I spi_regs_inst_wire30/Z VDD VDD VSS VSS
+ gf180mcu_fd_sc_mcu7t5v0__buf_2
XFILLER_115_864 VDD VDD VSS VSS gf180mcu_fd_sc_mcu7t5v0__fillcap_8
XFILLER_142_661 VDD VDD VSS VSS gf180mcu_fd_sc_mcu7t5v0__fillcap_4
XFILLER_114_396 VDD VDD VSS VSS gf180mcu_fd_sc_mcu7t5v0__fillcap_8
Xwave_controller_x_inst__2963_ wave_controller_x_inst__3702_/Q fanout530/I wave_controller_x_inst__2965_/A1
+ VDD VDD VSS VSS gf180mcu_fd_sc_mcu7t5v0__nor2_1
Xspi_regs_inst_wire96 spi_regs_inst_wire97/Z spi_regs_inst_wire96/Z VDD VDD VSS VSS
+ gf180mcu_fd_sc_mcu7t5v0__clkbuf_1
XFILLER_102_547 VDD VDD VSS VSS gf180mcu_fd_sc_mcu7t5v0__fillcap_16
XFILLER_130_889 VDD VDD VSS VSS gf180mcu_fd_sc_mcu7t5v0__fill_1
XFILLER_75_409 VDD VDD VSS VSS gf180mcu_fd_sc_mcu7t5v0__fill_1
Xwave_controller_y_inst__1930_ spi_regs_inst__1572_/Q wave_controller_y_inst__3163_/C
+ spi_regs_inst__1571_/Q wave_controller_y_inst__3305_/A1 wave_controller_y_inst__1930_/C
+ wave_controller_y_inst__1932_/A1 VDD VDD VSS VSS gf180mcu_fd_sc_mcu7t5v0__aoi221_1
Xwave_controller_x_inst__2894_ wave_controller_x_inst__3406_/A1 wave_controller_x_inst__3454_/A2
+ wave_controller_x_inst__2933_/A1 VDD VDD VSS VSS gf180mcu_fd_sc_mcu7t5v0__nor2_1
Xwave_controller_x_inst__1914_ spi_regs_inst__1496_/Q wave_controller_x_inst__3189_/C
+ wave_controller_x_inst__3340_/A1 spi_regs_inst__1497_/Q wave_controller_x_inst__1944_/A1
+ VDD VDD VSS VSS gf180mcu_fd_sc_mcu7t5v0__oai22_1
XFILLER_68_483 VDD VDD VSS VSS gf180mcu_fd_sc_mcu7t5v0__fill_1
Xwave_controller_y_inst__1861_ spi_regs_inst__1199_/A1 wave_controller_y_inst__2616_/A1
+ VDD VDD VSS VSS gf180mcu_fd_sc_mcu7t5v0__clkinv_1
Xwave_controller_x_inst__1845_ spi_regs_inst__1349_/A1 wave_controller_x_inst__2380_/A1
+ VDD VDD VSS VSS gf180mcu_fd_sc_mcu7t5v0__clkinv_1
XFILLER_110_580 VDD VDD VSS VSS gf180mcu_fd_sc_mcu7t5v0__fillcap_4
XFILLER_56_656 VDD VDD VSS VSS gf180mcu_fd_sc_mcu7t5v0__fill_1
XTAP_TAPCELL_ROW_2_1_346 VDD VSS gf180mcu_fd_sc_mcu7t5v0__filltie
Xwave_controller_y_inst__3600_ wave_controller_y_inst__3600_/I0 spi_regs_inst__1281_/A1
+ wave_controller_y_inst__3602_/S wave_controller_y_inst__3675_/D VDD VDD VSS VSS
+ gf180mcu_fd_sc_mcu7t5v0__mux2_2
Xwave_controller_y_inst__1792_ wave_controller_y_inst__1792_/I wave_controller_y_inst__3572_/A1
+ VDD VDD VSS VSS gf180mcu_fd_sc_mcu7t5v0__clkinv_1
XFILLER_18_69 VDD VDD VSS VSS gf180mcu_fd_sc_mcu7t5v0__fillcap_16
XFILLER_56_667 VDD VDD VSS VSS gf180mcu_fd_sc_mcu7t5v0__fillcap_8
Xwave_controller_y_inst__3531_ wave_controller_y_inst__3713_/Q wave_controller_y_inst__3555_/A2
+ wave_controller_y_inst__3533_/A2 VDD VDD VSS VSS gf180mcu_fd_sc_mcu7t5v0__nor2_1
Xwave_controller_x_inst__1776_ spi_regs_inst__1495_/Q wave_controller_x_inst__1915_/A1
+ VDD VDD VSS VSS gf180mcu_fd_sc_mcu7t5v0__clkinv_1
Xwave_controller_x_inst__3515_ wave_controller_x_inst__3530_/A1 wave_controller_x_inst__3515_/A2
+ wave_controller_x_inst__3515_/A3 wave_controller_x_inst__3530_/B1 wave_controller_x_inst__3515_/B2
+ wave_controller_x_inst__3634_/D VDD VDD VSS VSS gf180mcu_fd_sc_mcu7t5v0__oai32_1
XFILLER_36_391 VDD VDD VSS VSS gf180mcu_fd_sc_mcu7t5v0__fill_1
Xwave_controller_y_inst__3462_ wave_controller_y_inst__3554_/A1 wave_controller_y_inst__3462_/A2
+ wave_controller_y_inst__3461_/Z wave_controller_y_inst__3524_/B1 wave_controller_y_inst__3462_/B2
+ wave_controller_y_inst__3624_/D VDD VDD VSS VSS gf180mcu_fd_sc_mcu7t5v0__oai32_1
Xwave_controller_x_inst__3446_ wave_controller_x_inst__3489_/C wave_controller_x_inst__3446_/A2
+ wave_controller_x_inst__3419_/B wave_controller_x_inst__3450_/A1 VDD VDD VSS VSS
+ gf180mcu_fd_sc_mcu7t5v0__nand3_1
XFILLER_54_1017 VDD VDD VSS VSS gf180mcu_fd_sc_mcu7t5v0__fillcap_64
Xwave_controller_y_inst__2413_ wave_controller_y_inst__2399_/Z wave_controller_y_inst__2425_/A3
+ wave_controller_y_inst__2416_/A3 VDD VDD VSS VSS gf180mcu_fd_sc_mcu7t5v0__nor2_1
Xwave_controller_y_inst__3393_ wave_controller_y_inst__1818_/I wave_controller_y_inst__3394_/B1
+ wave_controller_y_inst__3360_/Z wave_controller_y_inst__1819_/I wave_controller_y_inst__3395_/A2
+ VDD VDD VSS VSS gf180mcu_fd_sc_mcu7t5v0__aoi22_1
Xsignal_processor_x_inst__121_ signal_processor_x_inst__128_/A1 signal_processor_x_inst__249_/Q
+ signal_processor_x_inst__250_/D VDD VDD VSS VSS gf180mcu_fd_sc_mcu7t5v0__and2_1
XTAP_TAPCELL_ROW_137_2134 VDD VSS gf180mcu_fd_sc_mcu7t5v0__filltie
Xwave_controller_y_inst__2344_ wave_controller_y_inst__2310_/I wave_controller_y_inst__2345_/A2
+ wave_controller_y_inst__2346_/A2 VDD VDD VSS VSS gf180mcu_fd_sc_mcu7t5v0__nor2_1
Xwave_controller_x_inst__3377_ fanout530/Z wave_controller_x_inst__3282_/B wave_controller_x_inst__3377_/B
+ wave_controller_x_inst__3382_/A1 VDD VDD VSS VSS gf180mcu_fd_sc_mcu7t5v0__aoi21_1
XFILLER_137_411 VDD VDD VSS VSS gf180mcu_fd_sc_mcu7t5v0__fillcap_8
XFILLER_149_282 VDD VDD VSS VSS gf180mcu_fd_sc_mcu7t5v0__fillcap_4
XTAP_TAPCELL_ROW_137_2145 VDD VSS gf180mcu_fd_sc_mcu7t5v0__filltie
Xwave_controller_x_inst__2328_ wave_controller_x_inst__2328_/A1 wave_controller_x_inst__2303_/Z
+ wave_controller_x_inst__2327_/B wave_controller_x_inst__2328_/Z VDD VDD VSS VSS
+ gf180mcu_fd_sc_mcu7t5v0__or3_1
Xclkload1 clkload1/I clkload1/Z VDD VDD VSS VSS gf180mcu_fd_sc_mcu7t5v0__clkbuf_2
XFILLER_166_34 VDD VDD VSS VSS gf180mcu_fd_sc_mcu7t5v0__fill_1
Xwave_controller_y_inst__2275_ fanout502/Z wave_controller_y_inst__2286_/A2 wave_controller_y_inst__2275_/A3
+ wave_controller_y_inst__2275_/Z VDD VDD VSS VSS gf180mcu_fd_sc_mcu7t5v0__xor3_1
Xwave_controller_x_inst__2259_ wave_controller_x_inst__2259_/A1 wave_controller_x_inst__2259_/A2
+ wave_controller_x_inst__2259_/B1 wave_controller_x_inst_wire184/Z wave_controller_x_inst__2259_/C
+ wave_controller_x_inst_wire170/I VDD VDD VSS VSS gf180mcu_fd_sc_mcu7t5v0__oai221_1
XFILLER_125_639 VDD VDD VSS VSS gf180mcu_fd_sc_mcu7t5v0__fillcap_4
XFILLER_137_466 VDD VDD VSS VSS gf180mcu_fd_sc_mcu7t5v0__fillcap_16
XTAP_TAPCELL_ROW_150_2345 VDD VSS gf180mcu_fd_sc_mcu7t5v0__filltie
XTAP_TAPCELL_ROW_150_2356 VDD VSS gf180mcu_fd_sc_mcu7t5v0__filltie
XTAP_TAPCELL_ROW_40_1_635 VDD VSS gf180mcu_fd_sc_mcu7t5v0__filltie
XFILLER_105_352 VDD VDD VSS VSS gf180mcu_fd_sc_mcu7t5v0__fillcap_8
XFILLER_3_457 VDD VDD VSS VSS gf180mcu_fd_sc_mcu7t5v0__fillcap_4
XFILLER_79_726 VDD VDD VSS VSS gf180mcu_fd_sc_mcu7t5v0__fill_1
XTAP_TAPCELL_ROW_115_1775 VDD VSS gf180mcu_fd_sc_mcu7t5v0__filltie
XFILLER_105_385 VDD VDD VSS VSS gf180mcu_fd_sc_mcu7t5v0__fillcap_4
XFILLER_120_300 VDD VDD VSS VSS gf180mcu_fd_sc_mcu7t5v0__fill_2
XFILLER_132_160 VDD VDD VSS VSS gf180mcu_fd_sc_mcu7t5v0__fill_1
XFILLER_59_76 VDD VDD VSS VSS gf180mcu_fd_sc_mcu7t5v0__fill_1
XFILLER_132_193 VDD VDD VSS VSS gf180mcu_fd_sc_mcu7t5v0__fillcap_8
XFILLER_78_247 VDD VDD VSS VSS gf180mcu_fd_sc_mcu7t5v0__fillcap_8
XFILLER_94_718 VDD VDD VSS VSS gf180mcu_fd_sc_mcu7t5v0__fill_1
XFILLER_87_792 VDD VDD VSS VSS gf180mcu_fd_sc_mcu7t5v0__fill_1
XPHY_EDGE_ROW_47_1_Right_46 VDD VSS gf180mcu_fd_sc_mcu7t5v0__endcap
XFILLER_19_336 VDD VDD VSS VSS gf180mcu_fd_sc_mcu7t5v0__fill_1
XFILLER_74_442 VDD VDD VSS VSS gf180mcu_fd_sc_mcu7t5v0__fillcap_8
XFILLER_46_155 VDD VDD VSS VSS gf180mcu_fd_sc_mcu7t5v0__fill_2
XFILLER_75_97 VDD VDD VSS VSS gf180mcu_fd_sc_mcu7t5v0__fillcap_4
XFILLER_75_976 VDD VDD VSS VSS gf180mcu_fd_sc_mcu7t5v0__fillcap_4
XFILLER_46_177 VDD VDD VSS VSS gf180mcu_fd_sc_mcu7t5v0__fillcap_16
XFILLER_46_199 VDD VDD VSS VSS gf180mcu_fd_sc_mcu7t5v0__fill_1
Xwave_controller_y_inst__3729_ wave_controller_y_inst__3729_/D fanout547/Z clkload6/I
+ wave_controller_y_inst__3729_/Q VDD VDD VSS VSS gf180mcu_fd_sc_mcu7t5v0__dffrnq_1
XFILLER_61_158 VDD VDD VSS VSS gf180mcu_fd_sc_mcu7t5v0__fillcap_4
XFILLER_30_501 VDD VDD VSS VSS gf180mcu_fd_sc_mcu7t5v0__fill_2
XFILLER_42_361 VDD VDD VSS VSS gf180mcu_fd_sc_mcu7t5v0__fill_2
XFILLER_91_52 VDD VDD VSS VSS gf180mcu_fd_sc_mcu7t5v0__fillcap_16
Xspi_regs_inst_max_cap197 spi_regs_inst__0780_/S spi_regs_inst__0778_/S VDD VDD VSS
+ VSS gf180mcu_fd_sc_mcu7t5v0__buf_4
Xspi_regs_inst_max_cap186 spi_regs_inst__1448_/S spi_regs_inst__1451_/S VDD VDD VSS
+ VSS gf180mcu_fd_sc_mcu7t5v0__buf_2
XFILLER_129_912 VDD VDD VSS VSS gf180mcu_fd_sc_mcu7t5v0__fillcap_64
Xspi_regs_inst__1203_ spi_regs_inst__1203_/A1 spi_regs_inst__1203_/A2 spi_regs_inst__1325_/A2
+ spi_regs_inst_wire101/Z spi_regs_inst__1205_/A3 VDD VDD VSS VSS gf180mcu_fd_sc_mcu7t5v0__aoi22_1
XFILLER_116_617 VDD VDD VSS VSS gf180mcu_fd_sc_mcu7t5v0__fillcap_4
XFILLER_128_466 VDD VDD VSS VSS gf180mcu_fd_sc_mcu7t5v0__fillcap_32
XTAP_TAPCELL_ROW_26_1_525 VDD VSS gf180mcu_fd_sc_mcu7t5v0__filltie
Xmax_cap427 max_cap427/I max_cap427/Z VDD VDD VSS VSS gf180mcu_fd_sc_mcu7t5v0__clkbuf_4
Xmax_cap405 fanout404/Z fanout402/I VDD VDD VSS VSS gf180mcu_fd_sc_mcu7t5v0__buf_8
Xspi_regs_inst__1134_ spi_regs_inst__1134_/A1 spi_regs_inst_wire288/I spi_regs_inst__1182_/B1
+ spi_regs_inst__1622_/Q spi_regs_inst__1137_/A1 VDD VDD VSS VSS gf180mcu_fd_sc_mcu7t5v0__aoi22_1
Xspi_regs_inst__1065_ spi_regs_inst__1065_/A1 spi_regs_inst_wire290/Z spi_regs_inst__1306_/B1
+ spi_regs_inst__1065_/B2 spi_regs_inst__1067_/A3 VDD VDD VSS VSS gf180mcu_fd_sc_mcu7t5v0__aoi22_1
XFILLER_112_867 VDD VDD VSS VSS gf180mcu_fd_sc_mcu7t5v0__fillcap_8
XFILLER_111_388 VDD VDD VSS VSS gf180mcu_fd_sc_mcu7t5v0__fillcap_4
XTAP_TAPCELL_ROW_88_1321 VDD VSS gf180mcu_fd_sc_mcu7t5v0__filltie
XTAP_TAPCELL_ROW_88_1332 VDD VSS gf180mcu_fd_sc_mcu7t5v0__filltie
XFILLER_1_72 VDD VDD VSS VSS gf180mcu_fd_sc_mcu7t5v0__fillcap_64
Xwave_controller_y_inst_load_slew410 wave_controller_y_inst__2815_/A2 wave_controller_y_inst__2805_/S
+ VDD VDD VSS VSS gf180mcu_fd_sc_mcu7t5v0__buf_4
Xspi_regs_inst__0918_ spi_regs_inst__1630_/Q spi_regs_inst__1631_/Q spi_regs_inst__0918_/Z
+ VDD VDD VSS VSS gf180mcu_fd_sc_mcu7t5v0__and2_1
XFILLER_37_199 VDD VDD VSS VSS gf180mcu_fd_sc_mcu7t5v0__fillcap_4
XFILLER_53_648 VDD VDD VSS VSS gf180mcu_fd_sc_mcu7t5v0__fillcap_8
XFILLER_81_979 VDD VDD VSS VSS gf180mcu_fd_sc_mcu7t5v0__fill_1
Xwave_controller_x_inst__3300_ wave_controller_x_inst__3305_/B2 spi_regs_inst__1549_/Q
+ wave_controller_x_inst__3297_/Z wave_controller_x_inst__3299_/I wave_controller_x_inst__3363_/A1
+ VDD VDD VSS VSS gf180mcu_fd_sc_mcu7t5v0__aoi22_1
Xspi_regs_inst__0849_ spi_regs_inst__1588_/Q spi_regs_inst__1443_/I1 spi_regs_inst__0849_/S
+ spi_regs_inst__1588_/D VDD VDD VSS VSS gf180mcu_fd_sc_mcu7t5v0__mux2_2
Xwave_controller_x_inst__3231_ wave_controller_x_inst__3701_/Q wave_controller_x_inst__3231_/A2
+ wave_controller_x_inst__3231_/B wave_controller_x_inst__3232_/C VDD VDD VSS VSS
+ gf180mcu_fd_sc_mcu7t5v0__aoi21_1
Xwave_controller_x_inst__3162_ wave_controller_x_inst__3154_/Z wave_controller_x_inst__3205_/A2
+ wave_controller_x_inst__3162_/B wave_controller_x_inst__3166_/A1 VDD VDD VSS VSS
+ gf180mcu_fd_sc_mcu7t5v0__oai21_1
XFILLER_146_241 VDD VDD VSS VSS gf180mcu_fd_sc_mcu7t5v0__fillcap_4
XFILLER_147_742 VDD VDD VSS VSS gf180mcu_fd_sc_mcu7t5v0__fillcap_4
Xwave_controller_x_inst__3093_ wave_controller_x_inst__3096_/A1 wave_controller_x_inst__3097_/A1
+ state_machine_inst__34_/A1 fanout498/Z wave_controller_x_inst__3611_/D VDD VDD VSS
+ VSS gf180mcu_fd_sc_mcu7t5v0__oai211_1
Xwave_controller_x_inst__2113_ wave_controller_x_inst__2092_/B wave_controller_x_inst__2130_/A1
+ wave_controller_x_inst__2114_/A2 VDD VDD VSS VSS gf180mcu_fd_sc_mcu7t5v0__nor2_1
Xwave_controller_y_inst__2060_ wave_controller_y_inst__2092_/A1 wave_controller_y_inst__2077_/A1
+ wave_controller_y_inst__2074_/A3 VDD VDD VSS VSS gf180mcu_fd_sc_mcu7t5v0__nand2_1
Xwave_controller_x_inst__2044_ wave_controller_x_inst__2035_/Z wave_controller_x_inst__2037_/Z
+ wave_controller_x_inst__2107_/B VDD VDD VSS VSS gf180mcu_fd_sc_mcu7t5v0__nor2_1
XFILLER_20_37 VDD VDD VSS VSS gf180mcu_fd_sc_mcu7t5v0__fillcap_32
XFILLER_88_1157 VDD VDD VSS VSS gf180mcu_fd_sc_mcu7t5v0__fillcap_16
XTAP_TAPCELL_ROW_132_2053 VDD VSS gf180mcu_fd_sc_mcu7t5v0__filltie
XFILLER_161_266 VDD VDD VSS VSS gf180mcu_fd_sc_mcu7t5v0__fill_1
Xspi_regs_inst_wire242 spi_regs_inst_wire242/I spi_regs_inst_wire242/Z VDD VDD VSS
+ VSS gf180mcu_fd_sc_mcu7t5v0__buf_2
Xspi_regs_inst_wire231 spi_regs_inst_wire231/I spi_regs_inst_wire231/Z VDD VDD VSS
+ VSS gf180mcu_fd_sc_mcu7t5v0__buf_2
XFILLER_115_683 VDD VDD VSS VSS gf180mcu_fd_sc_mcu7t5v0__fillcap_16
XFILLER_130_642 VDD VDD VSS VSS gf180mcu_fd_sc_mcu7t5v0__fillcap_8
XFILLER_88_567 VDD VDD VSS VSS gf180mcu_fd_sc_mcu7t5v0__fillcap_8
Xwave_controller_y_inst__2962_ wave_controller_y_inst__3702_/Q fanout509/I wave_controller_y_inst__2965_/B
+ VDD VDD VSS VSS gf180mcu_fd_sc_mcu7t5v0__nand2_1
Xwave_controller_x_inst__2946_ wave_controller_x_inst__1790_/I wave_controller_x_inst__2981_/A2
+ wave_controller_x_inst__2985_/A2 VDD VDD VSS VSS gf180mcu_fd_sc_mcu7t5v0__nor2_1
Xspi_regs_inst_wire297 spi_regs_inst_wire297/I spi_regs_inst_wire297/Z VDD VDD VSS
+ VSS gf180mcu_fd_sc_mcu7t5v0__buf_2
Xspi_regs_inst_wire286 spi_regs_inst_wire286/I spi_regs_inst_wire286/Z VDD VDD VSS
+ VSS gf180mcu_fd_sc_mcu7t5v0__buf_2
Xwave_controller_y_inst__1913_ wave_controller_y_inst__3189_/A1 spi_regs_inst__1560_/Q
+ wave_controller_y_inst__1944_/B VDD VDD VSS VSS gf180mcu_fd_sc_mcu7t5v0__nand2_1
XFILLER_152_47 VDD VDD VSS VSS gf180mcu_fd_sc_mcu7t5v0__fill_1
XTAP_TAPCELL_ROW_110_1694 VDD VSS gf180mcu_fd_sc_mcu7t5v0__filltie
Xwave_controller_y_inst__2893_ wave_controller_y_inst__3738_/Q wave_controller_y_inst__3739_/Q
+ wave_controller_y_inst__2893_/Z VDD VDD VSS VSS gf180mcu_fd_sc_mcu7t5v0__xor2_1
Xwave_controller_x_inst__2877_ wave_controller_x_inst__2881_/B wave_controller_x_inst__2880_/A3
+ wave_controller_x_inst__2878_/A2 VDD VDD VSS VSS gf180mcu_fd_sc_mcu7t5v0__nand2_1
XFILLER_28_166 VDD VDD VSS VSS gf180mcu_fd_sc_mcu7t5v0__fillcap_8
XFILLER_57_976 VDD VDD VSS VSS gf180mcu_fd_sc_mcu7t5v0__fillcap_4
XFILLER_60_1087 VDD VDD VSS VSS gf180mcu_fd_sc_mcu7t5v0__fillcap_64
Xwave_controller_y_inst__1844_ spi_regs_inst__1278_/A1 wave_controller_y_inst__2349_/A1
+ VDD VDD VSS VSS gf180mcu_fd_sc_mcu7t5v0__clkinv_1
Xwave_controller_x_inst__1828_ wave_controller_x_inst__3231_/B wave_controller_x_inst__3376_/B
+ VDD VDD VSS VSS gf180mcu_fd_sc_mcu7t5v0__clkinv_1
XFILLER_28_177 VDD VDD VSS VSS gf180mcu_fd_sc_mcu7t5v0__fillcap_4
XFILLER_45_56 VDD VDD VSS VSS gf180mcu_fd_sc_mcu7t5v0__fill_2
XTAP_TAPCELL_ROW_67_982 VDD VSS gf180mcu_fd_sc_mcu7t5v0__filltie
Xwave_controller_y_inst__1775_ wave_controller_y_inst__3719_/Q wave_controller_y_inst__3262_/A1
+ VDD VDD VSS VSS gf180mcu_fd_sc_mcu7t5v0__clkinv_1
XFILLER_43_136 VDD VDD VSS VSS gf180mcu_fd_sc_mcu7t5v0__fillcap_4
XFILLER_45_67 VDD VDD VSS VSS gf180mcu_fd_sc_mcu7t5v0__fill_2
Xwave_controller_y_inst__3514_ spi_regs_inst__1312_/B2 wave_controller_y_inst__3529_/A2
+ wave_controller_y_inst__3515_/A3 VDD VDD VSS VSS gf180mcu_fd_sc_mcu7t5v0__nor2_1
XFILLER_24_361 VDD VDD VSS VSS gf180mcu_fd_sc_mcu7t5v0__fillcap_4
Xwave_controller_y_inst__3445_ wave_controller_y_inst__3449_/A1 wave_controller_y_inst__3494_/A1
+ wave_controller_y_inst__3445_/B wave_controller_y_inst__3451_/A2 VDD VDD VSS VSS
+ gf180mcu_fd_sc_mcu7t5v0__oai21_1
Xwave_controller_x_inst__3429_ wave_controller_x_inst__3429_/I wave_controller_x_inst__3430_/B2
+ VDD VDD VSS VSS gf180mcu_fd_sc_mcu7t5v0__clkinv_1
XFILLER_131_2 VDD VDD VSS VSS gf180mcu_fd_sc_mcu7t5v0__fillcap_16
XFILLER_8_527 VDD VDD VSS VSS gf180mcu_fd_sc_mcu7t5v0__fill_2
Xwave_controller_y_inst__3376_ wave_controller_y_inst__2797_/C spi_regs_inst__1599_/Q
+ wave_controller_y_inst__3376_/B wave_controller_y_inst__3378_/C VDD VDD VSS VSS
+ gf180mcu_fd_sc_mcu7t5v0__aoi21_1
XTAP_TAPCELL_ROW_117_1804 VDD VSS gf180mcu_fd_sc_mcu7t5v0__filltie
Xwave_controller_y_inst__2327_ wave_controller_y_inst__2328_/A1 wave_controller_y_inst__2303_/Z
+ wave_controller_y_inst__2327_/B wave_controller_y_inst__2345_/C VDD VDD VSS VSS
+ gf180mcu_fd_sc_mcu7t5v0__oai21_1
XTAP_TAPCELL_ROW_117_1815 VDD VSS gf180mcu_fd_sc_mcu7t5v0__filltie
Xwave_controller_y_inst__2258_ wave_controller_y_inst__2259_/A1 wave_controller_y_inst__2259_/A2
+ wave_controller_y_inst__2260_/B VDD VDD VSS VSS gf180mcu_fd_sc_mcu7t5v0__nor2_1
XFILLER_98_309 VDD VDD VSS VSS gf180mcu_fd_sc_mcu7t5v0__fillcap_4
Xwave_controller_y_inst__2189_ wave_controller_y_inst__2186_/I wave_controller_y_inst__2213_/A2
+ wave_controller_y_inst__2202_/A1 VDD VDD VSS VSS gf180mcu_fd_sc_mcu7t5v0__nor2_1
XFILLER_3_276 VDD VDD VSS VSS gf180mcu_fd_sc_mcu7t5v0__fillcap_4
XFILLER_79_545 VDD VDD VSS VSS gf180mcu_fd_sc_mcu7t5v0__fillcap_8
XTAP_TAPCELL_ROW_167_2650 VDD VSS gf180mcu_fd_sc_mcu7t5v0__filltie
XFILLER_120_141 VDD VDD VSS VSS gf180mcu_fd_sc_mcu7t5v0__fill_2
XFILLER_121_697 VDD VDD VSS VSS gf180mcu_fd_sc_mcu7t5v0__fill_2
XFILLER_66_217 VDD VDD VSS VSS gf180mcu_fd_sc_mcu7t5v0__fillcap_8
XFILLER_120_174 VDD VDD VSS VSS gf180mcu_fd_sc_mcu7t5v0__fill_1
XFILLER_120_185 VDD VDD VSS VSS gf180mcu_fd_sc_mcu7t5v0__fillcap_4
XFILLER_47_431 VDD VDD VSS VSS gf180mcu_fd_sc_mcu7t5v0__fillcap_16
XFILLER_94_537 VDD VDD VSS VSS gf180mcu_fd_sc_mcu7t5v0__fill_1
XFILLER_81_209 VDD VDD VSS VSS gf180mcu_fd_sc_mcu7t5v0__fill_1
XTAP_TAPCELL_ROW_163_2569 VDD VSS gf180mcu_fd_sc_mcu7t5v0__filltie
XFILLER_90_721 VDD VDD VSS VSS gf180mcu_fd_sc_mcu7t5v0__fill_2
XTAP_TAPCELL_ROW_128_1988 VDD VSS gf180mcu_fd_sc_mcu7t5v0__filltie
Xspi_regs_inst_load_slew243 spi_regs_inst__1336_/B1 spi_regs_inst__1324_/B1 VDD VDD
+ VSS VSS gf180mcu_fd_sc_mcu7t5v0__buf_2
XFILLER_34_147 VDD VDD VSS VSS gf180mcu_fd_sc_mcu7t5v0__fill_1
XFILLER_63_979 VDD VDD VSS VSS gf180mcu_fd_sc_mcu7t5v0__fill_1
XFILLER_128_1151 VDD VDD VSS VSS gf180mcu_fd_sc_mcu7t5v0__fillcap_4
XTAP_TAPCELL_ROW_83_1240 VDD VSS gf180mcu_fd_sc_mcu7t5v0__filltie
XTAP_TAPCELL_ROW_83_1251 VDD VSS gf180mcu_fd_sc_mcu7t5v0__filltie
XFILLER_148_539 VDD VDD VSS VSS gf180mcu_fd_sc_mcu7t5v0__fillcap_8
XFILLER_116_403 VDD VDD VSS VSS gf180mcu_fd_sc_mcu7t5v0__fillcap_4
XFILLER_128_263 VDD VDD VSS VSS gf180mcu_fd_sc_mcu7t5v0__fillcap_32
XFILLER_156_572 VDD VDD VSS VSS gf180mcu_fd_sc_mcu7t5v0__fill_2
XPHY_EDGE_ROW_160_Right_160 VDD VSS gf180mcu_fd_sc_mcu7t5v0__endcap
XFILLER_116_469 VDD VDD VSS VSS gf180mcu_fd_sc_mcu7t5v0__fillcap_32
XFILLER_132_907 VDD VDD VSS VSS gf180mcu_fd_sc_mcu7t5v0__fillcap_32
XFILLER_89_309 VDD VDD VSS VSS gf180mcu_fd_sc_mcu7t5v0__fillcap_8
Xspi_regs_inst__1117_ spi_regs_inst__1117_/A1 spi_regs_inst__1117_/A2 spi_regs_inst__1117_/A3
+ spi_regs_inst__1117_/A4 spi_regs_inst__1123_/A1 VDD VDD VSS VSS gf180mcu_fd_sc_mcu7t5v0__nand4_1
XFILLER_100_1081 VDD VDD VSS VSS gf180mcu_fd_sc_mcu7t5v0__fillcap_4
XFILLER_131_417 VDD VDD VSS VSS gf180mcu_fd_sc_mcu7t5v0__fill_2
XFILLER_135_1122 VDD VDD VSS VSS gf180mcu_fd_sc_mcu7t5v0__fillcap_32
XFILLER_98_854 VDD VDD VSS VSS gf180mcu_fd_sc_mcu7t5v0__fillcap_16
Xwave_controller_x_inst__2800_ max_cap460/I spi_regs_inst__1212_/B2 wave_controller_x_inst__2805_/S
+ wave_controller_x_inst__2800_/Z VDD VDD VSS VSS gf180mcu_fd_sc_mcu7t5v0__mux2_2
Xspi_regs_inst__1048_ spi_regs_inst__1039_/Z spi_regs_inst__1048_/A2 spi_regs_inst_wire190/Z
+ spi_regs_inst__1048_/A4 spi_regs_inst__1072_/A2 VDD VDD VSS VSS gf180mcu_fd_sc_mcu7t5v0__nand4_1
XFILLER_100_815 VDD VDD VSS VSS gf180mcu_fd_sc_mcu7t5v0__fillcap_4
XFILLER_57_228 VDD VDD VSS VSS gf180mcu_fd_sc_mcu7t5v0__fillcap_4
Xwave_controller_x_inst__2731_ spi_regs_inst__1185_/B2 wave_controller_x_inst__3554_/B2
+ wave_controller_x_inst_wire95/Z wave_controller_x_inst__2731_/Z VDD VDD VSS VSS
+ gf180mcu_fd_sc_mcu7t5v0__xor3_1
Xwave_controller_x_inst__2662_ wave_controller_x_inst__2663_/A1 wave_controller_x_inst__2663_/A2
+ wave_controller_x_inst__2681_/C VDD VDD VSS VSS gf180mcu_fd_sc_mcu7t5v0__nand2_1
XFILLER_65_272 VDD VDD VSS VSS gf180mcu_fd_sc_mcu7t5v0__fill_2
XFILLER_81_710 VDD VDD VSS VSS gf180mcu_fd_sc_mcu7t5v0__fillcap_4
XTAP_TAPCELL_ROW_64_930 VDD VSS gf180mcu_fd_sc_mcu7t5v0__filltie
XTAP_TAPCELL_ROW_64_941 VDD VSS gf180mcu_fd_sc_mcu7t5v0__filltie
Xwave_controller_x_inst__2593_ wave_controller_x_inst__2608_/A1 wave_controller_x_inst__2593_/A2
+ wave_controller_x_inst__2594_/A2 VDD VDD VSS VSS gf180mcu_fd_sc_mcu7t5v0__nand2_1
XFILLER_25_169 VDD VDD VSS VSS gf180mcu_fd_sc_mcu7t5v0__fill_2
XFILLER_53_478 VDD VDD VSS VSS gf180mcu_fd_sc_mcu7t5v0__fillcap_8
Xwave_controller_y_inst__3230_ fanout509/Z wave_controller_y_inst__3133_/B wave_controller_y_inst__3232_/B2
+ VDD VDD VSS VSS gf180mcu_fd_sc_mcu7t5v0__nand2_1
XFILLER_139_528 VDD VDD VSS VSS gf180mcu_fd_sc_mcu7t5v0__fillcap_32
Xwave_controller_x_inst__3214_ wave_controller_x_inst__3238_/A1 wave_controller_x_inst__3213_/Z
+ wave_controller_x_inst__3240_/A1 VDD VDD VSS VSS gf180mcu_fd_sc_mcu7t5v0__nor2_1
Xwave_controller_y_inst__3161_ wave_controller_y_inst__3158_/I wave_controller_y_inst__3203_/B
+ wave_controller_y_inst__3162_/B VDD VDD VSS VSS gf180mcu_fd_sc_mcu7t5v0__nor2_1
Xwave_controller_x_inst__3145_ wave_controller_x_inst__3126_/I wave_controller_x_inst__3221_/A2
+ wave_controller_x_inst__3145_/B wave_controller_x_inst__3218_/C VDD VDD VSS VSS
+ gf180mcu_fd_sc_mcu7t5v0__aoi21_1
XFILLER_119_241 VDD VDD VSS VSS gf180mcu_fd_sc_mcu7t5v0__fill_1
XFILLER_31_36 VDD VDD VSS VSS gf180mcu_fd_sc_mcu7t5v0__fillcap_32
Xwave_controller_y_inst__3092_ wave_controller_y_inst__3092_/A1 wave_controller_y_inst__3097_/A1
+ wave_controller_y_inst__3092_/B1 wave_controller_y_inst__3593_/A1 wave_controller_y_inst__3721_/D
+ VDD VDD VSS VSS gf180mcu_fd_sc_mcu7t5v0__aoi22_1
Xwave_controller_y_inst__2112_ wave_controller_y_inst__2125_/B wave_controller_y_inst__2125_/C
+ wave_controller_y_inst__2130_/A1 VDD VDD VSS VSS gf180mcu_fd_sc_mcu7t5v0__nor2_1
XFILLER_107_436 VDD VDD VSS VSS gf180mcu_fd_sc_mcu7t5v0__fill_1
XFILLER_147_47 VDD VDD VSS VSS gf180mcu_fd_sc_mcu7t5v0__fillcap_8
XPHY_EDGE_ROW_39_1_Left_206 VDD VSS gf180mcu_fd_sc_mcu7t5v0__endcap
Xwave_controller_y_inst__2043_ wave_controller_y_inst__2079_/B wave_controller_y_inst__2108_/B
+ wave_controller_y_inst__2072_/B VDD VDD VSS VSS gf180mcu_fd_sc_mcu7t5v0__nand2_1
Xwave_controller_x_inst__3076_ wave_controller_x_inst__3265_/A1 wave_controller_x_inst__3090_/B1
+ wave_controller_x_inst__3076_/B1 wave_controller_x_inst__2762_/I wave_controller_x_inst__3714_/D
+ VDD VDD VSS VSS gf180mcu_fd_sc_mcu7t5v0__oai22_1
XFILLER_122_406 VDD VDD VSS VSS gf180mcu_fd_sc_mcu7t5v0__fill_1
XFILLER_123_918 VDD VDD VSS VSS gf180mcu_fd_sc_mcu7t5v0__fillcap_32
Xwave_controller_x_inst__2027_ wave_controller_x_inst__2425_/B2 wave_controller_x_inst__2027_/A2
+ wave_controller_x_inst__2027_/B wave_controller_x_inst__2028_/A2 VDD VDD VSS VSS
+ gf180mcu_fd_sc_mcu7t5v0__aoi21_1
Xoutput14 _92_/Z bidir_out[7] VDD VDD VSS VSS gf180mcu_fd_sc_mcu7t5v0__buf_1
XFILLER_150_737 VDD VDD VSS VSS gf180mcu_fd_sc_mcu7t5v0__fillcap_4
XFILLER_162_597 VDD VDD VSS VSS gf180mcu_fd_sc_mcu7t5v0__fill_1
XTAP_TAPCELL_ROW_112_1723 VDD VSS gf180mcu_fd_sc_mcu7t5v0__filltie
XFILLER_150_759 VDD VDD VSS VSS gf180mcu_fd_sc_mcu7t5v0__fillcap_32
XFILLER_89_854 VDD VDD VSS VSS gf180mcu_fd_sc_mcu7t5v0__fill_1
XFILLER_48_206 VDD VDD VSS VSS gf180mcu_fd_sc_mcu7t5v0__fill_1
XFILLER_88_364 VDD VDD VSS VSS gf180mcu_fd_sc_mcu7t5v0__fill_1
Xspi_regs_inst_fanout559 fanout560/Z spi_regs_inst__1659_/RN VDD VDD VSS VSS gf180mcu_fd_sc_mcu7t5v0__dlyb_1
XFILLER_48_228 VDD VDD VSS VSS gf180mcu_fd_sc_mcu7t5v0__fill_2
Xwave_controller_y_inst__2945_ wave_controller_y_inst__3163_/C fanout517/Z wave_controller_y_inst__2945_/Z
+ VDD VDD VSS VSS gf180mcu_fd_sc_mcu7t5v0__xor2_1
Xwave_controller_x_inst__2929_ wave_controller_x_inst__3591_/I0 spi_regs_inst__1198_/B2
+ wave_controller_x_inst__2929_/S wave_controller_x_inst__3689_/D VDD VDD VSS VSS
+ gf180mcu_fd_sc_mcu7t5v0__mux2_2
XTAP_TAPCELL_ROW_145_2266 VDD VSS gf180mcu_fd_sc_mcu7t5v0__filltie
XTAP_TAPCELL_ROW_145_2277 VDD VSS gf180mcu_fd_sc_mcu7t5v0__filltie
Xwave_controller_y_inst__2876_ wave_controller_y_inst__3697_/Q wave_controller_y_inst__3472_/A1
+ wave_controller_y_inst__2879_/B wave_controller_y_inst__2880_/A3 VDD VDD VSS VSS
+ gf180mcu_fd_sc_mcu7t5v0__aoi21_1
Xwave_controller_y_inst__1827_ fanout509/Z wave_controller_y_inst__3043_/A2 VDD VDD
+ VSS VSS gf180mcu_fd_sc_mcu7t5v0__clkinv_1
XFILLER_56_294 VDD VDD VSS VSS gf180mcu_fd_sc_mcu7t5v0__fillcap_8
XFILLER_60_905 VDD VDD VSS VSS gf180mcu_fd_sc_mcu7t5v0__fill_1
XFILLER_71_220 VDD VDD VSS VSS gf180mcu_fd_sc_mcu7t5v0__fillcap_4
XFILLER_72_743 VDD VDD VSS VSS gf180mcu_fd_sc_mcu7t5v0__fill_1
Xwave_controller_x_inst_fanout32 wave_controller_x_inst__3538_/A2 wave_controller_x_inst__3556_/A2
+ VDD VDD VSS VSS gf180mcu_fd_sc_mcu7t5v0__dlyb_1
XFILLER_72_32 VDD VDD VSS VSS gf180mcu_fd_sc_mcu7t5v0__fill_2
XTAP_TAPCELL_ROW_33_1_581 VDD VSS gf180mcu_fd_sc_mcu7t5v0__filltie
Xwave_controller_x_inst_fanout65 wave_controller_x_inst_wire68/Z wave_controller_x_inst__3573_/S
+ VDD VDD VSS VSS gf180mcu_fd_sc_mcu7t5v0__dlyb_1
XFILLER_31_139 VDD VDD VSS VSS gf180mcu_fd_sc_mcu7t5v0__fill_1
Xwave_controller_y_inst__3428_ wave_controller_y_inst__3430_/A1 wave_controller_y_inst__3494_/A1
+ wave_controller_y_inst__3428_/B wave_controller_y_inst__3429_/I VDD VDD VSS VSS
+ gf180mcu_fd_sc_mcu7t5v0__oai21_1
XFILLER_12_364 VDD VDD VSS VSS gf180mcu_fd_sc_mcu7t5v0__fillcap_4
Xwave_controller_y_inst__3359_ wave_controller_y_inst__3359_/A1 wave_controller_y_inst__3358_/Z
+ wave_controller_y_inst__3394_/B1 VDD VDD VSS VSS gf180mcu_fd_sc_mcu7t5v0__nand2_1
XFILLER_126_701 VDD VDD VSS VSS gf180mcu_fd_sc_mcu7t5v0__fillcap_16
XFILLER_126_734 VDD VDD VSS VSS gf180mcu_fd_sc_mcu7t5v0__fill_1
XFILLER_138_583 VDD VDD VSS VSS gf180mcu_fd_sc_mcu7t5v0__fillcap_8
XFILLER_125_255 VDD VDD VSS VSS gf180mcu_fd_sc_mcu7t5v0__fillcap_4
XFILLER_126_767 VDD VDD VSS VSS gf180mcu_fd_sc_mcu7t5v0__fill_2
XFILLER_137_80 VDD VDD VSS VSS gf180mcu_fd_sc_mcu7t5v0__fillcap_4
XFILLER_99_629 VDD VDD VSS VSS gf180mcu_fd_sc_mcu7t5v0__fill_1
XFILLER_140_247 VDD VDD VSS VSS gf180mcu_fd_sc_mcu7t5v0__fill_2
XFILLER_121_461 VDD VDD VSS VSS gf180mcu_fd_sc_mcu7t5v0__fillcap_16
XFILLER_39_206 VDD VDD VSS VSS gf180mcu_fd_sc_mcu7t5v0__fillcap_4
XFILLER_97_84 VDD VDD VSS VSS gf180mcu_fd_sc_mcu7t5v0__fill_1
XFILLER_94_345 VDD VDD VSS VSS gf180mcu_fd_sc_mcu7t5v0__fillcap_8
XFILLER_75_570 VDD VDD VSS VSS gf180mcu_fd_sc_mcu7t5v0__fillcap_4
XTAP_TAPCELL_ROW_19_1_471 VDD VSS gf180mcu_fd_sc_mcu7t5v0__filltie
XFILLER_15_180 VDD VDD VSS VSS gf180mcu_fd_sc_mcu7t5v0__fillcap_16
XFILLER_148_314 VDD VDD VSS VSS gf180mcu_fd_sc_mcu7t5v0__fill_1
XFILLER_149_837 VDD VDD VSS VSS gf180mcu_fd_sc_mcu7t5v0__fill_2
Xspi_regs_inst__1597_ spi_regs_inst__1597_/D fanout564/Z clkbuf_leaf_9_clk/Z spi_regs_inst__1597_/Q
+ VDD VDD VSS VSS gf180mcu_fd_sc_mcu7t5v0__dffrnq_1
XFILLER_164_807 VDD VDD VSS VSS gf180mcu_fd_sc_mcu7t5v0__fillcap_64
XFILLER_129_572 VDD VDD VSS VSS gf180mcu_fd_sc_mcu7t5v0__fill_1
XFILLER_141_1170 VDD VDD VSS VSS gf180mcu_fd_sc_mcu7t5v0__fillcap_4
XFILLER_117_723 VDD VDD VSS VSS gf180mcu_fd_sc_mcu7t5v0__fillcap_8
XFILLER_163_328 VDD VDD VSS VSS gf180mcu_fd_sc_mcu7t5v0__fillcap_4
XTAP_TAPCELL_ROW_96_1453 VDD VSS gf180mcu_fd_sc_mcu7t5v0__filltie
XFILLER_102_1165 VDD VDD VSS VSS gf180mcu_fd_sc_mcu7t5v0__fillcap_4
XFILLER_85_1116 VDD VDD VSS VSS gf180mcu_fd_sc_mcu7t5v0__fillcap_4
XTAP_TAPCELL_ROW_42_1_649 VDD VSS gf180mcu_fd_sc_mcu7t5v0__filltie
XTAP_TAPCELL_ROW_96_1464 VDD VSS gf180mcu_fd_sc_mcu7t5v0__filltie
XFILLER_132_726 VDD VDD VSS VSS gf180mcu_fd_sc_mcu7t5v0__fillcap_8
XFILLER_132_737 VDD VDD VSS VSS gf180mcu_fd_sc_mcu7t5v0__fillcap_16
XFILLER_144_597 VDD VDD VSS VSS gf180mcu_fd_sc_mcu7t5v0__fillcap_16
XFILLER_98_673 VDD VDD VSS VSS gf180mcu_fd_sc_mcu7t5v0__fill_1
XFILLER_100_612 VDD VDD VSS VSS gf180mcu_fd_sc_mcu7t5v0__fillcap_8
XFILLER_58_537 VDD VDD VSS VSS gf180mcu_fd_sc_mcu7t5v0__fill_1
XFILLER_85_323 VDD VDD VSS VSS gf180mcu_fd_sc_mcu7t5v0__fillcap_4
XFILLER_100_667 VDD VDD VSS VSS gf180mcu_fd_sc_mcu7t5v0__fillcap_4
XFILLER_73_507 VDD VDD VSS VSS gf180mcu_fd_sc_mcu7t5v0__fillcap_4
Xwave_controller_y_inst__2730_ wave_controller_y_inst__2730_/A1 wave_controller_y_inst__2716_/Z
+ wave_controller_y_inst__2730_/A3 spi_regs_inst__1138_/B2 wave_controller_y_inst__2730_/B2
+ wave_controller_y_inst__2741_/B VDD VDD VSS VSS gf180mcu_fd_sc_mcu7t5v0__oai32_1
Xwave_controller_x_inst__2714_ wave_controller_x_inst__2711_/Z wave_controller_x_inst__2713_/B
+ wave_controller_x_inst__2714_/Z VDD VDD VSS VSS gf180mcu_fd_sc_mcu7t5v0__and2_1
XFILLER_73_529 VDD VDD VSS VSS gf180mcu_fd_sc_mcu7t5v0__fillcap_16
Xwave_controller_y_inst__2661_ wave_controller_y_inst__2661_/I wave_controller_y_inst__2663_/A2
+ VDD VDD VSS VSS gf180mcu_fd_sc_mcu7t5v0__clkinv_1
Xwave_controller_x_inst__3694_ wave_controller_x_inst__3694_/D wave_controller_x_inst__3723_/RN
+ clkload28/I wave_controller_x_inst__3694_/Q VDD VDD VSS VSS gf180mcu_fd_sc_mcu7t5v0__dffrnq_1
XFILLER_165_8 VDD VDD VSS VSS gf180mcu_fd_sc_mcu7t5v0__fillcap_32
Xwave_controller_x_inst__2645_ wave_controller_x_inst__2642_/Z wave_controller_x_inst__2679_/A2
+ wave_controller_x_inst__2646_/B VDD VDD VSS VSS gf180mcu_fd_sc_mcu7t5v0__xor2_1
XFILLER_26_69 VDD VDD VSS VSS gf180mcu_fd_sc_mcu7t5v0__fill_2
XFILLER_54_776 VDD VDD VSS VSS gf180mcu_fd_sc_mcu7t5v0__fill_2
XFILLER_81_551 VDD VDD VSS VSS gf180mcu_fd_sc_mcu7t5v0__fillcap_8
XFILLER_81_562 VDD VDD VSS VSS gf180mcu_fd_sc_mcu7t5v0__fillcap_16
Xwave_controller_y_inst__2592_ wave_controller_y_inst__2609_/A1 wave_controller_y_inst__2591_/Z
+ wave_controller_y_inst__2594_/A1 VDD VDD VSS VSS gf180mcu_fd_sc_mcu7t5v0__nor2_1
Xwave_controller_x_inst__2576_ wave_controller_x_inst__2576_/I wave_controller_x_inst__2578_/A2
+ VDD VDD VSS VSS gf180mcu_fd_sc_mcu7t5v0__clkinv_1
XTAP_TAPCELL_ROW_140_2185 VDD VSS gf180mcu_fd_sc_mcu7t5v0__filltie
XFILLER_146_1081 VDD VDD VSS VSS gf180mcu_fd_sc_mcu7t5v0__fillcap_4
XFILLER_139_325 VDD VDD VSS VSS gf180mcu_fd_sc_mcu7t5v0__fillcap_16
Xwave_controller_y_inst__3213_ wave_controller_y_inst__3572_/A1 wave_controller_y_inst__3213_/A2
+ wave_controller_y_inst__3213_/A3 wave_controller_y_inst__3213_/Z VDD VDD VSS VSS
+ gf180mcu_fd_sc_mcu7t5v0__xor3_1
XFILLER_154_317 VDD VDD VSS VSS gf180mcu_fd_sc_mcu7t5v0__fillcap_32
XTAP_TAPCELL_ROW_28_1_539 VDD VSS gf180mcu_fd_sc_mcu7t5v0__filltie
XFILLER_108_734 VDD VDD VSS VSS gf180mcu_fd_sc_mcu7t5v0__fill_1
XFILLER_147_380 VDD VDD VSS VSS gf180mcu_fd_sc_mcu7t5v0__fill_2
XFILLER_166_177 VDD VDD VSS VSS gf180mcu_fd_sc_mcu7t5v0__fillcap_32
Xwave_controller_y_inst__3144_ wave_controller_y_inst__3146_/C wave_controller_y_inst__3146_/B
+ wave_controller_y_inst__3145_/B VDD VDD VSS VSS gf180mcu_fd_sc_mcu7t5v0__nand2_1
Xwave_controller_x_inst__3128_ wave_controller_x_inst__3128_/I wave_controller_x_inst__3224_/A1
+ VDD VDD VSS VSS gf180mcu_fd_sc_mcu7t5v0__clkinv_1
XFILLER_135_531 VDD VDD VSS VSS gf180mcu_fd_sc_mcu7t5v0__fill_2
XFILLER_135_553 VDD VDD VSS VSS gf180mcu_fd_sc_mcu7t5v0__fillcap_4
Xwave_controller_y_inst__3075_ wave_controller_y_inst__3075_/A1 wave_controller_y_inst__2990_/Z
+ wave_controller_y_inst__3076_/B1 VDD VDD VSS VSS gf180mcu_fd_sc_mcu7t5v0__xnor2_1
Xwave_controller_x_inst__3059_ wave_controller_x_inst__3572_/A1 wave_controller_x_inst__3090_/B1
+ wave_controller_x_inst__3058_/Z wave_controller_x_inst_wire166/Z wave_controller_x_inst__3708_/D
+ VDD VDD VSS VSS gf180mcu_fd_sc_mcu7t5v0__oai22_1
XFILLER_135_586 VDD VDD VSS VSS gf180mcu_fd_sc_mcu7t5v0__fill_2
XFILLER_150_523 VDD VDD VSS VSS gf180mcu_fd_sc_mcu7t5v0__fill_2
XFILLER_1_500 VDD VDD VSS VSS gf180mcu_fd_sc_mcu7t5v0__fillcap_4
Xwave_controller_y_inst__2026_ wave_controller_y_inst__2425_/B2 wave_controller_y_inst__2027_/B
+ wave_controller_y_inst_wire31/Z wave_controller_y_inst__2026_/Z VDD VDD VSS VSS
+ gf180mcu_fd_sc_mcu7t5v0__and3_1
XFILLER_107_299 VDD VDD VSS VSS gf180mcu_fd_sc_mcu7t5v0__fillcap_8
XFILLER_122_247 VDD VDD VSS VSS gf180mcu_fd_sc_mcu7t5v0__fillcap_64
XFILLER_153_1052 VDD VDD VSS VSS gf180mcu_fd_sc_mcu7t5v0__fillcap_64
XFILLER_89_673 VDD VDD VSS VSS gf180mcu_fd_sc_mcu7t5v0__fillcap_16
XTAP_TAPCELL_ROW_147_2306 VDD VSS gf180mcu_fd_sc_mcu7t5v0__filltie
Xspi_regs_inst_fanout345 spi_regs_inst_wire346/I spi_regs_inst__0939_/S VDD VDD VSS
+ VSS gf180mcu_fd_sc_mcu7t5v0__dlyb_1
XFILLER_88_172 VDD VDD VSS VSS gf180mcu_fd_sc_mcu7t5v0__fill_2
Xwave_controller_y_inst__2928_ wave_controller_y_inst__3189_/A1 wave_controller_y_inst_wire323/Z
+ wave_controller_y_inst__3591_/I0 VDD VDD VSS VSS gf180mcu_fd_sc_mcu7t5v0__nor2_1
XTAP_TAPCELL_ROW_160_2517 VDD VSS gf180mcu_fd_sc_mcu7t5v0__filltie
XTAP_TAPCELL_ROW_125_1936 VDD VSS gf180mcu_fd_sc_mcu7t5v0__filltie
XTAP_TAPCELL_ROW_125_1947 VDD VSS gf180mcu_fd_sc_mcu7t5v0__filltie
Xwave_controller_y_inst__2859_ wave_controller_y_inst__2880_/A1 wave_controller_y_inst__2883_/A3
+ wave_controller_y_inst__2878_/A1 VDD VDD VSS VSS gf180mcu_fd_sc_mcu7t5v0__nand2_1
XFILLER_17_467 VDD VDD VSS VSS gf180mcu_fd_sc_mcu7t5v0__fillcap_8
XFILLER_44_242 VDD VDD VSS VSS gf180mcu_fd_sc_mcu7t5v0__fill_2
Xwave_controller_x_inst_max_cap57 wave_controller_x_inst__3489_/B1 wave_controller_x_inst__3447_/S
+ VDD VDD VSS VSS gf180mcu_fd_sc_mcu7t5v0__buf_2
Xspi_regs_inst__1520_ spi_regs_inst__1520_/D spi_regs_inst__1601_/RN clkbuf_leaf_36_clk/Z
+ spi_regs_inst__1520_/Q VDD VDD VSS VSS gf180mcu_fd_sc_mcu7t5v0__dffrnq_1
XFILLER_44_275 VDD VDD VSS VSS gf180mcu_fd_sc_mcu7t5v0__fill_2
XTAP_TAPCELL_ROW_55_782 VDD VSS gf180mcu_fd_sc_mcu7t5v0__filltie
Xspi_regs_inst__1451_ spi_regs_inst__1519_/Q spi_regs_inst__1451_/I1 spi_regs_inst__1451_/S
+ spi_regs_inst__1519_/D VDD VDD VSS VSS gf180mcu_fd_sc_mcu7t5v0__mux2_2
XFILLER_125_1154 VDD VDD VSS VSS gf180mcu_fd_sc_mcu7t5v0__fillcap_16
XTAP_TAPCELL_ROW_158_2479 VDD VSS gf180mcu_fd_sc_mcu7t5v0__filltie
Xspi_regs_inst__1382_ spi_regs_inst__1639_/Q spi_regs_inst__1410_/I1 spi_regs_inst__1384_/S
+ spi_regs_inst__1662_/D VDD VDD VSS VSS gf180mcu_fd_sc_mcu7t5v0__mux2_2
XFILLER_146_807 VDD VDD VSS VSS gf180mcu_fd_sc_mcu7t5v0__fillcap_8
XFILLER_160_309 VDD VDD VSS VSS gf180mcu_fd_sc_mcu7t5v0__fillcap_4
XTAP_TAPCELL_ROW_78_1161 VDD VSS gf180mcu_fd_sc_mcu7t5v0__filltie
XTAP_TAPCELL_ROW_78_1172 VDD VSS gf180mcu_fd_sc_mcu7t5v0__filltie
XFILLER_114_737 VDD VDD VSS VSS gf180mcu_fd_sc_mcu7t5v0__fillcap_64
XFILLER_126_597 VDD VDD VSS VSS gf180mcu_fd_sc_mcu7t5v0__fillcap_8
XTAP_TAPCELL_ROW_91_1372 VDD VSS gf180mcu_fd_sc_mcu7t5v0__filltie
XTAP_TAPCELL_ROW_91_1383 VDD VSS gf180mcu_fd_sc_mcu7t5v0__filltie
XFILLER_68_846 VDD VDD VSS VSS gf180mcu_fd_sc_mcu7t5v0__fill_1
Xsignal_processor_y_inst__194_ signal_processor_y_inst__196_/B1 signal_processor_y_inst__195_/A2
+ signal_processor_y_inst__194_/Z VDD VDD VSS VSS gf180mcu_fd_sc_mcu7t5v0__and2_1
XFILLER_94_131 VDD VDD VSS VSS gf180mcu_fd_sc_mcu7t5v0__fill_2
XFILLER_83_838 VDD VDD VSS VSS gf180mcu_fd_sc_mcu7t5v0__fill_2
XFILLER_95_698 VDD VDD VSS VSS gf180mcu_fd_sc_mcu7t5v0__fill_2
XFILLER_82_359 VDD VDD VSS VSS gf180mcu_fd_sc_mcu7t5v0__fillcap_4
XFILLER_63_562 VDD VDD VSS VSS gf180mcu_fd_sc_mcu7t5v0__fillcap_4
Xwave_controller_x_inst__2430_ wave_controller_x_inst__2430_/A1 wave_controller_x_inst__2417_/Z
+ wave_controller_x_inst__2430_/B wave_controller_x_inst__2446_/B VDD VDD VSS VSS
+ gf180mcu_fd_sc_mcu7t5v0__oai21_1
XFILLER_23_448 VDD VDD VSS VSS gf180mcu_fd_sc_mcu7t5v0__fill_1
Xwave_controller_x_inst__2361_ wave_controller_x_inst__2373_/A1 wave_controller_x_inst_wire78/Z
+ wave_controller_x_inst__2361_/B wave_controller_x_inst__2362_/A2 VDD VDD VSS VSS
+ gf180mcu_fd_sc_mcu7t5v0__oai21_1
Xspi_regs_inst__1649_ spi_regs_inst__1649_/D spi_regs_inst__1649_/RN clkload18/I _88_/I
+ VDD VDD VSS VSS gf180mcu_fd_sc_mcu7t5v0__dffrnq_1
XPHY_EDGE_ROW_8_1_Left_175 VDD VSS gf180mcu_fd_sc_mcu7t5v0__endcap
Xwave_controller_x_inst__2292_ fanout521/Z wave_controller_x_inst__2815_/A1 wave_controller_x_inst__2292_/A3
+ wave_controller_x_inst__2293_/B VDD VDD VSS VSS gf180mcu_fd_sc_mcu7t5v0__xor3_1
XFILLER_148_166 VDD VDD VSS VSS gf180mcu_fd_sc_mcu7t5v0__fill_1
XFILLER_164_615 VDD VDD VSS VSS gf180mcu_fd_sc_mcu7t5v0__fillcap_32
XFILLER_31_492 VDD VDD VSS VSS gf180mcu_fd_sc_mcu7t5v0__fillcap_16
XFILLER_136_317 VDD VDD VSS VSS gf180mcu_fd_sc_mcu7t5v0__fill_1
XFILLER_148_188 VDD VDD VSS VSS gf180mcu_fd_sc_mcu7t5v0__fill_2
XFILLER_129_391 VDD VDD VSS VSS gf180mcu_fd_sc_mcu7t5v0__fill_1
XFILLER_163_136 VDD VDD VSS VSS gf180mcu_fd_sc_mcu7t5v0__fillcap_4
XTAP_TAPCELL_ROW_24_1_512 VDD VSS gf180mcu_fd_sc_mcu7t5v0__filltie
XFILLER_132_512 VDD VDD VSS VSS gf180mcu_fd_sc_mcu7t5v0__fillcap_8
XFILLER_104_225 VDD VDD VSS VSS gf180mcu_fd_sc_mcu7t5v0__fill_1
XFILLER_104_247 VDD VDD VSS VSS gf180mcu_fd_sc_mcu7t5v0__fillcap_8
XFILLER_99_982 VDD VDD VSS VSS gf180mcu_fd_sc_mcu7t5v0__fillcap_64
XTAP_TAPCELL_ROW_129_2003 VDD VSS gf180mcu_fd_sc_mcu7t5v0__filltie
Xfanout601 fanout608/Z fanout601/Z VDD VDD VSS VSS gf180mcu_fd_sc_mcu7t5v0__dlyb_1
XFILLER_113_792 VDD VDD VSS VSS gf180mcu_fd_sc_mcu7t5v0__fill_2
XFILLER_58_312 VDD VDD VSS VSS gf180mcu_fd_sc_mcu7t5v0__fill_2
XFILLER_100_453 VDD VDD VSS VSS gf180mcu_fd_sc_mcu7t5v0__fill_2
XFILLER_101_976 VDD VDD VSS VSS gf180mcu_fd_sc_mcu7t5v0__fillcap_4
XFILLER_58_345 VDD VDD VSS VSS gf180mcu_fd_sc_mcu7t5v0__fill_1
XFILLER_85_142 VDD VDD VSS VSS gf180mcu_fd_sc_mcu7t5v0__fillcap_16
XFILLER_58_389 VDD VDD VSS VSS gf180mcu_fd_sc_mcu7t5v0__fill_1
XFILLER_74_849 VDD VDD VSS VSS gf180mcu_fd_sc_mcu7t5v0__fill_2
XTAP_TAPCELL_ROW_142_2214 VDD VSS gf180mcu_fd_sc_mcu7t5v0__filltie
XTAP_TAPCELL_ROW_142_2225 VDD VSS gf180mcu_fd_sc_mcu7t5v0__filltie
Xwave_controller_y_inst__2713_ wave_controller_y_inst__2713_/A1 wave_controller_y_inst__2713_/A2
+ wave_controller_y_inst__2713_/B wave_controller_y_inst__2739_/B2 VDD VDD VSS VSS
+ gf180mcu_fd_sc_mcu7t5v0__oai21_1
XFILLER_85_197 VDD VDD VSS VSS gf180mcu_fd_sc_mcu7t5v0__fillcap_8
XTAP_TAPCELL_ROW_107_1644 VDD VSS gf180mcu_fd_sc_mcu7t5v0__filltie
Xwave_controller_y_inst__3693_ wave_controller_y_inst__3693_/D wave_controller_y_inst__3695_/RN
+ clkload16/I wave_controller_y_inst__3693_/Q VDD VDD VSS VSS gf180mcu_fd_sc_mcu7t5v0__dffrnq_1
Xwave_controller_x_inst__3677_ wave_controller_x_inst__3677_/D wave_controller_x_inst__3704_/RN
+ clkload35/I spi_regs_inst__1343_/B2 VDD VDD VSS VSS gf180mcu_fd_sc_mcu7t5v0__dffrnq_1
XFILLER_54_573 VDD VDD VSS VSS gf180mcu_fd_sc_mcu7t5v0__fillcap_4
Xwave_controller_y_inst__2644_ wave_controller_y_inst__2642_/Z wave_controller_y_inst__2679_/A2
+ wave_controller_y_inst__2680_/A1 VDD VDD VSS VSS gf180mcu_fd_sc_mcu7t5v0__nand2_1
Xwave_controller_x_inst__2628_ wave_controller_x_inst__2634_/C wave_controller_x_inst__2627_/Z
+ wave_controller_x_inst__2630_/A1 VDD VDD VSS VSS gf180mcu_fd_sc_mcu7t5v0__nand2_1
XFILLER_109_1116 VDD VDD VSS VSS gf180mcu_fd_sc_mcu7t5v0__fillcap_4
XFILLER_148_1165 VDD VDD VSS VSS gf180mcu_fd_sc_mcu7t5v0__fillcap_4
XFILLER_82_893 VDD VDD VSS VSS gf180mcu_fd_sc_mcu7t5v0__fill_2
Xwave_controller_y_inst__2575_ wave_controller_y_inst__2572_/Z wave_controller_y_inst__2575_/A2
+ wave_controller_y_inst__2576_/I VDD VDD VSS VSS gf180mcu_fd_sc_mcu7t5v0__xnor2_1
XFILLER_41_256 VDD VDD VSS VSS gf180mcu_fd_sc_mcu7t5v0__fillcap_16
XTAP_TAPCELL_ROW_120_1855 VDD VSS gf180mcu_fd_sc_mcu7t5v0__filltie
Xwave_controller_x_inst__2559_ spi_regs_inst__1332_/A1 wave_controller_x_inst__2558_/Z
+ wave_controller_x_inst__2573_/B VDD VDD VSS VSS gf180mcu_fd_sc_mcu7t5v0__nand2_1
XFILLER_154_103 VDD VDD VSS VSS gf180mcu_fd_sc_mcu7t5v0__fill_2
XFILLER_155_648 VDD VDD VSS VSS gf180mcu_fd_sc_mcu7t5v0__fillcap_4
XFILLER_108_553 VDD VDD VSS VSS gf180mcu_fd_sc_mcu7t5v0__fill_1
XTAP_TAPCELL_ROW_153_2398 VDD VSS gf180mcu_fd_sc_mcu7t5v0__filltie
Xwave_controller_y_inst__3127_ wave_controller_y_inst__3562_/A1 spi_regs_inst__1585_/Q
+ wave_controller_y_inst__3128_/I VDD VDD VSS VSS gf180mcu_fd_sc_mcu7t5v0__nand2_1
XTAP_TAPCELL_ROW_18_1_470 VDD VSS gf180mcu_fd_sc_mcu7t5v0__filltie
XFILLER_118_93 VDD VDD VSS VSS gf180mcu_fd_sc_mcu7t5v0__fillcap_8
Xwave_controller_y_inst__3058_ wave_controller_y_inst__3708_/Q fanout501/Z wave_controller_y_inst__3058_/A3
+ wave_controller_y_inst__3058_/Z VDD VDD VSS VSS gf180mcu_fd_sc_mcu7t5v0__xor3_1
XFILLER_150_353 VDD VDD VSS VSS gf180mcu_fd_sc_mcu7t5v0__fill_1
XFILLER_150_364 VDD VDD VSS VSS gf180mcu_fd_sc_mcu7t5v0__fillcap_16
XFILLER_1_352 VDD VDD VSS VSS gf180mcu_fd_sc_mcu7t5v0__fillcap_16
XFILLER_78_53 VDD VDD VSS VSS gf180mcu_fd_sc_mcu7t5v0__fillcap_4
Xwave_controller_y_inst__2009_ wave_controller_y_inst__2009_/A1 wave_controller_y_inst__2000_/Z
+ wave_controller_y_inst__2009_/A3 wave_controller_y_inst__2009_/B wave_controller_y_inst_wire82/I
+ VDD VDD VSS VSS gf180mcu_fd_sc_mcu7t5v0__oai31_1
XFILLER_104_781 VDD VDD VSS VSS gf180mcu_fd_sc_mcu7t5v0__fillcap_4
XFILLER_77_632 VDD VDD VSS VSS gf180mcu_fd_sc_mcu7t5v0__fillcap_16
XFILLER_89_492 VDD VDD VSS VSS gf180mcu_fd_sc_mcu7t5v0__fillcap_8
XTAP_TAPCELL_ROW_73_1080 VDD VSS gf180mcu_fd_sc_mcu7t5v0__filltie
Xwave_controller_x_inst_wire164 wave_controller_x_inst__3471_/B wave_controller_x_inst__3496_/B
+ VDD VDD VSS VSS gf180mcu_fd_sc_mcu7t5v0__buf_3
XFILLER_49_334 VDD VDD VSS VSS gf180mcu_fd_sc_mcu7t5v0__fillcap_4
XPHY_EDGE_ROW_142_Left_309 VDD VSS gf180mcu_fd_sc_mcu7t5v0__endcap
Xspi_regs_inst_fanout175 spi_regs_inst__1376_/A2 spi_regs_inst__1379_/S VDD VDD VSS
+ VSS gf180mcu_fd_sc_mcu7t5v0__dlyb_1
Xspi_regs_inst__0951_ spi_regs_inst__0995_/A3 spi_regs_inst__1008_/A3 spi_regs_inst__1030_/A2
+ VDD VDD VSS VSS gf180mcu_fd_sc_mcu7t5v0__nand2_1
XFILLER_77_687 VDD VDD VSS VSS gf180mcu_fd_sc_mcu7t5v0__fill_1
XFILLER_91_134 VDD VDD VSS VSS gf180mcu_fd_sc_mcu7t5v0__fillcap_4
Xspi_regs_inst__0882_ spi_regs_inst__1616_/Q spi_regs_inst__1378_/I1 spi_regs_inst__0885_/S
+ spi_regs_inst__1616_/D VDD VDD VSS VSS gf180mcu_fd_sc_mcu7t5v0__mux2_2
XFILLER_17_253 VDD VDD VSS VSS gf180mcu_fd_sc_mcu7t5v0__fill_2
XTAP_TAPCELL_ROW_41_1_637 VDD VSS gf180mcu_fd_sc_mcu7t5v0__filltie
XFILLER_60_521 VDD VDD VSS VSS gf180mcu_fd_sc_mcu7t5v0__fillcap_4
Xspi_regs_inst__1503_ spi_regs_inst__1503_/D spi_regs_inst__1605_/RN clkbuf_leaf_38_clk/Z
+ spi_regs_inst__1503_/Q VDD VDD VSS VSS gf180mcu_fd_sc_mcu7t5v0__dffrnq_1
XPHY_EDGE_ROW_151_Left_318 VDD VSS gf180mcu_fd_sc_mcu7t5v0__endcap
Xspi_regs_inst__1434_ spi_regs_inst__1504_/Q spi_regs_inst__1443_/I1 spi_regs_inst__1436_/S
+ spi_regs_inst__1504_/D VDD VDD VSS VSS gf180mcu_fd_sc_mcu7t5v0__mux2_2
XFILLER_159_976 VDD VDD VSS VSS gf180mcu_fd_sc_mcu7t5v0__fillcap_4
Xspi_regs_inst__1365_ spi_regs_inst__1651_/Q spi_regs_inst__1384_/S spi_regs_inst__1366_/B
+ VDD VDD VSS VSS gf180mcu_fd_sc_mcu7t5v0__nand2_1
XFILLER_145_136 VDD VDD VSS VSS gf180mcu_fd_sc_mcu7t5v0__fillcap_4
Xspi_regs_inst__1296_ spi_regs_inst__1296_/A1 spi_regs_inst__1296_/A2 spi_regs_inst__1296_/A3
+ spi_regs_inst__1296_/A4 spi_regs_inst__1296_/Z VDD VDD VSS VSS gf180mcu_fd_sc_mcu7t5v0__and4_1
XFILLER_127_884 VDD VDD VSS VSS gf180mcu_fd_sc_mcu7t5v0__fill_2
XFILLER_161_629 VDD VDD VSS VSS gf180mcu_fd_sc_mcu7t5v0__fill_1
XTAP_TAPCELL_ROW_93_1412 VDD VSS gf180mcu_fd_sc_mcu7t5v0__filltie
XFILLER_114_523 VDD VDD VSS VSS gf180mcu_fd_sc_mcu7t5v0__fill_2
XFILLER_141_331 VDD VDD VSS VSS gf180mcu_fd_sc_mcu7t5v0__fill_2
XFILLER_99_212 VDD VDD VSS VSS gf180mcu_fd_sc_mcu7t5v0__fillcap_16
XFILLER_88_919 VDD VDD VSS VSS gf180mcu_fd_sc_mcu7t5v0__fillcap_4
XPHY_EDGE_ROW_160_Left_327 VDD VSS gf180mcu_fd_sc_mcu7t5v0__endcap
Xwave_controller_x_inst__1930_ spi_regs_inst__1509_/Q wave_controller_x_inst__3163_/C
+ spi_regs_inst__1508_/Q wave_controller_x_inst__3305_/A1 wave_controller_x_inst__1930_/C
+ wave_controller_x_inst__1932_/A1 VDD VDD VSS VSS gf180mcu_fd_sc_mcu7t5v0__aoi221_1
Xsignal_processor_y_inst__246_ signal_processor_y_inst__246_/D signal_processor_y_inst__253_/RN
+ clkbuf_leaf_0_clk/Z signal_processor_y_inst__246_/Q VDD VDD VSS VSS gf180mcu_fd_sc_mcu7t5v0__dffrnq_1
XFILLER_114_18 VDD VDD VSS VSS gf180mcu_fd_sc_mcu7t5v0__fillcap_4
XFILLER_67_142 VDD VDD VSS VSS gf180mcu_fd_sc_mcu7t5v0__fillcap_8
XFILLER_68_654 VDD VDD VSS VSS gf180mcu_fd_sc_mcu7t5v0__fillcap_8
Xwave_controller_x_inst__3600_ wave_controller_x_inst__3600_/I0 spi_regs_inst__1284_/B2
+ wave_controller_x_inst__3602_/S wave_controller_x_inst__3675_/D VDD VDD VSS VSS
+ gf180mcu_fd_sc_mcu7t5v0__mux2_2
Xwave_controller_x_inst__1861_ wire454/Z wave_controller_x_inst__2616_/A1 VDD VDD
+ VSS VSS gf180mcu_fd_sc_mcu7t5v0__clkinv_1
XFILLER_67_175 VDD VDD VSS VSS gf180mcu_fd_sc_mcu7t5v0__fill_1
XFILLER_82_101 VDD VDD VSS VSS gf180mcu_fd_sc_mcu7t5v0__fillcap_4
XFILLER_95_484 VDD VDD VSS VSS gf180mcu_fd_sc_mcu7t5v0__fillcap_4
Xwave_controller_x_inst__1792_ wave_controller_x_inst__1792_/I wave_controller_x_inst__3572_/A1
+ VDD VDD VSS VSS gf180mcu_fd_sc_mcu7t5v0__clkinv_1
Xsignal_processor_y_inst__177_ signal_processor_y_inst__177_/A1 signal_processor_y_inst__187_/A1
+ signal_processor_y_inst__237_/D VDD VDD VSS VSS gf180mcu_fd_sc_mcu7t5v0__nor2_1
XFILLER_55_348 VDD VDD VSS VSS gf180mcu_fd_sc_mcu7t5v0__fill_2
Xwave_controller_x_inst__3531_ wave_controller_x_inst__3713_/Q wave_controller_x_inst__3555_/A2
+ wave_controller_x_inst__3533_/A2 VDD VDD VSS VSS gf180mcu_fd_sc_mcu7t5v0__nor2_1
XFILLER_130_17 VDD VDD VSS VSS gf180mcu_fd_sc_mcu7t5v0__fillcap_4
XFILLER_36_551 VDD VDD VSS VSS gf180mcu_fd_sc_mcu7t5v0__fillcap_4
Xwave_controller_x_inst__3462_ wave_controller_x_inst__3557_/A1 wave_controller_x_inst__3462_/A2
+ wave_controller_x_inst__3461_/Z wave_controller_x_inst__3545_/B1 wave_controller_x_inst__3462_/B2
+ wave_controller_x_inst__3624_/D VDD VDD VSS VSS gf180mcu_fd_sc_mcu7t5v0__oai32_1
XFILLER_23_212 VDD VDD VSS VSS gf180mcu_fd_sc_mcu7t5v0__fillcap_4
XFILLER_70_329 VDD VDD VSS VSS gf180mcu_fd_sc_mcu7t5v0__fill_1
XPHY_EDGE_ROW_48_1_Left_215 VDD VSS gf180mcu_fd_sc_mcu7t5v0__endcap
XTAP_TAPCELL_ROW_35_1_595 VDD VSS gf180mcu_fd_sc_mcu7t5v0__filltie
Xwave_controller_x_inst__2413_ wave_controller_x_inst__2399_/Z wave_controller_x_inst__2425_/A3
+ wave_controller_x_inst__2416_/A3 VDD VDD VSS VSS gf180mcu_fd_sc_mcu7t5v0__nor2_1
Xwave_controller_x_inst__3393_ fanout536/I wave_controller_x_inst__3394_/B1 wave_controller_x_inst__3360_/Z
+ fanout537/Z wave_controller_x_inst__3395_/A2 VDD VDD VSS VSS gf180mcu_fd_sc_mcu7t5v0__aoi22_1
XFILLER_56_1081 VDD VDD VSS VSS gf180mcu_fd_sc_mcu7t5v0__fillcap_4
XTAP_TAPCELL_ROW_102_1552 VDD VSS gf180mcu_fd_sc_mcu7t5v0__filltie
XTAP_TAPCELL_ROW_102_1563 VDD VSS gf180mcu_fd_sc_mcu7t5v0__filltie
Xwave_controller_y_inst__2360_ wave_controller_y_inst__2375_/B wave_controller_y_inst__2359_/I
+ wave_controller_y_inst__2373_/A2 VDD VDD VSS VSS gf180mcu_fd_sc_mcu7t5v0__nand2_1
Xwave_controller_x_inst__2344_ wave_controller_x_inst__2310_/I wave_controller_x_inst__2345_/A2
+ wave_controller_x_inst__2346_/A2 VDD VDD VSS VSS gf180mcu_fd_sc_mcu7t5v0__nor2_1
XFILLER_149_464 VDD VDD VSS VSS gf180mcu_fd_sc_mcu7t5v0__fillcap_4
Xwave_controller_y_inst__2291_ wave_controller_y_inst__1823_/I wave_controller_y_inst__2292_/A3
+ wave_controller_y_inst__2305_/A2 VDD VDD VSS VSS gf180mcu_fd_sc_mcu7t5v0__nand2_1
Xwave_controller_x_inst__2275_ fanout523/Z wave_controller_x_inst__2286_/A2 wave_controller_x_inst__2275_/A3
+ wave_controller_x_inst__2275_/Z VDD VDD VSS VSS gf180mcu_fd_sc_mcu7t5v0__xor3_1
XFILLER_136_103 VDD VDD VSS VSS gf180mcu_fd_sc_mcu7t5v0__fill_2
Xwave_controller_y_inst_fanout503 fanout504/Z wave_controller_y_inst__1825_/I VDD
+ VDD VSS VSS gf180mcu_fd_sc_mcu7t5v0__dlyb_1
XFILLER_132_331 VDD VDD VSS VSS gf180mcu_fd_sc_mcu7t5v0__fill_1
Xwave_controller_y_inst_fanout514 spi_regs_inst__1482_/Q wave_controller_y_inst__1818_/I
+ VDD VDD VSS VSS gf180mcu_fd_sc_mcu7t5v0__dlyb_1
XFILLER_132_353 VDD VDD VSS VSS gf180mcu_fd_sc_mcu7t5v0__fill_1
XFILLER_155_69 VDD VDD VSS VSS gf180mcu_fd_sc_mcu7t5v0__fill_1
XFILLER_132_397 VDD VDD VSS VSS gf180mcu_fd_sc_mcu7t5v0__fill_1
XFILLER_59_632 VDD VDD VSS VSS gf180mcu_fd_sc_mcu7t5v0__fillcap_16
XFILLER_63_1052 VDD VDD VSS VSS gf180mcu_fd_sc_mcu7t5v0__fillcap_64
XFILLER_87_930 VDD VDD VSS VSS gf180mcu_fd_sc_mcu7t5v0__fill_1
XFILLER_87_941 VDD VDD VSS VSS gf180mcu_fd_sc_mcu7t5v0__fillcap_32
XFILLER_150_1011 VDD VDD VSS VSS gf180mcu_fd_sc_mcu7t5v0__fillcap_4
XFILLER_74_613 VDD VDD VSS VSS gf180mcu_fd_sc_mcu7t5v0__fillcap_4
XTAP_TAPCELL_ROW_57_811 VDD VSS gf180mcu_fd_sc_mcu7t5v0__filltie
XTAP_TAPCELL_ROW_57_822 VDD VSS gf180mcu_fd_sc_mcu7t5v0__filltie
Xwave_controller_x_inst__3729_ wave_controller_x_inst__3729_/D wave_controller_x_inst__3735_/RN
+ clkbuf_leaf_20_clk/Z wave_controller_x_inst__3729_/Q VDD VDD VSS VSS gf180mcu_fd_sc_mcu7t5v0__dffrnq_1
Xsignal_processor_x_inst_fanout586 fanout587/Z signal_processor_x_inst__242_/RN VDD
+ VDD VSS VSS gf180mcu_fd_sc_mcu7t5v0__dlyb_1
Xwave_controller_y_inst__3676_ wave_controller_y_inst__3676_/D wave_controller_y_inst__3708_/RN
+ clkload19/I spi_regs_inst__1315_/A1 VDD VDD VSS VSS gf180mcu_fd_sc_mcu7t5v0__dffrnq_1
Xspi_regs_inst_max_cap313 spi_regs_inst__0886_/S spi_regs_inst__0888_/S VDD VDD VSS
+ VSS gf180mcu_fd_sc_mcu7t5v0__clkbuf_1
XFILLER_161_2 VDD VDD VSS VSS gf180mcu_fd_sc_mcu7t5v0__fillcap_64
XPHY_EDGE_ROW_32_1_Left_199 VDD VSS gf180mcu_fd_sc_mcu7t5v0__endcap
Xwave_controller_y_inst__2627_ wave_controller_y_inst__2627_/A1 wave_controller_y_inst__2600_/Z
+ wave_controller_y_inst__2626_/B wave_controller_y_inst__2627_/Z VDD VDD VSS VSS
+ gf180mcu_fd_sc_mcu7t5v0__or3_1
XFILLER_42_543 VDD VDD VSS VSS gf180mcu_fd_sc_mcu7t5v0__fillcap_8
Xwave_controller_y_inst__2558_ wave_controller_y_inst__1825_/I wave_controller_y_inst__2550_/Z
+ wave_controller_y_inst_wire151/Z wave_controller_y_inst__2558_/Z VDD VDD VSS VSS
+ gf180mcu_fd_sc_mcu7t5v0__xor3_1
XTAP_TAPCELL_ROW_155_2427 VDD VSS gf180mcu_fd_sc_mcu7t5v0__filltie
XTAP_TAPCELL_ROW_155_2438 VDD VSS gf180mcu_fd_sc_mcu7t5v0__filltie
Xwave_controller_y_inst__2489_ wave_controller_y_inst__2490_/A1 wave_controller_y_inst__2490_/A2
+ wave_controller_y_inst__2489_/Z VDD VDD VSS VSS gf180mcu_fd_sc_mcu7t5v0__and2_1
XFILLER_80_87 VDD VDD VSS VSS gf180mcu_fd_sc_mcu7t5v0__fillcap_8
Xsignal_processor_x_inst__197_ _89_/I signal_processor_x_inst__214_/A2 signal_processor_x_inst__198_/B
+ VDD VDD VSS VSS gf180mcu_fd_sc_mcu7t5v0__nand2_1
XFILLER_122_1157 VDD VDD VSS VSS gf180mcu_fd_sc_mcu7t5v0__fillcap_16
Xspi_regs_inst__1150_ spi_regs_inst__1150_/A1 spi_regs_inst__1234_/A2 spi_regs_inst__1352_/A2
+ spi_regs_inst__1593_/Q spi_regs_inst__1152_/A3 VDD VDD VSS VSS gf180mcu_fd_sc_mcu7t5v0__aoi22_1
XFILLER_108_350 VDD VDD VSS VSS gf180mcu_fd_sc_mcu7t5v0__fillcap_32
XFILLER_143_629 VDD VDD VSS VSS gf180mcu_fd_sc_mcu7t5v0__fill_1
XFILLER_155_489 VDD VDD VSS VSS gf180mcu_fd_sc_mcu7t5v0__fill_1
Xspi_regs_inst__1081_ spi_regs_inst__1558_/Q spi_regs_inst__1180_/A2 spi_regs_inst__1088_/A1
+ VDD VDD VSS VSS gf180mcu_fd_sc_mcu7t5v0__nand2_1
XFILLER_109_895 VDD VDD VSS VSS gf180mcu_fd_sc_mcu7t5v0__fill_2
XFILLER_142_139 VDD VDD VSS VSS gf180mcu_fd_sc_mcu7t5v0__fillcap_8
XFILLER_89_85 VDD VDD VSS VSS gf180mcu_fd_sc_mcu7t5v0__fill_1
XPHY_EDGE_ROW_19_1_Right_18 VDD VSS gf180mcu_fd_sc_mcu7t5v0__endcap
XTAP_TAPCELL_ROW_75_1120 VDD VSS gf180mcu_fd_sc_mcu7t5v0__filltie
XFILLER_145_80 VDD VDD VSS VSS gf180mcu_fd_sc_mcu7t5v0__fillcap_16
XFILLER_151_695 VDD VDD VSS VSS gf180mcu_fd_sc_mcu7t5v0__fillcap_4
XFILLER_96_215 VDD VDD VSS VSS gf180mcu_fd_sc_mcu7t5v0__fill_1
XFILLER_65_624 VDD VDD VSS VSS gf180mcu_fd_sc_mcu7t5v0__fillcap_4
XFILLER_37_326 VDD VDD VSS VSS gf180mcu_fd_sc_mcu7t5v0__fill_2
XFILLER_65_657 VDD VDD VSS VSS gf180mcu_fd_sc_mcu7t5v0__fillcap_4
Xspi_regs_inst__0934_ spi_regs_inst__1636_/Q spi_regs_inst__1635_/Q spi_regs_inst__0939_/S
+ spi_regs_inst__1636_/D VDD VDD VSS VSS gf180mcu_fd_sc_mcu7t5v0__mux2_2
XFILLER_80_605 VDD VDD VSS VSS gf180mcu_fd_sc_mcu7t5v0__fill_1
XFILLER_93_977 VDD VDD VSS VSS gf180mcu_fd_sc_mcu7t5v0__fill_2
Xspi_regs_inst__0865_ spi_regs_inst__1601_/Q spi_regs_inst__1416_/I0 spi_regs_inst__0868_/S
+ spi_regs_inst__1601_/D VDD VDD VSS VSS gf180mcu_fd_sc_mcu7t5v0__mux2_2
XFILLER_61_830 VDD VDD VSS VSS gf180mcu_fd_sc_mcu7t5v0__fill_1
XFILLER_92_487 VDD VDD VSS VSS gf180mcu_fd_sc_mcu7t5v0__fill_1
XTAP_TAPCELL_ROW_86_1293 VDD VSS gf180mcu_fd_sc_mcu7t5v0__filltie
Xspi_regs_inst__0796_ spi_regs_inst__1547_/Q spi_regs_inst__1411_/I1 spi_regs_inst__0797_/S
+ spi_regs_inst__1547_/D VDD VDD VSS VSS gf180mcu_fd_sc_mcu7t5v0__mux2_2
XFILLER_127_1046 VDD VDD VSS VSS gf180mcu_fd_sc_mcu7t5v0__fillcap_4
XFILLER_158_283 VDD VDD VSS VSS gf180mcu_fd_sc_mcu7t5v0__fillcap_16
Xspi_regs_inst__1417_ spi_regs_inst__1441_/I1 spi_regs_inst__1489_/Q spi_regs_inst__1419_/S
+ spi_regs_inst__1489_/D VDD VDD VSS VSS gf180mcu_fd_sc_mcu7t5v0__mux2_2
XFILLER_109_18 VDD VDD VSS VSS gf180mcu_fd_sc_mcu7t5v0__fillcap_8
XFILLER_119_648 VDD VDD VSS VSS gf180mcu_fd_sc_mcu7t5v0__fillcap_8
XFILLER_9_282 VDD VDD VSS VSS gf180mcu_fd_sc_mcu7t5v0__fillcap_32
Xwave_controller_x_inst__2060_ wave_controller_x_inst__2071_/A1 wave_controller_x_inst__2077_/A1
+ wave_controller_x_inst__2074_/A3 VDD VDD VSS VSS gf180mcu_fd_sc_mcu7t5v0__nand2_1
Xspi_regs_inst__1348_ fanout501/Z spi_regs_inst_wire299/Z spi_regs_inst__1348_/B1
+ spi_regs_inst__1535_/Q spi_regs_inst__1351_/A2 VDD VDD VSS VSS gf180mcu_fd_sc_mcu7t5v0__aoi22_1
Xclkload30 clkload30/I clkload30/ZN VDD VDD VSS VSS gf180mcu_fd_sc_mcu7t5v0__clkinv_2
XFILLER_127_681 VDD VDD VSS VSS gf180mcu_fd_sc_mcu7t5v0__fill_1
XFILLER_127_692 VDD VDD VSS VSS gf180mcu_fd_sc_mcu7t5v0__fillcap_8
Xspi_regs_inst_wire20 spi_regs_inst_wire20/I spi_regs_inst_wire20/Z VDD VDD VSS VSS
+ gf180mcu_fd_sc_mcu7t5v0__buf_2
Xspi_regs_inst__1279_ spi_regs_inst__1525_/Q spi_regs_inst__1357_/A2 spi_regs_inst_wire218/Z
+ spi_regs_inst__1279_/B2 spi_regs_inst__1280_/A3 VDD VDD VSS VSS gf180mcu_fd_sc_mcu7t5v0__aoi22_1
XFILLER_102_537 VDD VDD VSS VSS gf180mcu_fd_sc_mcu7t5v0__fill_1
XFILLER_134_1017 VDD VDD VSS VSS gf180mcu_fd_sc_mcu7t5v0__fillcap_64
XFILLER_141_172 VDD VDD VSS VSS gf180mcu_fd_sc_mcu7t5v0__fillcap_16
Xwave_controller_x_inst__2962_ wave_controller_x_inst__3702_/Q fanout530/Z wave_controller_x_inst__2965_/B
+ VDD VDD VSS VSS gf180mcu_fd_sc_mcu7t5v0__nand2_1
Xspi_regs_inst_wire97 spi_regs_inst_wire98/Z spi_regs_inst_wire97/Z VDD VDD VSS VSS
+ gf180mcu_fd_sc_mcu7t5v0__clkbuf_1
Xspi_regs_inst_wire86 spi_regs_inst_wire86/I spi_regs_inst_wire86/Z VDD VDD VSS VSS
+ gf180mcu_fd_sc_mcu7t5v0__buf_2
Xwave_controller_x_inst__2893_ wave_controller_x_inst__3738_/Q wave_controller_x_inst__3739_/Q
+ wave_controller_x_inst__2893_/Z VDD VDD VSS VSS gf180mcu_fd_sc_mcu7t5v0__xor2_1
Xwave_controller_x_inst__1913_ wave_controller_x_inst__3340_/A1 spi_regs_inst__1497_/Q
+ wave_controller_x_inst__1944_/B VDD VDD VSS VSS gf180mcu_fd_sc_mcu7t5v0__nand2_1
XFILLER_96_771 VDD VDD VSS VSS gf180mcu_fd_sc_mcu7t5v0__fillcap_8
Xwave_controller_y_inst__1860_ spi_regs_inst__1139_/B2 wave_controller_y_inst__2616_/C
+ VDD VDD VSS VSS gf180mcu_fd_sc_mcu7t5v0__clkinv_1
Xwave_controller_x_inst__1844_ spi_regs_inst__1277_/A1 wave_controller_x_inst__2349_/A1
+ VDD VDD VSS VSS gf180mcu_fd_sc_mcu7t5v0__clkinv_1
Xsignal_processor_y_inst__229_ signal_processor_y_inst__229_/D _17_/B clkload2/I signal_processor_y_inst__229_/Q
+ VDD VDD VSS VSS gf180mcu_fd_sc_mcu7t5v0__dffrnq_1
XFILLER_18_37 VDD VDD VSS VSS gf180mcu_fd_sc_mcu7t5v0__fillcap_32
Xwave_controller_y_inst__1791_ wave_controller_y_inst__3709_/Q wave_controller_y_inst__3305_/B2
+ VDD VDD VSS VSS gf180mcu_fd_sc_mcu7t5v0__clkinv_1
XTAP_TAPCELL_ROW_2_1_347 VDD VSS gf180mcu_fd_sc_mcu7t5v0__filltie
Xwave_controller_y_inst__3530_ wave_controller_y_inst__3554_/A1 wave_controller_y_inst__3530_/A2
+ wave_controller_y_inst__3530_/A3 wave_controller_y_inst_wire139/I wave_controller_y_inst__3530_/B2
+ wave_controller_y_inst__3639_/D VDD VDD VSS VSS gf180mcu_fd_sc_mcu7t5v0__oai32_1
Xwave_controller_x_inst__3514_ spi_regs_inst__1311_/B2 wave_controller_x_inst__3538_/A2
+ wave_controller_x_inst__3515_/A3 VDD VDD VSS VSS gf180mcu_fd_sc_mcu7t5v0__nor2_1
Xwave_controller_x_inst__1775_ wave_controller_x_inst__3719_/Q wave_controller_x_inst__3262_/A1
+ VDD VDD VSS VSS gf180mcu_fd_sc_mcu7t5v0__clkinv_1
XFILLER_55_189 VDD VDD VSS VSS gf180mcu_fd_sc_mcu7t5v0__fill_2
XFILLER_70_104 VDD VDD VSS VSS gf180mcu_fd_sc_mcu7t5v0__fill_1
XFILLER_97_1170 VDD VDD VSS VSS gf180mcu_fd_sc_mcu7t5v0__fillcap_4
XFILLER_24_554 VDD VDD VSS VSS gf180mcu_fd_sc_mcu7t5v0__fill_1
Xwave_controller_y_inst__3461_ wave_controller_y_inst__3700_/Q wave_controller_y_inst__3461_/A2
+ wave_controller_y_inst__3461_/Z VDD VDD VSS VSS gf180mcu_fd_sc_mcu7t5v0__and2_1
Xwave_controller_x_inst__3445_ wave_controller_x_inst__3449_/A1 wave_controller_x_inst__3494_/A1
+ wave_controller_x_inst__3445_/B wave_controller_x_inst__3451_/A2 VDD VDD VSS VSS
+ gf180mcu_fd_sc_mcu7t5v0__oai21_1
Xwave_controller_y_inst__2412_ wave_controller_y_inst__2379_/Z wave_controller_y_inst__2412_/A2
+ wave_controller_y_inst__2412_/B wave_controller_y_inst__2412_/C wave_controller_y_inst__2425_/A3
+ VDD VDD VSS VSS gf180mcu_fd_sc_mcu7t5v0__aoi211_1
Xwave_controller_y_inst__3392_ wave_controller_y_inst__1819_/I wave_controller_y_inst__3360_/Z
+ wave_controller_y_inst__3392_/B1 wave_controller_y_inst__3392_/B2 wave_controller_y_inst__3392_/C
+ wave_controller_y_inst__3395_/A1 VDD VDD VSS VSS gf180mcu_fd_sc_mcu7t5v0__oai221_1
Xwave_controller_x_inst__3376_ wave_controller_x_inst__2797_/C spi_regs_inst__1541_/Q
+ wave_controller_x_inst__3376_/B wave_controller_x_inst__3378_/C VDD VDD VSS VSS
+ gf180mcu_fd_sc_mcu7t5v0__aoi21_1
Xsignal_processor_x_inst__120_ signal_processor_x_inst__128_/A1 wave_controller_x_inst__3615_/Q
+ signal_processor_x_inst__249_/D VDD VDD VSS VSS gf180mcu_fd_sc_mcu7t5v0__and2_1
XFILLER_51_395 VDD VDD VSS VSS gf180mcu_fd_sc_mcu7t5v0__fillcap_16
Xwave_controller_y_inst__2343_ wave_controller_y_inst__2343_/A1 wave_controller_y_inst__2345_/C
+ wave_controller_y_inst__2328_/Z wave_controller_y_inst__2345_/A2 VDD VDD VSS VSS
+ gf180mcu_fd_sc_mcu7t5v0__nand3_1
Xwave_controller_x_inst__2327_ wave_controller_x_inst__2328_/A1 wave_controller_x_inst__2303_/Z
+ wave_controller_x_inst__2327_/B wave_controller_x_inst__2345_/C VDD VDD VSS VSS
+ gf180mcu_fd_sc_mcu7t5v0__oai21_1
XTAP_TAPCELL_ROW_137_2135 VDD VSS gf180mcu_fd_sc_mcu7t5v0__filltie
Xclkload2 clkload2/I clkload2/Z VDD VDD VSS VSS gf180mcu_fd_sc_mcu7t5v0__clkbuf_4
XFILLER_109_136 VDD VDD VSS VSS gf180mcu_fd_sc_mcu7t5v0__fillcap_4
XFILLER_137_434 VDD VDD VSS VSS gf180mcu_fd_sc_mcu7t5v0__fillcap_16
Xwave_controller_y_inst__2274_ wave_controller_y_inst__2952_/A2 wave_controller_y_inst__2274_/A2
+ wave_controller_y_inst__2294_/A1 VDD VDD VSS VSS gf180mcu_fd_sc_mcu7t5v0__nand2_1
Xwave_controller_x_inst__2258_ wave_controller_x_inst__2259_/A1 wave_controller_x_inst__2259_/A2
+ wave_controller_x_inst__2260_/B VDD VDD VSS VSS gf180mcu_fd_sc_mcu7t5v0__nor2_1
XFILLER_125_629 VDD VDD VSS VSS gf180mcu_fd_sc_mcu7t5v0__fill_1
XFILLER_50_79 VDD VDD VSS VSS gf180mcu_fd_sc_mcu7t5v0__fill_1
Xwave_controller_x_inst__2189_ wave_controller_x_inst__2186_/I wave_controller_x_inst__2213_/A2
+ wave_controller_x_inst__2202_/A1 VDD VDD VSS VSS gf180mcu_fd_sc_mcu7t5v0__nor2_1
XFILLER_164_297 VDD VDD VSS VSS gf180mcu_fd_sc_mcu7t5v0__fill_1
XTAP_TAPCELL_ROW_150_2346 VDD VSS gf180mcu_fd_sc_mcu7t5v0__filltie
XTAP_TAPCELL_ROW_150_2357 VDD VSS gf180mcu_fd_sc_mcu7t5v0__filltie
XFILLER_117_191 VDD VDD VSS VSS gf180mcu_fd_sc_mcu7t5v0__fill_1
XFILLER_133_640 VDD VDD VSS VSS gf180mcu_fd_sc_mcu7t5v0__fillcap_4
XTAP_TAPCELL_ROW_115_1776 VDD VSS gf180mcu_fd_sc_mcu7t5v0__filltie
Xwave_controller_y_inst_fanout322 wave_controller_y_inst__3572_/A2 wave_controller_y_inst_wire323/I
+ VDD VDD VSS VSS gf180mcu_fd_sc_mcu7t5v0__dlyb_1
XFILLER_121_846 VDD VDD VSS VSS gf180mcu_fd_sc_mcu7t5v0__fill_2
XFILLER_161_982 VDD VDD VSS VSS gf180mcu_fd_sc_mcu7t5v0__fillcap_64
XFILLER_79_738 VDD VDD VSS VSS gf180mcu_fd_sc_mcu7t5v0__fillcap_8
Xwave_controller_y_inst_fanout366 wave_controller_y_inst__3560_/A1 wave_controller_y_inst__3279_/A1
+ VDD VDD VSS VSS gf180mcu_fd_sc_mcu7t5v0__dlyb_1
XFILLER_59_462 VDD VDD VSS VSS gf180mcu_fd_sc_mcu7t5v0__fillcap_16
XFILLER_101_581 VDD VDD VSS VSS gf180mcu_fd_sc_mcu7t5v0__fillcap_8
XFILLER_46_123 VDD VDD VSS VSS gf180mcu_fd_sc_mcu7t5v0__fillcap_16
XFILLER_75_54 VDD VDD VSS VSS gf180mcu_fd_sc_mcu7t5v0__fill_1
XFILLER_86_281 VDD VDD VSS VSS gf180mcu_fd_sc_mcu7t5v0__fillcap_4
XFILLER_74_454 VDD VDD VSS VSS gf180mcu_fd_sc_mcu7t5v0__fill_1
XFILLER_90_925 VDD VDD VSS VSS gf180mcu_fd_sc_mcu7t5v0__fill_2
Xwave_controller_y_inst__3728_ wave_controller_y_inst__3728_/D fanout547/Z clkload6/I
+ wave_controller_y_inst__3728_/Q VDD VDD VSS VSS gf180mcu_fd_sc_mcu7t5v0__dffrnq_1
Xwave_controller_y_inst__1989_ wave_controller_y_inst__3212_/B wave_controller_y_inst__2284_/A1
+ wave_controller_y_inst__1991_/A1 VDD VDD VSS VSS gf180mcu_fd_sc_mcu7t5v0__nand2_1
XFILLER_90_947 VDD VDD VSS VSS gf180mcu_fd_sc_mcu7t5v0__fillcap_64
XFILLER_15_554 VDD VDD VSS VSS gf180mcu_fd_sc_mcu7t5v0__fill_1
XPHY_EDGE_ROW_141_Right_141 VDD VSS gf180mcu_fd_sc_mcu7t5v0__endcap
Xwave_controller_y_inst__3659_ wave_controller_y_inst__3659_/D wave_controller_y_inst__3683_/RN
+ clkbuf_leaf_46_clk/Z spi_regs_inst__1139_/B2 VDD VDD VSS VSS gf180mcu_fd_sc_mcu7t5v0__dffrnq_1
Xsignal_processor_x_inst__249_ signal_processor_x_inst__249_/D fanout595/Z clkbuf_leaf_20_clk/Z
+ signal_processor_x_inst__249_/Q VDD VDD VSS VSS gf180mcu_fd_sc_mcu7t5v0__dffrnq_1
Xspi_regs_inst__1202_ spi_regs_inst__1202_/A1 spi_regs_inst__1202_/A2 spi_regs_inst__1352_/A2
+ spi_regs_inst__1594_/Q spi_regs_inst__1205_/A2 VDD VDD VSS VSS gf180mcu_fd_sc_mcu7t5v0__aoi22_1
XFILLER_6_241 VDD VDD VSS VSS gf180mcu_fd_sc_mcu7t5v0__fillcap_4
XTAP_TAPCELL_ROW_26_1_526 VDD VSS gf180mcu_fd_sc_mcu7t5v0__filltie
Xchip_core_680 bidir_ie[2] VDD VDD VSS VSS gf180mcu_fd_sc_mcu7t5v0__tieh
XFILLER_109_681 VDD VDD VSS VSS gf180mcu_fd_sc_mcu7t5v0__fillcap_4
Xspi_regs_inst__1133_ spi_regs_inst__1133_/A1 spi_regs_inst__1133_/A2 spi_regs_inst__1133_/Z
+ VDD VDD VSS VSS gf180mcu_fd_sc_mcu7t5v0__and2_1
XTAP_TAPCELL_ROW_34_1_583 VDD VSS gf180mcu_fd_sc_mcu7t5v0__filltie
Xspi_regs_inst__1064_ spi_regs_inst__1064_/A1 spi_regs_inst_wire240/Z spi_regs_inst_wire214/Z
+ spi_regs_inst__1064_/B2 spi_regs_inst__1067_/A2 VDD VDD VSS VSS gf180mcu_fd_sc_mcu7t5v0__aoi22_1
XFILLER_151_481 VDD VDD VSS VSS gf180mcu_fd_sc_mcu7t5v0__fillcap_8
XFILLER_97_513 VDD VDD VSS VSS gf180mcu_fd_sc_mcu7t5v0__fillcap_8
XFILLER_151_492 VDD VDD VSS VSS gf180mcu_fd_sc_mcu7t5v0__fillcap_16
XFILLER_69_248 VDD VDD VSS VSS gf180mcu_fd_sc_mcu7t5v0__fillcap_32
XFILLER_97_579 VDD VDD VSS VSS gf180mcu_fd_sc_mcu7t5v0__fill_2
XFILLER_65_432 VDD VDD VSS VSS gf180mcu_fd_sc_mcu7t5v0__fillcap_16
XTAP_TAPCELL_ROW_88_1322 VDD VSS gf180mcu_fd_sc_mcu7t5v0__filltie
XTAP_TAPCELL_ROW_88_1333 VDD VSS gf180mcu_fd_sc_mcu7t5v0__filltie
Xspi_regs_inst__0917_ spi_regs_inst__1638_/Q spi_regs_inst__0931_/A2 spi_regs_inst__0924_/B
+ VDD VDD VSS VSS gf180mcu_fd_sc_mcu7t5v0__nand2_1
XFILLER_52_104 VDD VDD VSS VSS gf180mcu_fd_sc_mcu7t5v0__fill_1
XFILLER_53_638 VDD VDD VSS VSS gf180mcu_fd_sc_mcu7t5v0__fill_2
XFILLER_65_476 VDD VDD VSS VSS gf180mcu_fd_sc_mcu7t5v0__fillcap_4
XFILLER_80_413 VDD VDD VSS VSS gf180mcu_fd_sc_mcu7t5v0__fill_1
Xspi_regs_inst__0848_ spi_regs_inst__1587_/Q spi_regs_inst__1391_/I1 spi_regs_inst__0849_/S
+ spi_regs_inst__1587_/D VDD VDD VSS VSS gf180mcu_fd_sc_mcu7t5v0__mux2_2
Xwave_controller_x_inst__3230_ fanout530/I wave_controller_x_inst__3133_/B wave_controller_x_inst__3232_/B2
+ VDD VDD VSS VSS gf180mcu_fd_sc_mcu7t5v0__nand2_1
Xspi_regs_inst__0779_ spi_regs_inst__1534_/Q spi_regs_inst__1411_/I1 spi_regs_inst__0780_/S
+ spi_regs_inst__1534_/D VDD VDD VSS VSS gf180mcu_fd_sc_mcu7t5v0__mux2_2
XFILLER_60_170 VDD VDD VSS VSS gf180mcu_fd_sc_mcu7t5v0__fillcap_4
XFILLER_119_401 VDD VDD VSS VSS gf180mcu_fd_sc_mcu7t5v0__fill_1
XFILLER_166_518 VDD VDD VSS VSS gf180mcu_fd_sc_mcu7t5v0__fillcap_4
Xwave_controller_x_inst__3161_ wave_controller_x_inst__3158_/I wave_controller_x_inst__3203_/B
+ wave_controller_x_inst__3162_/B VDD VDD VSS VSS gf180mcu_fd_sc_mcu7t5v0__nor2_1
XFILLER_135_905 VDD VDD VSS VSS gf180mcu_fd_sc_mcu7t5v0__fillcap_4
XFILLER_147_754 VDD VDD VSS VSS gf180mcu_fd_sc_mcu7t5v0__fillcap_16
Xwave_controller_x_inst__3092_ wave_controller_x_inst__3092_/A1 wave_controller_x_inst__3097_/A1
+ wave_controller_x_inst__3092_/B1 wave_controller_x_inst__3593_/A1 wave_controller_x_inst__3721_/D
+ VDD VDD VSS VSS gf180mcu_fd_sc_mcu7t5v0__aoi22_1
Xwave_controller_x_inst__2112_ wave_controller_x_inst__2125_/B wave_controller_x_inst__2125_/C
+ wave_controller_x_inst__2130_/A1 VDD VDD VSS VSS gf180mcu_fd_sc_mcu7t5v0__nor2_1
XFILLER_140_1087 VDD VDD VSS VSS gf180mcu_fd_sc_mcu7t5v0__fillcap_64
XFILLER_146_253 VDD VDD VSS VSS gf180mcu_fd_sc_mcu7t5v0__fillcap_16
XFILLER_147_776 VDD VDD VSS VSS gf180mcu_fd_sc_mcu7t5v0__fill_2
Xwave_controller_x_inst__2043_ wave_controller_x_inst__2114_/B wave_controller_x_inst__2125_/C
+ wave_controller_x_inst__2072_/B VDD VDD VSS VSS gf180mcu_fd_sc_mcu7t5v0__nand2_1
XTAP_TAPCELL_ROW_132_2054 VDD VSS gf180mcu_fd_sc_mcu7t5v0__filltie
XFILLER_103_802 VDD VDD VSS VSS gf180mcu_fd_sc_mcu7t5v0__fillcap_8
XFILLER_115_640 VDD VDD VSS VSS gf180mcu_fd_sc_mcu7t5v0__fillcap_4
XFILLER_161_256 VDD VDD VSS VSS gf180mcu_fd_sc_mcu7t5v0__fillcap_8
Xspi_regs_inst_wire221 spi_regs_inst_wire222/I spi_regs_inst_wire221/Z VDD VDD VSS
+ VSS gf180mcu_fd_sc_mcu7t5v0__buf_2
Xspi_regs_inst_wire210 spi_regs_inst_wire210/I spi_regs_inst_wire210/Z VDD VDD VSS
+ VSS gf180mcu_fd_sc_mcu7t5v0__buf_2
XFILLER_103_835 VDD VDD VSS VSS gf180mcu_fd_sc_mcu7t5v0__fillcap_4
XFILLER_114_172 VDD VDD VSS VSS gf180mcu_fd_sc_mcu7t5v0__fill_2
XFILLER_142_470 VDD VDD VSS VSS gf180mcu_fd_sc_mcu7t5v0__fill_1
XFILLER_143_982 VDD VDD VSS VSS gf180mcu_fd_sc_mcu7t5v0__fillcap_64
XFILLER_88_524 VDD VDD VSS VSS gf180mcu_fd_sc_mcu7t5v0__fill_1
XFILLER_88_535 VDD VDD VSS VSS gf180mcu_fd_sc_mcu7t5v0__fill_2
Xspi_regs_inst_wire254 spi_regs_inst_wire254/I spi_regs_inst_wire254/Z VDD VDD VSS
+ VSS gf180mcu_fd_sc_mcu7t5v0__buf_2
XFILLER_88_546 VDD VDD VSS VSS gf180mcu_fd_sc_mcu7t5v0__fillcap_8
Xwave_controller_y_inst__2961_ wave_controller_y_inst__3703_/Q fanout507/Z wave_controller_y_inst__2961_/Z
+ VDD VDD VSS VSS gf180mcu_fd_sc_mcu7t5v0__or2_1
Xwave_controller_x_inst__2945_ wave_controller_x_inst__3163_/C fanout539/Z wave_controller_x_inst__2945_/Z
+ VDD VDD VSS VSS gf180mcu_fd_sc_mcu7t5v0__xor2_1
XFILLER_102_356 VDD VDD VSS VSS gf180mcu_fd_sc_mcu7t5v0__fill_2
XFILLER_152_26 VDD VDD VSS VSS gf180mcu_fd_sc_mcu7t5v0__fillcap_4
XFILLER_152_37 VDD VDD VSS VSS gf180mcu_fd_sc_mcu7t5v0__fillcap_8
XFILLER_29_36 VDD VDD VSS VSS gf180mcu_fd_sc_mcu7t5v0__fillcap_16
XFILLER_60_1011 VDD VDD VSS VSS gf180mcu_fd_sc_mcu7t5v0__fillcap_4
XFILLER_88_579 VDD VDD VSS VSS gf180mcu_fd_sc_mcu7t5v0__fill_1
XTAP_TAPCELL_ROW_110_1684 VDD VSS gf180mcu_fd_sc_mcu7t5v0__filltie
Xwave_controller_y_inst__2892_ wave_controller_y_inst__3738_/Q wave_controller_y_inst__2935_/A2
+ wave_controller_y_inst__2896_/B VDD VDD VSS VSS gf180mcu_fd_sc_mcu7t5v0__xor2_1
Xwave_controller_y_inst__1912_ wave_controller_y_inst__3098_/B fanout499/Z wave_controller_y_inst__3406_/A2
+ VDD VDD VSS VSS gf180mcu_fd_sc_mcu7t5v0__nand2_1
XFILLER_28_123 VDD VDD VSS VSS gf180mcu_fd_sc_mcu7t5v0__fill_2
XFILLER_68_270 VDD VDD VSS VSS gf180mcu_fd_sc_mcu7t5v0__fill_1
XFILLER_96_590 VDD VDD VSS VSS gf180mcu_fd_sc_mcu7t5v0__fillcap_4
XTAP_TAPCELL_ROW_110_1695 VDD VSS gf180mcu_fd_sc_mcu7t5v0__filltie
Xwave_controller_y_inst__1843_ spi_regs_inst__1232_/B2 wave_controller_y_inst__2349_/C
+ VDD VDD VSS VSS gf180mcu_fd_sc_mcu7t5v0__clkinv_1
Xwave_controller_x_inst__2876_ wave_controller_x_inst__3697_/Q wave_controller_x_inst__3472_/A1
+ wave_controller_x_inst__2879_/B wave_controller_x_inst__2880_/A3 VDD VDD VSS VSS
+ gf180mcu_fd_sc_mcu7t5v0__aoi21_1
XFILLER_56_465 VDD VDD VSS VSS gf180mcu_fd_sc_mcu7t5v0__fillcap_4
Xwave_controller_x_inst__1827_ fanout530/Z wave_controller_x_inst__3043_/A2 VDD VDD
+ VSS VSS gf180mcu_fd_sc_mcu7t5v0__clkinv_1
XFILLER_72_947 VDD VDD VSS VSS gf180mcu_fd_sc_mcu7t5v0__fillcap_64
XTAP_TAPCELL_ROW_67_983 VDD VSS gf180mcu_fd_sc_mcu7t5v0__filltie
XFILLER_45_79 VDD VDD VSS VSS gf180mcu_fd_sc_mcu7t5v0__fillcap_8
Xwave_controller_y_inst__3513_ wave_controller_y_inst__3707_/Q wave_controller_y_inst__3528_/A2
+ wave_controller_y_inst__3515_/A2 VDD VDD VSS VSS gf180mcu_fd_sc_mcu7t5v0__nor2_1
Xwave_controller_y_inst__3444_ spi_regs_inst__1190_/A1 wave_controller_y_inst__3494_/A1
+ wave_controller_y_inst__3445_/B VDD VDD VSS VSS gf180mcu_fd_sc_mcu7t5v0__nand2_1
Xwave_controller_x_inst__3428_ wave_controller_x_inst__3430_/A1 wave_controller_x_inst__3494_/A1
+ wave_controller_x_inst__3428_/B wave_controller_x_inst__3429_/I VDD VDD VSS VSS
+ gf180mcu_fd_sc_mcu7t5v0__oai21_1
XFILLER_12_524 VDD VDD VSS VSS gf180mcu_fd_sc_mcu7t5v0__fill_1
XFILLER_24_395 VDD VDD VSS VSS gf180mcu_fd_sc_mcu7t5v0__fill_2
XFILLER_138_721 VDD VDD VSS VSS gf180mcu_fd_sc_mcu7t5v0__fillcap_8
Xwave_controller_y_inst__3375_ wave_controller_y_inst__3374_/B wave_controller_y_inst__3375_/A2
+ wave_controller_y_inst__3373_/Z wave_controller_y_inst__3383_/B1 VDD VDD VSS VSS
+ gf180mcu_fd_sc_mcu7t5v0__nand3_1
Xwave_controller_x_inst__3359_ wave_controller_x_inst__3359_/A1 wave_controller_x_inst__3358_/Z
+ wave_controller_x_inst__3394_/B1 VDD VDD VSS VSS gf180mcu_fd_sc_mcu7t5v0__nand2_1
XFILLER_124_2 VDD VDD VSS VSS gf180mcu_fd_sc_mcu7t5v0__fillcap_8
XTAP_TAPCELL_ROW_117_1805 VDD VSS gf180mcu_fd_sc_mcu7t5v0__filltie
Xwave_controller_y_inst__2326_ wave_controller_y_inst__3209_/B wave_controller_y_inst__2616_/A1
+ wave_controller_y_inst__2326_/A3 wave_controller_y_inst__2327_/B VDD VDD VSS VSS
+ gf180mcu_fd_sc_mcu7t5v0__xor3_1
XFILLER_153_702 VDD VDD VSS VSS gf180mcu_fd_sc_mcu7t5v0__fill_2
Xwave_controller_y_inst__2257_ wave_controller_y_inst__2257_/A1 wave_controller_y_inst__2257_/A2
+ wave_controller_y_inst__2257_/A3 wave_controller_y_inst__2259_/B1 VDD VDD VSS VSS
+ gf180mcu_fd_sc_mcu7t5v0__nand3_1
XFILLER_165_595 VDD VDD VSS VSS gf180mcu_fd_sc_mcu7t5v0__fill_2
XFILLER_141_908 VDD VDD VSS VSS gf180mcu_fd_sc_mcu7t5v0__fill_2
Xwave_controller_y_inst__2188_ wave_controller_y_inst__2187_/B wave_controller_y_inst__2188_/A2
+ wave_controller_y_inst__2188_/B1 wave_controller_y_inst__2213_/A2 spi_regs_inst__1158_/A1
+ VDD VDD VSS VSS gf180mcu_fd_sc_mcu7t5v0__aoi22_1
XFILLER_105_150 VDD VDD VSS VSS gf180mcu_fd_sc_mcu7t5v0__fillcap_4
XFILLER_152_289 VDD VDD VSS VSS gf180mcu_fd_sc_mcu7t5v0__fill_1
Xwave_controller_y_inst_fanout141 wave_controller_y_inst__3554_/A1 wave_controller_y_inst__3557_/A1
+ VDD VDD VSS VSS gf180mcu_fd_sc_mcu7t5v0__dlyb_1
XFILLER_105_172 VDD VDD VSS VSS gf180mcu_fd_sc_mcu7t5v0__fill_2
XFILLER_133_492 VDD VDD VSS VSS gf180mcu_fd_sc_mcu7t5v0__fillcap_8
XFILLER_79_557 VDD VDD VSS VSS gf180mcu_fd_sc_mcu7t5v0__fill_2
XTAP_TAPCELL_ROW_167_2640 VDD VSS gf180mcu_fd_sc_mcu7t5v0__filltie
XTAP_TAPCELL_ROW_167_2651 VDD VSS gf180mcu_fd_sc_mcu7t5v0__filltie
XFILLER_94_527 VDD VDD VSS VSS gf180mcu_fd_sc_mcu7t5v0__fillcap_8
XFILLER_66_229 VDD VDD VSS VSS gf180mcu_fd_sc_mcu7t5v0__fill_1
XTAP_TAPCELL_ROW_163_2559 VDD VSS gf180mcu_fd_sc_mcu7t5v0__filltie
XFILLER_19_156 VDD VDD VSS VSS gf180mcu_fd_sc_mcu7t5v0__fill_1
XFILLER_19_80 VDD VDD VSS VSS gf180mcu_fd_sc_mcu7t5v0__fillcap_4
XFILLER_34_104 VDD VDD VSS VSS gf180mcu_fd_sc_mcu7t5v0__fill_1
XFILLER_74_284 VDD VDD VSS VSS gf180mcu_fd_sc_mcu7t5v0__fill_2
XTAP_TAPCELL_ROW_128_1989 VDD VSS gf180mcu_fd_sc_mcu7t5v0__filltie
XFILLER_62_446 VDD VDD VSS VSS gf180mcu_fd_sc_mcu7t5v0__fill_1
Xspi_regs_inst_load_slew244 spi_regs_inst__1322_/A2 spi_regs_inst__1354_/B1 VDD VDD
+ VSS VSS gf180mcu_fd_sc_mcu7t5v0__buf_2
XTAP_TAPCELL_ROW_83_1241 VDD VSS gf180mcu_fd_sc_mcu7t5v0__filltie
XTAP_TAPCELL_ROW_83_1252 VDD VSS gf180mcu_fd_sc_mcu7t5v0__filltie
XFILLER_128_231 VDD VDD VSS VSS gf180mcu_fd_sc_mcu7t5v0__fill_2
XFILLER_117_905 VDD VDD VSS VSS gf180mcu_fd_sc_mcu7t5v0__fill_1
XFILLER_129_776 VDD VDD VSS VSS gf180mcu_fd_sc_mcu7t5v0__fill_1
XFILLER_144_779 VDD VDD VSS VSS gf180mcu_fd_sc_mcu7t5v0__fillcap_16
Xspi_regs_inst__1116_ spi_regs_inst__1116_/A1 spi_regs_inst__1116_/A2 spi_regs_inst__1124_/A2
+ VDD VDD VSS VSS gf180mcu_fd_sc_mcu7t5v0__nor2_1
XFILLER_125_982 VDD VDD VSS VSS gf180mcu_fd_sc_mcu7t5v0__fillcap_64
XFILLER_140_941 VDD VDD VSS VSS gf180mcu_fd_sc_mcu7t5v0__fillcap_4
XFILLER_97_321 VDD VDD VSS VSS gf180mcu_fd_sc_mcu7t5v0__fillcap_8
Xspi_regs_inst__1047_ spi_regs_inst__1536_/Q spi_regs_inst__1251_/A2 spi_regs_inst__1085_/C1
+ max_cap465/Z spi_regs_inst__1049_/A4 VDD VDD VSS VSS gf180mcu_fd_sc_mcu7t5v0__aoi22_1
XFILLER_85_505 VDD VDD VSS VSS gf180mcu_fd_sc_mcu7t5v0__fillcap_8
XFILLER_98_899 VDD VDD VSS VSS gf180mcu_fd_sc_mcu7t5v0__fillcap_32
Xwave_controller_x_inst__2730_ wave_controller_x_inst__2730_/A1 wave_controller_x_inst__2716_/Z
+ wave_controller_x_inst__2730_/A3 spi_regs_inst__1169_/B2 wave_controller_x_inst__2730_/B2
+ wave_controller_x_inst_wire95/I VDD VDD VSS VSS gf180mcu_fd_sc_mcu7t5v0__oai32_1
XFILLER_111_186 VDD VDD VSS VSS gf180mcu_fd_sc_mcu7t5v0__fill_2
XFILLER_66_730 VDD VDD VSS VSS gf180mcu_fd_sc_mcu7t5v0__fillcap_4
XFILLER_38_465 VDD VDD VSS VSS gf180mcu_fd_sc_mcu7t5v0__fillcap_4
XFILLER_66_752 VDD VDD VSS VSS gf180mcu_fd_sc_mcu7t5v0__fillcap_4
Xwave_controller_x_inst__2661_ wave_controller_x_inst__2661_/I wave_controller_x_inst__2663_/A2
+ VDD VDD VSS VSS gf180mcu_fd_sc_mcu7t5v0__clkinv_1
XFILLER_38_498 VDD VDD VSS VSS gf180mcu_fd_sc_mcu7t5v0__fill_2
XFILLER_54_947 VDD VDD VSS VSS gf180mcu_fd_sc_mcu7t5v0__fillcap_64
XFILLER_93_582 VDD VDD VSS VSS gf180mcu_fd_sc_mcu7t5v0__fill_1
Xwave_controller_x_inst__2592_ wave_controller_x_inst__2609_/A1 wave_controller_x_inst__2591_/Z
+ wave_controller_x_inst__2594_/A1 VDD VDD VSS VSS gf180mcu_fd_sc_mcu7t5v0__nor2_1
XFILLER_81_766 VDD VDD VSS VSS gf180mcu_fd_sc_mcu7t5v0__fillcap_4
XTAP_TAPCELL_ROW_64_931 VDD VSS gf180mcu_fd_sc_mcu7t5v0__filltie
X_09_ _09_/A1 _09_/A2 _09_/Z VDD VDD VSS VSS gf180mcu_fd_sc_mcu7t5v0__and2_1
XFILLER_81_788 VDD VDD VSS VSS gf180mcu_fd_sc_mcu7t5v0__fill_1
XFILLER_81_799 VDD VDD VSS VSS gf180mcu_fd_sc_mcu7t5v0__fill_1
XFILLER_94_1151 VDD VDD VSS VSS gf180mcu_fd_sc_mcu7t5v0__fillcap_4
XFILLER_94_1173 VDD VDD VSS VSS gf180mcu_fd_sc_mcu7t5v0__fill_1
Xwave_controller_x_inst__3213_ wave_controller_x_inst__3572_/A1 wave_controller_x_inst__3213_/A2
+ wave_controller_x_inst__3213_/A3 wave_controller_x_inst__3213_/Z VDD VDD VSS VSS
+ gf180mcu_fd_sc_mcu7t5v0__xor3_1
XFILLER_21_398 VDD VDD VSS VSS gf180mcu_fd_sc_mcu7t5v0__fillcap_16
Xwave_controller_y_inst__3160_ wave_controller_y_inst__3712_/Q spi_regs_inst__1594_/Q
+ wave_controller_y_inst__3203_/B VDD VDD VSS VSS gf180mcu_fd_sc_mcu7t5v0__xor2_1
Xwave_controller_x_inst__3144_ wave_controller_x_inst__3146_/C wave_controller_x_inst__3146_/B
+ wave_controller_x_inst__3145_/B VDD VDD VSS VSS gf180mcu_fd_sc_mcu7t5v0__nand2_1
XFILLER_135_702 VDD VDD VSS VSS gf180mcu_fd_sc_mcu7t5v0__fill_2
XFILLER_147_26 VDD VDD VSS VSS gf180mcu_fd_sc_mcu7t5v0__fillcap_4
Xwave_controller_y_inst__3091_ wave_controller_y_inst__3091_/A1 wave_controller_y_inst__3005_/Z
+ wave_controller_y_inst__3092_/B1 VDD VDD VSS VSS gf180mcu_fd_sc_mcu7t5v0__nand2_1
Xwave_controller_y_inst__2111_ wave_controller_y_inst__2033_/Z wave_controller_y_inst_wire358/Z
+ wave_controller_y_inst__2125_/B wave_controller_y_inst__2108_/B wave_controller_y_inst__2114_/A1
+ VDD VDD VSS VSS gf180mcu_fd_sc_mcu7t5v0__nand4_1
XFILLER_108_938 VDD VDD VSS VSS gf180mcu_fd_sc_mcu7t5v0__fillcap_4
XFILLER_147_59 VDD VDD VSS VSS gf180mcu_fd_sc_mcu7t5v0__fill_2
Xwave_controller_y_inst__2042_ wave_controller_y_inst__1778_/I wave_controller_y_inst__3089_/B
+ wave_controller_y_inst__2125_/C VDD VDD VSS VSS gf180mcu_fd_sc_mcu7t5v0__xnor2_1
Xwave_controller_x_inst__3075_ wave_controller_x_inst__3075_/A1 wave_controller_x_inst__2990_/Z
+ wave_controller_x_inst__3076_/B1 VDD VDD VSS VSS gf180mcu_fd_sc_mcu7t5v0__xnor2_1
Xwave_controller_x_inst__2026_ wave_controller_x_inst__2425_/B2 wave_controller_x_inst__2027_/B
+ wave_controller_x_inst__2027_/A2 wave_controller_x_inst__2026_/Z VDD VDD VSS VSS
+ gf180mcu_fd_sc_mcu7t5v0__and3_1
Xoutput15 _93_/Z bidir_out[8] VDD VDD VSS VSS gf180mcu_fd_sc_mcu7t5v0__buf_1
XTAP_TAPCELL_ROW_112_1724 VDD VSS gf180mcu_fd_sc_mcu7t5v0__filltie
XFILLER_103_621 VDD VDD VSS VSS gf180mcu_fd_sc_mcu7t5v0__fillcap_8
XFILLER_103_632 VDD VDD VSS VSS gf180mcu_fd_sc_mcu7t5v0__fill_1
XFILLER_115_492 VDD VDD VSS VSS gf180mcu_fd_sc_mcu7t5v0__fillcap_8
XFILLER_88_310 VDD VDD VSS VSS gf180mcu_fd_sc_mcu7t5v0__fillcap_4
XFILLER_0_247 VDD VDD VSS VSS gf180mcu_fd_sc_mcu7t5v0__fillcap_16
XFILLER_89_899 VDD VDD VSS VSS gf180mcu_fd_sc_mcu7t5v0__fillcap_8
Xwave_controller_y_inst__2944_ wave_controller_y_inst__3312_/A1 wave_controller_y_inst__2944_/A2
+ wave_controller_y_inst__3000_/A1 VDD VDD VSS VSS gf180mcu_fd_sc_mcu7t5v0__nand2_1
XFILLER_130_473 VDD VDD VSS VSS gf180mcu_fd_sc_mcu7t5v0__fill_1
XFILLER_130_495 VDD VDD VSS VSS gf180mcu_fd_sc_mcu7t5v0__fill_1
XFILLER_76_527 VDD VDD VSS VSS gf180mcu_fd_sc_mcu7t5v0__fillcap_8
XFILLER_88_387 VDD VDD VSS VSS gf180mcu_fd_sc_mcu7t5v0__fillcap_4
Xwave_controller_x_inst__2928_ wave_controller_x_inst__3340_/A1 wave_controller_x_inst__3406_/A1
+ wave_controller_x_inst__3591_/I0 VDD VDD VSS VSS gf180mcu_fd_sc_mcu7t5v0__nor2_1
XTAP_TAPCELL_ROW_145_2267 VDD VSS gf180mcu_fd_sc_mcu7t5v0__filltie
Xwave_controller_y_inst__2875_ wave_controller_y_inst__3458_/A1 spi_regs_inst__1262_/A1
+ wave_controller_y_inst__2870_/Z wave_controller_y_inst__2879_/B VDD VDD VSS VSS
+ gf180mcu_fd_sc_mcu7t5v0__nor3_1
Xwave_controller_x_inst__2859_ wave_controller_x_inst__2880_/A1 wave_controller_x_inst__2883_/A3
+ wave_controller_x_inst__2878_/A1 VDD VDD VSS VSS gf180mcu_fd_sc_mcu7t5v0__nand2_1
XFILLER_29_487 VDD VDD VSS VSS gf180mcu_fd_sc_mcu7t5v0__fill_2
Xwave_controller_y_inst__1826_ wave_controller_y_inst__1826_/I wave_controller_y_inst__3374_/B
+ VDD VDD VSS VSS gf180mcu_fd_sc_mcu7t5v0__clkinv_1
XFILLER_16_126 VDD VDD VSS VSS gf180mcu_fd_sc_mcu7t5v0__fillcap_4
XFILLER_44_424 VDD VDD VSS VSS gf180mcu_fd_sc_mcu7t5v0__fillcap_4
XFILLER_44_457 VDD VDD VSS VSS gf180mcu_fd_sc_mcu7t5v0__fillcap_4
XFILLER_84_593 VDD VDD VSS VSS gf180mcu_fd_sc_mcu7t5v0__fill_2
Xwave_controller_x_inst_fanout33 wave_controller_x_inst__3523_/A2 wave_controller_x_inst__3538_/A2
+ VDD VDD VSS VSS gf180mcu_fd_sc_mcu7t5v0__dlyb_1
XFILLER_16_159 VDD VDD VSS VSS gf180mcu_fd_sc_mcu7t5v0__fillcap_4
XFILLER_72_799 VDD VDD VSS VSS gf180mcu_fd_sc_mcu7t5v0__fillcap_4
XTAP_TAPCELL_ROW_33_1_582 VDD VSS gf180mcu_fd_sc_mcu7t5v0__filltie
XFILLER_52_490 VDD VDD VSS VSS gf180mcu_fd_sc_mcu7t5v0__fill_2
XPHY_EDGE_ROW_28_1_Right_27 VDD VSS gf180mcu_fd_sc_mcu7t5v0__endcap
Xwave_controller_y_inst__3427_ spi_regs_inst__1091_/A1 wave_controller_y_inst__3494_/A1
+ wave_controller_y_inst__3428_/B VDD VDD VSS VSS gf180mcu_fd_sc_mcu7t5v0__nand2_1
Xclkbuf_leaf_51_clk clkbuf_3_2__f_clk/Z clkload16/I VDD VDD VSS VSS gf180mcu_fd_sc_mcu7t5v0__clkbuf_8
XFILLER_8_325 VDD VDD VSS VSS gf180mcu_fd_sc_mcu7t5v0__fillcap_4
Xwave_controller_y_inst__3358_ wave_controller_y_inst__3314_/B wave_controller_y_inst__3358_/A2
+ wave_controller_y_inst__3358_/A3 wave_controller_y_inst__3358_/Z VDD VDD VSS VSS
+ gf180mcu_fd_sc_mcu7t5v0__or3_1
XFILLER_166_871 VDD VDD VSS VSS gf180mcu_fd_sc_mcu7t5v0__fillcap_4
Xwave_controller_y_inst__2309_ wave_controller_y_inst__2280_/Z wave_controller_y_inst__2309_/A2
+ wave_controller_y_inst__2310_/I VDD VDD VSS VSS gf180mcu_fd_sc_mcu7t5v0__nand2_1
XFILLER_125_212 VDD VDD VSS VSS gf180mcu_fd_sc_mcu7t5v0__fillcap_4
Xwave_controller_y_inst__3289_ wave_controller_y_inst__3373_/A1 wave_controller_y_inst__3381_/A1
+ wave_controller_y_inst__3289_/B wave_controller_y_inst__3375_/A2 VDD VDD VSS VSS
+ gf180mcu_fd_sc_mcu7t5v0__oai21_1
XFILLER_153_532 VDD VDD VSS VSS gf180mcu_fd_sc_mcu7t5v0__fillcap_4
XFILLER_99_619 VDD VDD VSS VSS gf180mcu_fd_sc_mcu7t5v0__fillcap_8
XFILLER_107_982 VDD VDD VSS VSS gf180mcu_fd_sc_mcu7t5v0__fillcap_64
XFILLER_125_278 VDD VDD VSS VSS gf180mcu_fd_sc_mcu7t5v0__fill_2
XFILLER_98_107 VDD VDD VSS VSS gf180mcu_fd_sc_mcu7t5v0__fill_2
XFILLER_122_941 VDD VDD VSS VSS gf180mcu_fd_sc_mcu7t5v0__fillcap_4
XFILLER_79_310 VDD VDD VSS VSS gf180mcu_fd_sc_mcu7t5v0__fillcap_16
XFILLER_67_516 VDD VDD VSS VSS gf180mcu_fd_sc_mcu7t5v0__fill_2
XFILLER_79_376 VDD VDD VSS VSS gf180mcu_fd_sc_mcu7t5v0__fillcap_4
XFILLER_94_335 VDD VDD VSS VSS gf180mcu_fd_sc_mcu7t5v0__fill_1
XFILLER_95_847 VDD VDD VSS VSS gf180mcu_fd_sc_mcu7t5v0__fill_2
XFILLER_165_1116 VDD VDD VSS VSS gf180mcu_fd_sc_mcu7t5v0__fillcap_4
XFILLER_35_446 VDD VDD VSS VSS gf180mcu_fd_sc_mcu7t5v0__fillcap_16
XFILLER_78_1157 VDD VDD VSS VSS gf180mcu_fd_sc_mcu7t5v0__fillcap_16
XTAP_TAPCELL_ROW_19_1_472 VDD VSS gf180mcu_fd_sc_mcu7t5v0__filltie
XFILLER_63_788 VDD VDD VSS VSS gf180mcu_fd_sc_mcu7t5v0__fill_1
Xspi_regs_inst__1596_ spi_regs_inst__1596_/D fanout564/Z clkbuf_leaf_9_clk/Z spi_regs_inst__1596_/Q
+ VDD VDD VSS VSS gf180mcu_fd_sc_mcu7t5v0__dffrnq_1
Xclkbuf_leaf_42_clk clkbuf_leaf_9_clk/I clkload19/I VDD VDD VSS VSS gf180mcu_fd_sc_mcu7t5v0__clkbuf_8
XFILLER_87_2 VDD VDD VSS VSS gf180mcu_fd_sc_mcu7t5v0__fill_2
XFILLER_129_562 VDD VDD VSS VSS gf180mcu_fd_sc_mcu7t5v0__fillcap_8
XFILLER_148_359 VDD VDD VSS VSS gf180mcu_fd_sc_mcu7t5v0__fill_2
XFILLER_7_72 VDD VDD VSS VSS gf180mcu_fd_sc_mcu7t5v0__fillcap_64
XTAP_TAPCELL_ROW_96_1465 VDD VSS gf180mcu_fd_sc_mcu7t5v0__filltie
XTAP_TAPCELL_ROW_96_1454 VDD VSS gf180mcu_fd_sc_mcu7t5v0__filltie
XFILLER_140_771 VDD VDD VSS VSS gf180mcu_fd_sc_mcu7t5v0__fillcap_8
XFILLER_58_505 VDD VDD VSS VSS gf180mcu_fd_sc_mcu7t5v0__fillcap_4
XFILLER_100_624 VDD VDD VSS VSS gf180mcu_fd_sc_mcu7t5v0__fill_1
XFILLER_112_473 VDD VDD VSS VSS gf180mcu_fd_sc_mcu7t5v0__fillcap_4
XFILLER_140_793 VDD VDD VSS VSS gf180mcu_fd_sc_mcu7t5v0__fillcap_8
XFILLER_58_527 VDD VDD VSS VSS gf180mcu_fd_sc_mcu7t5v0__fillcap_8
Xwave_controller_x_inst__3693_ wave_controller_x_inst__3693_/D wave_controller_x_inst__3736_/RN
+ clkbuf_leaf_22_clk/Z wave_controller_x_inst__3693_/Q VDD VDD VSS VSS gf180mcu_fd_sc_mcu7t5v0__dffrnq_1
Xwave_controller_x_inst__2713_ wave_controller_x_inst__2713_/A1 wave_controller_x_inst__2713_/A2
+ wave_controller_x_inst__2713_/B wave_controller_x_inst__2739_/B2 VDD VDD VSS VSS
+ gf180mcu_fd_sc_mcu7t5v0__oai21_1
XFILLER_54_700 VDD VDD VSS VSS gf180mcu_fd_sc_mcu7t5v0__fill_2
Xwave_controller_y_inst__2660_ wave_controller_y_inst__1819_/I wave_controller_y_inst__3536_/B2
+ wave_controller_y_inst__2660_/A3 wave_controller_y_inst__2661_/I VDD VDD VSS VSS
+ gf180mcu_fd_sc_mcu7t5v0__xor3_1
Xwave_controller_x_inst__2644_ wave_controller_x_inst__2642_/Z wave_controller_x_inst__2679_/A2
+ wave_controller_x_inst__2680_/A1 VDD VDD VSS VSS gf180mcu_fd_sc_mcu7t5v0__nand2_1
XFILLER_26_37 VDD VDD VSS VSS gf180mcu_fd_sc_mcu7t5v0__fillcap_32
XFILLER_81_530 VDD VDD VSS VSS gf180mcu_fd_sc_mcu7t5v0__fill_1
XFILLER_26_457 VDD VDD VSS VSS gf180mcu_fd_sc_mcu7t5v0__fillcap_32
Xwave_controller_y_inst__2591_ wave_controller_y_inst__2591_/A1 wave_controller_y_inst__2591_/A2
+ wave_controller_y_inst__2590_/B wave_controller_y_inst__2591_/Z VDD VDD VSS VSS
+ gf180mcu_fd_sc_mcu7t5v0__and3_1
Xwave_controller_x_inst__2575_ wave_controller_x_inst__2572_/Z wave_controller_x_inst__2575_/A2
+ wave_controller_x_inst__2576_/I VDD VDD VSS VSS gf180mcu_fd_sc_mcu7t5v0__xnor2_1
XFILLER_41_438 VDD VDD VSS VSS gf180mcu_fd_sc_mcu7t5v0__fill_1
XFILLER_53_287 VDD VDD VSS VSS gf180mcu_fd_sc_mcu7t5v0__fillcap_8
XTAP_TAPCELL_ROW_140_2186 VDD VSS gf180mcu_fd_sc_mcu7t5v0__filltie
Xclkbuf_leaf_33_clk clkload0/I clkload36/I VDD VDD VSS VSS gf180mcu_fd_sc_mcu7t5v0__clkbuf_8
XFILLER_166_101 VDD VDD VSS VSS gf180mcu_fd_sc_mcu7t5v0__fillcap_4
Xwave_controller_y_inst__3212_ wave_controller_y_inst__3151_/Z wave_controller_y_inst__3239_/A3
+ wave_controller_y_inst__3212_/B wave_controller_y_inst__3240_/B VDD VDD VSS VSS
+ gf180mcu_fd_sc_mcu7t5v0__oai21_1
XFILLER_148_871 VDD VDD VSS VSS gf180mcu_fd_sc_mcu7t5v0__fillcap_4
XFILLER_21_195 VDD VDD VSS VSS gf180mcu_fd_sc_mcu7t5v0__fillcap_4
Xwave_controller_y_inst__3143_ wave_controller_y_inst__3705_/Q wave_controller_y_inst__3143_/A2
+ wave_controller_y_inst__3146_/B VDD VDD VSS VSS gf180mcu_fd_sc_mcu7t5v0__nand2_1
XFILLER_107_212 VDD VDD VSS VSS gf180mcu_fd_sc_mcu7t5v0__fillcap_16
Xwave_controller_x_inst__3127_ wave_controller_x_inst__3562_/A1 spi_regs_inst__1522_/Q
+ wave_controller_x_inst__3128_/I VDD VDD VSS VSS gf180mcu_fd_sc_mcu7t5v0__nand2_1
XFILLER_147_392 VDD VDD VSS VSS gf180mcu_fd_sc_mcu7t5v0__fillcap_16
XFILLER_162_340 VDD VDD VSS VSS gf180mcu_fd_sc_mcu7t5v0__fillcap_4
Xwave_controller_y_inst__3074_ wave_controller_y_inst__2762_/I wave_controller_y_inst__2989_/B
+ wave_controller_y_inst__3073_/Z wave_controller_y_inst__3090_/B1 wave_controller_y_inst__3266_/A1
+ wave_controller_y_inst__3713_/D VDD VDD VSS VSS gf180mcu_fd_sc_mcu7t5v0__oai32_1
Xwave_controller_x_inst__3058_ wave_controller_x_inst__3708_/Q wave_controller_x_inst__3238_/A1
+ wave_controller_x_inst__3058_/A3 wave_controller_x_inst__3058_/Z VDD VDD VSS VSS
+ gf180mcu_fd_sc_mcu7t5v0__xor3_1
XFILLER_107_278 VDD VDD VSS VSS gf180mcu_fd_sc_mcu7t5v0__fill_2
Xwave_controller_y_inst__2025_ spi_regs_inst__1169_/A1 wave_controller_y_inst_wire31/Z
+ spi_regs_inst__1132_/A1 VDD VDD VSS VSS gf180mcu_fd_sc_mcu7t5v0__xor2_1
Xwave_controller_x_inst__2009_ wave_controller_x_inst__2009_/A1 wave_controller_x_inst__2000_/Z
+ wave_controller_x_inst__2009_/A3 wave_controller_x_inst__2009_/B wave_controller_x_inst_wire87/I
+ VDD VDD VSS VSS gf180mcu_fd_sc_mcu7t5v0__oai31_1
XFILLER_104_941 VDD VDD VSS VSS gf180mcu_fd_sc_mcu7t5v0__fillcap_4
XFILLER_107_40 VDD VDD VSS VSS gf180mcu_fd_sc_mcu7t5v0__fillcap_8
XFILLER_162_384 VDD VDD VSS VSS gf180mcu_fd_sc_mcu7t5v0__fill_1
XPHY_EDGE_ROW_55_Left_222 VDD VSS gf180mcu_fd_sc_mcu7t5v0__endcap
XFILLER_118_1151 VDD VDD VSS VSS gf180mcu_fd_sc_mcu7t5v0__fillcap_4
XFILLER_49_505 VDD VDD VSS VSS gf180mcu_fd_sc_mcu7t5v0__fillcap_4
XTAP_TAPCELL_ROW_147_2307 VDD VSS gf180mcu_fd_sc_mcu7t5v0__filltie
XFILLER_118_1173 VDD VDD VSS VSS gf180mcu_fd_sc_mcu7t5v0__fill_1
XFILLER_76_313 VDD VDD VSS VSS gf180mcu_fd_sc_mcu7t5v0__fill_2
Xwave_controller_y_inst__2927_ wave_controller_y_inst__3590_/I0 spi_regs_inst__1169_/A1
+ wave_controller_y_inst__2929_/S wave_controller_y_inst__3688_/D VDD VDD VSS VSS
+ gf180mcu_fd_sc_mcu7t5v0__mux2_2
XTAP_TAPCELL_ROW_160_2518 VDD VSS gf180mcu_fd_sc_mcu7t5v0__filltie
Xwave_controller_y_inst__2858_ wave_controller_y_inst__3479_/A1 spi_regs_inst__1310_/A1
+ wave_controller_y_inst__2883_/A3 VDD VDD VSS VSS gf180mcu_fd_sc_mcu7t5v0__nand2_1
XFILLER_123_72 VDD VDD VSS VSS gf180mcu_fd_sc_mcu7t5v0__fillcap_32
XTAP_TAPCELL_ROW_125_1937 VDD VSS gf180mcu_fd_sc_mcu7t5v0__filltie
Xwave_controller_y_inst__1809_ spi_regs_inst__1610_/Q wave_controller_y_inst__3311_/A2
+ VDD VDD VSS VSS gf180mcu_fd_sc_mcu7t5v0__clkinv_1
XFILLER_17_479 VDD VDD VSS VSS gf180mcu_fd_sc_mcu7t5v0__fill_1
XPHY_EDGE_ROW_64_Left_231 VDD VSS gf180mcu_fd_sc_mcu7t5v0__endcap
Xwave_controller_y_inst__2789_ wave_controller_y_inst__2789_/A1 wave_controller_y_inst__2805_/S
+ wave_controller_y_inst__2789_/B wave_controller_y_inst__2790_/I VDD VDD VSS VSS
+ gf180mcu_fd_sc_mcu7t5v0__oai21_1
Xwave_controller_x_inst_max_cap58 wave_controller_x_inst__3489_/B1 wave_controller_x_inst__3494_/A2
+ VDD VDD VSS VSS gf180mcu_fd_sc_mcu7t5v0__buf_2
XFILLER_32_438 VDD VDD VSS VSS gf180mcu_fd_sc_mcu7t5v0__fillcap_16
XFILLER_44_298 VDD VDD VSS VSS gf180mcu_fd_sc_mcu7t5v0__fill_2
XTAP_TAPCELL_ROW_55_783 VDD VSS gf180mcu_fd_sc_mcu7t5v0__filltie
XTAP_TAPCELL_ROW_80_1200 VDD VSS gf180mcu_fd_sc_mcu7t5v0__filltie
XFILLER_125_1122 VDD VDD VSS VSS gf180mcu_fd_sc_mcu7t5v0__fillcap_32
Xspi_regs_inst__1450_ spi_regs_inst__1518_/Q spi_regs_inst_wire480/I spi_regs_inst__1451_/S
+ spi_regs_inst__1518_/D VDD VDD VSS VSS gf180mcu_fd_sc_mcu7t5v0__mux2_2
Xclkbuf_leaf_24_clk clkbuf_3_5__f_clk/Z clkload28/I VDD VDD VSS VSS gf180mcu_fd_sc_mcu7t5v0__clkbuf_8
Xspi_regs_inst__1381_ spi_regs_inst__1638_/Q spi_regs_inst__1451_/I1 spi_regs_inst__1384_/S
+ spi_regs_inst__1661_/D VDD VDD VSS VSS gf180mcu_fd_sc_mcu7t5v0__mux2_2
XFILLER_12_173 VDD VDD VSS VSS gf180mcu_fd_sc_mcu7t5v0__fill_2
XFILLER_139_893 VDD VDD VSS VSS gf180mcu_fd_sc_mcu7t5v0__fillcap_16
XFILLER_8_177 VDD VDD VSS VSS gf180mcu_fd_sc_mcu7t5v0__fillcap_64
XTAP_TAPCELL_ROW_78_1162 VDD VSS gf180mcu_fd_sc_mcu7t5v0__filltie
XFILLER_126_565 VDD VDD VSS VSS gf180mcu_fd_sc_mcu7t5v0__fillcap_16
XFILLER_59_6 VDD VDD VSS VSS gf180mcu_fd_sc_mcu7t5v0__fillcap_8
XPHY_EDGE_ROW_73_Left_240 VDD VSS gf180mcu_fd_sc_mcu7t5v0__endcap
XFILLER_99_449 VDD VDD VSS VSS gf180mcu_fd_sc_mcu7t5v0__fillcap_4
XFILLER_80_1003 VDD VDD VSS VSS gf180mcu_fd_sc_mcu7t5v0__fillcap_8
XTAP_TAPCELL_ROW_91_1373 VDD VSS gf180mcu_fd_sc_mcu7t5v0__filltie
XFILLER_68_825 VDD VDD VSS VSS gf180mcu_fd_sc_mcu7t5v0__fill_1
XFILLER_95_611 VDD VDD VSS VSS gf180mcu_fd_sc_mcu7t5v0__fill_2
XFILLER_95_622 VDD VDD VSS VSS gf180mcu_fd_sc_mcu7t5v0__fillcap_8
XTAP_TAPCELL_ROW_91_1384 VDD VSS gf180mcu_fd_sc_mcu7t5v0__filltie
Xsignal_processor_y_inst__193_ signal_processor_y_inst__171_/Z signal_processor_y_inst__193_/A2
+ signal_processor_y_inst__238_/Q signal_processor_y_inst__193_/C signal_processor_y_inst__195_/A2
+ VDD VDD VSS VSS gf180mcu_fd_sc_mcu7t5v0__oai211_1
XFILLER_67_346 VDD VDD VSS VSS gf180mcu_fd_sc_mcu7t5v0__fillcap_4
XFILLER_68_869 VDD VDD VSS VSS gf180mcu_fd_sc_mcu7t5v0__fillcap_4
XFILLER_82_349 VDD VDD VSS VSS gf180mcu_fd_sc_mcu7t5v0__fill_1
XFILLER_94_187 VDD VDD VSS VSS gf180mcu_fd_sc_mcu7t5v0__fill_2
XFILLER_94_198 VDD VDD VSS VSS gf180mcu_fd_sc_mcu7t5v0__fill_1
XFILLER_23_438 VDD VDD VSS VSS gf180mcu_fd_sc_mcu7t5v0__fillcap_8
Xwave_controller_x_inst__2360_ wave_controller_x_inst__2375_/B wave_controller_x_inst__2359_/I
+ wave_controller_x_inst__2373_/A2 VDD VDD VSS VSS gf180mcu_fd_sc_mcu7t5v0__nand2_1
XFILLER_91_1154 VDD VDD VSS VSS gf180mcu_fd_sc_mcu7t5v0__fillcap_16
Xspi_regs_inst__1648_ spi_regs_inst__1648_/D spi_regs_inst__1648_/RN clkload18/I spi_regs_inst__1648_/Q
+ VDD VDD VSS VSS gf180mcu_fd_sc_mcu7t5v0__dffrnq_1
Xclkbuf_leaf_15_clk clkbuf_leaf_8_clk/I clkload10/I VDD VDD VSS VSS gf180mcu_fd_sc_mcu7t5v0__clkbuf_8
XFILLER_50_279 VDD VDD VSS VSS gf180mcu_fd_sc_mcu7t5v0__fill_1
Xwave_controller_x_inst__2291_ fanout521/Z wave_controller_x_inst__2292_/A3 wave_controller_x_inst__2305_/A2
+ VDD VDD VSS VSS gf180mcu_fd_sc_mcu7t5v0__nand2_1
Xspi_regs_inst__1579_ spi_regs_inst__1579_/D fanout563/Z clkload9/I spi_regs_inst__1579_/Q
+ VDD VDD VSS VSS gf180mcu_fd_sc_mcu7t5v0__dffrnq_1
XTAP_TAPCELL_ROW_24_1_513 VDD VSS gf180mcu_fd_sc_mcu7t5v0__filltie
XFILLER_144_362 VDD VDD VSS VSS gf180mcu_fd_sc_mcu7t5v0__fill_1
XFILLER_132_524 VDD VDD VSS VSS gf180mcu_fd_sc_mcu7t5v0__fill_1
XTAP_TAPCELL_ROW_32_1_570 VDD VSS gf180mcu_fd_sc_mcu7t5v0__filltie
XFILLER_101_900 VDD VDD VSS VSS gf180mcu_fd_sc_mcu7t5v0__fillcap_8
XFILLER_104_259 VDD VDD VSS VSS gf180mcu_fd_sc_mcu7t5v0__fill_2
XFILLER_160_877 VDD VDD VSS VSS gf180mcu_fd_sc_mcu7t5v0__fillcap_64
XTAP_TAPCELL_ROW_129_2004 VDD VSS gf180mcu_fd_sc_mcu7t5v0__filltie
XFILLER_112_281 VDD VDD VSS VSS gf180mcu_fd_sc_mcu7t5v0__fill_2
XFILLER_37_36 VDD VDD VSS VSS gf180mcu_fd_sc_mcu7t5v0__fill_1
XTAP_TAPCELL_ROW_142_2215 VDD VSS gf180mcu_fd_sc_mcu7t5v0__filltie
XTAP_TAPCELL_ROW_142_2226 VDD VSS gf180mcu_fd_sc_mcu7t5v0__filltie
Xwave_controller_y_inst__2712_ wave_controller_y_inst__2712_/A1 wave_controller_y_inst__2712_/A2
+ wave_controller_y_inst__2712_/B wave_controller_y_inst__2712_/C wave_controller_y_inst__2713_/B
+ VDD VDD VSS VSS gf180mcu_fd_sc_mcu7t5v0__aoi211_1
XFILLER_160_37 VDD VDD VSS VSS gf180mcu_fd_sc_mcu7t5v0__fillcap_64
XFILLER_37_69 VDD VDD VSS VSS gf180mcu_fd_sc_mcu7t5v0__fill_1
XFILLER_73_349 VDD VDD VSS VSS gf180mcu_fd_sc_mcu7t5v0__fill_1
Xwave_controller_y_inst__3692_ wave_controller_y_inst__3692_/D wave_controller_y_inst__3695_/RN
+ clkload16/I wave_controller_y_inst__3692_/Q VDD VDD VSS VSS gf180mcu_fd_sc_mcu7t5v0__dffrnq_1
Xwave_controller_x_inst__3676_ wave_controller_x_inst__3676_/D fanout619/Z clkload32/I
+ spi_regs_inst__1320_/B2 VDD VDD VSS VSS gf180mcu_fd_sc_mcu7t5v0__dffrnq_1
XFILLER_26_243 VDD VDD VSS VSS gf180mcu_fd_sc_mcu7t5v0__fill_2
XTAP_TAPCELL_ROW_107_1645 VDD VSS gf180mcu_fd_sc_mcu7t5v0__filltie
Xwave_controller_y_inst__2643_ wave_controller_y_inst__3530_/B2 wave_controller_y_inst__2623_/Z
+ wave_controller_y_inst__2643_/B wave_controller_y_inst__2679_/A2 VDD VDD VSS VSS
+ gf180mcu_fd_sc_mcu7t5v0__oai21_1
Xwave_controller_x_inst__2627_ wave_controller_x_inst__2627_/A1 wave_controller_x_inst__2600_/Z
+ wave_controller_x_inst__2626_/B wave_controller_x_inst__2627_/Z VDD VDD VSS VSS
+ gf180mcu_fd_sc_mcu7t5v0__or3_1
XFILLER_26_287 VDD VDD VSS VSS gf180mcu_fd_sc_mcu7t5v0__fill_1
XFILLER_96_1087 VDD VDD VSS VSS gf180mcu_fd_sc_mcu7t5v0__fillcap_64
Xwave_controller_y_inst__2574_ wave_controller_y_inst__2572_/Z wave_controller_y_inst__2575_/A2
+ wave_controller_y_inst__2608_/A1 VDD VDD VSS VSS gf180mcu_fd_sc_mcu7t5v0__nand2_1
XFILLER_53_79 VDD VDD VSS VSS gf180mcu_fd_sc_mcu7t5v0__fillcap_8
Xwave_controller_x_inst__2558_ fanout524/Z wave_controller_x_inst__2550_/Z wave_controller_x_inst_wire169/Z
+ wave_controller_x_inst__2558_/Z VDD VDD VSS VSS gf180mcu_fd_sc_mcu7t5v0__xor3_1
XFILLER_167_410 VDD VDD VSS VSS gf180mcu_fd_sc_mcu7t5v0__fillcap_32
XTAP_TAPCELL_ROW_120_1856 VDD VSS gf180mcu_fd_sc_mcu7t5v0__filltie
Xwave_controller_x_inst__2489_ wave_controller_x_inst__2490_/A1 wave_controller_x_inst__2490_/A2
+ wave_controller_x_inst__2489_/Z VDD VDD VSS VSS gf180mcu_fd_sc_mcu7t5v0__and2_1
XFILLER_22_493 VDD VDD VSS VSS gf180mcu_fd_sc_mcu7t5v0__fill_1
XFILLER_5_136 VDD VDD VSS VSS gf180mcu_fd_sc_mcu7t5v0__fillcap_4
Xwave_controller_y_inst__3126_ wave_controller_y_inst__3126_/I wave_controller_y_inst__3146_/A1
+ VDD VDD VSS VSS gf180mcu_fd_sc_mcu7t5v0__clkinv_1
XFILLER_136_863 VDD VDD VSS VSS gf180mcu_fd_sc_mcu7t5v0__fillcap_4
XTAP_TAPCELL_ROW_153_2399 VDD VSS gf180mcu_fd_sc_mcu7t5v0__filltie
Xwave_controller_y_inst__3057_ wave_controller_y_inst__3570_/A1 wave_controller_y_inst__3059_/A2
+ wave_controller_y_inst__3057_/B1 wave_controller_y_inst__3057_/B2 wave_controller_y_inst__3707_/D
+ VDD VDD VSS VSS gf180mcu_fd_sc_mcu7t5v0__oai22_1
XFILLER_135_395 VDD VDD VSS VSS gf180mcu_fd_sc_mcu7t5v0__fillcap_16
XFILLER_150_332 VDD VDD VSS VSS gf180mcu_fd_sc_mcu7t5v0__fillcap_8
Xwave_controller_y_inst__2008_ spi_regs_inst__1482_/Q spi_regs_inst__1318_/C2 wave_controller_y_inst__2008_/Z
+ VDD VDD VSS VSS gf180mcu_fd_sc_mcu7t5v0__xor2_1
XFILLER_123_557 VDD VDD VSS VSS gf180mcu_fd_sc_mcu7t5v0__fill_2
Xwave_controller_x_inst_wire121 wave_controller_x_inst_wire121/I wave_controller_x_inst_wire121/Z
+ VDD VDD VSS VSS gf180mcu_fd_sc_mcu7t5v0__clkbuf_1
XFILLER_110_218 VDD VDD VSS VSS gf180mcu_fd_sc_mcu7t5v0__fillcap_4
XFILLER_150_387 VDD VDD VSS VSS gf180mcu_fd_sc_mcu7t5v0__fillcap_16
XTAP_TAPCELL_ROW_73_1081 VDD VSS gf180mcu_fd_sc_mcu7t5v0__filltie
XFILLER_65_806 VDD VDD VSS VSS gf180mcu_fd_sc_mcu7t5v0__fill_1
Xspi_regs_inst__0950_ spi_regs_inst__1374_/A1 spi_regs_inst__1632_/Q spi_regs_inst__1376_/A1
+ spi_regs_inst__1031_/A1 VDD VDD VSS VSS gf180mcu_fd_sc_mcu7t5v0__nand3_1
XFILLER_134_93 VDD VDD VSS VSS gf180mcu_fd_sc_mcu7t5v0__fillcap_4
Xspi_regs_inst__0881_ spi_regs_inst__1615_/Q spi_regs_inst__1377_/I1 spi_regs_inst__0884_/S
+ spi_regs_inst__1615_/D VDD VDD VSS VSS gf180mcu_fd_sc_mcu7t5v0__mux2_2
XFILLER_131_1170 VDD VDD VSS VSS gf180mcu_fd_sc_mcu7t5v0__fillcap_4
XFILLER_64_338 VDD VDD VSS VSS gf180mcu_fd_sc_mcu7t5v0__fillcap_16
XFILLER_75_1116 VDD VDD VSS VSS gf180mcu_fd_sc_mcu7t5v0__fillcap_4
XTAP_TAPCELL_ROW_41_1_638 VDD VSS gf180mcu_fd_sc_mcu7t5v0__filltie
XFILLER_150_92 VDD VDD VSS VSS gf180mcu_fd_sc_mcu7t5v0__fill_1
XFILLER_17_276 VDD VDD VSS VSS gf180mcu_fd_sc_mcu7t5v0__fillcap_4
XFILLER_17_287 VDD VDD VSS VSS gf180mcu_fd_sc_mcu7t5v0__fillcap_8
XFILLER_32_202 VDD VDD VSS VSS gf180mcu_fd_sc_mcu7t5v0__fill_2
XFILLER_32_224 VDD VDD VSS VSS gf180mcu_fd_sc_mcu7t5v0__fill_1
Xspi_regs_inst__1502_ spi_regs_inst__1502_/D spi_regs_inst__1551_/RN clkload33/I spi_regs_inst__1502_/Q
+ VDD VDD VSS VSS gf180mcu_fd_sc_mcu7t5v0__dffrnq_1
XFILLER_60_599 VDD VDD VSS VSS gf180mcu_fd_sc_mcu7t5v0__fill_1
Xspi_regs_inst__1433_ spi_regs_inst__1503_/Q spi_regs_inst_wire476/Z spi_regs_inst__1436_/S
+ spi_regs_inst__1503_/D VDD VDD VSS VSS gf180mcu_fd_sc_mcu7t5v0__mux2_2
XFILLER_146_605 VDD VDD VSS VSS gf180mcu_fd_sc_mcu7t5v0__fillcap_4
XFILLER_118_329 VDD VDD VSS VSS gf180mcu_fd_sc_mcu7t5v0__fillcap_16
XFILLER_145_104 VDD VDD VSS VSS gf180mcu_fd_sc_mcu7t5v0__fillcap_4
Xspi_regs_inst__1364_ spi_regs_inst__1364_/A1 spi_regs_inst__1384_/S spi_regs_inst__1364_/B
+ spi_regs_inst__1650_/D VDD VDD VSS VSS gf180mcu_fd_sc_mcu7t5v0__oai21_1
XFILLER_145_148 VDD VDD VSS VSS gf180mcu_fd_sc_mcu7t5v0__fill_1
Xspi_regs_inst__1295_ spi_regs_inst__1295_/A1 spi_regs_inst__1295_/A2 spi_regs_inst__1295_/A3
+ spi_regs_inst__1295_/A4 spi_regs_inst__1296_/A4 VDD VDD VSS VSS gf180mcu_fd_sc_mcu7t5v0__nor4_1
XFILLER_160_107 VDD VDD VSS VSS gf180mcu_fd_sc_mcu7t5v0__fillcap_64
XTAP_TAPCELL_ROW_93_1413 VDD VSS gf180mcu_fd_sc_mcu7t5v0__filltie
XFILLER_126_384 VDD VDD VSS VSS gf180mcu_fd_sc_mcu7t5v0__fill_1
XFILLER_142_877 VDD VDD VSS VSS gf180mcu_fd_sc_mcu7t5v0__fillcap_64
XFILLER_141_376 VDD VDD VSS VSS gf180mcu_fd_sc_mcu7t5v0__fillcap_8
Xwave_controller_x_inst__1860_ max_cap455/I wave_controller_x_inst__2616_/C VDD VDD
+ VSS VSS gf180mcu_fd_sc_mcu7t5v0__clkinv_1
Xsignal_processor_y_inst__245_ signal_processor_y_inst__245_/D signal_processor_y_inst__253_/RN
+ clkbuf_leaf_0_clk/Z signal_processor_y_inst__245_/Q VDD VDD VSS VSS gf180mcu_fd_sc_mcu7t5v0__dffrnq_1
Xclkbuf_leaf_4_clk clkbuf_leaf_8_clk/I clkload7/I VDD VDD VSS VSS gf180mcu_fd_sc_mcu7t5v0__clkbuf_8
XFILLER_136_1081 VDD VDD VSS VSS gf180mcu_fd_sc_mcu7t5v0__fillcap_4
XPHY_EDGE_ROW_155_Right_155 VDD VSS gf180mcu_fd_sc_mcu7t5v0__endcap
Xsignal_processor_y_inst__176_ signal_processor_y_inst__187_/A1 signal_processor_y_inst__175_/Z
+ signal_processor_y_inst__236_/D VDD VDD VSS VSS gf180mcu_fd_sc_mcu7t5v0__nor2_1
XFILLER_67_165 VDD VDD VSS VSS gf180mcu_fd_sc_mcu7t5v0__fillcap_8
XFILLER_68_699 VDD VDD VSS VSS gf180mcu_fd_sc_mcu7t5v0__fillcap_4
XFILLER_83_614 VDD VDD VSS VSS gf180mcu_fd_sc_mcu7t5v0__fill_1
Xwave_controller_x_inst__1791_ wave_controller_x_inst__3709_/Q wave_controller_x_inst__3305_/B2
+ VDD VDD VSS VSS gf180mcu_fd_sc_mcu7t5v0__clkinv_1
XFILLER_82_124 VDD VDD VSS VSS gf180mcu_fd_sc_mcu7t5v0__fill_1
XFILLER_83_658 VDD VDD VSS VSS gf180mcu_fd_sc_mcu7t5v0__fill_1
Xwave_controller_x_inst__3530_ wave_controller_x_inst__3530_/A1 wave_controller_x_inst__3530_/A2
+ wave_controller_x_inst__3530_/A3 wave_controller_x_inst__3530_/B1 wave_controller_x_inst__3530_/B2
+ wave_controller_x_inst__3639_/D VDD VDD VSS VSS gf180mcu_fd_sc_mcu7t5v0__oai32_1
XFILLER_167_1019 VDD VDD VSS VSS gf180mcu_fd_sc_mcu7t5v0__fill_1
Xwave_controller_x_inst__3461_ wave_controller_x_inst__3700_/Q wave_controller_x_inst__3461_/A2
+ wave_controller_x_inst__3461_/Z VDD VDD VSS VSS gf180mcu_fd_sc_mcu7t5v0__and2_1
XFILLER_63_382 VDD VDD VSS VSS gf180mcu_fd_sc_mcu7t5v0__fill_2
XTAP_TAPCELL_ROW_35_1_596 VDD VSS gf180mcu_fd_sc_mcu7t5v0__filltie
Xwave_controller_x_inst__2412_ wave_controller_x_inst__2379_/Z wave_controller_x_inst__2412_/A2
+ wave_controller_x_inst__2412_/B wave_controller_x_inst__2412_/C wave_controller_x_inst__2425_/A3
+ VDD VDD VSS VSS gf180mcu_fd_sc_mcu7t5v0__aoi211_1
Xwave_controller_x_inst__3392_ fanout537/Z wave_controller_x_inst__3360_/Z wave_controller_x_inst__3392_/B1
+ wave_controller_x_inst__3392_/B2 wave_controller_x_inst__3392_/C wave_controller_x_inst__3395_/A1
+ VDD VDD VSS VSS gf180mcu_fd_sc_mcu7t5v0__oai221_1
XTAP_TAPCELL_ROW_102_1553 VDD VSS gf180mcu_fd_sc_mcu7t5v0__filltie
XTAP_TAPCELL_ROW_102_1564 VDD VSS gf180mcu_fd_sc_mcu7t5v0__filltie
Xwave_controller_x_inst__2343_ wave_controller_x_inst__2343_/A1 wave_controller_x_inst__2345_/C
+ wave_controller_x_inst__2328_/Z wave_controller_x_inst__2345_/A2 VDD VDD VSS VSS
+ gf180mcu_fd_sc_mcu7t5v0__nand3_1
XFILLER_143_1052 VDD VDD VSS VSS gf180mcu_fd_sc_mcu7t5v0__fillcap_64
Xwave_controller_y_inst__2290_ wave_controller_y_inst__1823_/I wave_controller_y_inst__2292_/A3
+ wave_controller_y_inst__2305_/B VDD VDD VSS VSS gf180mcu_fd_sc_mcu7t5v0__nor2_1
Xwave_controller_x_inst__2274_ wave_controller_x_inst__2952_/A2 wave_controller_x_inst__2274_/A2
+ wave_controller_x_inst__2294_/A1 VDD VDD VSS VSS gf180mcu_fd_sc_mcu7t5v0__nand2_1
XFILLER_164_402 VDD VDD VSS VSS gf180mcu_fd_sc_mcu7t5v0__fill_2
XFILLER_118_830 VDD VDD VSS VSS gf180mcu_fd_sc_mcu7t5v0__fill_1
XFILLER_118_841 VDD VDD VSS VSS gf180mcu_fd_sc_mcu7t5v0__fillcap_4
XFILLER_164_457 VDD VDD VSS VSS gf180mcu_fd_sc_mcu7t5v0__fill_2
XFILLER_117_384 VDD VDD VSS VSS gf180mcu_fd_sc_mcu7t5v0__fillcap_4
Xwave_controller_y_inst_fanout515 fanout516/I wave_controller_y_inst__1819_/I VDD
+ VDD VSS VSS gf180mcu_fd_sc_mcu7t5v0__dlyb_1
Xwave_controller_y_inst_fanout548 fanout570/Z wave_controller_y_inst__3618_/RN VDD
+ VDD VSS VSS gf180mcu_fd_sc_mcu7t5v0__dlyb_1
XFILLER_132_387 VDD VDD VSS VSS gf180mcu_fd_sc_mcu7t5v0__fillcap_8
XPHY_EDGE_ROW_37_1_Right_36 VDD VSS gf180mcu_fd_sc_mcu7t5v0__endcap
XFILLER_113_590 VDD VDD VSS VSS gf180mcu_fd_sc_mcu7t5v0__fillcap_4
XFILLER_100_251 VDD VDD VSS VSS gf180mcu_fd_sc_mcu7t5v0__fill_1
XFILLER_115_1154 VDD VDD VSS VSS gf180mcu_fd_sc_mcu7t5v0__fillcap_16
XFILLER_59_699 VDD VDD VSS VSS gf180mcu_fd_sc_mcu7t5v0__fill_1
XPHY_EDGE_ROW_122_Right_122 VDD VSS gf180mcu_fd_sc_mcu7t5v0__endcap
XTAP_TAPCELL_ROW_57_812 VDD VSS gf180mcu_fd_sc_mcu7t5v0__filltie
Xwave_controller_x_inst__1989_ fanout542/Z wave_controller_x_inst__2284_/A1 wave_controller_x_inst__1991_/A1
+ VDD VDD VSS VSS gf180mcu_fd_sc_mcu7t5v0__nand2_1
Xfanout498 fanout499/Z fanout498/Z VDD VDD VSS VSS gf180mcu_fd_sc_mcu7t5v0__dlyb_1
XFILLER_101_796 VDD VDD VSS VSS gf180mcu_fd_sc_mcu7t5v0__fill_2
XFILLER_86_485 VDD VDD VSS VSS gf180mcu_fd_sc_mcu7t5v0__fillcap_8
XTAP_TAPCELL_ROW_57_823 VDD VSS gf180mcu_fd_sc_mcu7t5v0__filltie
Xwave_controller_x_inst__3728_ wave_controller_x_inst__3728_/D wave_controller_x_inst__3735_/RN
+ clkload26/I wave_controller_x_inst__3728_/Q VDD VDD VSS VSS gf180mcu_fd_sc_mcu7t5v0__dffrnq_1
XFILLER_64_34 VDD VDD VSS VSS gf180mcu_fd_sc_mcu7t5v0__fill_1
XFILLER_73_157 VDD VDD VSS VSS gf180mcu_fd_sc_mcu7t5v0__fillcap_4
Xwave_controller_y_inst__3675_ wave_controller_y_inst__3675_/D wave_controller_y_inst__3703_/RN
+ clkload20/I spi_regs_inst__1281_/A1 VDD VDD VSS VSS gf180mcu_fd_sc_mcu7t5v0__dffrnq_1
Xspi_regs_inst_max_cap303 spi_regs_inst__0879_/S spi_regs_inst__0877_/S VDD VDD VSS
+ VSS gf180mcu_fd_sc_mcu7t5v0__buf_2
Xwave_controller_y_inst__2626_ wave_controller_y_inst__2627_/A1 wave_controller_y_inst__2600_/Z
+ wave_controller_y_inst__2626_/B wave_controller_y_inst__2634_/C VDD VDD VSS VSS
+ gf180mcu_fd_sc_mcu7t5v0__oai21_1
Xwave_controller_x_inst__3659_ wave_controller_x_inst__3659_/D wave_controller_x_inst__3682_/RN
+ clkload34/I max_cap455/I VDD VDD VSS VSS gf180mcu_fd_sc_mcu7t5v0__dffrnq_1
XFILLER_154_2 VDD VDD VSS VSS gf180mcu_fd_sc_mcu7t5v0__fillcap_16
Xwave_controller_y_inst__2557_ wave_controller_y_inst__2550_/Z wave_controller_y_inst_wire151/Z
+ wave_controller_y_inst__2557_/Z VDD VDD VSS VSS gf180mcu_fd_sc_mcu7t5v0__xor2_1
XFILLER_167_240 VDD VDD VSS VSS gf180mcu_fd_sc_mcu7t5v0__fillcap_4
XTAP_TAPCELL_ROW_155_2428 VDD VSS gf180mcu_fd_sc_mcu7t5v0__filltie
XTAP_TAPCELL_ROW_155_2439 VDD VSS gf180mcu_fd_sc_mcu7t5v0__filltie
Xwave_controller_y_inst__2488_ spi_regs_inst__1247_/A1 wave_controller_y_inst__3509_/B2
+ wave_controller_y_inst__2488_/Z VDD VDD VSS VSS gf180mcu_fd_sc_mcu7t5v0__xor2_1
Xsignal_processor_x_inst__196_ signal_processor_x_inst__202_/A1 signal_processor_x_inst__196_/A2
+ signal_processor_x_inst__200_/A2 signal_processor_x_inst__196_/B1 signal_processor_x_inst__215_/A1
+ signal_processor_x_inst__216_/D VDD VDD VSS VSS gf180mcu_fd_sc_mcu7t5v0__oai32_1
XFILLER_10_430 VDD VDD VSS VSS gf180mcu_fd_sc_mcu7t5v0__fillcap_16
XFILLER_127_104 VDD VDD VSS VSS gf180mcu_fd_sc_mcu7t5v0__fill_2
XFILLER_156_947 VDD VDD VSS VSS gf180mcu_fd_sc_mcu7t5v0__fillcap_64
XFILLER_80_99 VDD VDD VSS VSS gf180mcu_fd_sc_mcu7t5v0__fill_1
XFILLER_13_82 VDD VDD VSS VSS gf180mcu_fd_sc_mcu7t5v0__fill_1
XFILLER_108_340 VDD VDD VSS VSS gf180mcu_fd_sc_mcu7t5v0__fill_1
XFILLER_109_863 VDD VDD VSS VSS gf180mcu_fd_sc_mcu7t5v0__fillcap_32
XFILLER_124_811 VDD VDD VSS VSS gf180mcu_fd_sc_mcu7t5v0__fill_1
XTAP_TAPCELL_ROW_75_1110 VDD VSS gf180mcu_fd_sc_mcu7t5v0__filltie
Xwave_controller_y_inst__3109_ wave_controller_y_inst__3265_/A1 spi_regs_inst__1596_/Q
+ wave_controller_y_inst__3109_/Z VDD VDD VSS VSS gf180mcu_fd_sc_mcu7t5v0__and2_1
Xspi_regs_inst__1080_ spi_regs_inst__1500_/Q spi_regs_inst_wire277/Z spi_regs_inst__1241_/B1
+ spi_regs_inst__1080_/B2 spi_regs_inst__1114_/A1 VDD VDD VSS VSS gf180mcu_fd_sc_mcu7t5v0__aoi22_1
XFILLER_108_384 VDD VDD VSS VSS gf180mcu_fd_sc_mcu7t5v0__fill_1
XFILLER_108_395 VDD VDD VSS VSS gf180mcu_fd_sc_mcu7t5v0__fill_2
XFILLER_135_170 VDD VDD VSS VSS gf180mcu_fd_sc_mcu7t5v0__fill_1
XFILLER_136_682 VDD VDD VSS VSS gf180mcu_fd_sc_mcu7t5v0__fillcap_8
XFILLER_142_129 VDD VDD VSS VSS gf180mcu_fd_sc_mcu7t5v0__fill_2
XTAP_TAPCELL_ROW_75_1121 VDD VSS gf180mcu_fd_sc_mcu7t5v0__filltie
XFILLER_124_877 VDD VDD VSS VSS gf180mcu_fd_sc_mcu7t5v0__fillcap_4
XFILLER_97_706 VDD VDD VSS VSS gf180mcu_fd_sc_mcu7t5v0__fill_2
XFILLER_77_430 VDD VDD VSS VSS gf180mcu_fd_sc_mcu7t5v0__fill_1
XFILLER_93_912 VDD VDD VSS VSS gf180mcu_fd_sc_mcu7t5v0__fillcap_8
Xspi_regs_inst__0933_ spi_regs_inst__1635_/Q spi_regs_inst__1461_/Q spi_regs_inst__0939_/S
+ spi_regs_inst__1635_/D VDD VDD VSS VSS gf180mcu_fd_sc_mcu7t5v0__mux2_2
XFILLER_37_338 VDD VDD VSS VSS gf180mcu_fd_sc_mcu7t5v0__fillcap_8
XFILLER_65_636 VDD VDD VSS VSS gf180mcu_fd_sc_mcu7t5v0__fill_2
XFILLER_92_433 VDD VDD VSS VSS gf180mcu_fd_sc_mcu7t5v0__fillcap_4
Xspi_regs_inst__0864_ spi_regs_inst__1600_/Q spi_regs_inst__1430_/I1 spi_regs_inst__0868_/S
+ spi_regs_inst__1600_/D VDD VDD VSS VSS gf180mcu_fd_sc_mcu7t5v0__mux2_2
Xclkbuf_3_7__f_clk clkbuf_0_clk/Z clkload0/I VDD VDD VSS VSS gf180mcu_fd_sc_mcu7t5v0__clkbuf_16
XFILLER_33_500 VDD VDD VSS VSS gf180mcu_fd_sc_mcu7t5v0__fill_2
XTAP_TAPCELL_ROW_23_1_501 VDD VSS gf180mcu_fd_sc_mcu7t5v0__filltie
Xspi_regs_inst__0795_ spi_regs_inst__1546_/Q spi_regs_inst__1410_/I1 spi_regs_inst__0795_/S
+ spi_regs_inst__1546_/D VDD VDD VSS VSS gf180mcu_fd_sc_mcu7t5v0__mux2_2
XFILLER_60_341 VDD VDD VSS VSS gf180mcu_fd_sc_mcu7t5v0__fill_2
XFILLER_61_842 VDD VDD VSS VSS gf180mcu_fd_sc_mcu7t5v0__fillcap_4
XTAP_TAPCELL_ROW_86_1294 VDD VSS gf180mcu_fd_sc_mcu7t5v0__filltie
XFILLER_119_627 VDD VDD VSS VSS gf180mcu_fd_sc_mcu7t5v0__fill_2
XFILLER_13_290 VDD VDD VSS VSS gf180mcu_fd_sc_mcu7t5v0__fillcap_4
XFILLER_158_251 VDD VDD VSS VSS gf180mcu_fd_sc_mcu7t5v0__fill_2
Xspi_regs_inst__1416_ spi_regs_inst__1416_/I0 fanout507/Z spi_regs_inst__1419_/S spi_regs_inst__1488_/D
+ VDD VDD VSS VSS gf180mcu_fd_sc_mcu7t5v0__mux2_2
XFILLER_146_446 VDD VDD VSS VSS gf180mcu_fd_sc_mcu7t5v0__fillcap_8
XFILLER_146_457 VDD VDD VSS VSS gf180mcu_fd_sc_mcu7t5v0__fillcap_4
Xspi_regs_inst__1347_ spi_regs_inst__1577_/Q spi_regs_inst__1347_/A2 spi_regs_inst_wire252/Z
+ spi_regs_inst__1548_/Q spi_regs_inst__1358_/A2 VDD VDD VSS VSS gf180mcu_fd_sc_mcu7t5v0__aoi22_1
Xclkload20 clkload20/I clkload20/ZN VDD VDD VSS VSS gf180mcu_fd_sc_mcu7t5v0__inv_2
Xclkload31 clkload31/I clkload31/ZN VDD VDD VSS VSS gf180mcu_fd_sc_mcu7t5v0__inv_2
Xspi_regs_inst__1278_ spi_regs_inst__1278_/A1 spi_regs_inst__1278_/A2 spi_regs_inst__1345_/B1
+ spi_regs_inst__1278_/B2 spi_regs_inst__1280_/A2 VDD VDD VSS VSS gf180mcu_fd_sc_mcu7t5v0__aoi22_1
XFILLER_130_803 VDD VDD VSS VSS gf180mcu_fd_sc_mcu7t5v0__fill_2
XFILLER_102_527 VDD VDD VSS VSS gf180mcu_fd_sc_mcu7t5v0__fillcap_8
XFILLER_87_205 VDD VDD VSS VSS gf180mcu_fd_sc_mcu7t5v0__fillcap_4
Xwave_controller_x_inst__2961_ wave_controller_x_inst__3703_/Q fanout529/Z wave_controller_x_inst__2961_/Z
+ VDD VDD VSS VSS gf180mcu_fd_sc_mcu7t5v0__or2_1
Xspi_regs_inst_wire98 spi_regs_inst_wire98/I spi_regs_inst_wire98/Z VDD VDD VSS VSS
+ gf180mcu_fd_sc_mcu7t5v0__dlyb_1
Xspi_regs_inst_wire76 spi_regs_inst_wire76/I spi_regs_inst_wire76/Z VDD VDD VSS VSS
+ gf180mcu_fd_sc_mcu7t5v0__buf_2
Xwave_controller_x_inst__2892_ wave_controller_x_inst__3738_/Q wave_controller_x_inst__2935_/A2
+ wave_controller_x_inst__2892_/Z VDD VDD VSS VSS gf180mcu_fd_sc_mcu7t5v0__xor2_1
Xwave_controller_x_inst__1912_ wave_controller_x_inst__3098_/B fanout498/Z wave_controller_x_inst__3406_/A2
+ VDD VDD VSS VSS gf180mcu_fd_sc_mcu7t5v0__nand2_1
Xsignal_processor_y_inst__228_ signal_processor_y_inst__228_/D fanout557/Z clkload2/I
+ spi_regs_inst__1176_/B2 VDD VDD VSS VSS gf180mcu_fd_sc_mcu7t5v0__dffrnq_1
XFILLER_28_305 VDD VDD VSS VSS gf180mcu_fd_sc_mcu7t5v0__fillcap_4
XFILLER_95_260 VDD VDD VSS VSS gf180mcu_fd_sc_mcu7t5v0__fillcap_16
Xwave_controller_x_inst__1843_ spi_regs_inst__1250_/B2 wave_controller_x_inst__2349_/C
+ VDD VDD VSS VSS gf180mcu_fd_sc_mcu7t5v0__clkinv_1
XFILLER_83_422 VDD VDD VSS VSS gf180mcu_fd_sc_mcu7t5v0__fillcap_8
XFILLER_95_282 VDD VDD VSS VSS gf180mcu_fd_sc_mcu7t5v0__fillcap_16
Xwave_controller_y_inst__1790_ wave_controller_y_inst__1790_/I wave_controller_y_inst__3305_/A1
+ VDD VDD VSS VSS gf180mcu_fd_sc_mcu7t5v0__clkinv_1
Xsignal_processor_y_inst__159_ signal_processor_y_inst__187_/A1 signal_processor_y_inst__158_/Z
+ signal_processor_y_inst__231_/D VDD VDD VSS VSS gf180mcu_fd_sc_mcu7t5v0__nor2_1
XTAP_TAPCELL_ROW_2_1_348 VDD VSS gf180mcu_fd_sc_mcu7t5v0__filltie
Xwave_controller_x_inst__3513_ wave_controller_x_inst__3707_/Q wave_controller_x_inst__3537_/A2
+ wave_controller_x_inst__3515_/A2 VDD VDD VSS VSS gf180mcu_fd_sc_mcu7t5v0__nor2_1
XFILLER_55_168 VDD VDD VSS VSS gf180mcu_fd_sc_mcu7t5v0__fillcap_8
XFILLER_83_488 VDD VDD VSS VSS gf180mcu_fd_sc_mcu7t5v0__fill_2
Xwave_controller_y_inst__3460_ wave_controller_y_inst__3460_/A1 wave_controller_y_inst__3459_/Z
+ wave_controller_y_inst__3700_/Q wave_controller_y_inst__3460_/C wave_controller_y_inst__3462_/A2
+ VDD VDD VSS VSS gf180mcu_fd_sc_mcu7t5v0__aoi211_1
XFILLER_93_1046 VDD VDD VSS VSS gf180mcu_fd_sc_mcu7t5v0__fillcap_4
Xwave_controller_y_inst__2411_ spi_regs_inst__1169_/A1 spi_regs_inst__1150_/A1 wave_controller_y_inst__2411_/Z
+ VDD VDD VSS VSS gf180mcu_fd_sc_mcu7t5v0__xor2_1
Xwave_controller_x_inst__3444_ spi_regs_inst__1197_/B2 wave_controller_x_inst__3487_/A2
+ wave_controller_x_inst__3445_/B VDD VDD VSS VSS gf180mcu_fd_sc_mcu7t5v0__nand2_1
XFILLER_51_352 VDD VDD VSS VSS gf180mcu_fd_sc_mcu7t5v0__fill_1
Xwave_controller_y_inst__3391_ wave_controller_y_inst__3391_/A1 wave_controller_y_inst__3361_/Z
+ wave_controller_y_inst__3363_/Z wave_controller_y_inst__3209_/B wave_controller_y_inst__3392_/B2
+ VDD VDD VSS VSS gf180mcu_fd_sc_mcu7t5v0__oai22_1
Xwave_controller_x_inst__3375_ wave_controller_x_inst__3374_/B wave_controller_x_inst__3375_/A2
+ wave_controller_x_inst__3373_/Z wave_controller_x_inst__3383_/B1 VDD VDD VSS VSS
+ gf180mcu_fd_sc_mcu7t5v0__nand3_1
XTAP_TAPCELL_ROW_62_892 VDD VSS gf180mcu_fd_sc_mcu7t5v0__filltie
Xwave_controller_y_inst__2342_ wave_controller_y_inst__2304_/Z wave_controller_y_inst__2342_/A2
+ wave_controller_y_inst__2328_/Z wave_controller_y_inst__2345_/B VDD VDD VSS VSS
+ gf180mcu_fd_sc_mcu7t5v0__nand3_1
Xwave_controller_x_inst__2326_ wave_controller_x_inst__3209_/B wave_controller_x_inst__2616_/A1
+ wave_controller_x_inst__2326_/A3 wave_controller_x_inst__2327_/B VDD VDD VSS VSS
+ gf180mcu_fd_sc_mcu7t5v0__xor3_1
XFILLER_109_104 VDD VDD VSS VSS gf180mcu_fd_sc_mcu7t5v0__fillcap_32
XTAP_TAPCELL_ROW_137_2136 VDD VSS gf180mcu_fd_sc_mcu7t5v0__filltie
Xwave_controller_y_inst__2273_ wave_controller_y_inst__2286_/A2 wave_controller_y_inst__2275_/A3
+ wave_controller_y_inst__2274_/A2 VDD VDD VSS VSS gf180mcu_fd_sc_mcu7t5v0__xnor2_1
Xclkload3 _21_/CLK clkload3/Z VDD VDD VSS VSS gf180mcu_fd_sc_mcu7t5v0__clkbuf_2
XFILLER_126_6 VDD VDD VSS VSS gf180mcu_fd_sc_mcu7t5v0__fill_2
XFILLER_138_947 VDD VDD VSS VSS gf180mcu_fd_sc_mcu7t5v0__fillcap_64
XFILLER_153_906 VDD VDD VSS VSS gf180mcu_fd_sc_mcu7t5v0__fillcap_4
XFILLER_166_14 VDD VDD VSS VSS gf180mcu_fd_sc_mcu7t5v0__fillcap_16
Xwave_controller_x_inst__2257_ wave_controller_x_inst__2257_/A1 wave_controller_x_inst__2257_/A2
+ wave_controller_x_inst__2257_/A3 wave_controller_x_inst__2259_/B1 VDD VDD VSS VSS
+ gf180mcu_fd_sc_mcu7t5v0__nand3_1
XFILLER_118_660 VDD VDD VSS VSS gf180mcu_fd_sc_mcu7t5v0__fillcap_4
XFILLER_124_107 VDD VDD VSS VSS gf180mcu_fd_sc_mcu7t5v0__fill_2
XFILLER_164_243 VDD VDD VSS VSS gf180mcu_fd_sc_mcu7t5v0__fill_2
XFILLER_165_766 VDD VDD VSS VSS gf180mcu_fd_sc_mcu7t5v0__fillcap_4
Xwave_controller_x_inst__2188_ wave_controller_x_inst__2187_/B wave_controller_x_inst__2188_/A2
+ wave_controller_x_inst__2188_/B1 wave_controller_x_inst__2213_/A2 spi_regs_inst_wire107/I
+ VDD VDD VSS VSS gf180mcu_fd_sc_mcu7t5v0__aoi22_1
XFILLER_3_404 VDD VDD VSS VSS gf180mcu_fd_sc_mcu7t5v0__fill_2
XTAP_TAPCELL_ROW_150_2347 VDD VSS gf180mcu_fd_sc_mcu7t5v0__filltie
XTAP_TAPCELL_ROW_150_2358 VDD VSS gf180mcu_fd_sc_mcu7t5v0__filltie
XFILLER_3_448 VDD VDD VSS VSS gf180mcu_fd_sc_mcu7t5v0__fill_1
XTAP_TAPCELL_ROW_115_1777 VDD VSS gf180mcu_fd_sc_mcu7t5v0__filltie
XFILLER_120_302 VDD VDD VSS VSS gf180mcu_fd_sc_mcu7t5v0__fill_1
XFILLER_121_825 VDD VDD VSS VSS gf180mcu_fd_sc_mcu7t5v0__fillcap_8
XFILLER_133_674 VDD VDD VSS VSS gf180mcu_fd_sc_mcu7t5v0__fillcap_8
XTAP_TAPCELL_ROW_70_1040 VDD VSS gf180mcu_fd_sc_mcu7t5v0__filltie
XFILLER_87_772 VDD VDD VSS VSS gf180mcu_fd_sc_mcu7t5v0__fill_1
XFILLER_115_95 VDD VDD VSS VSS gf180mcu_fd_sc_mcu7t5v0__fill_2
Xwave_controller_y_inst__1988_ wave_controller_y_inst__1988_/A1 wave_controller_y_inst__1988_/A2
+ spi_regs_inst__1103_/C1 VDD VDD VSS VSS gf180mcu_fd_sc_mcu7t5v0__xor2_1
XFILLER_19_349 VDD VDD VSS VSS gf180mcu_fd_sc_mcu7t5v0__fill_1
Xwave_controller_y_inst__3727_ wave_controller_y_inst__3727_/D fanout547/Z clkload6/I
+ wave_controller_y_inst__3727_/Q VDD VDD VSS VSS gf180mcu_fd_sc_mcu7t5v0__dffrnq_1
XFILLER_62_617 VDD VDD VSS VSS gf180mcu_fd_sc_mcu7t5v0__fillcap_8
XFILLER_74_477 VDD VDD VSS VSS gf180mcu_fd_sc_mcu7t5v0__fill_2
XFILLER_131_72 VDD VDD VSS VSS gf180mcu_fd_sc_mcu7t5v0__fillcap_8
XFILLER_27_393 VDD VDD VSS VSS gf180mcu_fd_sc_mcu7t5v0__fillcap_8
Xwave_controller_y_inst__3658_ wave_controller_y_inst__3658_/D load_slew576/Z clkbuf_leaf_41_clk/Z
+ spi_regs_inst__1109_/B2 VDD VDD VSS VSS gf180mcu_fd_sc_mcu7t5v0__dffrnq_1
XFILLER_70_661 VDD VDD VSS VSS gf180mcu_fd_sc_mcu7t5v0__fillcap_4
Xwave_controller_y_inst__2609_ wave_controller_y_inst__2609_/A1 wave_controller_y_inst__2609_/A2
+ wave_controller_y_inst__2634_/A1 VDD VDD VSS VSS gf180mcu_fd_sc_mcu7t5v0__nor2_1
Xwave_controller_y_inst__3589_ wave_controller_y_inst__3589_/I0 spi_regs_inst__1078_/A1
+ wave_controller_y_inst__3591_/S wave_controller_y_inst__3666_/D VDD VDD VSS VSS
+ gf180mcu_fd_sc_mcu7t5v0__mux2_2
XFILLER_70_683 VDD VDD VSS VSS gf180mcu_fd_sc_mcu7t5v0__fill_2
XFILLER_91_98 VDD VDD VSS VSS gf180mcu_fd_sc_mcu7t5v0__fill_2
Xsignal_processor_x_inst__248_ signal_processor_x_inst__248_/D fanout587/Z clkload24/I
+ signal_processor_x_inst__248_/Q VDD VDD VSS VSS gf180mcu_fd_sc_mcu7t5v0__dffrnq_1
XFILLER_128_435 VDD VDD VSS VSS gf180mcu_fd_sc_mcu7t5v0__fill_2
Xspi_regs_inst__1201_ spi_regs_inst__1201_/A1 spi_regs_inst__1201_/A2 spi_regs_inst__1201_/A3
+ spi_regs_inst__1201_/A4 spi_regs_inst__1206_/A1 VDD VDD VSS VSS gf180mcu_fd_sc_mcu7t5v0__nand4_1
Xsignal_processor_x_inst__179_ fanout397/Z signal_processor_x_inst__239_/Q signal_processor_x_inst__203_/A1
+ signal_processor_x_inst__181_/B VDD VDD VSS VSS gf180mcu_fd_sc_mcu7t5v0__nand3_1
XTAP_TAPCELL_ROW_26_1_527 VDD VSS gf180mcu_fd_sc_mcu7t5v0__filltie
Xspi_regs_inst__1132_ spi_regs_inst__1132_/A1 spi_regs_inst__1252_/A2 spi_regs_inst__1132_/B1
+ spi_regs_inst__1132_/B2 spi_regs_inst__1184_/B spi_regs_inst__1133_/A2 VDD VDD VSS
+ VSS gf180mcu_fd_sc_mcu7t5v0__aoi221_1
Xchip_core_681 bidir_oe[4] VDD VDD VSS VSS gf180mcu_fd_sc_mcu7t5v0__tieh
Xchip_core_670 bidir_sl[7] VDD VDD VSS VSS gf180mcu_fd_sc_mcu7t5v0__tiel
Xmax_cap429 max_cap429/I max_cap429/Z VDD VDD VSS VSS gf180mcu_fd_sc_mcu7t5v0__buf_4
XTAP_TAPCELL_ROW_34_1_584 VDD VSS gf180mcu_fd_sc_mcu7t5v0__filltie
Xspi_regs_inst__1063_ spi_regs_inst__1486_/Q spi_regs_inst_wire299/Z spi_regs_inst__1246_/B1
+ spi_regs_inst__1063_/B2 spi_regs_inst__1067_/A1 VDD VDD VSS VSS gf180mcu_fd_sc_mcu7t5v0__aoi22_1
XFILLER_112_803 VDD VDD VSS VSS gf180mcu_fd_sc_mcu7t5v0__fill_2
XFILLER_2_470 VDD VDD VSS VSS gf180mcu_fd_sc_mcu7t5v0__fillcap_8
XFILLER_69_227 VDD VDD VSS VSS gf180mcu_fd_sc_mcu7t5v0__fillcap_4
XFILLER_66_901 VDD VDD VSS VSS gf180mcu_fd_sc_mcu7t5v0__fill_2
XFILLER_65_400 VDD VDD VSS VSS gf180mcu_fd_sc_mcu7t5v0__fill_1
XFILLER_65_411 VDD VDD VSS VSS gf180mcu_fd_sc_mcu7t5v0__fill_1
XTAP_TAPCELL_ROW_88_1323 VDD VSS gf180mcu_fd_sc_mcu7t5v0__filltie
XTAP_TAPCELL_ROW_88_1334 VDD VSS gf180mcu_fd_sc_mcu7t5v0__filltie
Xspi_regs_inst__0916_ spi_regs_inst__0916_/A1 spi_regs_inst__1024_/A1 spi_regs_inst__0916_/B
+ spi_regs_inst__1631_/D VDD VDD VSS VSS gf180mcu_fd_sc_mcu7t5v0__oai21_1
XFILLER_80_403 VDD VDD VSS VSS gf180mcu_fd_sc_mcu7t5v0__fillcap_8
XFILLER_92_263 VDD VDD VSS VSS gf180mcu_fd_sc_mcu7t5v0__fill_1
Xspi_regs_inst__0847_ spi_regs_inst__1586_/Q spi_regs_inst_wire480/Z spi_regs_inst__0849_/S
+ spi_regs_inst__1586_/D VDD VDD VSS VSS gf180mcu_fd_sc_mcu7t5v0__mux2_2
XFILLER_33_341 VDD VDD VSS VSS gf180mcu_fd_sc_mcu7t5v0__fillcap_8
XFILLER_33_352 VDD VDD VSS VSS gf180mcu_fd_sc_mcu7t5v0__fill_2
Xspi_regs_inst__0778_ spi_regs_inst__1533_/Q spi_regs_inst__1410_/I1 spi_regs_inst__0778_/S
+ spi_regs_inst__1533_/D VDD VDD VSS VSS gf180mcu_fd_sc_mcu7t5v0__mux2_2
Xwave_controller_x_inst__3160_ wave_controller_x_inst__3712_/Q spi_regs_inst__1531_/Q
+ wave_controller_x_inst__3203_/B VDD VDD VSS VSS gf180mcu_fd_sc_mcu7t5v0__xor2_1
XFILLER_140_1011 VDD VDD VSS VSS gf180mcu_fd_sc_mcu7t5v0__fillcap_4
Xwave_controller_x_inst__2111_ wave_controller_x_inst_wire377/Z wave_controller_x_inst__2035_/Z
+ wave_controller_x_inst__2039_/B wave_controller_x_inst__2125_/C wave_controller_x_inst__2114_/A1
+ VDD VDD VSS VSS gf180mcu_fd_sc_mcu7t5v0__nand4_1
XFILLER_159_582 VDD VDD VSS VSS gf180mcu_fd_sc_mcu7t5v0__fillcap_4
Xwave_controller_x_inst__3091_ wave_controller_x_inst__3091_/A1 wave_controller_x_inst__3005_/Z
+ wave_controller_x_inst__3092_/B1 VDD VDD VSS VSS gf180mcu_fd_sc_mcu7t5v0__nand2_1
XFILLER_119_479 VDD VDD VSS VSS gf180mcu_fd_sc_mcu7t5v0__fill_2
Xwave_controller_x_inst__2042_ wave_controller_x_inst__3717_/Q wave_controller_x_inst__2052_/A2
+ wave_controller_x_inst__2092_/C VDD VDD VSS VSS gf180mcu_fd_sc_mcu7t5v0__xnor2_1
XFILLER_161_202 VDD VDD VSS VSS gf180mcu_fd_sc_mcu7t5v0__fill_2
XTAP_TAPCELL_ROW_132_2055 VDD VSS gf180mcu_fd_sc_mcu7t5v0__filltie
Xspi_regs_inst_wire233 spi_regs_inst_wire233/I spi_regs_inst_wire233/Z VDD VDD VSS
+ VSS gf180mcu_fd_sc_mcu7t5v0__buf_2
Xspi_regs_inst_wire222 spi_regs_inst_wire222/I spi_regs_inst_wire222/Z VDD VDD VSS
+ VSS gf180mcu_fd_sc_mcu7t5v0__buf_2
XFILLER_115_663 VDD VDD VSS VSS gf180mcu_fd_sc_mcu7t5v0__fillcap_4
XFILLER_115_674 VDD VDD VSS VSS gf180mcu_fd_sc_mcu7t5v0__fill_2
Xwave_controller_y_inst__2960_ wave_controller_y_inst__2960_/I wave_controller_y_inst__2967_/B
+ VDD VDD VSS VSS gf180mcu_fd_sc_mcu7t5v0__clkinv_1
Xwave_controller_x_inst__2944_ wave_controller_x_inst__3312_/A1 wave_controller_x_inst__2944_/A2
+ wave_controller_x_inst__3000_/A1 VDD VDD VSS VSS gf180mcu_fd_sc_mcu7t5v0__nand2_1
Xspi_regs_inst_wire299 spi_regs_inst_wire299/I spi_regs_inst_wire299/Z VDD VDD VSS
+ VSS gf180mcu_fd_sc_mcu7t5v0__buf_2
Xspi_regs_inst_wire288 spi_regs_inst_wire288/I spi_regs_inst_wire288/Z VDD VDD VSS
+ VSS gf180mcu_fd_sc_mcu7t5v0__buf_2
Xspi_regs_inst_wire277 spi_regs_inst_wire277/I spi_regs_inst_wire277/Z VDD VDD VSS
+ VSS gf180mcu_fd_sc_mcu7t5v0__buf_2
XFILLER_75_208 VDD VDD VSS VSS gf180mcu_fd_sc_mcu7t5v0__fill_2
Xwave_controller_y_inst__2891_ wave_controller_y_inst__3010_/B wave_controller_y_inst__2764_/Z
+ wave_controller_y_inst__2891_/ZN VDD VDD VSS VSS gf180mcu_fd_sc_mcu7t5v0__nand2_1
Xwave_controller_y_inst__1911_ wave_controller_y_inst__3700_/Q wave_controller_y_inst__1911_/ZN
+ VDD VDD VSS VSS gf180mcu_fd_sc_mcu7t5v0__clkinv_1
XFILLER_56_411 VDD VDD VSS VSS gf180mcu_fd_sc_mcu7t5v0__fill_2
XFILLER_84_731 VDD VDD VSS VSS gf180mcu_fd_sc_mcu7t5v0__fillcap_4
XTAP_TAPCELL_ROW_110_1685 VDD VSS gf180mcu_fd_sc_mcu7t5v0__filltie
XTAP_TAPCELL_ROW_110_1696 VDD VSS gf180mcu_fd_sc_mcu7t5v0__filltie
Xwave_controller_y_inst__1842_ spi_regs_inst__1179_/A1 wave_controller_y_inst__2318_/A1
+ VDD VDD VSS VSS gf180mcu_fd_sc_mcu7t5v0__clkinv_1
Xwave_controller_x_inst__2875_ wave_controller_x_inst__3458_/A1 spi_regs_inst__1239_/A1
+ wave_controller_x_inst__2870_/Z wave_controller_x_inst__2879_/B VDD VDD VSS VSS
+ gf180mcu_fd_sc_mcu7t5v0__nor3_1
XFILLER_112_1157 VDD VDD VSS VSS gf180mcu_fd_sc_mcu7t5v0__fillcap_16
Xwave_controller_x_inst__1826_ spi_regs_inst__1473_/Q wave_controller_x_inst__3374_/B
+ VDD VDD VSS VSS gf180mcu_fd_sc_mcu7t5v0__clkinv_1
XFILLER_45_47 VDD VDD VSS VSS gf180mcu_fd_sc_mcu7t5v0__fillcap_4
XTAP_TAPCELL_ROW_67_984 VDD VSS gf180mcu_fd_sc_mcu7t5v0__filltie
XFILLER_45_69 VDD VDD VSS VSS gf180mcu_fd_sc_mcu7t5v0__fill_1
Xwave_controller_y_inst__3512_ wave_controller_y_inst_wire144/Z wave_controller_y_inst__3512_/A2
+ wave_controller_y_inst__3512_/A3 wave_controller_y_inst_wire139/Z wave_controller_y_inst__3512_/B2
+ wave_controller_y_inst__3633_/D VDD VDD VSS VSS gf180mcu_fd_sc_mcu7t5v0__oai32_1
Xwave_controller_y_inst__3443_ wave_controller_y_inst__3443_/A1 wave_controller_y_inst__3557_/B1
+ wave_controller_y_inst__3443_/B1 wave_controller_y_inst__3443_/B2 wave_controller_y_inst__3622_/D
+ VDD VDD VSS VSS gf180mcu_fd_sc_mcu7t5v0__oai22_1
Xwave_controller_x_inst__3427_ spi_regs_inst__1094_/A1 wave_controller_x_inst__3494_/A1
+ wave_controller_x_inst__3428_/B VDD VDD VSS VSS gf180mcu_fd_sc_mcu7t5v0__nand2_1
XFILLER_157_508 VDD VDD VSS VSS gf180mcu_fd_sc_mcu7t5v0__fillcap_4
XFILLER_51_182 VDD VDD VSS VSS gf180mcu_fd_sc_mcu7t5v0__fillcap_4
Xwave_controller_y_inst__3374_ wave_controller_y_inst__3375_/A2 wave_controller_y_inst__3373_/Z
+ wave_controller_y_inst__3374_/B wave_controller_y_inst__3383_/C VDD VDD VSS VSS
+ gf180mcu_fd_sc_mcu7t5v0__aoi21_1
XFILLER_61_68 VDD VDD VSS VSS gf180mcu_fd_sc_mcu7t5v0__fill_2
Xwave_controller_y_inst__2325_ wave_controller_y_inst__1821_/I wave_controller_y_inst__2326_/A3
+ wave_controller_y_inst__2325_/Z VDD VDD VSS VSS gf180mcu_fd_sc_mcu7t5v0__and2_1
Xwave_controller_x_inst__3358_ wave_controller_x_inst__3314_/B wave_controller_x_inst__3358_/A2
+ wave_controller_x_inst__3358_/A3 wave_controller_x_inst__3358_/Z VDD VDD VSS VSS
+ gf180mcu_fd_sc_mcu7t5v0__or3_1
XFILLER_138_733 VDD VDD VSS VSS gf180mcu_fd_sc_mcu7t5v0__fill_2
Xwave_controller_x_inst__3289_ wave_controller_x_inst__3373_/A1 wave_controller_x_inst__3381_/A1
+ wave_controller_x_inst__3289_/B wave_controller_x_inst__3375_/A2 VDD VDD VSS VSS
+ gf180mcu_fd_sc_mcu7t5v0__oai21_1
Xwave_controller_x_inst__2309_ wave_controller_x_inst__2280_/Z wave_controller_x_inst__2309_/A2
+ wave_controller_x_inst__2310_/I VDD VDD VSS VSS gf180mcu_fd_sc_mcu7t5v0__nand2_1
XFILLER_137_243 VDD VDD VSS VSS gf180mcu_fd_sc_mcu7t5v0__fill_2
XTAP_TAPCELL_ROW_117_1806 VDD VSS gf180mcu_fd_sc_mcu7t5v0__filltie
Xwave_controller_y_inst__2256_ wave_controller_y_inst__2257_/A1 wave_controller_y_inst__2257_/A2
+ wave_controller_y_inst__2257_/A3 wave_controller_y_inst__2256_/Z VDD VDD VSS VSS
+ gf180mcu_fd_sc_mcu7t5v0__and3_1
XFILLER_137_298 VDD VDD VSS VSS gf180mcu_fd_sc_mcu7t5v0__fillcap_4
Xwave_controller_y_inst__2187_ wave_controller_y_inst__2187_/A1 wave_controller_y_inst__2184_/I
+ wave_controller_y_inst__2187_/B wave_controller_y_inst__2213_/A2 VDD VDD VSS VSS
+ gf180mcu_fd_sc_mcu7t5v0__aoi21_1
XFILLER_125_449 VDD VDD VSS VSS gf180mcu_fd_sc_mcu7t5v0__fill_1
XFILLER_152_235 VDD VDD VSS VSS gf180mcu_fd_sc_mcu7t5v0__fillcap_8
XFILLER_3_212 VDD VDD VSS VSS gf180mcu_fd_sc_mcu7t5v0__fillcap_64
XTAP_TAPCELL_ROW_22_1_500 VDD VSS gf180mcu_fd_sc_mcu7t5v0__filltie
XFILLER_140_408 VDD VDD VSS VSS gf180mcu_fd_sc_mcu7t5v0__fill_2
Xwave_controller_y_inst_fanout142 wave_controller_y_inst_wire144/I wave_controller_y_inst__3554_/A1
+ VDD VDD VSS VSS gf180mcu_fd_sc_mcu7t5v0__dlyb_1
XFILLER_117_1046 VDD VDD VSS VSS gf180mcu_fd_sc_mcu7t5v0__fillcap_4
XTAP_TAPCELL_ROW_167_2630 VDD VSS gf180mcu_fd_sc_mcu7t5v0__filltie
XTAP_TAPCELL_ROW_167_2641 VDD VSS gf180mcu_fd_sc_mcu7t5v0__filltie
XTAP_TAPCELL_ROW_167_2652 VDD VSS gf180mcu_fd_sc_mcu7t5v0__filltie
XFILLER_121_677 VDD VDD VSS VSS gf180mcu_fd_sc_mcu7t5v0__fillcap_4
XFILLER_67_709 VDD VDD VSS VSS gf180mcu_fd_sc_mcu7t5v0__fillcap_8
XFILLER_121_699 VDD VDD VSS VSS gf180mcu_fd_sc_mcu7t5v0__fill_1
XFILLER_47_411 VDD VDD VSS VSS gf180mcu_fd_sc_mcu7t5v0__fillcap_8
XFILLER_63_904 VDD VDD VSS VSS gf180mcu_fd_sc_mcu7t5v0__fillcap_4
XFILLER_75_742 VDD VDD VSS VSS gf180mcu_fd_sc_mcu7t5v0__fillcap_4
XFILLER_62_403 VDD VDD VSS VSS gf180mcu_fd_sc_mcu7t5v0__fillcap_16
XFILLER_74_274 VDD VDD VSS VSS gf180mcu_fd_sc_mcu7t5v0__fill_2
XFILLER_15_352 VDD VDD VSS VSS gf180mcu_fd_sc_mcu7t5v0__fillcap_4
XFILLER_90_789 VDD VDD VSS VSS gf180mcu_fd_sc_mcu7t5v0__fill_1
XTAP_TAPCELL_ROW_83_1242 VDD VSS gf180mcu_fd_sc_mcu7t5v0__filltie
XTAP_TAPCELL_ROW_83_1253 VDD VSS gf180mcu_fd_sc_mcu7t5v0__filltie
XFILLER_30_300 VDD VDD VSS VSS gf180mcu_fd_sc_mcu7t5v0__fillcap_8
XFILLER_35_80 VDD VDD VSS VSS gf180mcu_fd_sc_mcu7t5v0__fill_2
XFILLER_124_1017 VDD VDD VSS VSS gf180mcu_fd_sc_mcu7t5v0__fillcap_64
XFILLER_30_366 VDD VDD VSS VSS gf180mcu_fd_sc_mcu7t5v0__fill_1
XFILLER_129_755 VDD VDD VSS VSS gf180mcu_fd_sc_mcu7t5v0__fillcap_8
XFILLER_30_399 VDD VDD VSS VSS gf180mcu_fd_sc_mcu7t5v0__fillcap_16
XFILLER_143_202 VDD VDD VSS VSS gf180mcu_fd_sc_mcu7t5v0__fill_1
XFILLER_156_574 VDD VDD VSS VSS gf180mcu_fd_sc_mcu7t5v0__fill_1
XTAP_TAPCELL_ROW_1_1_336 VDD VSS gf180mcu_fd_sc_mcu7t5v0__filltie
XFILLER_125_950 VDD VDD VSS VSS gf180mcu_fd_sc_mcu7t5v0__fillcap_16
XFILLER_87_1170 VDD VDD VSS VSS gf180mcu_fd_sc_mcu7t5v0__fillcap_4
Xspi_regs_inst__1115_ spi_regs_inst__1115_/A1 spi_regs_inst__1115_/A2 spi_regs_inst__1115_/A3
+ spi_regs_inst__1115_/A4 spi_regs_inst__1116_/A2 VDD VDD VSS VSS gf180mcu_fd_sc_mcu7t5v0__nand4_1
XFILLER_131_419 VDD VDD VSS VSS gf180mcu_fd_sc_mcu7t5v0__fill_1
XFILLER_152_780 VDD VDD VSS VSS gf180mcu_fd_sc_mcu7t5v0__fillcap_16
XFILLER_97_300 VDD VDD VSS VSS gf180mcu_fd_sc_mcu7t5v0__fillcap_8
XFILLER_98_823 VDD VDD VSS VSS gf180mcu_fd_sc_mcu7t5v0__fillcap_8
Xspi_regs_inst__1046_ spi_regs_inst__1515_/Q spi_regs_inst__1246_/A2 spi_regs_inst__1249_/A2
+ spi_regs_inst__1046_/B2 spi_regs_inst__1048_/A4 VDD VDD VSS VSS gf180mcu_fd_sc_mcu7t5v0__aoi22_1
XFILLER_32_2 VDD VDD VSS VSS gf180mcu_fd_sc_mcu7t5v0__fillcap_32
XFILLER_57_208 VDD VDD VSS VSS gf180mcu_fd_sc_mcu7t5v0__fill_2
Xwave_controller_x_inst__2660_ wave_controller_x_inst__3244_/B2 wave_controller_x_inst__3536_/B2
+ wave_controller_x_inst__2660_/A3 wave_controller_x_inst__2661_/I VDD VDD VSS VSS
+ gf180mcu_fd_sc_mcu7t5v0__xor3_1
XFILLER_38_488 VDD VDD VSS VSS gf180mcu_fd_sc_mcu7t5v0__fill_1
XFILLER_65_274 VDD VDD VSS VSS gf180mcu_fd_sc_mcu7t5v0__fill_1
Xwave_controller_x_inst__2591_ wave_controller_x_inst__2591_/A1 wave_controller_x_inst__2591_/A2
+ wave_controller_x_inst__2590_/B wave_controller_x_inst__2591_/Z VDD VDD VSS VSS
+ gf180mcu_fd_sc_mcu7t5v0__and3_1
X_08_ _08_/I _08_/ZN VDD VDD VSS VSS gf180mcu_fd_sc_mcu7t5v0__clkinv_1
XTAP_TAPCELL_ROW_64_932 VDD VSS gf180mcu_fd_sc_mcu7t5v0__filltie
XFILLER_80_244 VDD VDD VSS VSS gf180mcu_fd_sc_mcu7t5v0__fill_1
XFILLER_21_300 VDD VDD VSS VSS gf180mcu_fd_sc_mcu7t5v0__fill_1
XFILLER_139_508 VDD VDD VSS VSS gf180mcu_fd_sc_mcu7t5v0__fillcap_4
Xwave_controller_x_inst__3212_ wave_controller_x_inst__3151_/Z wave_controller_x_inst__3239_/A3
+ fanout542/I wave_controller_x_inst__3240_/B VDD VDD VSS VSS gf180mcu_fd_sc_mcu7t5v0__oai21_1
XFILLER_119_221 VDD VDD VSS VSS gf180mcu_fd_sc_mcu7t5v0__fillcap_4
XPHY_EDGE_ROW_46_1_Right_45 VDD VSS gf180mcu_fd_sc_mcu7t5v0__endcap
Xwave_controller_x_inst__3143_ wave_controller_x_inst__3705_/Q wave_controller_x_inst__3143_/A2
+ wave_controller_x_inst__3146_/B VDD VDD VSS VSS gf180mcu_fd_sc_mcu7t5v0__nand2_1
Xwave_controller_y_inst__3090_ wave_controller_y_inst__2762_/I wave_controller_y_inst__3005_/Z
+ wave_controller_y_inst__3090_/A3 wave_controller_y_inst__3090_/B1 wave_controller_y_inst__3189_/A1
+ wave_controller_y_inst__3720_/D VDD VDD VSS VSS gf180mcu_fd_sc_mcu7t5v0__oai32_1
Xwave_controller_y_inst__2110_ wave_controller_y_inst__2138_/A1 wave_controller_y_inst__2144_/A2
+ wave_controller_y_inst__2110_/B wave_controller_y_inst__2116_/A2 VDD VDD VSS VSS
+ gf180mcu_fd_sc_mcu7t5v0__aoi21_1
XFILLER_119_276 VDD VDD VSS VSS gf180mcu_fd_sc_mcu7t5v0__fillcap_4
XFILLER_135_747 VDD VDD VSS VSS gf180mcu_fd_sc_mcu7t5v0__fill_2
XFILLER_147_38 VDD VDD VSS VSS gf180mcu_fd_sc_mcu7t5v0__fill_2
XFILLER_162_511 VDD VDD VSS VSS gf180mcu_fd_sc_mcu7t5v0__fill_1
Xwave_controller_y_inst__2041_ wave_controller_y_inst__1778_/I wave_controller_y_inst__3089_/B
+ wave_controller_y_inst__2109_/B VDD VDD VSS VSS gf180mcu_fd_sc_mcu7t5v0__xor2_1
Xwave_controller_x_inst__3074_ wave_controller_x_inst__2762_/I wave_controller_x_inst__2989_/B
+ wave_controller_x_inst__3073_/Z wave_controller_x_inst__3090_/B1 wave_controller_x_inst__3266_/A1
+ wave_controller_x_inst__3713_/D VDD VDD VSS VSS gf180mcu_fd_sc_mcu7t5v0__oai32_1
XFILLER_123_909 VDD VDD VSS VSS gf180mcu_fd_sc_mcu7t5v0__fill_1
Xwave_controller_x_inst__2025_ spi_regs_inst__1148_/B2 wave_controller_x_inst__2027_/A2
+ spi_regs_inst__1145_/A1 VDD VDD VSS VSS gf180mcu_fd_sc_mcu7t5v0__xor2_1
XTAP_TAPCELL_ROW_112_1725 VDD VSS gf180mcu_fd_sc_mcu7t5v0__filltie
Xoutput16 _94_/Z bidir_out[9] VDD VDD VSS VSS gf180mcu_fd_sc_mcu7t5v0__buf_1
XFILLER_0_237 VDD VDD VSS VSS gf180mcu_fd_sc_mcu7t5v0__fill_1
XFILLER_143_780 VDD VDD VSS VSS gf180mcu_fd_sc_mcu7t5v0__fillcap_4
XFILLER_89_834 VDD VDD VSS VSS gf180mcu_fd_sc_mcu7t5v0__fillcap_4
XFILLER_76_506 VDD VDD VSS VSS gf180mcu_fd_sc_mcu7t5v0__fillcap_4
Xwave_controller_y_inst__2943_ wave_controller_y_inst__1785_/I fanout513/Z wave_controller_y_inst__3001_/A1
+ VDD VDD VSS VSS gf180mcu_fd_sc_mcu7t5v0__nor2_1
XFILLER_29_422 VDD VDD VSS VSS gf180mcu_fd_sc_mcu7t5v0__fillcap_8
XFILLER_76_539 VDD VDD VSS VSS gf180mcu_fd_sc_mcu7t5v0__fill_1
Xwave_controller_x_inst__2927_ wave_controller_x_inst__3590_/I0 spi_regs_inst__1148_/B2
+ wave_controller_x_inst__2929_/S wave_controller_x_inst__3688_/D VDD VDD VSS VSS
+ gf180mcu_fd_sc_mcu7t5v0__mux2_2
XFILLER_29_444 VDD VDD VSS VSS gf180mcu_fd_sc_mcu7t5v0__fill_2
XFILLER_56_46 VDD VDD VSS VSS gf180mcu_fd_sc_mcu7t5v0__fillcap_8
XFILLER_57_764 VDD VDD VSS VSS gf180mcu_fd_sc_mcu7t5v0__fill_1
XTAP_TAPCELL_ROW_145_2268 VDD VSS gf180mcu_fd_sc_mcu7t5v0__filltie
Xwave_controller_y_inst__2874_ wave_controller_y_inst__2881_/A1 wave_controller_y_inst__2874_/A2
+ wave_controller_y_inst__2881_/B VDD VDD VSS VSS gf180mcu_fd_sc_mcu7t5v0__nand2_1
Xwave_controller_x_inst__2858_ wave_controller_x_inst__3479_/A1 spi_regs_inst__1305_/B2
+ wave_controller_x_inst__2883_/A3 VDD VDD VSS VSS gf180mcu_fd_sc_mcu7t5v0__nand2_1
XFILLER_56_241 VDD VDD VSS VSS gf180mcu_fd_sc_mcu7t5v0__fillcap_4
XFILLER_72_723 VDD VDD VSS VSS gf180mcu_fd_sc_mcu7t5v0__fillcap_8
XFILLER_99_1052 VDD VDD VSS VSS gf180mcu_fd_sc_mcu7t5v0__fillcap_64
Xwave_controller_y_inst__1825_ wave_controller_y_inst__1825_/I wave_controller_y_inst__1981_/A1
+ VDD VDD VSS VSS gf180mcu_fd_sc_mcu7t5v0__clkinv_1
Xwave_controller_x_inst__1809_ spi_regs_inst__1552_/Q wave_controller_x_inst__3311_/A2
+ VDD VDD VSS VSS gf180mcu_fd_sc_mcu7t5v0__clkinv_1
Xwave_controller_x_inst_fanout34 wave_controller_x_inst__3537_/A2 wave_controller_x_inst__3555_/A2
+ VDD VDD VSS VSS gf180mcu_fd_sc_mcu7t5v0__dlyb_1
Xwave_controller_x_inst__2789_ wave_controller_x_inst__2789_/A1 wave_controller_x_inst__2805_/S
+ wave_controller_x_inst__2789_/B wave_controller_x_inst__2790_/I VDD VDD VSS VSS
+ gf180mcu_fd_sc_mcu7t5v0__oai21_1
XFILLER_60_918 VDD VDD VSS VSS gf180mcu_fd_sc_mcu7t5v0__fillcap_16
XFILLER_72_34 VDD VDD VSS VSS gf180mcu_fd_sc_mcu7t5v0__fill_1
Xwave_controller_x_inst_fanout67 wave_controller_x_inst_wire68/Z wave_controller_x_inst__3581_/A1
+ VDD VDD VSS VSS gf180mcu_fd_sc_mcu7t5v0__dlyb_1
XFILLER_24_160 VDD VDD VSS VSS gf180mcu_fd_sc_mcu7t5v0__fill_2
XFILLER_52_480 VDD VDD VSS VSS gf180mcu_fd_sc_mcu7t5v0__fill_1
XFILLER_72_45 VDD VDD VSS VSS gf180mcu_fd_sc_mcu7t5v0__fillcap_4
Xwave_controller_y_inst__3426_ wave_controller_y_inst__3454_/B wave_controller_y_inst__3426_/A2
+ wave_controller_y_inst__3426_/A3 wave_controller_y_inst__3465_/B wave_controller_y_inst__3431_/C
+ VDD VDD VSS VSS gf180mcu_fd_sc_mcu7t5v0__oai31_1
XFILLER_157_349 VDD VDD VSS VSS gf180mcu_fd_sc_mcu7t5v0__fill_1
Xwave_controller_y_inst__3357_ fanout513/Z wave_controller_y_inst__3356_/Z wave_controller_y_inst__3357_/Z
+ VDD VDD VSS VSS gf180mcu_fd_sc_mcu7t5v0__and2_1
Xwave_controller_y_inst__3288_ wave_controller_y_inst__3288_/I wave_controller_y_inst__3289_/B
+ VDD VDD VSS VSS gf180mcu_fd_sc_mcu7t5v0__clkinv_1
Xwave_controller_y_inst__2308_ wave_controller_y_inst__2304_/Z wave_controller_y_inst__2306_/I
+ wave_controller_y_inst__2308_/Z VDD VDD VSS VSS gf180mcu_fd_sc_mcu7t5v0__xor2_1
XFILLER_125_202 VDD VDD VSS VSS gf180mcu_fd_sc_mcu7t5v0__fillcap_8
Xwave_controller_y_inst__2239_ wave_controller_y_inst__2259_/A1 wave_controller_y_inst__2239_/A2
+ wave_controller_y_inst__2239_/B wave_controller_y_inst__2242_/A3 VDD VDD VSS VSS
+ gf180mcu_fd_sc_mcu7t5v0__aoi21_1
XFILLER_4_543 VDD VDD VSS VSS gf180mcu_fd_sc_mcu7t5v0__fillcap_8
XFILLER_141_739 VDD VDD VSS VSS gf180mcu_fd_sc_mcu7t5v0__fillcap_8
XFILLER_153_566 VDD VDD VSS VSS gf180mcu_fd_sc_mcu7t5v0__fill_1
XFILLER_158_1157 VDD VDD VSS VSS gf180mcu_fd_sc_mcu7t5v0__fillcap_16
XFILLER_97_31 VDD VDD VSS VSS gf180mcu_fd_sc_mcu7t5v0__fill_1
XFILLER_133_290 VDD VDD VSS VSS gf180mcu_fd_sc_mcu7t5v0__fillcap_4
XFILLER_95_815 VDD VDD VSS VSS gf180mcu_fd_sc_mcu7t5v0__fillcap_16
XFILLER_121_485 VDD VDD VSS VSS gf180mcu_fd_sc_mcu7t5v0__fillcap_4
XFILLER_35_403 VDD VDD VSS VSS gf180mcu_fd_sc_mcu7t5v0__fillcap_16
XFILLER_130_1087 VDD VDD VSS VSS gf180mcu_fd_sc_mcu7t5v0__fillcap_64
XTAP_TAPCELL_ROW_19_1_473 VDD VSS gf180mcu_fd_sc_mcu7t5v0__filltie
Xspi_regs_inst__1664_ spi_regs_inst__1664_/D fanout560/Z clkbuf_leaf_6_clk/Z spi_regs_inst__1664_/Q
+ VDD VDD VSS VSS gf180mcu_fd_sc_mcu7t5v0__dffrnq_1
XFILLER_15_171 VDD VDD VSS VSS gf180mcu_fd_sc_mcu7t5v0__fill_1
XFILLER_149_839 VDD VDD VSS VSS gf180mcu_fd_sc_mcu7t5v0__fill_1
Xspi_regs_inst__1595_ spi_regs_inst__1595_/D fanout566/Z clkbuf_leaf_9_clk/Z spi_regs_inst__1595_/Q
+ VDD VDD VSS VSS gf180mcu_fd_sc_mcu7t5v0__dffrnq_1
Xclkbuf_0_clk clk clkbuf_0_clk/Z VDD VDD VSS VSS gf180mcu_fd_sc_mcu7t5v0__clkbuf_16
XFILLER_129_541 VDD VDD VSS VSS gf180mcu_fd_sc_mcu7t5v0__fill_2
XFILLER_30_196 VDD VDD VSS VSS gf180mcu_fd_sc_mcu7t5v0__fillcap_8
XFILLER_117_714 VDD VDD VSS VSS gf180mcu_fd_sc_mcu7t5v0__fill_1
XFILLER_129_596 VDD VDD VSS VSS gf180mcu_fd_sc_mcu7t5v0__fillcap_16
XFILLER_144_522 VDD VDD VSS VSS gf180mcu_fd_sc_mcu7t5v0__fill_2
XTAP_TAPCELL_ROW_96_1466 VDD VSS gf180mcu_fd_sc_mcu7t5v0__filltie
XTAP_TAPCELL_ROW_96_1455 VDD VSS gf180mcu_fd_sc_mcu7t5v0__filltie
XFILLER_132_717 VDD VDD VSS VSS gf180mcu_fd_sc_mcu7t5v0__fill_2
XFILLER_131_227 VDD VDD VSS VSS gf180mcu_fd_sc_mcu7t5v0__fillcap_16
XFILLER_86_804 VDD VDD VSS VSS gf180mcu_fd_sc_mcu7t5v0__fill_1
Xspi_regs_inst__1029_ spi_regs_inst__1029_/A1 spi_regs_inst__1029_/A2 spi_regs_inst_wire210/I
+ VDD VDD VSS VSS gf180mcu_fd_sc_mcu7t5v0__nor2_1
XFILLER_85_336 VDD VDD VSS VSS gf180mcu_fd_sc_mcu7t5v0__fillcap_4
Xwave_controller_x_inst__3692_ wave_controller_x_inst__3692_/D wave_controller_x_inst__3692_/RN
+ clkbuf_leaf_22_clk/Z wave_controller_x_inst__3692_/Q VDD VDD VSS VSS gf180mcu_fd_sc_mcu7t5v0__dffrnq_1
Xwave_controller_x_inst__2712_ wave_controller_x_inst__2712_/A1 wave_controller_x_inst__2712_/A2
+ wave_controller_x_inst__2712_/B wave_controller_x_inst__2712_/C wave_controller_x_inst__2713_/B
+ VDD VDD VSS VSS gf180mcu_fd_sc_mcu7t5v0__aoi211_1
Xwave_controller_x_inst__2643_ wave_controller_x_inst__3530_/B2 wave_controller_x_inst__2623_/Z
+ wave_controller_x_inst__2643_/B wave_controller_x_inst__2679_/A2 VDD VDD VSS VSS
+ gf180mcu_fd_sc_mcu7t5v0__oai21_1
XFILLER_54_734 VDD VDD VSS VSS gf180mcu_fd_sc_mcu7t5v0__fill_1
XFILLER_81_520 VDD VDD VSS VSS gf180mcu_fd_sc_mcu7t5v0__fillcap_8
XFILLER_93_391 VDD VDD VSS VSS gf180mcu_fd_sc_mcu7t5v0__fill_2
Xwave_controller_y_inst__2590_ wave_controller_y_inst__2591_/A1 wave_controller_y_inst__2591_/A2
+ wave_controller_y_inst__2590_/B wave_controller_y_inst__2609_/A1 VDD VDD VSS VSS
+ gf180mcu_fd_sc_mcu7t5v0__aoi21_1
XFILLER_54_778 VDD VDD VSS VSS gf180mcu_fd_sc_mcu7t5v0__fill_1
Xwave_controller_x_inst__2574_ wave_controller_x_inst__2572_/Z wave_controller_x_inst__2575_/A2
+ wave_controller_x_inst__2608_/A1 VDD VDD VSS VSS gf180mcu_fd_sc_mcu7t5v0__nand2_1
XTAP_TAPCELL_ROW_140_2187 VDD VSS gf180mcu_fd_sc_mcu7t5v0__filltie
XFILLER_167_614 VDD VDD VSS VSS gf180mcu_fd_sc_mcu7t5v0__fillcap_32
XFILLER_21_130 VDD VDD VSS VSS gf180mcu_fd_sc_mcu7t5v0__fill_2
XFILLER_42_26 VDD VDD VSS VSS gf180mcu_fd_sc_mcu7t5v0__fillcap_4
Xwave_controller_y_inst__3211_ wave_controller_y_inst__3211_/A1 wave_controller_y_inst__3211_/A2
+ wave_controller_y_inst__3211_/B wave_controller_y_inst__3239_/A3 VDD VDD VSS VSS
+ gf180mcu_fd_sc_mcu7t5v0__aoi21_1
XFILLER_139_349 VDD VDD VSS VSS gf180mcu_fd_sc_mcu7t5v0__fill_1
XFILLER_158_37 VDD VDD VSS VSS gf180mcu_fd_sc_mcu7t5v0__fillcap_64
XFILLER_21_174 VDD VDD VSS VSS gf180mcu_fd_sc_mcu7t5v0__fillcap_8
Xwave_controller_y_inst__3142_ wave_controller_y_inst__3224_/A1 wave_controller_y_inst__3224_/A2
+ wave_controller_y_inst__3142_/B wave_controller_y_inst__3221_/A2 VDD VDD VSS VSS
+ gf180mcu_fd_sc_mcu7t5v0__oai21_1
Xwave_controller_x_inst__3126_ wave_controller_x_inst__3126_/I wave_controller_x_inst__3146_/A1
+ VDD VDD VSS VSS gf180mcu_fd_sc_mcu7t5v0__clkinv_1
XFILLER_163_842 VDD VDD VSS VSS gf180mcu_fd_sc_mcu7t5v0__fillcap_64
Xwave_controller_y_inst__3073_ wave_controller_y_inst__3073_/A1 wave_controller_y_inst__2987_/Z
+ wave_controller_y_inst__3073_/Z VDD VDD VSS VSS gf180mcu_fd_sc_mcu7t5v0__and2_1
Xwave_controller_x_inst__3057_ wave_controller_x_inst__3570_/A1 wave_controller_x_inst__3090_/B1
+ wave_controller_x_inst__3057_/B1 wave_controller_x_inst__3057_/B2 wave_controller_x_inst__3707_/D
+ VDD VDD VSS VSS gf180mcu_fd_sc_mcu7t5v0__oai22_1
XTAP_TAPCELL_ROW_36_1_598 VDD VSS gf180mcu_fd_sc_mcu7t5v0__filltie
Xwave_controller_y_inst__2024_ wave_controller_y_inst__2024_/A1 wave_controller_y_inst__2017_/Z
+ wave_controller_y_inst__2024_/A3 wave_controller_y_inst__2024_/B wave_controller_y_inst_wire31/I
+ VDD VDD VSS VSS gf180mcu_fd_sc_mcu7t5v0__oai31_1
Xwave_controller_x_inst__2008_ fanout536/Z spi_regs_inst__1309_/C2 wave_controller_x_inst__2008_/Z
+ VDD VDD VSS VSS gf180mcu_fd_sc_mcu7t5v0__xor2_1
XFILLER_122_238 VDD VDD VSS VSS gf180mcu_fd_sc_mcu7t5v0__fillcap_4
XFILLER_103_430 VDD VDD VSS VSS gf180mcu_fd_sc_mcu7t5v0__fill_2
XFILLER_107_52 VDD VDD VSS VSS gf180mcu_fd_sc_mcu7t5v0__fill_2
XFILLER_131_761 VDD VDD VSS VSS gf180mcu_fd_sc_mcu7t5v0__fill_2
XFILLER_150_558 VDD VDD VSS VSS gf180mcu_fd_sc_mcu7t5v0__fillcap_4
XFILLER_77_804 VDD VDD VSS VSS gf180mcu_fd_sc_mcu7t5v0__fill_2
XTAP_TAPCELL_ROW_147_2308 VDD VSS gf180mcu_fd_sc_mcu7t5v0__filltie
Xspi_regs_inst_fanout336 spi_regs_inst__0960_/ZN spi_regs_inst__1019_/A2 VDD VDD VSS
+ VSS gf180mcu_fd_sc_mcu7t5v0__dlyb_1
XFILLER_107_96 VDD VDD VSS VSS gf180mcu_fd_sc_mcu7t5v0__fill_1
XFILLER_131_772 VDD VDD VSS VSS gf180mcu_fd_sc_mcu7t5v0__fillcap_16
XFILLER_88_174 VDD VDD VSS VSS gf180mcu_fd_sc_mcu7t5v0__fill_1
XFILLER_89_697 VDD VDD VSS VSS gf180mcu_fd_sc_mcu7t5v0__fill_2
XFILLER_92_807 VDD VDD VSS VSS gf180mcu_fd_sc_mcu7t5v0__fillcap_8
Xwave_controller_y_inst__2926_ wave_controller_y_inst__3189_/C wave_controller_y_inst_wire323/Z
+ wave_controller_y_inst__3590_/I0 VDD VDD VSS VSS gf180mcu_fd_sc_mcu7t5v0__nor2_1
XTAP_TAPCELL_ROW_160_2519 VDD VSS gf180mcu_fd_sc_mcu7t5v0__filltie
Xwave_controller_y_inst__2857_ wave_controller_y_inst__3698_/Q wave_controller_y_inst__3482_/A1
+ wave_controller_y_inst__2880_/A1 VDD VDD VSS VSS gf180mcu_fd_sc_mcu7t5v0__nand2_1
XFILLER_17_436 VDD VDD VSS VSS gf180mcu_fd_sc_mcu7t5v0__fillcap_8
XFILLER_57_594 VDD VDD VSS VSS gf180mcu_fd_sc_mcu7t5v0__fillcap_4
XTAP_TAPCELL_ROW_125_1938 VDD VSS gf180mcu_fd_sc_mcu7t5v0__filltie
Xwave_controller_y_inst__1808_ spi_regs_inst__1614_/Q wave_controller_y_inst__3332_/A2
+ VDD VDD VSS VSS gf180mcu_fd_sc_mcu7t5v0__clkinv_1
XFILLER_44_244 VDD VDD VSS VSS gf180mcu_fd_sc_mcu7t5v0__fill_1
Xwave_controller_y_inst__2788_ spi_regs_inst__1343_/A1 wave_controller_y_inst__2805_/S
+ wave_controller_y_inst__2789_/B VDD VDD VSS VSS gf180mcu_fd_sc_mcu7t5v0__nand2_1
Xwave_controller_x_inst_max_cap59 wave_controller_x_inst__3441_/A1 wave_controller_x_inst__3490_/A1
+ VDD VDD VSS VSS gf180mcu_fd_sc_mcu7t5v0__buf_2
XFILLER_44_288 VDD VDD VSS VSS gf180mcu_fd_sc_mcu7t5v0__fill_2
XFILLER_60_737 VDD VDD VSS VSS gf180mcu_fd_sc_mcu7t5v0__fill_2
XTAP_TAPCELL_ROW_55_784 VDD VSS gf180mcu_fd_sc_mcu7t5v0__filltie
XTAP_TAPCELL_ROW_80_1201 VDD VSS gf180mcu_fd_sc_mcu7t5v0__filltie
XFILLER_8_101 VDD VDD VSS VSS gf180mcu_fd_sc_mcu7t5v0__fillcap_4
Xwave_controller_y_inst__3409_ wave_controller_y_inst__3699_/Q wave_controller_y_inst__3491_/B
+ wave_controller_y_inst__3409_/A3 wave_controller_y_inst__3410_/A2 VDD VDD VSS VSS
+ gf180mcu_fd_sc_mcu7t5v0__nand3_1
Xspi_regs_inst__1380_ spi_regs_inst__1637_/Q spi_regs_inst__1380_/I1 spi_regs_inst__1384_/S
+ spi_regs_inst__1660_/D VDD VDD VSS VSS gf180mcu_fd_sc_mcu7t5v0__mux2_2
XFILLER_139_861 VDD VDD VSS VSS gf180mcu_fd_sc_mcu7t5v0__fillcap_32
XFILLER_157_135 VDD VDD VSS VSS gf180mcu_fd_sc_mcu7t5v0__fillcap_4
XFILLER_126_500 VDD VDD VSS VSS gf180mcu_fd_sc_mcu7t5v0__fill_2
XFILLER_148_92 VDD VDD VSS VSS gf180mcu_fd_sc_mcu7t5v0__fill_2
XFILLER_165_190 VDD VDD VSS VSS gf180mcu_fd_sc_mcu7t5v0__fillcap_8
XTAP_TAPCELL_ROW_78_1163 VDD VSS gf180mcu_fd_sc_mcu7t5v0__filltie
XFILLER_114_728 VDD VDD VSS VSS gf180mcu_fd_sc_mcu7t5v0__fillcap_4
XFILLER_153_352 VDD VDD VSS VSS gf180mcu_fd_sc_mcu7t5v0__fillcap_4
XFILLER_99_417 VDD VDD VSS VSS gf180mcu_fd_sc_mcu7t5v0__fill_2
XPHY_EDGE_ROW_136_Right_136 VDD VSS gf180mcu_fd_sc_mcu7t5v0__endcap
XFILLER_84_1151 VDD VDD VSS VSS gf180mcu_fd_sc_mcu7t5v0__fillcap_4
XFILLER_84_1173 VDD VDD VSS VSS gf180mcu_fd_sc_mcu7t5v0__fill_1
XTAP_TAPCELL_ROW_91_1374 VDD VSS gf180mcu_fd_sc_mcu7t5v0__filltie
XFILLER_121_271 VDD VDD VSS VSS gf180mcu_fd_sc_mcu7t5v0__fillcap_8
XFILLER_94_100 VDD VDD VSS VSS gf180mcu_fd_sc_mcu7t5v0__fillcap_4
XTAP_TAPCELL_ROW_91_1385 VDD VSS gf180mcu_fd_sc_mcu7t5v0__filltie
Xsignal_processor_y_inst__192_ signal_processor_y_inst__192_/A1 signal_processor_y_inst__192_/A2
+ signal_processor_y_inst__192_/B signal_processor_y_inst__234_/Q signal_processor_y_inst__196_/B1
+ VDD VDD VSS VSS gf180mcu_fd_sc_mcu7t5v0__oai211_1
XFILLER_121_282 VDD VDD VSS VSS gf180mcu_fd_sc_mcu7t5v0__fillcap_16
XFILLER_94_133 VDD VDD VSS VSS gf180mcu_fd_sc_mcu7t5v0__fill_1
XFILLER_82_317 VDD VDD VSS VSS gf180mcu_fd_sc_mcu7t5v0__fillcap_8
XPHY_EDGE_ROW_60_Right_60 VDD VSS gf180mcu_fd_sc_mcu7t5v0__endcap
Xwave_controller_x_inst_fanout380 wave_controller_x_inst__1911_/ZN wave_controller_x_inst__3485_/B
+ VDD VDD VSS VSS gf180mcu_fd_sc_mcu7t5v0__dlyb_1
XFILLER_82_339 VDD VDD VSS VSS gf180mcu_fd_sc_mcu7t5v0__fillcap_8
XPHY_EDGE_ROW_38_1_Left_205 VDD VSS gf180mcu_fd_sc_mcu7t5v0__endcap
XFILLER_35_244 VDD VDD VSS VSS gf180mcu_fd_sc_mcu7t5v0__fill_2
XFILLER_35_266 VDD VDD VSS VSS gf180mcu_fd_sc_mcu7t5v0__fillcap_8
XFILLER_50_247 VDD VDD VSS VSS gf180mcu_fd_sc_mcu7t5v0__fillcap_32
XFILLER_91_1122 VDD VDD VSS VSS gf180mcu_fd_sc_mcu7t5v0__fillcap_32
Xspi_regs_inst__1647_ spi_regs_inst__1647_/D spi_regs_inst__1647_/RN clkload18/I spi_regs_inst__1647_/Q
+ VDD VDD VSS VSS gf180mcu_fd_sc_mcu7t5v0__dffrnq_1
Xwave_controller_x_inst__2290_ fanout521/Z wave_controller_x_inst__2292_/A3 wave_controller_x_inst__2305_/B
+ VDD VDD VSS VSS gf180mcu_fd_sc_mcu7t5v0__nor2_1
Xspi_regs_inst__1578_ spi_regs_inst__1578_/D fanout561/Z clkload9/I spi_regs_inst__1578_/Q
+ VDD VDD VSS VSS gf180mcu_fd_sc_mcu7t5v0__dffrnq_1
XFILLER_145_842 VDD VDD VSS VSS gf180mcu_fd_sc_mcu7t5v0__fillcap_64
XFILLER_105_728 VDD VDD VSS VSS gf180mcu_fd_sc_mcu7t5v0__fill_1
XFILLER_160_801 VDD VDD VSS VSS gf180mcu_fd_sc_mcu7t5v0__fillcap_4
XPHY_EDGE_ROW_103_Right_103 VDD VSS gf180mcu_fd_sc_mcu7t5v0__endcap
XTAP_TAPCELL_ROW_24_1_514 VDD VSS gf180mcu_fd_sc_mcu7t5v0__filltie
XTAP_TAPCELL_ROW_129_2005 VDD VSS gf180mcu_fd_sc_mcu7t5v0__filltie
XTAP_TAPCELL_ROW_32_1_571 VDD VSS gf180mcu_fd_sc_mcu7t5v0__filltie
XFILLER_101_912 VDD VDD VSS VSS gf180mcu_fd_sc_mcu7t5v0__fillcap_64
XFILLER_113_772 VDD VDD VSS VSS gf180mcu_fd_sc_mcu7t5v0__fillcap_16
XFILLER_113_794 VDD VDD VSS VSS gf180mcu_fd_sc_mcu7t5v0__fill_1
XFILLER_58_314 VDD VDD VSS VSS gf180mcu_fd_sc_mcu7t5v0__fill_1
XFILLER_58_325 VDD VDD VSS VSS gf180mcu_fd_sc_mcu7t5v0__fill_1
XFILLER_74_807 VDD VDD VSS VSS gf180mcu_fd_sc_mcu7t5v0__fillcap_8
XFILLER_86_667 VDD VDD VSS VSS gf180mcu_fd_sc_mcu7t5v0__fillcap_16
XFILLER_39_550 VDD VDD VSS VSS gf180mcu_fd_sc_mcu7t5v0__fill_1
XFILLER_73_317 VDD VDD VSS VSS gf180mcu_fd_sc_mcu7t5v0__fill_2
XFILLER_85_166 VDD VDD VSS VSS gf180mcu_fd_sc_mcu7t5v0__fill_2
XFILLER_85_177 VDD VDD VSS VSS gf180mcu_fd_sc_mcu7t5v0__fillcap_4
XTAP_TAPCELL_ROW_142_2216 VDD VSS gf180mcu_fd_sc_mcu7t5v0__filltie
Xwave_controller_y_inst__2711_ wave_controller_y_inst__2713_/A1 wave_controller_y_inst__2713_/A2
+ wave_controller_y_inst__2711_/Z VDD VDD VSS VSS gf180mcu_fd_sc_mcu7t5v0__or2_1
XFILLER_54_531 VDD VDD VSS VSS gf180mcu_fd_sc_mcu7t5v0__fill_1
XFILLER_96_1011 VDD VDD VSS VSS gf180mcu_fd_sc_mcu7t5v0__fillcap_4
XTAP_TAPCELL_ROW_142_2227 VDD VSS gf180mcu_fd_sc_mcu7t5v0__filltie
Xwave_controller_y_inst__3691_ wave_controller_y_inst__3691_/D wave_controller_y_inst__3695_/RN
+ clkload15/I spi_regs_inst__1091_/B2 VDD VDD VSS VSS gf180mcu_fd_sc_mcu7t5v0__dffrnq_1
Xwave_controller_x_inst__3675_ wave_controller_x_inst__3675_/D wave_controller_x_inst__3706_/RN
+ clkload36/I spi_regs_inst__1284_/B2 VDD VDD VSS VSS gf180mcu_fd_sc_mcu7t5v0__dffrnq_1
XPHY_EDGE_ROW_22_1_Left_189 VDD VSS gf180mcu_fd_sc_mcu7t5v0__endcap
XTAP_TAPCELL_ROW_107_1635 VDD VSS gf180mcu_fd_sc_mcu7t5v0__filltie
XTAP_TAPCELL_ROW_107_1646 VDD VSS gf180mcu_fd_sc_mcu7t5v0__filltie
Xwave_controller_y_inst__2642_ spi_regs_inst__1256_/A1 wave_controller_y_inst__2640_/Z
+ wave_controller_y_inst__2642_/Z VDD VDD VSS VSS gf180mcu_fd_sc_mcu7t5v0__xor2_1
Xwave_controller_x_inst__2626_ wave_controller_x_inst__2627_/A1 wave_controller_x_inst__2600_/Z
+ wave_controller_x_inst__2626_/B wave_controller_x_inst__2634_/C VDD VDD VSS VSS
+ gf180mcu_fd_sc_mcu7t5v0__oai21_1
XFILLER_14_428 VDD VDD VSS VSS gf180mcu_fd_sc_mcu7t5v0__fillcap_8
XFILLER_53_25 VDD VDD VSS VSS gf180mcu_fd_sc_mcu7t5v0__fill_1
Xwave_controller_y_inst__2573_ wave_controller_y_inst__1825_/I wave_controller_y_inst__2557_/Z
+ wave_controller_y_inst__2573_/B wave_controller_y_inst__2575_/A2 VDD VDD VSS VSS
+ gf180mcu_fd_sc_mcu7t5v0__oai21_1
Xwave_controller_x_inst__2557_ wave_controller_x_inst__2550_/Z wave_controller_x_inst_wire169/Z
+ wave_controller_x_inst__2557_/Z VDD VDD VSS VSS gf180mcu_fd_sc_mcu7t5v0__xor2_1
XFILLER_156_6 VDD VDD VSS VSS gf180mcu_fd_sc_mcu7t5v0__fillcap_16
XTAP_TAPCELL_ROW_120_1857 VDD VSS gf180mcu_fd_sc_mcu7t5v0__filltie
Xwave_controller_x_inst__2488_ wave_controller_x_inst__2793_/I0 wave_controller_x_inst__3509_/B2
+ wave_controller_x_inst__2488_/Z VDD VDD VSS VSS gf180mcu_fd_sc_mcu7t5v0__xor2_1
XFILLER_139_124 VDD VDD VSS VSS gf180mcu_fd_sc_mcu7t5v0__fill_1
XFILLER_155_606 VDD VDD VSS VSS gf180mcu_fd_sc_mcu7t5v0__fill_2
XFILLER_167_444 VDD VDD VSS VSS gf180mcu_fd_sc_mcu7t5v0__fillcap_32
XTAP_TAPCELL_ROW_157_2470 VDD VSS gf180mcu_fd_sc_mcu7t5v0__filltie
Xwave_controller_y_inst__3125_ wave_controller_y_inst__3564_/A1 spi_regs_inst__1586_/Q
+ wave_controller_y_inst__3126_/I VDD VDD VSS VSS gf180mcu_fd_sc_mcu7t5v0__nand2_1
Xwave_controller_x_inst__3109_ wave_controller_x_inst__3265_/A1 spi_regs_inst__1533_/Q
+ wave_controller_x_inst__3109_/Z VDD VDD VSS VSS gf180mcu_fd_sc_mcu7t5v0__and2_1
XFILLER_135_352 VDD VDD VSS VSS gf180mcu_fd_sc_mcu7t5v0__fillcap_4
XFILLER_135_363 VDD VDD VSS VSS gf180mcu_fd_sc_mcu7t5v0__fillcap_16
Xwave_controller_y_inst__3056_ wave_controller_y_inst__3062_/A1 wave_controller_y_inst__3056_/A2
+ wave_controller_y_inst__3057_/B2 VDD VDD VSS VSS gf180mcu_fd_sc_mcu7t5v0__nand2_1
XFILLER_123_525 VDD VDD VSS VSS gf180mcu_fd_sc_mcu7t5v0__fillcap_8
XFILLER_155_1116 VDD VDD VSS VSS gf180mcu_fd_sc_mcu7t5v0__fillcap_4
XFILLER_162_171 VDD VDD VSS VSS gf180mcu_fd_sc_mcu7t5v0__fillcap_4
XFILLER_68_1157 VDD VDD VSS VSS gf180mcu_fd_sc_mcu7t5v0__fillcap_16
Xwave_controller_y_inst__2007_ wave_controller_y_inst__2671_/A1 spi_regs_inst__1318_/C2
+ wave_controller_y_inst__2016_/C VDD VDD VSS VSS gf180mcu_fd_sc_mcu7t5v0__nand2_1
XFILLER_150_344 VDD VDD VSS VSS gf180mcu_fd_sc_mcu7t5v0__fill_1
XFILLER_103_260 VDD VDD VSS VSS gf180mcu_fd_sc_mcu7t5v0__fillcap_4
XFILLER_1_376 VDD VDD VSS VSS gf180mcu_fd_sc_mcu7t5v0__fill_2
XTAP_TAPCELL_ROW_73_1082 VDD VSS gf180mcu_fd_sc_mcu7t5v0__filltie
Xwave_controller_x_inst_wire166 wave_controller_x_inst_wire166/I wave_controller_x_inst_wire166/Z
+ VDD VDD VSS VSS gf180mcu_fd_sc_mcu7t5v0__clkbuf_3
XFILLER_103_282 VDD VDD VSS VSS gf180mcu_fd_sc_mcu7t5v0__fillcap_8
XFILLER_104_794 VDD VDD VSS VSS gf180mcu_fd_sc_mcu7t5v0__fillcap_8
XFILLER_64_317 VDD VDD VSS VSS gf180mcu_fd_sc_mcu7t5v0__fill_2
XFILLER_94_43 VDD VDD VSS VSS gf180mcu_fd_sc_mcu7t5v0__fill_2
Xwave_controller_y_inst__2909_ wave_controller_y_inst__2764_/Z wave_controller_y_inst__2909_/A2
+ wave_controller_y_inst__2909_/A3 wave_controller_y_inst__2934_/A2 VDD VDD VSS VSS
+ gf180mcu_fd_sc_mcu7t5v0__nor3_1
Xspi_regs_inst__0880_ spi_regs_inst__1437_/A1 spi_regs_inst__0880_/A2 spi_regs_inst__1437_/A2
+ spi_regs_inst__0885_/S VDD VDD VSS VSS gf180mcu_fd_sc_mcu7t5v0__nor3_1
XFILLER_45_520 VDD VDD VSS VSS gf180mcu_fd_sc_mcu7t5v0__fillcap_16
XFILLER_58_881 VDD VDD VSS VSS gf180mcu_fd_sc_mcu7t5v0__fill_2
XFILLER_64_328 VDD VDD VSS VSS gf180mcu_fd_sc_mcu7t5v0__fill_2
XFILLER_92_637 VDD VDD VSS VSS gf180mcu_fd_sc_mcu7t5v0__fillcap_16
XFILLER_17_255 VDD VDD VSS VSS gf180mcu_fd_sc_mcu7t5v0__fill_1
XFILLER_57_391 VDD VDD VSS VSS gf180mcu_fd_sc_mcu7t5v0__fillcap_16
XFILLER_73_862 VDD VDD VSS VSS gf180mcu_fd_sc_mcu7t5v0__fill_1
XTAP_TAPCELL_ROW_41_1_639 VDD VSS gf180mcu_fd_sc_mcu7t5v0__filltie
XFILLER_150_60 VDD VDD VSS VSS gf180mcu_fd_sc_mcu7t5v0__fill_1
XFILLER_60_501 VDD VDD VSS VSS gf180mcu_fd_sc_mcu7t5v0__fill_1
XFILLER_72_350 VDD VDD VSS VSS gf180mcu_fd_sc_mcu7t5v0__fillcap_4
XFILLER_159_912 VDD VDD VSS VSS gf180mcu_fd_sc_mcu7t5v0__fillcap_64
XFILLER_32_247 VDD VDD VSS VSS gf180mcu_fd_sc_mcu7t5v0__fillcap_8
Xspi_regs_inst__1501_ spi_regs_inst__1501_/D spi_regs_inst__1527_/RN clkload32/I spi_regs_inst__1501_/Q
+ VDD VDD VSS VSS gf180mcu_fd_sc_mcu7t5v0__dffrnq_1
XFILLER_13_461 VDD VDD VSS VSS gf180mcu_fd_sc_mcu7t5v0__fillcap_8
XFILLER_158_411 VDD VDD VSS VSS gf180mcu_fd_sc_mcu7t5v0__fill_2
Xspi_regs_inst__1432_ spi_regs_inst__1502_/Q spi_regs_inst__1441_/I1 spi_regs_inst__1436_/S
+ spi_regs_inst__1502_/D VDD VDD VSS VSS gf180mcu_fd_sc_mcu7t5v0__mux2_2
XFILLER_43_80 VDD VDD VSS VSS gf180mcu_fd_sc_mcu7t5v0__fillcap_4
XFILLER_9_443 VDD VDD VSS VSS gf180mcu_fd_sc_mcu7t5v0__fillcap_4
Xspi_regs_inst__1363_ spi_regs_inst__1650_/Q spi_regs_inst__1384_/S spi_regs_inst__1364_/B
+ VDD VDD VSS VSS gf180mcu_fd_sc_mcu7t5v0__nand2_1
XFILLER_145_116 VDD VDD VSS VSS gf180mcu_fd_sc_mcu7t5v0__fillcap_8
XFILLER_9_476 VDD VDD VSS VSS gf180mcu_fd_sc_mcu7t5v0__fillcap_4
Xspi_regs_inst__1294_ spi_regs_inst__1294_/A1 spi_regs_inst__1294_/A2 spi_regs_inst__1294_/A3
+ spi_regs_inst__1294_/A4 spi_regs_inst__1295_/A4 VDD VDD VSS VSS gf180mcu_fd_sc_mcu7t5v0__nand4_1
XFILLER_126_341 VDD VDD VSS VSS gf180mcu_fd_sc_mcu7t5v0__fill_1
XFILLER_126_352 VDD VDD VSS VSS gf180mcu_fd_sc_mcu7t5v0__fillcap_4
XTAP_TAPCELL_ROW_93_1414 VDD VSS gf180mcu_fd_sc_mcu7t5v0__filltie
XFILLER_68_601 VDD VDD VSS VSS gf180mcu_fd_sc_mcu7t5v0__fill_2
XFILLER_96_921 VDD VDD VSS VSS gf180mcu_fd_sc_mcu7t5v0__fill_1
Xsignal_processor_y_inst__244_ signal_processor_y_inst__244_/D fanout545/Z clkload1/I
+ wave_controller_y_inst__1891_/I VDD VDD VSS VSS gf180mcu_fd_sc_mcu7t5v0__dffrnq_1
XFILLER_110_731 VDD VDD VSS VSS gf180mcu_fd_sc_mcu7t5v0__fillcap_4
XFILLER_122_591 VDD VDD VSS VSS gf180mcu_fd_sc_mcu7t5v0__fillcap_4
XFILLER_67_133 VDD VDD VSS VSS gf180mcu_fd_sc_mcu7t5v0__fillcap_4
XFILLER_95_431 VDD VDD VSS VSS gf180mcu_fd_sc_mcu7t5v0__fillcap_8
Xsignal_processor_y_inst__175_ signal_processor_y_inst__236_/Q signal_processor_y_inst__175_/A2
+ signal_processor_y_inst__175_/Z VDD VDD VSS VSS gf180mcu_fd_sc_mcu7t5v0__xor2_1
XFILLER_68_667 VDD VDD VSS VSS gf180mcu_fd_sc_mcu7t5v0__fillcap_8
XFILLER_83_604 VDD VDD VSS VSS gf180mcu_fd_sc_mcu7t5v0__fillcap_8
XFILLER_95_453 VDD VDD VSS VSS gf180mcu_fd_sc_mcu7t5v0__fillcap_8
Xwave_controller_x_inst__1790_ wave_controller_x_inst__1790_/I wave_controller_x_inst__3305_/A1
+ VDD VDD VSS VSS gf180mcu_fd_sc_mcu7t5v0__clkinv_1
XFILLER_167_1009 VDD VDD VSS VSS gf180mcu_fd_sc_mcu7t5v0__fillcap_8
XFILLER_55_328 VDD VDD VSS VSS gf180mcu_fd_sc_mcu7t5v0__fillcap_16
XFILLER_83_648 VDD VDD VSS VSS gf180mcu_fd_sc_mcu7t5v0__fillcap_8
XFILLER_36_531 VDD VDD VSS VSS gf180mcu_fd_sc_mcu7t5v0__fill_1
XFILLER_64_840 VDD VDD VSS VSS gf180mcu_fd_sc_mcu7t5v0__fillcap_4
XFILLER_82_169 VDD VDD VSS VSS gf180mcu_fd_sc_mcu7t5v0__fillcap_4
Xwave_controller_x_inst__3460_ wave_controller_x_inst__3460_/A1 wave_controller_x_inst__3459_/Z
+ wave_controller_x_inst__3700_/Q wave_controller_x_inst__3460_/C wave_controller_x_inst__3462_/A2
+ VDD VDD VSS VSS gf180mcu_fd_sc_mcu7t5v0__aoi211_1
XTAP_TAPCELL_ROW_35_1_597 VDD VSS gf180mcu_fd_sc_mcu7t5v0__filltie
Xwave_controller_x_inst__2411_ spi_regs_inst__1148_/B2 wire450/Z wave_controller_x_inst__2411_/Z
+ VDD VDD VSS VSS gf180mcu_fd_sc_mcu7t5v0__xor2_1
Xwave_controller_x_inst__3391_ wave_controller_x_inst__3391_/A1 wave_controller_x_inst__3361_/Z
+ wave_controller_x_inst__3363_/Z wave_controller_x_inst__3209_/B wave_controller_x_inst__3392_/B2
+ VDD VDD VSS VSS gf180mcu_fd_sc_mcu7t5v0__oai22_1
XFILLER_149_422 VDD VDD VSS VSS gf180mcu_fd_sc_mcu7t5v0__fill_2
XTAP_TAPCELL_ROW_102_1554 VDD VSS gf180mcu_fd_sc_mcu7t5v0__filltie
XTAP_TAPCELL_ROW_102_1565 VDD VSS gf180mcu_fd_sc_mcu7t5v0__filltie
Xwave_controller_x_inst__2342_ wave_controller_x_inst__2304_/Z wave_controller_x_inst__2342_/A2
+ wave_controller_x_inst__2328_/Z wave_controller_x_inst__2345_/B VDD VDD VSS VSS
+ gf180mcu_fd_sc_mcu7t5v0__nand3_1
XFILLER_108_1151 VDD VDD VSS VSS gf180mcu_fd_sc_mcu7t5v0__fillcap_4
XFILLER_108_1173 VDD VDD VSS VSS gf180mcu_fd_sc_mcu7t5v0__fill_1
Xwave_controller_x_inst__2273_ wave_controller_x_inst__2286_/A2 wave_controller_x_inst__2275_/A3
+ wave_controller_x_inst__2274_/A2 VDD VDD VSS VSS gf180mcu_fd_sc_mcu7t5v0__xnor2_1
XFILLER_137_628 VDD VDD VSS VSS gf180mcu_fd_sc_mcu7t5v0__fill_2
XFILLER_164_447 VDD VDD VSS VSS gf180mcu_fd_sc_mcu7t5v0__fillcap_8
XFILLER_117_352 VDD VDD VSS VSS gf180mcu_fd_sc_mcu7t5v0__fillcap_16
XTAP_TAPCELL_ROW_135_2097 VDD VSS gf180mcu_fd_sc_mcu7t5v0__filltie
XFILLER_105_536 VDD VDD VSS VSS gf180mcu_fd_sc_mcu7t5v0__fillcap_16
XFILLER_117_396 VDD VDD VSS VSS gf180mcu_fd_sc_mcu7t5v0__fill_1
XFILLER_132_300 VDD VDD VSS VSS gf180mcu_fd_sc_mcu7t5v0__fill_2
XFILLER_145_672 VDD VDD VSS VSS gf180mcu_fd_sc_mcu7t5v0__fillcap_16
XFILLER_2_107 VDD VDD VSS VSS gf180mcu_fd_sc_mcu7t5v0__fillcap_64
XFILLER_160_664 VDD VDD VSS VSS gf180mcu_fd_sc_mcu7t5v0__fill_1
XFILLER_59_623 VDD VDD VSS VSS gf180mcu_fd_sc_mcu7t5v0__fillcap_4
Xfanout400 fanout402/Z fanout400/Z VDD VDD VSS VSS gf180mcu_fd_sc_mcu7t5v0__dlyb_1
XFILLER_115_1122 VDD VDD VSS VSS gf180mcu_fd_sc_mcu7t5v0__fillcap_32
XFILLER_120_539 VDD VDD VSS VSS gf180mcu_fd_sc_mcu7t5v0__fillcap_16
XFILLER_58_122 VDD VDD VSS VSS gf180mcu_fd_sc_mcu7t5v0__fill_2
XPHY_EDGE_ROW_92_Left_259 VDD VSS gf180mcu_fd_sc_mcu7t5v0__endcap
XFILLER_101_753 VDD VDD VSS VSS gf180mcu_fd_sc_mcu7t5v0__fill_1
XFILLER_104_20 VDD VDD VSS VSS gf180mcu_fd_sc_mcu7t5v0__fillcap_8
XFILLER_58_166 VDD VDD VSS VSS gf180mcu_fd_sc_mcu7t5v0__fill_2
XFILLER_59_689 VDD VDD VSS VSS gf180mcu_fd_sc_mcu7t5v0__fillcap_8
Xwave_controller_x_inst__1988_ wave_controller_x_inst__1988_/A1 wave_controller_x_inst__1988_/A2
+ spi_regs_inst__1112_/B2 VDD VDD VSS VSS gf180mcu_fd_sc_mcu7t5v0__xor2_1
Xfanout499 fanout499/I fanout499/Z VDD VDD VSS VSS gf180mcu_fd_sc_mcu7t5v0__dlyb_1
XFILLER_27_520 VDD VDD VSS VSS gf180mcu_fd_sc_mcu7t5v0__fill_1
XFILLER_46_317 VDD VDD VSS VSS gf180mcu_fd_sc_mcu7t5v0__fillcap_16
XTAP_TAPCELL_ROW_57_813 VDD VSS gf180mcu_fd_sc_mcu7t5v0__filltie
XTAP_TAPCELL_ROW_57_824 VDD VSS gf180mcu_fd_sc_mcu7t5v0__filltie
Xwave_controller_x_inst__3727_ wave_controller_x_inst__3727_/D wave_controller_x_inst__3735_/RN
+ clkload26/I wave_controller_x_inst__3727_/Q VDD VDD VSS VSS gf180mcu_fd_sc_mcu7t5v0__dffrnq_1
XFILLER_64_24 VDD VDD VSS VSS gf180mcu_fd_sc_mcu7t5v0__fillcap_8
Xwave_controller_y_inst__3674_ wave_controller_y_inst__3674_/D fanout580/Z clkload21/I
+ spi_regs_inst__1226_/A1 VDD VDD VSS VSS gf180mcu_fd_sc_mcu7t5v0__dffrnq_1
Xwave_controller_x_inst__3658_ wave_controller_x_inst__3658_/D wave_controller_x_inst__3712_/RN
+ clkbuf_leaf_31_clk/Z spi_regs_inst__1090_/A1 VDD VDD VSS VSS gf180mcu_fd_sc_mcu7t5v0__dffrnq_1
Xspi_regs_inst_max_cap304 spi_regs_inst__0838_/S spi_regs_inst__0840_/S VDD VDD VSS
+ VSS gf180mcu_fd_sc_mcu7t5v0__clkbuf_2
Xwave_controller_y_inst__2625_ wave_controller_y_inst__2625_/I wave_controller_y_inst__2626_/B
+ VDD VDD VSS VSS gf180mcu_fd_sc_mcu7t5v0__clkinv_1
Xwave_controller_x_inst__2609_ wave_controller_x_inst__2609_/A1 wave_controller_x_inst__2609_/A2
+ wave_controller_x_inst__2634_/A1 VDD VDD VSS VSS gf180mcu_fd_sc_mcu7t5v0__nor2_1
XFILLER_14_247 VDD VDD VSS VSS gf180mcu_fd_sc_mcu7t5v0__fillcap_16
XFILLER_42_523 VDD VDD VSS VSS gf180mcu_fd_sc_mcu7t5v0__fill_2
XFILLER_54_383 VDD VDD VSS VSS gf180mcu_fd_sc_mcu7t5v0__fill_2
XFILLER_70_843 VDD VDD VSS VSS gf180mcu_fd_sc_mcu7t5v0__fill_1
Xwave_controller_x_inst__3589_ wave_controller_x_inst__3589_/I0 max_cap451/I wave_controller_x_inst__3591_/S
+ wave_controller_x_inst__3666_/D VDD VDD VSS VSS gf180mcu_fd_sc_mcu7t5v0__mux2_2
XFILLER_147_2 VDD VDD VSS VSS gf180mcu_fd_sc_mcu7t5v0__fillcap_16
Xwave_controller_y_inst__2556_ wave_controller_y_inst__2556_/A1 wave_controller_y_inst__2552_/Z
+ wave_controller_y_inst__2556_/B wave_controller_y_inst__2556_/C wave_controller_y_inst_wire149/I
+ VDD VDD VSS VSS gf180mcu_fd_sc_mcu7t5v0__aoi211_1
XTAP_TAPCELL_ROW_155_2429 VDD VSS gf180mcu_fd_sc_mcu7t5v0__filltie
Xwave_controller_y_inst__2487_ wave_controller_y_inst__3566_/A1 wave_controller_y_inst__3509_/B2
+ wave_controller_y_inst__2501_/B VDD VDD VSS VSS gf180mcu_fd_sc_mcu7t5v0__nand2_1
Xsignal_processor_x_inst__195_ signal_processor_x_inst__196_/B1 signal_processor_x_inst__195_/A2
+ signal_processor_x_inst__195_/B signal_processor_x_inst__200_/A2 VDD VDD VSS VSS
+ gf180mcu_fd_sc_mcu7t5v0__aoi21_1
XFILLER_128_628 VDD VDD VSS VSS gf180mcu_fd_sc_mcu7t5v0__fillcap_32
XFILLER_167_274 VDD VDD VSS VSS gf180mcu_fd_sc_mcu7t5v0__fillcap_32
XFILLER_109_820 VDD VDD VSS VSS gf180mcu_fd_sc_mcu7t5v0__fillcap_16
XFILLER_109_842 VDD VDD VSS VSS gf180mcu_fd_sc_mcu7t5v0__fill_2
XFILLER_127_127 VDD VDD VSS VSS gf180mcu_fd_sc_mcu7t5v0__fill_2
XFILLER_127_138 VDD VDD VSS VSS gf180mcu_fd_sc_mcu7t5v0__fill_2
XFILLER_13_72 VDD VDD VSS VSS gf180mcu_fd_sc_mcu7t5v0__fillcap_8
XFILLER_109_853 VDD VDD VSS VSS gf180mcu_fd_sc_mcu7t5v0__fill_1
XFILLER_124_801 VDD VDD VSS VSS gf180mcu_fd_sc_mcu7t5v0__fillcap_4
XFILLER_6_457 VDD VDD VSS VSS gf180mcu_fd_sc_mcu7t5v0__fillcap_4
Xwave_controller_y_inst__3108_ wave_controller_y_inst__3265_/A1 spi_regs_inst__1596_/Q
+ wave_controller_y_inst__3197_/A1 VDD VDD VSS VSS gf180mcu_fd_sc_mcu7t5v0__nor2_1
XFILLER_123_311 VDD VDD VSS VSS gf180mcu_fd_sc_mcu7t5v0__fillcap_8
XFILLER_89_76 VDD VDD VSS VSS gf180mcu_fd_sc_mcu7t5v0__fill_2
XTAP_TAPCELL_ROW_75_1111 VDD VSS gf180mcu_fd_sc_mcu7t5v0__filltie
XTAP_TAPCELL_ROW_75_1122 VDD VSS gf180mcu_fd_sc_mcu7t5v0__filltie
Xwave_controller_y_inst__3039_ wave_controller_y_inst__3039_/A1 wave_controller_y_inst__3081_/C
+ wave_controller_y_inst__3039_/ZN VDD VDD VSS VSS gf180mcu_fd_sc_mcu7t5v0__nand2_1
XTAP_TAPCELL_ROW_49_1_700 VDD VSS gf180mcu_fd_sc_mcu7t5v0__filltie
XFILLER_104_591 VDD VDD VSS VSS gf180mcu_fd_sc_mcu7t5v0__fillcap_4
XFILLER_49_122 VDD VDD VSS VSS gf180mcu_fd_sc_mcu7t5v0__fillcap_8
XFILLER_78_932 VDD VDD VSS VSS gf180mcu_fd_sc_mcu7t5v0__fillcap_4
XFILLER_81_1154 VDD VDD VSS VSS gf180mcu_fd_sc_mcu7t5v0__fillcap_16
XPHY_EDGE_ROW_7_1_Left_174 VDD VSS gf180mcu_fd_sc_mcu7t5v0__endcap
Xspi_regs_inst__0932_ spi_regs_inst__0932_/A1 spi_regs_inst__0932_/A2 spi_regs_inst__1634_/D
+ VDD VDD VSS VSS gf180mcu_fd_sc_mcu7t5v0__nand2_1
XFILLER_64_136 VDD VDD VSS VSS gf180mcu_fd_sc_mcu7t5v0__fillcap_4
XFILLER_93_979 VDD VDD VSS VSS gf180mcu_fd_sc_mcu7t5v0__fill_1
Xspi_regs_inst__0863_ spi_regs_inst__1599_/Q spi_regs_inst__1429_/I1 spi_regs_inst__0868_/S
+ spi_regs_inst__1599_/D VDD VDD VSS VSS gf180mcu_fd_sc_mcu7t5v0__mux2_2
XFILLER_73_670 VDD VDD VSS VSS gf180mcu_fd_sc_mcu7t5v0__fillcap_16
XTAP_TAPCELL_ROW_23_1_502 VDD VSS gf180mcu_fd_sc_mcu7t5v0__filltie
Xspi_regs_inst__0794_ spi_regs_inst__1545_/Q spi_regs_inst__1391_/I1 spi_regs_inst__0795_/S
+ spi_regs_inst__1545_/D VDD VDD VSS VSS gf180mcu_fd_sc_mcu7t5v0__mux2_2
XTAP_TAPCELL_ROW_86_1295 VDD VSS gf180mcu_fd_sc_mcu7t5v0__filltie
XFILLER_20_239 VDD VDD VSS VSS gf180mcu_fd_sc_mcu7t5v0__fillcap_4
Xspi_regs_inst__1415_ spi_regs_inst__1430_/I1 fanout509/Z spi_regs_inst__1419_/S spi_regs_inst__1487_/D
+ VDD VDD VSS VSS gf180mcu_fd_sc_mcu7t5v0__mux2_2
Xspi_regs_inst__1346_ spi_regs_inst__1606_/Q spi_regs_inst_wire286/Z spi_regs_inst__1346_/B1
+ spi_regs_inst__1346_/B2 spi_regs_inst__1358_/A1 VDD VDD VSS VSS gf180mcu_fd_sc_mcu7t5v0__aoi22_1
Xclkload10 clkload10/I clkload10/ZN VDD VDD VSS VSS gf180mcu_fd_sc_mcu7t5v0__clkinv_2
Xspi_regs_inst__1277_ spi_regs_inst__1277_/A1 spi_regs_inst_wire228/Z spi_regs_inst_wire207/Z
+ fanout524/Z spi_regs_inst__1296_/A2 VDD VDD VSS VSS gf180mcu_fd_sc_mcu7t5v0__aoi22_1
Xclkload32 clkload32/I clkload32/ZN VDD VDD VSS VSS gf180mcu_fd_sc_mcu7t5v0__clkinv_2
Xclkload21 clkload21/I clkload21/ZN VDD VDD VSS VSS gf180mcu_fd_sc_mcu7t5v0__clkinv_2
XFILLER_142_653 VDD VDD VSS VSS gf180mcu_fd_sc_mcu7t5v0__fillcap_4
XFILLER_154_491 VDD VDD VSS VSS gf180mcu_fd_sc_mcu7t5v0__fill_1
XFILLER_86_1087 VDD VDD VSS VSS gf180mcu_fd_sc_mcu7t5v0__fillcap_64
Xwave_controller_x_inst__2960_ wave_controller_x_inst__2960_/I wave_controller_x_inst__2967_/B
+ VDD VDD VSS VSS gf180mcu_fd_sc_mcu7t5v0__clkinv_1
XFILLER_115_889 VDD VDD VSS VSS gf180mcu_fd_sc_mcu7t5v0__fillcap_16
Xwave_controller_x_inst__1911_ wave_controller_x_inst__3700_/Q wave_controller_x_inst__1911_/ZN
+ VDD VDD VSS VSS gf180mcu_fd_sc_mcu7t5v0__clkinv_1
Xspi_regs_inst_wire88 spi_regs_inst_wire88/I spi_regs_inst_wire88/Z VDD VDD VSS VSS
+ gf180mcu_fd_sc_mcu7t5v0__clkbuf_2
Xspi_regs_inst_wire77 spi_regs_inst_wire77/I spi_regs_inst_wire77/Z VDD VDD VSS VSS
+ gf180mcu_fd_sc_mcu7t5v0__buf_2
XFILLER_68_431 VDD VDD VSS VSS gf180mcu_fd_sc_mcu7t5v0__fill_2
Xwave_controller_x_inst__2891_ wave_controller_x_inst__2910_/B wave_controller_x_inst__2764_/Z
+ wave_controller_x_inst__3518_/B1 VDD VDD VSS VSS gf180mcu_fd_sc_mcu7t5v0__nand2_1
Xsignal_processor_y_inst__227_ signal_processor_y_inst__227_/D fanout561/Z clkbuf_leaf_6_clk/Z
+ spi_regs_inst__1144_/B2 VDD VDD VSS VSS gf180mcu_fd_sc_mcu7t5v0__dffrnq_1
XFILLER_69_976 VDD VDD VSS VSS gf180mcu_fd_sc_mcu7t5v0__fillcap_4
Xwave_controller_x_inst__1842_ spi_regs_inst__1211_/B2 wave_controller_x_inst__2318_/A1
+ VDD VDD VSS VSS gf180mcu_fd_sc_mcu7t5v0__clkinv_1
XFILLER_110_572 VDD VDD VSS VSS gf180mcu_fd_sc_mcu7t5v0__fillcap_8
XFILLER_110_594 VDD VDD VSS VSS gf180mcu_fd_sc_mcu7t5v0__fill_1
XFILLER_28_317 VDD VDD VSS VSS gf180mcu_fd_sc_mcu7t5v0__fillcap_4
XFILLER_56_648 VDD VDD VSS VSS gf180mcu_fd_sc_mcu7t5v0__fillcap_8
XFILLER_96_795 VDD VDD VSS VSS gf180mcu_fd_sc_mcu7t5v0__fillcap_8
Xsignal_processor_y_inst__158_ signal_processor_y_inst__231_/Q signal_processor_y_inst__158_/A2
+ signal_processor_y_inst__158_/Z VDD VDD VSS VSS gf180mcu_fd_sc_mcu7t5v0__xor2_1
XTAP_TAPCELL_ROW_2_1_349 VDD VSS gf180mcu_fd_sc_mcu7t5v0__filltie
Xwave_controller_x_inst__3512_ wave_controller_x_inst__3539_/A1 wave_controller_x_inst__3512_/A2
+ wave_controller_x_inst__3512_/A3 wave_controller_x_inst__3530_/B1 wave_controller_x_inst__3512_/B2
+ wave_controller_x_inst__3633_/D VDD VDD VSS VSS gf180mcu_fd_sc_mcu7t5v0__oai32_1
XTAP_TAPCELL_ROW_17_1_460 VDD VSS gf180mcu_fd_sc_mcu7t5v0__filltie
Xwave_controller_y_inst__2410_ wave_controller_y_inst__2436_/A1 wave_controller_y_inst__2422_/A2
+ spi_regs_inst__1046_/B2 VDD VDD VSS VSS gf180mcu_fd_sc_mcu7t5v0__xor2_1
Xwave_controller_x_inst__3443_ wave_controller_x_inst__3443_/A1 wave_controller_x_inst__3557_/B1
+ wave_controller_x_inst__3443_/B1 wave_controller_x_inst__3443_/B2 wave_controller_x_inst__3622_/D
+ VDD VDD VSS VSS gf180mcu_fd_sc_mcu7t5v0__oai22_1
Xwave_controller_y_inst__3390_ wave_controller_y_inst__3209_/B wave_controller_y_inst__3363_/Z
+ wave_controller_y_inst__3390_/B1 wave_controller_y_inst__3390_/B2 wave_controller_y_inst__3390_/C
+ wave_controller_y_inst__3392_/B1 VDD VDD VSS VSS gf180mcu_fd_sc_mcu7t5v0__aoi221_1
Xwave_controller_x_inst__3374_ wave_controller_x_inst__3375_/A2 wave_controller_x_inst__3373_/Z
+ wave_controller_x_inst__3374_/B wave_controller_x_inst__3383_/C VDD VDD VSS VSS
+ gf180mcu_fd_sc_mcu7t5v0__aoi21_1
XTAP_TAPCELL_ROW_62_893 VDD VSS gf180mcu_fd_sc_mcu7t5v0__filltie
Xwave_controller_y_inst__2341_ wave_controller_y_inst__2338_/Z wave_controller_y_inst__2341_/A2
+ wave_controller_y_inst__2373_/A1 VDD VDD VSS VSS gf180mcu_fd_sc_mcu7t5v0__xnor2_1
Xwave_controller_x_inst__2325_ fanout540/Z wave_controller_x_inst__2326_/A3 wave_controller_x_inst__2325_/Z
+ VDD VDD VSS VSS gf180mcu_fd_sc_mcu7t5v0__and2_1
XTAP_TAPCELL_ROW_137_2137 VDD VSS gf180mcu_fd_sc_mcu7t5v0__filltie
Xwave_controller_y_inst__2272_ wave_controller_y_inst__2254_/Z wave_controller_y_inst__2272_/A2
+ wave_controller_y_inst__2272_/B wave_controller_y_inst__2275_/A3 VDD VDD VSS VSS
+ gf180mcu_fd_sc_mcu7t5v0__aoi21_1
Xclkload4 clkload4/I clkload4/ZN VDD VDD VSS VSS gf180mcu_fd_sc_mcu7t5v0__inv_3
XFILLER_50_37 VDD VDD VSS VSS gf180mcu_fd_sc_mcu7t5v0__fillcap_8
Xwave_controller_x_inst__2256_ wave_controller_x_inst__2257_/A1 wave_controller_x_inst__2257_/A2
+ wave_controller_x_inst__2257_/A3 wave_controller_x_inst__2256_/Z VDD VDD VSS VSS
+ gf180mcu_fd_sc_mcu7t5v0__and3_1
XFILLER_121_1170 VDD VDD VSS VSS gf180mcu_fd_sc_mcu7t5v0__fillcap_4
XFILLER_125_609 VDD VDD VSS VSS gf180mcu_fd_sc_mcu7t5v0__fillcap_8
XFILLER_137_458 VDD VDD VSS VSS gf180mcu_fd_sc_mcu7t5v0__fillcap_4
XFILLER_166_37 VDD VDD VSS VSS gf180mcu_fd_sc_mcu7t5v0__fillcap_64
Xwave_controller_x_inst__2187_ wave_controller_x_inst__2187_/A1 wave_controller_x_inst__2184_/I
+ wave_controller_x_inst__2187_/B wave_controller_x_inst__2213_/A2 VDD VDD VSS VSS
+ gf180mcu_fd_sc_mcu7t5v0__aoi21_1
XFILLER_106_823 VDD VDD VSS VSS gf180mcu_fd_sc_mcu7t5v0__fillcap_4
XFILLER_164_277 VDD VDD VSS VSS gf180mcu_fd_sc_mcu7t5v0__fillcap_16
XTAP_TAPCELL_ROW_150_2348 VDD VSS gf180mcu_fd_sc_mcu7t5v0__filltie
XTAP_TAPCELL_ROW_150_2359 VDD VSS gf180mcu_fd_sc_mcu7t5v0__filltie
XFILLER_132_130 VDD VDD VSS VSS gf180mcu_fd_sc_mcu7t5v0__fillcap_8
XFILLER_65_1116 VDD VDD VSS VSS gf180mcu_fd_sc_mcu7t5v0__fillcap_4
XTAP_TAPCELL_ROW_115_1767 VDD VSS gf180mcu_fd_sc_mcu7t5v0__filltie
XTAP_TAPCELL_ROW_115_1778 VDD VSS gf180mcu_fd_sc_mcu7t5v0__filltie
XFILLER_105_377 VDD VDD VSS VSS gf180mcu_fd_sc_mcu7t5v0__fillcap_8
XFILLER_121_837 VDD VDD VSS VSS gf180mcu_fd_sc_mcu7t5v0__fill_2
Xwave_controller_y_inst_fanout368 wave_controller_y_inst__3262_/A1 wave_controller_y_inst__3189_/C
+ VDD VDD VSS VSS gf180mcu_fd_sc_mcu7t5v0__dlyb_1
XFILLER_120_325 VDD VDD VSS VSS gf180mcu_fd_sc_mcu7t5v0__fill_2
XFILLER_132_174 VDD VDD VSS VSS gf180mcu_fd_sc_mcu7t5v0__fill_1
XFILLER_59_431 VDD VDD VSS VSS gf180mcu_fd_sc_mcu7t5v0__fillcap_16
XTAP_TAPCELL_ROW_70_1030 VDD VSS gf180mcu_fd_sc_mcu7t5v0__filltie
Xsignal_processor_x_inst_max_cap201 signal_processor_x_inst__211_/A1 signal_processor_x_inst__215_/A1
+ VDD VDD VSS VSS gf180mcu_fd_sc_mcu7t5v0__buf_2
XFILLER_87_751 VDD VDD VSS VSS gf180mcu_fd_sc_mcu7t5v0__fill_2
XFILLER_19_317 VDD VDD VSS VSS gf180mcu_fd_sc_mcu7t5v0__fill_2
XFILLER_59_486 VDD VDD VSS VSS gf180mcu_fd_sc_mcu7t5v0__fillcap_4
Xwave_controller_y_inst__1987_ wave_controller_y_inst__1988_/A1 wave_controller_y_inst__1988_/A2
+ wave_controller_y_inst__1992_/B VDD VDD VSS VSS gf180mcu_fd_sc_mcu7t5v0__and2_1
XFILLER_75_89 VDD VDD VSS VSS gf180mcu_fd_sc_mcu7t5v0__fillcap_8
XFILLER_75_968 VDD VDD VSS VSS gf180mcu_fd_sc_mcu7t5v0__fillcap_8
Xwave_controller_y_inst__3726_ wave_controller_y_inst__3726_/D fanout547/Z clkload5/I
+ wave_controller_y_inst__3726_/Q VDD VDD VSS VSS gf180mcu_fd_sc_mcu7t5v0__dffrnq_1
XFILLER_62_629 VDD VDD VSS VSS gf180mcu_fd_sc_mcu7t5v0__fill_1
XFILLER_90_927 VDD VDD VSS VSS gf180mcu_fd_sc_mcu7t5v0__fill_1
Xsignal_processor_x_inst_fanout396 fanout397/Z signal_processor_x_inst__108_/I VDD
+ VDD VSS VSS gf180mcu_fd_sc_mcu7t5v0__dlyb_1
XFILLER_27_372 VDD VDD VSS VSS gf180mcu_fd_sc_mcu7t5v0__fillcap_4
XFILLER_61_139 VDD VDD VSS VSS gf180mcu_fd_sc_mcu7t5v0__fill_1
Xwave_controller_y_inst__3657_ wave_controller_y_inst__3657_/D load_slew576/Z clkbuf_leaf_41_clk/Z
+ spi_regs_inst__1034_/A1 VDD VDD VSS VSS gf180mcu_fd_sc_mcu7t5v0__dffrnq_1
XFILLER_54_191 VDD VDD VSS VSS gf180mcu_fd_sc_mcu7t5v0__fillcap_4
Xwave_controller_y_inst__2608_ wave_controller_y_inst__2608_/A1 wave_controller_y_inst__2591_/Z
+ wave_controller_y_inst__2609_/A2 VDD VDD VSS VSS gf180mcu_fd_sc_mcu7t5v0__nor2_1
Xwave_controller_y_inst__3588_ wave_controller_y_inst__3082_/B spi_regs_inst__1045_/A1
+ wave_controller_y_inst__3588_/S wave_controller_y_inst__3665_/D VDD VDD VSS VSS
+ gf180mcu_fd_sc_mcu7t5v0__mux2_2
XFILLER_42_375 VDD VDD VSS VSS gf180mcu_fd_sc_mcu7t5v0__fillcap_4
XFILLER_42_397 VDD VDD VSS VSS gf180mcu_fd_sc_mcu7t5v0__fillcap_8
XFILLER_91_88 VDD VDD VSS VSS gf180mcu_fd_sc_mcu7t5v0__fill_2
Xwave_controller_y_inst__2539_ wave_controller_y_inst__3515_/B2 wave_controller_y_inst__2537_/Z
+ wave_controller_y_inst__2540_/I VDD VDD VSS VSS gf180mcu_fd_sc_mcu7t5v0__xor2_1
Xspi_regs_inst_max_cap189 spi_regs_inst__1394_/S spi_regs_inst__1391_/S VDD VDD VSS
+ VSS gf180mcu_fd_sc_mcu7t5v0__buf_3
Xsignal_processor_x_inst__247_ signal_processor_x_inst__247_/D fanout587/Z clkload24/I
+ signal_processor_x_inst__247_/Q VDD VDD VSS VSS gf180mcu_fd_sc_mcu7t5v0__dffrnq_1
XFILLER_126_1081 VDD VDD VSS VSS gf180mcu_fd_sc_mcu7t5v0__fillcap_4
XFILLER_156_734 VDD VDD VSS VSS gf180mcu_fd_sc_mcu7t5v0__fill_1
XFILLER_156_745 VDD VDD VSS VSS gf180mcu_fd_sc_mcu7t5v0__fill_1
Xspi_regs_inst__1200_ spi_regs_inst__1200_/A1 spi_regs_inst__1200_/A2 spi_regs_inst__1200_/B1
+ spi_regs_inst__1200_/B2 spi_regs_inst__1201_/A4 VDD VDD VSS VSS gf180mcu_fd_sc_mcu7t5v0__aoi22_1
Xsignal_processor_x_inst__178_ signal_processor_x_inst__187_/A1 signal_processor_x_inst__146_/Z
+ signal_processor_x_inst__238_/D VDD VDD VSS VSS gf180mcu_fd_sc_mcu7t5v0__nor2_1
XFILLER_116_609 VDD VDD VSS VSS gf180mcu_fd_sc_mcu7t5v0__fillcap_8
XTAP_TAPCELL_ROW_26_1_528 VDD VSS gf180mcu_fd_sc_mcu7t5v0__filltie
Xspi_regs_inst__1131_ spi_regs_inst__1131_/A1 spi_regs_inst__1184_/A2 spi_regs_inst__1194_/A2
+ max_cap455/Z spi_regs_inst_wire269/Z spi_regs_inst__1530_/Q spi_regs_inst__1133_/A1
+ VDD VDD VSS VSS gf180mcu_fd_sc_mcu7t5v0__aoi222_1
Xchip_core_682 bidir_oe[5] VDD VDD VSS VSS gf180mcu_fd_sc_mcu7t5v0__tieh
Xchip_core_671 bidir_sl[8] VDD VDD VSS VSS gf180mcu_fd_sc_mcu7t5v0__tiel
Xchip_core_660 bidir_pu[6] VDD VDD VSS VSS gf180mcu_fd_sc_mcu7t5v0__tiel
XFILLER_143_417 VDD VDD VSS VSS gf180mcu_fd_sc_mcu7t5v0__fill_2
XFILLER_155_277 VDD VDD VSS VSS gf180mcu_fd_sc_mcu7t5v0__fill_2
XPHY_EDGE_ROW_139_Left_306 VDD VSS gf180mcu_fd_sc_mcu7t5v0__endcap
XFILLER_108_193 VDD VDD VSS VSS gf180mcu_fd_sc_mcu7t5v0__fillcap_4
XPHY_EDGE_ROW_47_1_Left_214 VDD VSS gf180mcu_fd_sc_mcu7t5v0__endcap
XTAP_TAPCELL_ROW_34_1_585 VDD VSS gf180mcu_fd_sc_mcu7t5v0__filltie
Xspi_regs_inst__1062_ spi_regs_inst__1062_/A1 spi_regs_inst__1062_/A2 spi_regs_inst__1062_/A3
+ spi_regs_inst__1062_/A4 spi_regs_inst__1071_/A2 VDD VDD VSS VSS gf180mcu_fd_sc_mcu7t5v0__nand4_1
XFILLER_124_675 VDD VDD VSS VSS gf180mcu_fd_sc_mcu7t5v0__fillcap_4
Xwave_controller_y_inst_wire82 wave_controller_y_inst_wire82/I wave_controller_y_inst_wire82/Z
+ VDD VDD VSS VSS gf180mcu_fd_sc_mcu7t5v0__clkbuf_1
XFILLER_111_314 VDD VDD VSS VSS gf180mcu_fd_sc_mcu7t5v0__fill_1
XFILLER_123_174 VDD VDD VSS VSS gf180mcu_fd_sc_mcu7t5v0__fill_1
XFILLER_123_185 VDD VDD VSS VSS gf180mcu_fd_sc_mcu7t5v0__fill_1
XFILLER_124_697 VDD VDD VSS VSS gf180mcu_fd_sc_mcu7t5v0__fillcap_8
XFILLER_2_482 VDD VDD VSS VSS gf180mcu_fd_sc_mcu7t5v0__fill_1
XFILLER_97_559 VDD VDD VSS VSS gf180mcu_fd_sc_mcu7t5v0__fill_1
Xwave_controller_y_inst_wire93 wave_controller_y_inst_wire93/I wave_controller_y_inst_wire93/Z
+ VDD VDD VSS VSS gf180mcu_fd_sc_mcu7t5v0__clkbuf_1
XFILLER_133_1052 VDD VDD VSS VSS gf180mcu_fd_sc_mcu7t5v0__fillcap_64
XFILLER_93_710 VDD VDD VSS VSS gf180mcu_fd_sc_mcu7t5v0__fill_1
XTAP_TAPCELL_ROW_88_1324 VDD VSS gf180mcu_fd_sc_mcu7t5v0__filltie
XTAP_TAPCELL_ROW_88_1335 VDD VSS gf180mcu_fd_sc_mcu7t5v0__filltie
Xspi_regs_inst__0915_ spi_regs_inst__1637_/Q spi_regs_inst__0911_/B spi_regs_inst__0912_/B
+ spi_regs_inst__1631_/Q spi_regs_inst__0916_/B VDD VDD VSS VSS gf180mcu_fd_sc_mcu7t5v0__aoi22_1
XFILLER_65_489 VDD VDD VSS VSS gf180mcu_fd_sc_mcu7t5v0__fill_1
XFILLER_81_949 VDD VDD VSS VSS gf180mcu_fd_sc_mcu7t5v0__fillcap_16
XFILLER_93_776 VDD VDD VSS VSS gf180mcu_fd_sc_mcu7t5v0__fill_1
XPHY_EDGE_ROW_148_Left_315 VDD VSS gf180mcu_fd_sc_mcu7t5v0__endcap
Xspi_regs_inst__0846_ spi_regs_inst__1585_/Q spi_regs_inst__1416_/I0 spi_regs_inst__0849_/S
+ spi_regs_inst__1585_/D VDD VDD VSS VSS gf180mcu_fd_sc_mcu7t5v0__mux2_2
XFILLER_18_383 VDD VDD VSS VSS gf180mcu_fd_sc_mcu7t5v0__fill_2
XFILLER_45_191 VDD VDD VSS VSS gf180mcu_fd_sc_mcu7t5v0__fill_2
XFILLER_61_662 VDD VDD VSS VSS gf180mcu_fd_sc_mcu7t5v0__fill_2
Xspi_regs_inst__0777_ spi_regs_inst__1532_/Q spi_regs_inst__1451_/I1 spi_regs_inst__0778_/S
+ spi_regs_inst__1532_/D VDD VDD VSS VSS gf180mcu_fd_sc_mcu7t5v0__mux2_2
XFILLER_33_397 VDD VDD VSS VSS gf180mcu_fd_sc_mcu7t5v0__fill_2
XFILLER_61_695 VDD VDD VSS VSS gf180mcu_fd_sc_mcu7t5v0__fillcap_4
Xwave_controller_x_inst__2110_ wave_controller_x_inst__2138_/A1 wave_controller_x_inst__2144_/A2
+ wave_controller_x_inst__2110_/B wave_controller_x_inst__2116_/A2 VDD VDD VSS VSS
+ gf180mcu_fd_sc_mcu7t5v0__aoi21_1
XFILLER_105_1154 VDD VDD VSS VSS gf180mcu_fd_sc_mcu7t5v0__fillcap_16
XFILLER_119_414 VDD VDD VSS VSS gf180mcu_fd_sc_mcu7t5v0__fill_1
Xwave_controller_x_inst__3090_ wave_controller_x_inst__2762_/I wave_controller_x_inst__3005_/Z
+ wave_controller_x_inst__3090_/A3 wave_controller_x_inst__3090_/B1 wave_controller_x_inst__3090_/B2
+ wave_controller_x_inst__3720_/D VDD VDD VSS VSS gf180mcu_fd_sc_mcu7t5v0__oai32_1
XFILLER_146_233 VDD VDD VSS VSS gf180mcu_fd_sc_mcu7t5v0__fillcap_8
XPHY_EDGE_ROW_157_Left_324 VDD VSS gf180mcu_fd_sc_mcu7t5v0__endcap
Xwave_controller_x_inst__2041_ wave_controller_x_inst__3717_/Q wave_controller_x_inst__2052_/A2
+ wave_controller_x_inst__2109_/B VDD VDD VSS VSS gf180mcu_fd_sc_mcu7t5v0__xor2_1
XFILLER_162_737 VDD VDD VSS VSS gf180mcu_fd_sc_mcu7t5v0__fillcap_64
Xspi_regs_inst__1329_ spi_regs_inst__1647_/Q spi_regs_inst__1074_/Z spi_regs_inst__1330_/A3
+ VDD VDD VSS VSS gf180mcu_fd_sc_mcu7t5v0__nor2_1
XPHY_EDGE_ROW_31_1_Left_198 VDD VSS gf180mcu_fd_sc_mcu7t5v0__endcap
XTAP_TAPCELL_ROW_132_2056 VDD VSS gf180mcu_fd_sc_mcu7t5v0__filltie
XFILLER_102_314 VDD VDD VSS VSS gf180mcu_fd_sc_mcu7t5v0__fill_1
XFILLER_102_325 VDD VDD VSS VSS gf180mcu_fd_sc_mcu7t5v0__fillcap_4
XFILLER_114_174 VDD VDD VSS VSS gf180mcu_fd_sc_mcu7t5v0__fill_1
XFILLER_114_185 VDD VDD VSS VSS gf180mcu_fd_sc_mcu7t5v0__fill_2
XFILLER_88_537 VDD VDD VSS VSS gf180mcu_fd_sc_mcu7t5v0__fill_1
Xwave_controller_x_inst__2943_ wave_controller_x_inst__1785_/I fanout535/Z wave_controller_x_inst__3001_/A1
+ VDD VDD VSS VSS gf180mcu_fd_sc_mcu7t5v0__nor2_1
XFILLER_102_358 VDD VDD VSS VSS gf180mcu_fd_sc_mcu7t5v0__fill_1
XFILLER_130_667 VDD VDD VSS VSS gf180mcu_fd_sc_mcu7t5v0__fillcap_16
XPHY_EDGE_ROW_89_Right_89 VDD VSS gf180mcu_fd_sc_mcu7t5v0__endcap
Xwave_controller_y_inst__2890_ wave_controller_y_inst__3557_/A1 wave_controller_y_inst__2909_/A2
+ wave_controller_y_inst__2895_/C VDD VDD VSS VSS gf180mcu_fd_sc_mcu7t5v0__nor2_1
Xwave_controller_y_inst__1910_ spi_regs_inst__1334_/A1 wave_controller_y_inst__3492_/A1
+ VDD VDD VSS VSS gf180mcu_fd_sc_mcu7t5v0__clkinv_1
Xwave_controller_x_inst__2874_ wave_controller_x_inst__2881_/A1 wave_controller_x_inst__2874_/A2
+ wave_controller_x_inst__2881_/B VDD VDD VSS VSS gf180mcu_fd_sc_mcu7t5v0__nand2_1
XFILLER_130_689 VDD VDD VSS VSS gf180mcu_fd_sc_mcu7t5v0__fill_2
XFILLER_68_283 VDD VDD VSS VSS gf180mcu_fd_sc_mcu7t5v0__fill_1
XFILLER_69_795 VDD VDD VSS VSS gf180mcu_fd_sc_mcu7t5v0__fill_2
XFILLER_96_570 VDD VDD VSS VSS gf180mcu_fd_sc_mcu7t5v0__fillcap_4
XTAP_TAPCELL_ROW_110_1686 VDD VSS gf180mcu_fd_sc_mcu7t5v0__filltie
XTAP_TAPCELL_ROW_110_1697 VDD VSS gf180mcu_fd_sc_mcu7t5v0__filltie
Xwave_controller_y_inst__1841_ spi_regs_inst__1159_/C2 wave_controller_y_inst__2284_/A1
+ VDD VDD VSS VSS gf180mcu_fd_sc_mcu7t5v0__clkinv_1
Xwave_controller_x_inst__1825_ fanout524/Z wave_controller_x_inst__1981_/A1 VDD VDD
+ VSS VSS gf180mcu_fd_sc_mcu7t5v0__clkinv_1
XFILLER_57_968 VDD VDD VSS VSS gf180mcu_fd_sc_mcu7t5v0__fillcap_8
XFILLER_68_294 VDD VDD VSS VSS gf180mcu_fd_sc_mcu7t5v0__fillcap_4
XFILLER_84_765 VDD VDD VSS VSS gf180mcu_fd_sc_mcu7t5v0__fill_2
XPHY_EDGE_ROW_166_Left_333 VDD VSS gf180mcu_fd_sc_mcu7t5v0__endcap
XFILLER_84_787 VDD VDD VSS VSS gf180mcu_fd_sc_mcu7t5v0__fill_2
XTAP_TAPCELL_ROW_67_985 VDD VSS gf180mcu_fd_sc_mcu7t5v0__filltie
Xwave_controller_y_inst__3511_ spi_regs_inst__1275_/A1 wave_controller_y_inst__3529_/A2
+ wave_controller_y_inst__3512_/A3 VDD VDD VSS VSS gf180mcu_fd_sc_mcu7t5v0__nor2_1
XFILLER_43_128 VDD VDD VSS VSS gf180mcu_fd_sc_mcu7t5v0__fillcap_8
XPHY_EDGE_ROW_18_1_Right_17 VDD VSS gf180mcu_fd_sc_mcu7t5v0__endcap
Xwave_controller_y_inst__3442_ wave_controller_y_inst__3465_/B wave_controller_y_inst__3439_/I
+ wave_controller_y_inst__3491_/B wave_controller_y_inst__3443_/B2 VDD VDD VSS VSS
+ gf180mcu_fd_sc_mcu7t5v0__oai21_1
Xwave_controller_x_inst__3426_ wave_controller_x_inst__3454_/B wave_controller_x_inst__3426_/A2
+ wave_controller_x_inst__3426_/A3 wave_controller_x_inst__3465_/B wave_controller_x_inst__3431_/C
+ VDD VDD VSS VSS gf180mcu_fd_sc_mcu7t5v0__oai31_1
XFILLER_101_54 VDD VDD VSS VSS gf180mcu_fd_sc_mcu7t5v0__fill_2
XPHY_EDGE_ROW_98_Right_98 VDD VSS gf180mcu_fd_sc_mcu7t5v0__endcap
Xwave_controller_y_inst__3373_ wave_controller_y_inst__3373_/A1 wave_controller_y_inst__3381_/A1
+ wave_controller_y_inst__3289_/B wave_controller_y_inst__3373_/Z VDD VDD VSS VSS
+ gf180mcu_fd_sc_mcu7t5v0__or3_1
Xwave_controller_y_inst__2324_ wave_controller_y_inst__1821_/I wave_controller_y_inst__2326_/A3
+ wave_controller_y_inst__2339_/B VDD VDD VSS VSS gf180mcu_fd_sc_mcu7t5v0__or2_1
Xwave_controller_x_inst__3357_ fanout535/I wave_controller_x_inst__3356_/Z wave_controller_x_inst__3357_/Z
+ VDD VDD VSS VSS gf180mcu_fd_sc_mcu7t5v0__and2_1
XFILLER_138_745 VDD VDD VSS VSS gf180mcu_fd_sc_mcu7t5v0__fillcap_4
Xwave_controller_x_inst__3288_ wave_controller_x_inst__3288_/I wave_controller_x_inst__3289_/B
+ VDD VDD VSS VSS gf180mcu_fd_sc_mcu7t5v0__clkinv_1
Xwave_controller_x_inst__2308_ wave_controller_x_inst__2304_/Z wave_controller_x_inst__2306_/I
+ wave_controller_x_inst__2308_/Z VDD VDD VSS VSS gf180mcu_fd_sc_mcu7t5v0__xor2_1
XFILLER_153_704 VDD VDD VSS VSS gf180mcu_fd_sc_mcu7t5v0__fill_1
XTAP_TAPCELL_ROW_117_1807 VDD VSS gf180mcu_fd_sc_mcu7t5v0__filltie
Xwave_controller_y_inst__2255_ wave_controller_y_inst__2239_/B wave_controller_y_inst__2259_/C
+ wave_controller_y_inst__2257_/A3 VDD VDD VSS VSS gf180mcu_fd_sc_mcu7t5v0__nand2_1
Xwave_controller_x_inst__2239_ wave_controller_x_inst__2259_/A1 wave_controller_x_inst__2239_/A2
+ wave_controller_x_inst__2239_/B wave_controller_x_inst__2242_/A3 VDD VDD VSS VSS
+ gf180mcu_fd_sc_mcu7t5v0__aoi21_1
XFILLER_153_737 VDD VDD VSS VSS gf180mcu_fd_sc_mcu7t5v0__fillcap_4
XFILLER_165_575 VDD VDD VSS VSS gf180mcu_fd_sc_mcu7t5v0__fillcap_16
XFILLER_165_597 VDD VDD VSS VSS gf180mcu_fd_sc_mcu7t5v0__fill_1
Xwave_controller_y_inst__2186_ wave_controller_y_inst__2186_/I wave_controller_y_inst__2188_/B1
+ VDD VDD VSS VSS gf180mcu_fd_sc_mcu7t5v0__clkinv_1
XFILLER_152_247 VDD VDD VSS VSS gf180mcu_fd_sc_mcu7t5v0__fillcap_4
XFILLER_133_461 VDD VDD VSS VSS gf180mcu_fd_sc_mcu7t5v0__fillcap_4
Xwave_controller_y_inst_fanout143 wave_controller_y_inst__2766_/ZN wave_controller_y_inst_wire144/I
+ VDD VDD VSS VSS gf180mcu_fd_sc_mcu7t5v0__dlyb_1
XFILLER_105_174 VDD VDD VSS VSS gf180mcu_fd_sc_mcu7t5v0__fill_1
XFILLER_121_623 VDD VDD VSS VSS gf180mcu_fd_sc_mcu7t5v0__fillcap_4
XFILLER_121_645 VDD VDD VSS VSS gf180mcu_fd_sc_mcu7t5v0__fill_2
XFILLER_79_559 VDD VDD VSS VSS gf180mcu_fd_sc_mcu7t5v0__fill_1
XTAP_TAPCELL_ROW_167_2631 VDD VSS gf180mcu_fd_sc_mcu7t5v0__filltie
XTAP_TAPCELL_ROW_167_2642 VDD VSS gf180mcu_fd_sc_mcu7t5v0__filltie
Xwave_controller_y_inst_fanout176 wave_controller_y_inst__3039_/ZN wave_controller_y_inst__3090_/B1
+ VDD VDD VSS VSS gf180mcu_fd_sc_mcu7t5v0__dlyb_1
Xwave_controller_y_inst_fanout154 wave_controller_y_inst__2153_/A2 wave_controller_y_inst__2754_/A2
+ VDD VDD VSS VSS gf180mcu_fd_sc_mcu7t5v0__dlyb_1
XFILLER_120_122 VDD VDD VSS VSS gf180mcu_fd_sc_mcu7t5v0__fill_2
XFILLER_126_95 VDD VDD VSS VSS gf180mcu_fd_sc_mcu7t5v0__fill_1
XTAP_TAPCELL_ROW_167_2653 VDD VSS gf180mcu_fd_sc_mcu7t5v0__filltie
XFILLER_102_892 VDD VDD VSS VSS gf180mcu_fd_sc_mcu7t5v0__fill_1
XFILLER_120_177 VDD VDD VSS VSS gf180mcu_fd_sc_mcu7t5v0__fillcap_8
XFILLER_121_689 VDD VDD VSS VSS gf180mcu_fd_sc_mcu7t5v0__fillcap_8
XFILLER_101_380 VDD VDD VSS VSS gf180mcu_fd_sc_mcu7t5v0__fillcap_8
XFILLER_74_231 VDD VDD VSS VSS gf180mcu_fd_sc_mcu7t5v0__fillcap_8
XFILLER_75_765 VDD VDD VSS VSS gf180mcu_fd_sc_mcu7t5v0__fillcap_4
XFILLER_86_99 VDD VDD VSS VSS gf180mcu_fd_sc_mcu7t5v0__fill_1
XFILLER_142_61 VDD VDD VSS VSS gf180mcu_fd_sc_mcu7t5v0__fillcap_4
XFILLER_47_489 VDD VDD VSS VSS gf180mcu_fd_sc_mcu7t5v0__fill_1
XFILLER_63_916 VDD VDD VSS VSS gf180mcu_fd_sc_mcu7t5v0__fill_2
XFILLER_34_139 VDD VDD VSS VSS gf180mcu_fd_sc_mcu7t5v0__fillcap_8
XFILLER_74_286 VDD VDD VSS VSS gf180mcu_fd_sc_mcu7t5v0__fill_1
Xwave_controller_y_inst__3709_ wave_controller_y_inst__3709_/D fanout575/Z clkload12/I
+ wave_controller_y_inst__3709_/Q VDD VDD VSS VSS gf180mcu_fd_sc_mcu7t5v0__dffrnq_1
XTAP_TAPCELL_ROW_83_1243 VDD VSS gf180mcu_fd_sc_mcu7t5v0__filltie
XTAP_TAPCELL_ROW_83_1254 VDD VSS gf180mcu_fd_sc_mcu7t5v0__filltie
XFILLER_128_1165 VDD VDD VSS VSS gf180mcu_fd_sc_mcu7t5v0__fillcap_4
XFILLER_30_312 VDD VDD VSS VSS gf180mcu_fd_sc_mcu7t5v0__fill_2
XFILLER_71_982 VDD VDD VSS VSS gf180mcu_fd_sc_mcu7t5v0__fillcap_64
XFILLER_156_531 VDD VDD VSS VSS gf180mcu_fd_sc_mcu7t5v0__fill_1
XFILLER_30_356 VDD VDD VSS VSS gf180mcu_fd_sc_mcu7t5v0__fill_1
XFILLER_128_233 VDD VDD VSS VSS gf180mcu_fd_sc_mcu7t5v0__fill_1
Xwire450 wire450/I wire450/Z VDD VDD VSS VSS gf180mcu_fd_sc_mcu7t5v0__buf_3
XFILLER_144_737 VDD VDD VSS VSS gf180mcu_fd_sc_mcu7t5v0__fillcap_8
XFILLER_156_597 VDD VDD VSS VSS gf180mcu_fd_sc_mcu7t5v0__fillcap_4
XTAP_TAPCELL_ROW_1_1_337 VDD VSS gf180mcu_fd_sc_mcu7t5v0__filltie
XFILLER_109_480 VDD VDD VSS VSS gf180mcu_fd_sc_mcu7t5v0__fill_1
XFILLER_143_225 VDD VDD VSS VSS gf180mcu_fd_sc_mcu7t5v0__fill_1
Xspi_regs_inst__1114_ spi_regs_inst__1114_/A1 spi_regs_inst__1114_/A2 spi_regs_inst__1114_/A3
+ spi_regs_inst__1114_/A4 spi_regs_inst__1116_/A1 VDD VDD VSS VSS gf180mcu_fd_sc_mcu7t5v0__nand4_1
XFILLER_131_409 VDD VDD VSS VSS gf180mcu_fd_sc_mcu7t5v0__fillcap_8
Xspi_regs_inst__1045_ spi_regs_inst__1045_/A1 spi_regs_inst__1234_/A2 spi_regs_inst_wire221/Z
+ spi_regs_inst__1045_/B2 spi_regs_inst__1557_/Q spi_regs_inst__1180_/A2 spi_regs_inst_wire190/I
+ VDD VDD VSS VSS gf180mcu_fd_sc_mcu7t5v0__aoi222_1
XFILLER_83_1046 VDD VDD VSS VSS gf180mcu_fd_sc_mcu7t5v0__fillcap_4
XFILLER_100_807 VDD VDD VSS VSS gf180mcu_fd_sc_mcu7t5v0__fillcap_8
XFILLER_112_667 VDD VDD VSS VSS gf180mcu_fd_sc_mcu7t5v0__fillcap_4
XFILLER_111_188 VDD VDD VSS VSS gf180mcu_fd_sc_mcu7t5v0__fill_1
XFILLER_25_2 VDD VDD VSS VSS gf180mcu_fd_sc_mcu7t5v0__fillcap_64
XFILLER_97_389 VDD VDD VSS VSS gf180mcu_fd_sc_mcu7t5v0__fill_2
XFILLER_65_220 VDD VDD VSS VSS gf180mcu_fd_sc_mcu7t5v0__fill_2
XFILLER_66_776 VDD VDD VSS VSS gf180mcu_fd_sc_mcu7t5v0__fill_1
XFILLER_81_702 VDD VDD VSS VSS gf180mcu_fd_sc_mcu7t5v0__fillcap_8
XFILLER_93_562 VDD VDD VSS VSS gf180mcu_fd_sc_mcu7t5v0__fill_2
Xwave_controller_x_inst__2590_ wave_controller_x_inst__2591_/A1 wave_controller_x_inst__2591_/A2
+ wave_controller_x_inst__2590_/B wave_controller_x_inst__2609_/A1 VDD VDD VSS VSS
+ gf180mcu_fd_sc_mcu7t5v0__aoi21_1
XFILLER_81_746 VDD VDD VSS VSS gf180mcu_fd_sc_mcu7t5v0__fillcap_4
XTAP_TAPCELL_ROW_64_933 VDD VSS gf180mcu_fd_sc_mcu7t5v0__filltie
XFILLER_80_267 VDD VDD VSS VSS gf180mcu_fd_sc_mcu7t5v0__fillcap_16
Xspi_regs_inst__0829_ spi_regs_inst__1571_/Q spi_regs_inst__1378_/I1 spi_regs_inst__0834_/S
+ spi_regs_inst__1571_/D VDD VDD VSS VSS gf180mcu_fd_sc_mcu7t5v0__mux2_2
XFILLER_90_1017 VDD VDD VSS VSS gf180mcu_fd_sc_mcu7t5v0__fillcap_64
Xwave_controller_x_inst__3211_ wave_controller_x_inst__3211_/A1 wave_controller_x_inst__3211_/A2
+ wave_controller_x_inst__3211_/B wave_controller_x_inst__3239_/A3 VDD VDD VSS VSS
+ gf180mcu_fd_sc_mcu7t5v0__aoi21_1
XFILLER_167_818 VDD VDD VSS VSS gf180mcu_fd_sc_mcu7t5v0__fillcap_32
XFILLER_21_334 VDD VDD VSS VSS gf180mcu_fd_sc_mcu7t5v0__fill_2
XFILLER_166_317 VDD VDD VSS VSS gf180mcu_fd_sc_mcu7t5v0__fillcap_16
XFILLER_21_356 VDD VDD VSS VSS gf180mcu_fd_sc_mcu7t5v0__fill_2
Xwave_controller_x_inst__3142_ wave_controller_x_inst__3224_/A1 wave_controller_x_inst__3224_/A2
+ wave_controller_x_inst__3142_/B wave_controller_x_inst__3221_/A2 VDD VDD VSS VSS
+ gf180mcu_fd_sc_mcu7t5v0__oai21_1
XFILLER_135_704 VDD VDD VSS VSS gf180mcu_fd_sc_mcu7t5v0__fill_1
Xwave_controller_x_inst__3073_ wave_controller_x_inst__3073_/A1 wave_controller_x_inst__2987_/Z
+ wave_controller_x_inst__3073_/Z VDD VDD VSS VSS gf180mcu_fd_sc_mcu7t5v0__and2_1
XFILLER_135_715 VDD VDD VSS VSS gf180mcu_fd_sc_mcu7t5v0__fillcap_4
Xwave_controller_y_inst__2040_ wave_controller_y_inst__2079_/B wave_controller_y_inst__2092_/B
+ wave_controller_y_inst__2050_/A1 VDD VDD VSS VSS gf180mcu_fd_sc_mcu7t5v0__nand2_1
Xwave_controller_x_inst__2024_ wave_controller_x_inst__2024_/A1 wave_controller_x_inst__2017_/Z
+ wave_controller_x_inst__2024_/A3 wave_controller_x_inst__2024_/B wave_controller_x_inst__2027_/A2
+ VDD VDD VSS VSS gf180mcu_fd_sc_mcu7t5v0__oai31_1
XFILLER_103_601 VDD VDD VSS VSS gf180mcu_fd_sc_mcu7t5v0__fillcap_4
XFILLER_134_269 VDD VDD VSS VSS gf180mcu_fd_sc_mcu7t5v0__fill_2
XFILLER_162_567 VDD VDD VSS VSS gf180mcu_fd_sc_mcu7t5v0__fill_1
XFILLER_162_589 VDD VDD VSS VSS gf180mcu_fd_sc_mcu7t5v0__fill_1
XTAP_TAPCELL_ROW_112_1726 VDD VSS gf180mcu_fd_sc_mcu7t5v0__filltie
XFILLER_88_334 VDD VDD VSS VSS gf180mcu_fd_sc_mcu7t5v0__fillcap_4
XFILLER_131_976 VDD VDD VSS VSS gf180mcu_fd_sc_mcu7t5v0__fillcap_4
XFILLER_89_868 VDD VDD VSS VSS gf180mcu_fd_sc_mcu7t5v0__fillcap_16
Xwave_controller_y_inst__2942_ wave_controller_y_inst__1783_/I wave_controller_y_inst__1816_/I
+ wave_controller_y_inst__2942_/Z VDD VDD VSS VSS gf180mcu_fd_sc_mcu7t5v0__xor2_1
XFILLER_102_177 VDD VDD VSS VSS gf180mcu_fd_sc_mcu7t5v0__fillcap_8
Xwave_controller_x_inst__2926_ wave_controller_x_inst__3189_/C wave_controller_x_inst__3406_/A1
+ wave_controller_x_inst__3590_/I0 VDD VDD VSS VSS gf180mcu_fd_sc_mcu7t5v0__nor2_1
XTAP_TAPCELL_ROW_145_2269 VDD VSS gf180mcu_fd_sc_mcu7t5v0__filltie
Xwave_controller_y_inst__2873_ wave_controller_y_inst__2870_/Z wave_controller_y_inst__2873_/A2
+ wave_controller_y_inst__2879_/A2 wave_controller_y_inst__2874_/A2 VDD VDD VSS VSS
+ gf180mcu_fd_sc_mcu7t5v0__nor3_1
Xwave_controller_x_inst__2857_ wave_controller_x_inst__3698_/Q wave_controller_x_inst__3482_/A1
+ wave_controller_x_inst__2880_/A1 VDD VDD VSS VSS gf180mcu_fd_sc_mcu7t5v0__nand2_1
XFILLER_29_489 VDD VDD VSS VSS gf180mcu_fd_sc_mcu7t5v0__fill_1
XFILLER_72_713 VDD VDD VSS VSS gf180mcu_fd_sc_mcu7t5v0__fillcap_4
XTAP_TAPCELL_ROW_162_2550 VDD VSS gf180mcu_fd_sc_mcu7t5v0__filltie
XTAP_TAPCELL_ROW_25_1_516 VDD VSS gf180mcu_fd_sc_mcu7t5v0__filltie
Xwave_controller_y_inst__1824_ fanout502/Z wave_controller_y_inst__2952_/A2 VDD VDD
+ VSS VSS gf180mcu_fd_sc_mcu7t5v0__clkinv_1
Xwave_controller_x_inst__2788_ spi_regs_inst__1332_/A1 wave_controller_x_inst__2805_/S
+ wave_controller_x_inst__2789_/B VDD VDD VSS VSS gf180mcu_fd_sc_mcu7t5v0__nand2_1
Xwave_controller_x_inst__1808_ spi_regs_inst__1556_/Q wave_controller_x_inst__3332_/A2
+ VDD VDD VSS VSS gf180mcu_fd_sc_mcu7t5v0__clkinv_1
XFILLER_44_448 VDD VDD VSS VSS gf180mcu_fd_sc_mcu7t5v0__fillcap_4
XFILLER_71_212 VDD VDD VSS VSS gf180mcu_fd_sc_mcu7t5v0__fillcap_8
XTAP_TAPCELL_ROW_127_1980 VDD VSS gf180mcu_fd_sc_mcu7t5v0__filltie
Xwave_controller_x_inst_fanout35 wave_controller_x_inst__3493_/Z wave_controller_x_inst__3537_/A2
+ VDD VDD VSS VSS gf180mcu_fd_sc_mcu7t5v0__dlyb_1
XFILLER_112_53 VDD VDD VSS VSS gf180mcu_fd_sc_mcu7t5v0__fill_2
XFILLER_24_150 VDD VDD VSS VSS gf180mcu_fd_sc_mcu7t5v0__fill_2
Xwave_controller_y_inst__3425_ spi_regs_inst__1091_/A1 wave_controller_y_inst__3454_/A2
+ wave_controller_y_inst__3426_/A3 VDD VDD VSS VSS gf180mcu_fd_sc_mcu7t5v0__nor2_1
XFILLER_158_807 VDD VDD VSS VSS gf180mcu_fd_sc_mcu7t5v0__fillcap_64
XFILLER_52_492 VDD VDD VSS VSS gf180mcu_fd_sc_mcu7t5v0__fill_1
XTAP_TAPCELL_ROW_123_1899 VDD VSS gf180mcu_fd_sc_mcu7t5v0__filltie
Xwave_controller_x_inst__3409_ wave_controller_x_inst__3699_/Q wave_controller_x_inst__3496_/B
+ wave_controller_x_inst__3409_/A3 wave_controller_x_inst__3410_/A2 VDD VDD VSS VSS
+ gf180mcu_fd_sc_mcu7t5v0__nand3_1
XFILLER_12_356 VDD VDD VSS VSS gf180mcu_fd_sc_mcu7t5v0__fillcap_8
XPHY_EDGE_ROW_117_Right_117 VDD VSS gf180mcu_fd_sc_mcu7t5v0__endcap
Xwave_controller_y_inst__3356_ wave_controller_y_inst__3354_/Z wave_controller_y_inst__3394_/A3
+ wave_controller_y_inst__3356_/Z VDD VDD VSS VSS gf180mcu_fd_sc_mcu7t5v0__or2_1
XFILLER_138_531 VDD VDD VSS VSS gf180mcu_fd_sc_mcu7t5v0__fill_2
Xwave_controller_y_inst__3287_ wave_controller_y_inst__3704_/Q spi_regs_inst__1602_/Q
+ wave_controller_y_inst__3288_/I VDD VDD VSS VSS gf180mcu_fd_sc_mcu7t5v0__xor2_1
Xwave_controller_y_inst__2307_ wave_controller_y_inst__2304_/Z wave_controller_y_inst__2306_/I
+ wave_controller_y_inst__2343_/A1 VDD VDD VSS VSS gf180mcu_fd_sc_mcu7t5v0__xnor2_1
XFILLER_126_737 VDD VDD VSS VSS gf180mcu_fd_sc_mcu7t5v0__fillcap_16
XFILLER_138_597 VDD VDD VSS VSS gf180mcu_fd_sc_mcu7t5v0__fillcap_4
Xwave_controller_y_inst__2238_ wave_controller_y_inst__2259_/C wave_controller_y_inst__2257_/A2
+ wave_controller_y_inst__2242_/A2 VDD VDD VSS VSS gf180mcu_fd_sc_mcu7t5v0__nand2_1
XFILLER_153_556 VDD VDD VSS VSS gf180mcu_fd_sc_mcu7t5v0__fillcap_4
XFILLER_4_511 VDD VDD VSS VSS gf180mcu_fd_sc_mcu7t5v0__fillcap_4
XFILLER_107_973 VDD VDD VSS VSS gf180mcu_fd_sc_mcu7t5v0__fillcap_4
XFILLER_137_72 VDD VDD VSS VSS gf180mcu_fd_sc_mcu7t5v0__fillcap_8
XFILLER_97_10 VDD VDD VSS VSS gf180mcu_fd_sc_mcu7t5v0__fillcap_4
Xwave_controller_y_inst__2169_ wave_controller_y_inst__2157_/Z wave_controller_y_inst__2170_/A2
+ wave_controller_y_inst__2169_/B wave_controller_y_inst__2221_/A1 VDD VDD VSS VSS
+ gf180mcu_fd_sc_mcu7t5v0__oai21_1
XFILLER_140_217 VDD VDD VSS VSS gf180mcu_fd_sc_mcu7t5v0__fill_2
XFILLER_79_301 VDD VDD VSS VSS gf180mcu_fd_sc_mcu7t5v0__fill_1
XFILLER_79_334 VDD VDD VSS VSS gf180mcu_fd_sc_mcu7t5v0__fill_1
XFILLER_130_1011 VDD VDD VSS VSS gf180mcu_fd_sc_mcu7t5v0__fillcap_4
Xspi_regs_inst_hold689 spi_regs_inst__1460_/Q spi_regs_inst__1461_/D VDD VDD VSS VSS
+ gf180mcu_fd_sc_mcu7t5v0__dlyc_1
XFILLER_63_702 VDD VDD VSS VSS gf180mcu_fd_sc_mcu7t5v0__fillcap_16
XFILLER_75_562 VDD VDD VSS VSS gf180mcu_fd_sc_mcu7t5v0__fillcap_8
XTAP_TAPCELL_ROW_19_1_474 VDD VSS gf180mcu_fd_sc_mcu7t5v0__filltie
Xspi_regs_inst__1663_ spi_regs_inst__1663_/D fanout560/Z clkbuf_leaf_6_clk/Z spi_regs_inst__1663_/Q
+ VDD VDD VSS VSS gf180mcu_fd_sc_mcu7t5v0__dffrnq_1
XFILLER_15_150 VDD VDD VSS VSS gf180mcu_fd_sc_mcu7t5v0__fillcap_8
XFILLER_43_470 VDD VDD VSS VSS gf180mcu_fd_sc_mcu7t5v0__fill_2
XFILLER_149_829 VDD VDD VSS VSS gf180mcu_fd_sc_mcu7t5v0__fillcap_8
XFILLER_43_492 VDD VDD VSS VSS gf180mcu_fd_sc_mcu7t5v0__fillcap_4
Xspi_regs_inst__1594_ spi_regs_inst__1594_/D spi_regs_inst__1610_/RN clkload17/I spi_regs_inst__1594_/Q
+ VDD VDD VSS VSS gf180mcu_fd_sc_mcu7t5v0__dffrnq_1
XFILLER_87_4 VDD VDD VSS VSS gf180mcu_fd_sc_mcu7t5v0__fill_1
XFILLER_7_360 VDD VDD VSS VSS gf180mcu_fd_sc_mcu7t5v0__fill_1
XFILLER_102_1157 VDD VDD VSS VSS gf180mcu_fd_sc_mcu7t5v0__fillcap_8
XTAP_TAPCELL_ROW_96_1467 VDD VSS gf180mcu_fd_sc_mcu7t5v0__filltie
XTAP_TAPCELL_ROW_96_1456 VDD VSS gf180mcu_fd_sc_mcu7t5v0__filltie
XFILLER_144_578 VDD VDD VSS VSS gf180mcu_fd_sc_mcu7t5v0__fillcap_16
XFILLER_113_976 VDD VDD VSS VSS gf180mcu_fd_sc_mcu7t5v0__fillcap_4
Xspi_regs_inst__1028_ spi_regs_inst__1028_/A1 spi_regs_inst__1028_/A2 spi_regs_inst__1132_/B1
+ VDD VDD VSS VSS gf180mcu_fd_sc_mcu7t5v0__nor2_1
XFILLER_85_315 VDD VDD VSS VSS gf180mcu_fd_sc_mcu7t5v0__fill_2
XFILLER_86_827 VDD VDD VSS VSS gf180mcu_fd_sc_mcu7t5v0__fill_2
XFILLER_100_659 VDD VDD VSS VSS gf180mcu_fd_sc_mcu7t5v0__fillcap_4
Xwave_controller_x_inst__3691_ wave_controller_x_inst__3691_/D wave_controller_x_inst__3715_/RN
+ clkbuf_leaf_25_clk/Z spi_regs_inst__1059_/A1 VDD VDD VSS VSS gf180mcu_fd_sc_mcu7t5v0__dffrnq_1
Xwave_controller_x_inst__2711_ wave_controller_x_inst__2713_/A1 wave_controller_x_inst__2713_/A2
+ wave_controller_x_inst__2711_/Z VDD VDD VSS VSS gf180mcu_fd_sc_mcu7t5v0__or2_1
XFILLER_54_702 VDD VDD VSS VSS gf180mcu_fd_sc_mcu7t5v0__fill_1
Xwave_controller_x_inst__2642_ max_cap463/Z wave_controller_x_inst__2640_/Z wave_controller_x_inst__2642_/Z
+ VDD VDD VSS VSS gf180mcu_fd_sc_mcu7t5v0__xor2_1
XFILLER_93_381 VDD VDD VSS VSS gf180mcu_fd_sc_mcu7t5v0__fill_1
XFILLER_94_893 VDD VDD VSS VSS gf180mcu_fd_sc_mcu7t5v0__fillcap_4
Xwave_controller_x_inst__2573_ fanout524/Z wave_controller_x_inst__2557_/Z wave_controller_x_inst__2573_/B
+ wave_controller_x_inst__2575_/A2 VDD VDD VSS VSS gf180mcu_fd_sc_mcu7t5v0__oai21_1
XFILLER_41_418 VDD VDD VSS VSS gf180mcu_fd_sc_mcu7t5v0__fill_2
XTAP_TAPCELL_ROW_140_2188 VDD VSS gf180mcu_fd_sc_mcu7t5v0__filltie
XFILLER_107_1046 VDD VDD VSS VSS gf180mcu_fd_sc_mcu7t5v0__fillcap_4
XFILLER_167_648 VDD VDD VSS VSS gf180mcu_fd_sc_mcu7t5v0__fillcap_32
XFILLER_21_142 VDD VDD VSS VSS gf180mcu_fd_sc_mcu7t5v0__fillcap_32
Xwave_controller_y_inst__3210_ wave_controller_y_inst__3209_/B wave_controller_y_inst__3207_/Z
+ wave_controller_y_inst__3210_/A3 wave_controller_y_inst__3241_/B1 VDD VDD VSS VSS
+ gf180mcu_fd_sc_mcu7t5v0__nand3_1
Xwave_controller_y_inst__3141_ wave_controller_y_inst__3128_/I wave_controller_y_inst__3228_/A1
+ wave_controller_y_inst__3141_/B wave_controller_y_inst__3225_/A1 VDD VDD VSS VSS
+ gf180mcu_fd_sc_mcu7t5v0__aoi21_1
Xwave_controller_x_inst__3125_ wave_controller_x_inst__3564_/A1 spi_regs_inst__1523_/Q
+ wave_controller_x_inst__3126_/I VDD VDD VSS VSS gf180mcu_fd_sc_mcu7t5v0__nand2_1
XFILLER_108_726 VDD VDD VSS VSS gf180mcu_fd_sc_mcu7t5v0__fillcap_8
XFILLER_107_236 VDD VDD VSS VSS gf180mcu_fd_sc_mcu7t5v0__fill_1
XFILLER_135_523 VDD VDD VSS VSS gf180mcu_fd_sc_mcu7t5v0__fillcap_8
Xwave_controller_y_inst__3072_ wave_controller_y_inst__3312_/A1 wave_controller_y_inst__3090_/B1
+ wave_controller_y_inst__3071_/Z wave_controller_y_inst__2762_/I wave_controller_y_inst__3712_/D
+ VDD VDD VSS VSS gf180mcu_fd_sc_mcu7t5v0__oai22_1
Xwave_controller_x_inst__3056_ wave_controller_x_inst__3091_/A1 wave_controller_x_inst__3056_/A2
+ wave_controller_x_inst__3057_/B2 VDD VDD VSS VSS gf180mcu_fd_sc_mcu7t5v0__nand2_1
XFILLER_135_578 VDD VDD VSS VSS gf180mcu_fd_sc_mcu7t5v0__fillcap_8
XFILLER_150_504 VDD VDD VSS VSS gf180mcu_fd_sc_mcu7t5v0__fill_2
XTAP_TAPCELL_ROW_36_1_599 VDD VSS gf180mcu_fd_sc_mcu7t5v0__filltie
Xwave_controller_y_inst__2023_ fanout511/Z spi_regs_inst__1099_/A1 wave_controller_y_inst__2023_/A3
+ spi_regs_inst__1108_/A1 VDD VDD VSS VSS gf180mcu_fd_sc_mcu7t5v0__xor3_1
Xwave_controller_x_inst__2007_ wave_controller_x_inst__2671_/A1 spi_regs_inst__1309_/C2
+ wave_controller_x_inst__2016_/C VDD VDD VSS VSS gf180mcu_fd_sc_mcu7t5v0__nand2_1
XFILLER_122_206 VDD VDD VSS VSS gf180mcu_fd_sc_mcu7t5v0__fillcap_32
XFILLER_150_515 VDD VDD VSS VSS gf180mcu_fd_sc_mcu7t5v0__fillcap_8
XFILLER_89_632 VDD VDD VSS VSS gf180mcu_fd_sc_mcu7t5v0__fillcap_16
XTAP_TAPCELL_ROW_147_2309 VDD VSS gf180mcu_fd_sc_mcu7t5v0__filltie
XFILLER_114_1017 VDD VDD VSS VSS gf180mcu_fd_sc_mcu7t5v0__fillcap_64
Xspi_regs_inst_fanout337 spi_regs_inst__0960_/ZN spi_regs_inst__1027_/A1 VDD VDD VSS
+ VSS gf180mcu_fd_sc_mcu7t5v0__dlyb_1
Xwave_controller_y_inst__2925_ wave_controller_y_inst__3589_/I0 spi_regs_inst__1099_/A1
+ wave_controller_y_inst__2929_/S wave_controller_y_inst__3687_/D VDD VDD VSS VSS
+ gf180mcu_fd_sc_mcu7t5v0__mux2_2
Xwave_controller_x_inst__2909_ wave_controller_x_inst__2764_/Z wave_controller_x_inst__2909_/A2
+ wave_controller_x_inst__2909_/A3 wave_controller_x_inst__2934_/A2 VDD VDD VSS VSS
+ gf180mcu_fd_sc_mcu7t5v0__nor3_1
XFILLER_57_562 VDD VDD VSS VSS gf180mcu_fd_sc_mcu7t5v0__fillcap_32
XFILLER_92_819 VDD VDD VSS VSS gf180mcu_fd_sc_mcu7t5v0__fill_2
XTAP_TAPCELL_ROW_160_2509 VDD VSS gf180mcu_fd_sc_mcu7t5v0__filltie
Xwave_controller_y_inst__2856_ wave_controller_y_inst__2768_/Z wave_controller_y_inst__2889_/A2
+ wave_controller_y_inst__2856_/Z VDD VDD VSS VSS gf180mcu_fd_sc_mcu7t5v0__or2_1
XTAP_TAPCELL_ROW_125_1939 VDD VSS gf180mcu_fd_sc_mcu7t5v0__filltie
Xwave_controller_y_inst__1807_ spi_regs_inst__1618_/Q wave_controller_y_inst__3338_/A2
+ VDD VDD VSS VSS gf180mcu_fd_sc_mcu7t5v0__clkinv_1
XFILLER_17_448 VDD VDD VSS VSS gf180mcu_fd_sc_mcu7t5v0__fill_2
XFILLER_72_543 VDD VDD VSS VSS gf180mcu_fd_sc_mcu7t5v0__fillcap_4
Xwave_controller_y_inst__2787_ wave_controller_y_inst__2787_/I wave_controller_y_inst__2817_/A2
+ VDD VDD VSS VSS gf180mcu_fd_sc_mcu7t5v0__clkinv_1
XFILLER_32_418 VDD VDD VSS VSS gf180mcu_fd_sc_mcu7t5v0__fillcap_4
XFILLER_77_1170 VDD VDD VSS VSS gf180mcu_fd_sc_mcu7t5v0__fillcap_4
XTAP_TAPCELL_ROW_55_785 VDD VSS gf180mcu_fd_sc_mcu7t5v0__filltie
XTAP_TAPCELL_ROW_80_1202 VDD VSS gf180mcu_fd_sc_mcu7t5v0__filltie
XFILLER_164_1151 VDD VDD VSS VSS gf180mcu_fd_sc_mcu7t5v0__fillcap_4
XFILLER_25_492 VDD VDD VSS VSS gf180mcu_fd_sc_mcu7t5v0__fill_2
XFILLER_157_103 VDD VDD VSS VSS gf180mcu_fd_sc_mcu7t5v0__fill_2
XFILLER_164_1173 VDD VDD VSS VSS gf180mcu_fd_sc_mcu7t5v0__fill_1
Xwave_controller_y_inst__3408_ wave_controller_y_inst__3408_/A1 wire434/I wave_controller_y_inst__3410_/A1
+ VDD VDD VSS VSS gf180mcu_fd_sc_mcu7t5v0__nand2_1
XFILLER_157_158 VDD VDD VSS VSS gf180mcu_fd_sc_mcu7t5v0__fillcap_4
XFILLER_158_659 VDD VDD VSS VSS gf180mcu_fd_sc_mcu7t5v0__fillcap_4
Xwave_controller_y_inst__3339_ wave_controller_y_inst__3402_/C wave_controller_y_inst__3402_/A2
+ wave_controller_y_inst__3344_/A1 VDD VDD VSS VSS gf180mcu_fd_sc_mcu7t5v0__nand2_1
XFILLER_32_93 VDD VDD VSS VSS gf180mcu_fd_sc_mcu7t5v0__fillcap_4
XFILLER_99_407 VDD VDD VSS VSS gf180mcu_fd_sc_mcu7t5v0__fill_1
XPHY_EDGE_ROW_112_Left_279 VDD VSS gf180mcu_fd_sc_mcu7t5v0__endcap
XTAP_TAPCELL_ROW_78_1164 VDD VSS gf180mcu_fd_sc_mcu7t5v0__filltie
XFILLER_141_559 VDD VDD VSS VSS gf180mcu_fd_sc_mcu7t5v0__fill_1
XFILLER_110_913 VDD VDD VSS VSS gf180mcu_fd_sc_mcu7t5v0__fillcap_32
XFILLER_68_838 VDD VDD VSS VSS gf180mcu_fd_sc_mcu7t5v0__fillcap_8
XFILLER_95_613 VDD VDD VSS VSS gf180mcu_fd_sc_mcu7t5v0__fill_1
XTAP_TAPCELL_ROW_91_1375 VDD VSS gf180mcu_fd_sc_mcu7t5v0__filltie
XTAP_TAPCELL_ROW_91_1386 VDD VSS gf180mcu_fd_sc_mcu7t5v0__filltie
Xsignal_processor_y_inst__191_ signal_processor_y_inst__242_/Q signal_processor_y_inst__191_/A2
+ signal_processor_y_inst__185_/I signal_processor_y_inst__191_/B signal_processor_y_inst__242_/D
+ VDD VDD VSS VSS gf180mcu_fd_sc_mcu7t5v0__oai31_1
XFILLER_94_123 VDD VDD VSS VSS gf180mcu_fd_sc_mcu7t5v0__fillcap_8
Xwave_controller_x_inst_fanout381 wave_controller_x_inst__3090_/B2 wave_controller_x_inst__3340_/A1
+ VDD VDD VSS VSS gf180mcu_fd_sc_mcu7t5v0__dlyb_1
XFILLER_35_212 VDD VDD VSS VSS gf180mcu_fd_sc_mcu7t5v0__fillcap_8
XFILLER_82_329 VDD VDD VSS VSS gf180mcu_fd_sc_mcu7t5v0__fill_2
XPHY_EDGE_ROW_121_Left_288 VDD VSS gf180mcu_fd_sc_mcu7t5v0__endcap
XFILLER_35_278 VDD VDD VSS VSS gf180mcu_fd_sc_mcu7t5v0__fill_2
XFILLER_90_351 VDD VDD VSS VSS gf180mcu_fd_sc_mcu7t5v0__fillcap_4
XFILLER_90_384 VDD VDD VSS VSS gf180mcu_fd_sc_mcu7t5v0__fill_1
XFILLER_16_481 VDD VDD VSS VSS gf180mcu_fd_sc_mcu7t5v0__fill_2
XFILLER_90_395 VDD VDD VSS VSS gf180mcu_fd_sc_mcu7t5v0__fill_2
Xspi_regs_inst__1646_ spi_regs_inst__1646_/D spi_regs_inst__1649_/RN clkload18/I spi_regs_inst__1646_/Q
+ VDD VDD VSS VSS gf180mcu_fd_sc_mcu7t5v0__dffrnq_1
XFILLER_148_103 VDD VDD VSS VSS gf180mcu_fd_sc_mcu7t5v0__fill_2
XFILLER_149_626 VDD VDD VSS VSS gf180mcu_fd_sc_mcu7t5v0__fillcap_4
Xspi_regs_inst__1577_ spi_regs_inst__1577_/D fanout566/Z clkbuf_leaf_9_clk/Z spi_regs_inst__1577_/Q
+ VDD VDD VSS VSS gf180mcu_fd_sc_mcu7t5v0__dffrnq_1
XFILLER_31_484 VDD VDD VSS VSS gf180mcu_fd_sc_mcu7t5v0__fillcap_4
XFILLER_89_1052 VDD VDD VSS VSS gf180mcu_fd_sc_mcu7t5v0__fillcap_64
XPHY_EDGE_ROW_130_Left_297 VDD VSS gf180mcu_fd_sc_mcu7t5v0__endcap
XTAP_TAPCELL_ROW_24_1_515 VDD VSS gf180mcu_fd_sc_mcu7t5v0__filltie
XFILLER_132_559 VDD VDD VSS VSS gf180mcu_fd_sc_mcu7t5v0__fillcap_4
XPHY_EDGE_ROW_27_1_Right_26 VDD VSS gf180mcu_fd_sc_mcu7t5v0__endcap
XTAP_TAPCELL_ROW_129_2006 VDD VSS gf180mcu_fd_sc_mcu7t5v0__filltie
XTAP_TAPCELL_ROW_32_1_572 VDD VSS gf180mcu_fd_sc_mcu7t5v0__filltie
Xfanout615 fanout616/Z fanout615/Z VDD VDD VSS VSS gf180mcu_fd_sc_mcu7t5v0__dlyb_1
XFILLER_58_304 VDD VDD VSS VSS gf180mcu_fd_sc_mcu7t5v0__fillcap_8
XFILLER_86_613 VDD VDD VSS VSS gf180mcu_fd_sc_mcu7t5v0__fill_2
XFILLER_100_423 VDD VDD VSS VSS gf180mcu_fd_sc_mcu7t5v0__fillcap_16
XFILLER_112_272 VDD VDD VSS VSS gf180mcu_fd_sc_mcu7t5v0__fillcap_4
XFILLER_112_283 VDD VDD VSS VSS gf180mcu_fd_sc_mcu7t5v0__fill_1
XTAP_TAPCELL_ROW_142_2217 VDD VSS gf180mcu_fd_sc_mcu7t5v0__filltie
Xwave_controller_y_inst__2710_ wave_controller_y_inst__2646_/B wave_controller_y_inst__2681_/C
+ wave_controller_y_inst__2710_/A3 wave_controller_y_inst__2712_/A2 wave_controller_y_inst__2713_/A2
+ VDD VDD VSS VSS gf180mcu_fd_sc_mcu7t5v0__nand4_1
Xwave_controller_y_inst__3690_ wave_controller_y_inst__3690_/D wave_controller_y_inst__3721_/RN
+ clkload4/I spi_regs_inst__1254_/A1 VDD VDD VSS VSS gf180mcu_fd_sc_mcu7t5v0__dffrnq_1
XTAP_TAPCELL_ROW_142_2228 VDD VSS gf180mcu_fd_sc_mcu7t5v0__filltie
Xwave_controller_y_inst__2641_ spi_regs_inst__1256_/A1 wave_controller_y_inst__2640_/Z
+ wave_controller_y_inst__2664_/A2 VDD VDD VSS VSS gf180mcu_fd_sc_mcu7t5v0__nand2_1
Xwave_controller_x_inst__3674_ wave_controller_x_inst__3674_/D wave_controller_x_inst__3704_/RN
+ clkload36/I spi_regs_inst__1254_/B2 VDD VDD VSS VSS gf180mcu_fd_sc_mcu7t5v0__dffrnq_1
XFILLER_82_841 VDD VDD VSS VSS gf180mcu_fd_sc_mcu7t5v0__fillcap_16
XTAP_TAPCELL_ROW_107_1636 VDD VSS gf180mcu_fd_sc_mcu7t5v0__filltie
XTAP_TAPCELL_ROW_107_1647 VDD VSS gf180mcu_fd_sc_mcu7t5v0__filltie
Xwave_controller_x_inst__2625_ wave_controller_x_inst__2625_/I wave_controller_x_inst__2626_/B
+ VDD VDD VSS VSS gf180mcu_fd_sc_mcu7t5v0__clkinv_1
XFILLER_148_1157 VDD VDD VSS VSS gf180mcu_fd_sc_mcu7t5v0__fillcap_8
Xwave_controller_y_inst__2572_ spi_regs_inst__1045_/B2 wave_controller_y_inst__2570_/Z
+ wave_controller_y_inst__2572_/Z VDD VDD VSS VSS gf180mcu_fd_sc_mcu7t5v0__xor2_1
Xwave_controller_x_inst__2556_ wave_controller_x_inst__2556_/A1 wave_controller_x_inst__2552_/Z
+ wave_controller_x_inst__2556_/B wave_controller_x_inst__2556_/C wave_controller_x_inst__2567_/A2
+ VDD VDD VSS VSS gf180mcu_fd_sc_mcu7t5v0__aoi211_1
XFILLER_81_384 VDD VDD VSS VSS gf180mcu_fd_sc_mcu7t5v0__fillcap_16
XTAP_TAPCELL_ROW_120_1858 VDD VSS gf180mcu_fd_sc_mcu7t5v0__filltie
Xwave_controller_x_inst__2487_ wave_controller_x_inst__2793_/I0 wave_controller_x_inst__3509_/B2
+ wave_controller_x_inst__2501_/B VDD VDD VSS VSS gf180mcu_fd_sc_mcu7t5v0__nand2_1
XTAP_TAPCELL_ROW_157_2460 VDD VSS gf180mcu_fd_sc_mcu7t5v0__filltie
XTAP_TAPCELL_ROW_157_2471 VDD VSS gf180mcu_fd_sc_mcu7t5v0__filltie
XFILLER_139_158 VDD VDD VSS VSS gf180mcu_fd_sc_mcu7t5v0__fillcap_4
XFILLER_155_629 VDD VDD VSS VSS gf180mcu_fd_sc_mcu7t5v0__fill_1
XFILLER_167_478 VDD VDD VSS VSS gf180mcu_fd_sc_mcu7t5v0__fillcap_8
Xwave_controller_y_inst__3124_ wave_controller_y_inst__3290_/A1 spi_regs_inst__1587_/Q
+ wave_controller_y_inst__3146_/C VDD VDD VSS VSS gf180mcu_fd_sc_mcu7t5v0__nand2_1
Xwave_controller_x_inst__3108_ wave_controller_x_inst__3265_/A1 spi_regs_inst__1533_/Q
+ wave_controller_x_inst__3197_/A1 VDD VDD VSS VSS gf180mcu_fd_sc_mcu7t5v0__nor2_1
XFILLER_120_1087 VDD VDD VSS VSS gf180mcu_fd_sc_mcu7t5v0__fillcap_64
Xwave_controller_y_inst__3055_ wave_controller_y_inst__2951_/I wave_controller_y_inst__3055_/A2
+ wave_controller_y_inst__3055_/B wave_controller_y_inst__3057_/B1 VDD VDD VSS VSS
+ gf180mcu_fd_sc_mcu7t5v0__aoi21_1
Xwave_controller_x_inst__3039_ wave_controller_x_inst__2910_/B wave_controller_x_inst__3081_/C
+ wave_controller_x_inst__3039_/ZN VDD VDD VSS VSS gf180mcu_fd_sc_mcu7t5v0__nand2_1
XFILLER_150_301 VDD VDD VSS VSS gf180mcu_fd_sc_mcu7t5v0__fillcap_8
XFILLER_151_835 VDD VDD VSS VSS gf180mcu_fd_sc_mcu7t5v0__fillcap_4
Xwave_controller_y_inst__2006_ fanout516/Z spi_regs_inst__1278_/A1 wave_controller_y_inst__2006_/A3
+ spi_regs_inst__1272_/B2 VDD VDD VSS VSS gf180mcu_fd_sc_mcu7t5v0__xor3_1
XFILLER_123_559 VDD VDD VSS VSS gf180mcu_fd_sc_mcu7t5v0__fill_1
XTAP_TAPCELL_ROW_73_1083 VDD VSS gf180mcu_fd_sc_mcu7t5v0__filltie
XFILLER_103_294 VDD VDD VSS VSS gf180mcu_fd_sc_mcu7t5v0__fill_2
Xwave_controller_y_inst__2908_ wave_controller_y_inst__2908_/A1 wave_controller_y_inst__2933_/A2
+ wave_controller_y_inst__2908_/B1 wave_controller_y_inst__2764_/Z wave_controller_y_inst__3722_/D
+ VDD VDD VSS VSS gf180mcu_fd_sc_mcu7t5v0__oai22_1
XFILLER_17_201 VDD VDD VSS VSS gf180mcu_fd_sc_mcu7t5v0__fillcap_8
XFILLER_17_212 VDD VDD VSS VSS gf180mcu_fd_sc_mcu7t5v0__fillcap_4
XFILLER_58_893 VDD VDD VSS VSS gf180mcu_fd_sc_mcu7t5v0__fill_2
XFILLER_17_245 VDD VDD VSS VSS gf180mcu_fd_sc_mcu7t5v0__fillcap_8
XFILLER_45_554 VDD VDD VSS VSS gf180mcu_fd_sc_mcu7t5v0__fill_1
Xwave_controller_y_inst__2839_ wave_controller_y_inst__2839_/A1 wave_controller_y_inst__2839_/A2
+ wave_controller_y_inst__2839_/B wave_controller_y_inst__2852_/A1 VDD VDD VSS VSS
+ gf180mcu_fd_sc_mcu7t5v0__oai21_1
XFILLER_150_72 VDD VDD VSS VSS gf180mcu_fd_sc_mcu7t5v0__fillcap_16
XFILLER_60_513 VDD VDD VSS VSS gf180mcu_fd_sc_mcu7t5v0__fillcap_8
XFILLER_72_373 VDD VDD VSS VSS gf180mcu_fd_sc_mcu7t5v0__fill_2
Xspi_regs_inst__1500_ spi_regs_inst__1500_/D spi_regs_inst__1527_/RN clkload32/I spi_regs_inst__1500_/Q
+ VDD VDD VSS VSS gf180mcu_fd_sc_mcu7t5v0__dffrnq_1
XFILLER_72_395 VDD VDD VSS VSS gf180mcu_fd_sc_mcu7t5v0__fill_2
XFILLER_60_568 VDD VDD VSS VSS gf180mcu_fd_sc_mcu7t5v0__fillcap_4
Xspi_regs_inst__1431_ spi_regs_inst__1501_/Q spi_regs_inst_wire487/Z spi_regs_inst__1436_/S
+ spi_regs_inst__1501_/D VDD VDD VSS VSS gf180mcu_fd_sc_mcu7t5v0__mux2_2
Xspi_regs_inst__1362_ spi_regs_inst__1362_/A1 spi_regs_inst__1360_/Z spi_regs_inst__1362_/A3
+ spi_regs_inst__1362_/B spi_regs_inst__1649_/D VDD VDD VSS VSS gf180mcu_fd_sc_mcu7t5v0__oai31_1
XFILLER_158_467 VDD VDD VSS VSS gf180mcu_fd_sc_mcu7t5v0__fillcap_4
Xspi_regs_inst__1293_ spi_regs_inst__1567_/Q spi_regs_inst__1339_/A2 spi_regs_inst__1357_/B
+ spi_regs_inst__1294_/A4 VDD VDD VSS VSS gf180mcu_fd_sc_mcu7t5v0__aoi21_1
XTAP_TAPCELL_ROW_93_1415 VDD VSS gf180mcu_fd_sc_mcu7t5v0__filltie
XTAP_TAPCELL_ROW_93_1404 VDD VSS gf180mcu_fd_sc_mcu7t5v0__filltie
XFILLER_114_515 VDD VDD VSS VSS gf180mcu_fd_sc_mcu7t5v0__fillcap_8
XFILLER_126_364 VDD VDD VSS VSS gf180mcu_fd_sc_mcu7t5v0__fillcap_16
XFILLER_126_397 VDD VDD VSS VSS gf180mcu_fd_sc_mcu7t5v0__fillcap_16
XFILLER_141_323 VDD VDD VSS VSS gf180mcu_fd_sc_mcu7t5v0__fillcap_8
XFILLER_4_171 VDD VDD VSS VSS gf180mcu_fd_sc_mcu7t5v0__fillcap_4
Xsignal_processor_y_inst__243_ signal_processor_y_inst__243_/D fanout545/Z clkload1/I
+ wave_controller_y_inst__1890_/I VDD VDD VSS VSS gf180mcu_fd_sc_mcu7t5v0__dffrnq_1
XFILLER_96_944 VDD VDD VSS VSS gf180mcu_fd_sc_mcu7t5v0__fill_1
Xsignal_processor_y_inst__174_ signal_processor_y_inst__236_/Q signal_processor_y_inst__175_/A2
+ signal_processor_y_inst__193_/A2 VDD VDD VSS VSS gf180mcu_fd_sc_mcu7t5v0__xnor2_1
XFILLER_68_679 VDD VDD VSS VSS gf180mcu_fd_sc_mcu7t5v0__fill_2
XFILLER_95_443 VDD VDD VSS VSS gf180mcu_fd_sc_mcu7t5v0__fill_1
XFILLER_95_465 VDD VDD VSS VSS gf180mcu_fd_sc_mcu7t5v0__fill_2
XFILLER_95_476 VDD VDD VSS VSS gf180mcu_fd_sc_mcu7t5v0__fillcap_8
XFILLER_36_521 VDD VDD VSS VSS gf180mcu_fd_sc_mcu7t5v0__fillcap_4
XFILLER_23_204 VDD VDD VSS VSS gf180mcu_fd_sc_mcu7t5v0__fillcap_4
XFILLER_63_362 VDD VDD VSS VSS gf180mcu_fd_sc_mcu7t5v0__fillcap_16
Xwave_controller_x_inst__3390_ wave_controller_x_inst__3209_/B wave_controller_x_inst__3363_/Z
+ wave_controller_x_inst__3390_/B1 wave_controller_x_inst__3390_/B2 wave_controller_x_inst__3390_/C
+ wave_controller_x_inst__3392_/B1 VDD VDD VSS VSS gf180mcu_fd_sc_mcu7t5v0__aoi221_1
Xwave_controller_x_inst__2410_ wave_controller_x_inst__2436_/A1 wave_controller_x_inst__2422_/A2
+ spi_regs_inst__1044_/A1 VDD VDD VSS VSS gf180mcu_fd_sc_mcu7t5v0__xor2_1
Xwave_controller_x_inst__2341_ wave_controller_x_inst__2338_/Z wave_controller_x_inst__2341_/A2
+ wave_controller_x_inst__2373_/A1 VDD VDD VSS VSS gf180mcu_fd_sc_mcu7t5v0__xnor2_1
XTAP_TAPCELL_ROW_102_1555 VDD VSS gf180mcu_fd_sc_mcu7t5v0__filltie
Xspi_regs_inst__1629_ spi_regs_inst__1629_/D fanout583/Z clkbuf_leaf_14_clk/Z spi_regs_inst__1629_/Q
+ VDD VDD VSS VSS gf180mcu_fd_sc_mcu7t5v0__dffrnq_1
XTAP_TAPCELL_ROW_102_1566 VDD VSS gf180mcu_fd_sc_mcu7t5v0__filltie
Xwave_controller_x_inst__2272_ wave_controller_x_inst__2254_/Z wave_controller_x_inst__2272_/A2
+ wave_controller_x_inst__2272_/B wave_controller_x_inst__2275_/A3 VDD VDD VSS VSS
+ gf180mcu_fd_sc_mcu7t5v0__aoi21_1
XFILLER_164_404 VDD VDD VSS VSS gf180mcu_fd_sc_mcu7t5v0__fill_1
XTAP_TAPCELL_ROW_135_2098 VDD VSS gf180mcu_fd_sc_mcu7t5v0__filltie
XFILLER_105_504 VDD VDD VSS VSS gf180mcu_fd_sc_mcu7t5v0__fillcap_32
XFILLER_144_172 VDD VDD VSS VSS gf180mcu_fd_sc_mcu7t5v0__fill_2
XFILLER_160_621 VDD VDD VSS VSS gf180mcu_fd_sc_mcu7t5v0__fillcap_4
XTAP_TAPCELL_ROW_152_2390 VDD VSS gf180mcu_fd_sc_mcu7t5v0__filltie
XFILLER_133_879 VDD VDD VSS VSS gf180mcu_fd_sc_mcu7t5v0__fillcap_16
XFILLER_59_602 VDD VDD VSS VSS gf180mcu_fd_sc_mcu7t5v0__fillcap_4
XFILLER_113_570 VDD VDD VSS VSS gf180mcu_fd_sc_mcu7t5v0__fillcap_4
XFILLER_48_37 VDD VDD VSS VSS gf180mcu_fd_sc_mcu7t5v0__fillcap_64
XFILLER_86_432 VDD VDD VSS VSS gf180mcu_fd_sc_mcu7t5v0__fillcap_16
XFILLER_87_977 VDD VDD VSS VSS gf180mcu_fd_sc_mcu7t5v0__fill_2
Xwave_controller_x_inst__1987_ wave_controller_x_inst__1988_/A1 wave_controller_x_inst__1988_/A2
+ wave_controller_x_inst__1992_/B VDD VDD VSS VSS gf180mcu_fd_sc_mcu7t5v0__and2_1
XFILLER_101_798 VDD VDD VSS VSS gf180mcu_fd_sc_mcu7t5v0__fill_1
XFILLER_104_32 VDD VDD VSS VSS gf180mcu_fd_sc_mcu7t5v0__fill_2
XFILLER_104_54 VDD VDD VSS VSS gf180mcu_fd_sc_mcu7t5v0__fill_1
XPHY_EDGE_ROW_6_1_Right_5 VDD VSS gf180mcu_fd_sc_mcu7t5v0__endcap
XTAP_TAPCELL_ROW_57_814 VDD VSS gf180mcu_fd_sc_mcu7t5v0__filltie
XTAP_TAPCELL_ROW_57_825 VDD VSS gf180mcu_fd_sc_mcu7t5v0__filltie
Xwave_controller_x_inst__3726_ wave_controller_x_inst__3726_/D wave_controller_x_inst__3736_/RN
+ clkload26/I wave_controller_x_inst__3726_/Q VDD VDD VSS VSS gf180mcu_fd_sc_mcu7t5v0__dffrnq_1
Xwave_controller_y_inst__3673_ wave_controller_y_inst__3673_/D wave_controller_y_inst__3673_/RN
+ clkbuf_leaf_35_clk/Z max_cap423/I VDD VDD VSS VSS gf180mcu_fd_sc_mcu7t5v0__dffrnq_1
Xwave_controller_x_inst__3657_ wave_controller_x_inst__3657_/D wave_controller_x_inst__3710_/RN
+ clkbuf_leaf_31_clk/Z wire456/I VDD VDD VSS VSS gf180mcu_fd_sc_mcu7t5v0__dffrnq_1
XFILLER_82_660 VDD VDD VSS VSS gf180mcu_fd_sc_mcu7t5v0__fillcap_4
XFILLER_82_671 VDD VDD VSS VSS gf180mcu_fd_sc_mcu7t5v0__fill_2
Xwave_controller_y_inst__2624_ wave_controller_y_inst__1821_/I wave_controller_y_inst__3530_/B2
+ wave_controller_y_inst__2621_/Z wave_controller_y_inst__2625_/I VDD VDD VSS VSS
+ gf180mcu_fd_sc_mcu7t5v0__xor3_1
Xwave_controller_x_inst__2608_ wave_controller_x_inst__2608_/A1 wave_controller_x_inst__2591_/Z
+ wave_controller_x_inst__2609_/A2 VDD VDD VSS VSS gf180mcu_fd_sc_mcu7t5v0__nor2_1
Xspi_regs_inst_max_cap305 spi_regs_inst__0841_/S spi_regs_inst__0838_/S VDD VDD VSS
+ VSS gf180mcu_fd_sc_mcu7t5v0__buf_2
XTAP_TAPCELL_ROW_159_2500 VDD VSS gf180mcu_fd_sc_mcu7t5v0__filltie
Xwave_controller_y_inst__2555_ wave_controller_y_inst__2555_/A1 wave_controller_y_inst__2555_/A2
+ wave_controller_y_inst__2555_/B1 wave_controller_y_inst_wire179/Z wave_controller_y_inst__2555_/C
+ wave_controller_y_inst_wire151/I VDD VDD VSS VSS gf180mcu_fd_sc_mcu7t5v0__oai221_1
Xwave_controller_y_inst_wire352 wave_controller_y_inst__2893_/Z wave_controller_y_inst_wire352/Z
+ VDD VDD VSS VSS gf180mcu_fd_sc_mcu7t5v0__buf_2
Xwave_controller_x_inst__3588_ wave_controller_x_inst__3082_/B spi_regs_inst__1060_/A1
+ wave_controller_x_inst__3588_/S wave_controller_x_inst__3665_/D VDD VDD VSS VSS
+ gf180mcu_fd_sc_mcu7t5v0__mux2_2
XFILLER_74_1151 VDD VDD VSS VSS gf180mcu_fd_sc_mcu7t5v0__fillcap_4
Xwave_controller_x_inst__2539_ wave_controller_x_inst__3515_/B2 wave_controller_x_inst__2537_/Z
+ wave_controller_x_inst__2540_/I VDD VDD VSS VSS gf180mcu_fd_sc_mcu7t5v0__xor2_1
XFILLER_74_1173 VDD VDD VSS VSS gf180mcu_fd_sc_mcu7t5v0__fill_1
Xwave_controller_y_inst__2486_ wave_controller_y_inst__3566_/A1 wave_controller_y_inst__3509_/B2
+ wave_controller_y_inst__2501_/A1 VDD VDD VSS VSS gf180mcu_fd_sc_mcu7t5v0__nor2_1
Xsignal_processor_x_inst__194_ signal_processor_x_inst__196_/B1 signal_processor_x_inst__195_/A2
+ signal_processor_x_inst__194_/Z VDD VDD VSS VSS gf180mcu_fd_sc_mcu7t5v0__and2_1
XFILLER_127_106 VDD VDD VSS VSS gf180mcu_fd_sc_mcu7t5v0__fill_1
XFILLER_128_607 VDD VDD VSS VSS gf180mcu_fd_sc_mcu7t5v0__fill_2
XFILLER_161_1154 VDD VDD VSS VSS gf180mcu_fd_sc_mcu7t5v0__fillcap_16
Xwave_controller_y_inst__3107_ wave_controller_y_inst__3715_/Q spi_regs_inst__1597_/Q
+ wave_controller_y_inst__3107_/Z VDD VDD VSS VSS gf180mcu_fd_sc_mcu7t5v0__xor2_1
XTAP_TAPCELL_ROW_75_1112 VDD VSS gf180mcu_fd_sc_mcu7t5v0__filltie
XFILLER_108_397 VDD VDD VSS VSS gf180mcu_fd_sc_mcu7t5v0__fill_1
XFILLER_123_323 VDD VDD VSS VSS gf180mcu_fd_sc_mcu7t5v0__fill_2
XFILLER_123_345 VDD VDD VSS VSS gf180mcu_fd_sc_mcu7t5v0__fillcap_4
XFILLER_124_868 VDD VDD VSS VSS gf180mcu_fd_sc_mcu7t5v0__fill_1
XFILLER_151_632 VDD VDD VSS VSS gf180mcu_fd_sc_mcu7t5v0__fillcap_4
XFILLER_163_492 VDD VDD VSS VSS gf180mcu_fd_sc_mcu7t5v0__fillcap_8
XFILLER_97_708 VDD VDD VSS VSS gf180mcu_fd_sc_mcu7t5v0__fill_1
Xwave_controller_y_inst__3038_ wave_controller_y_inst__2895_/C wave_controller_y_inst__3038_/A2
+ wave_controller_y_inst__3700_/D VDD VDD VSS VSS gf180mcu_fd_sc_mcu7t5v0__nor2_1
Xwave_controller_x_inst_wire60 wave_controller_x_inst_wire60/I wave_controller_x_inst_wire60/Z
+ VDD VDD VSS VSS gf180mcu_fd_sc_mcu7t5v0__buf_2
XFILLER_81_1122 VDD VDD VSS VSS gf180mcu_fd_sc_mcu7t5v0__fillcap_32
XTAP_TAPCELL_ROW_49_1_701 VDD VSS gf180mcu_fd_sc_mcu7t5v0__filltie
XFILLER_49_134 VDD VDD VSS VSS gf180mcu_fd_sc_mcu7t5v0__fill_2
XFILLER_65_605 VDD VDD VSS VSS gf180mcu_fd_sc_mcu7t5v0__fillcap_4
Xspi_regs_inst__0931_ spi_regs_inst__1640_/Q spi_regs_inst__0931_/A2 spi_regs_inst__0931_/B1
+ spi_regs_inst__0753_/I spi_regs_inst__0932_/A2 VDD VDD VSS VSS gf180mcu_fd_sc_mcu7t5v0__aoi22_1
XFILLER_37_318 VDD VDD VSS VSS gf180mcu_fd_sc_mcu7t5v0__fillcap_8
XFILLER_64_104 VDD VDD VSS VSS gf180mcu_fd_sc_mcu7t5v0__fill_1
XFILLER_64_115 VDD VDD VSS VSS gf180mcu_fd_sc_mcu7t5v0__fillcap_4
XFILLER_65_638 VDD VDD VSS VSS gf180mcu_fd_sc_mcu7t5v0__fill_1
XFILLER_92_413 VDD VDD VSS VSS gf180mcu_fd_sc_mcu7t5v0__fill_2
XFILLER_92_457 VDD VDD VSS VSS gf180mcu_fd_sc_mcu7t5v0__fill_2
XFILLER_93_969 VDD VDD VSS VSS gf180mcu_fd_sc_mcu7t5v0__fillcap_8
Xwave_controller_y_inst_load_slew617 fanout616/Z wave_controller_y_inst__3673_/RN
+ VDD VDD VSS VSS gf180mcu_fd_sc_mcu7t5v0__buf_4
Xspi_regs_inst__0862_ spi_regs_inst__1437_/A1 spi_regs_inst__0862_/A2 spi_regs_inst_wire193/I
+ VDD VDD VSS VSS gf180mcu_fd_sc_mcu7t5v0__nor2_2
XFILLER_61_822 VDD VDD VSS VSS gf180mcu_fd_sc_mcu7t5v0__fillcap_8
XTAP_TAPCELL_ROW_23_1_503 VDD VSS gf180mcu_fd_sc_mcu7t5v0__filltie
Xspi_regs_inst__0793_ spi_regs_inst__1544_/Q spi_regs_inst_wire480/Z spi_regs_inst__0795_/S
+ spi_regs_inst__1544_/D VDD VDD VSS VSS gf180mcu_fd_sc_mcu7t5v0__mux2_2
XTAP_TAPCELL_ROW_86_1296 VDD VSS gf180mcu_fd_sc_mcu7t5v0__filltie
XFILLER_166_1087 VDD VDD VSS VSS gf180mcu_fd_sc_mcu7t5v0__fillcap_64
Xspi_regs_inst__1414_ spi_regs_inst__1429_/I1 spi_regs_inst__1486_/Q spi_regs_inst__1419_/S
+ spi_regs_inst__1486_/D VDD VDD VSS VSS gf180mcu_fd_sc_mcu7t5v0__mux2_2
XFILLER_119_607 VDD VDD VSS VSS gf180mcu_fd_sc_mcu7t5v0__fillcap_16
XFILLER_119_629 VDD VDD VSS VSS gf180mcu_fd_sc_mcu7t5v0__fill_1
XFILLER_158_253 VDD VDD VSS VSS gf180mcu_fd_sc_mcu7t5v0__fill_1
XFILLER_118_139 VDD VDD VSS VSS gf180mcu_fd_sc_mcu7t5v0__fillcap_16
Xspi_regs_inst__1345_ max_cap425/Z spi_regs_inst__1345_/A2 spi_regs_inst__1345_/B1
+ spi_regs_inst__1345_/B2 spi_regs_inst__1345_/C spi_regs_inst__1360_/A3 VDD VDD VSS
+ VSS gf180mcu_fd_sc_mcu7t5v0__aoi221_1
XFILLER_86_1011 VDD VDD VSS VSS gf180mcu_fd_sc_mcu7t5v0__fillcap_4
Xspi_regs_inst__1276_ fanout513/Z spi_regs_inst__1314_/A2 spi_regs_inst_wire233/Z
+ spi_regs_inst__1276_/B2 spi_regs_inst__1296_/A1 VDD VDD VSS VSS gf180mcu_fd_sc_mcu7t5v0__aoi22_1
Xclkload33 clkload33/I clkload33/ZN VDD VDD VSS VSS gf180mcu_fd_sc_mcu7t5v0__inv_4
Xclkload22 clkload22/I clkload22/Z VDD VDD VSS VSS gf180mcu_fd_sc_mcu7t5v0__clkbuf_2
Xclkload11 clkload11/I clkload11/ZN VDD VDD VSS VSS gf180mcu_fd_sc_mcu7t5v0__inv_4
XFILLER_114_312 VDD VDD VSS VSS gf180mcu_fd_sc_mcu7t5v0__fill_2
XFILLER_155_982 VDD VDD VSS VSS gf180mcu_fd_sc_mcu7t5v0__fillcap_64
XFILLER_114_334 VDD VDD VSS VSS gf180mcu_fd_sc_mcu7t5v0__fillcap_8
XFILLER_126_172 VDD VDD VSS VSS gf180mcu_fd_sc_mcu7t5v0__fill_2
XFILLER_102_507 VDD VDD VSS VSS gf180mcu_fd_sc_mcu7t5v0__fillcap_4
XFILLER_141_142 VDD VDD VSS VSS gf180mcu_fd_sc_mcu7t5v0__fillcap_4
XFILLER_142_676 VDD VDD VSS VSS gf180mcu_fd_sc_mcu7t5v0__fillcap_32
Xwave_controller_x_inst__1910_ spi_regs_inst__1333_/A1 wave_controller_x_inst__3492_/A1
+ VDD VDD VSS VSS gf180mcu_fd_sc_mcu7t5v0__clkinv_1
Xwave_controller_x_inst__2890_ wave_controller_x_inst__3557_/A1 wave_controller_x_inst__2909_/A2
+ wave_controller_x_inst__2895_/C VDD VDD VSS VSS gf180mcu_fd_sc_mcu7t5v0__nor2_1
Xsignal_processor_y_inst__226_ signal_processor_y_inst__226_/D fanout561/Z clkbuf_leaf_6_clk/Z
+ spi_regs_inst__1093_/B2 VDD VDD VSS VSS gf180mcu_fd_sc_mcu7t5v0__dffrnq_1
XFILLER_68_454 VDD VDD VSS VSS gf180mcu_fd_sc_mcu7t5v0__fill_1
Xwave_controller_x_inst__1841_ spi_regs_inst__1140_/B2 wave_controller_x_inst__2284_/A1
+ VDD VDD VSS VSS gf180mcu_fd_sc_mcu7t5v0__clkinv_1
XFILLER_110_584 VDD VDD VSS VSS gf180mcu_fd_sc_mcu7t5v0__fill_2
XFILLER_68_498 VDD VDD VSS VSS gf180mcu_fd_sc_mcu7t5v0__fill_1
XFILLER_83_402 VDD VDD VSS VSS gf180mcu_fd_sc_mcu7t5v0__fill_2
XFILLER_84_947 VDD VDD VSS VSS gf180mcu_fd_sc_mcu7t5v0__fillcap_64
Xsignal_processor_y_inst__157_ signal_processor_y_inst__231_/Q signal_processor_y_inst__158_/A2
+ signal_processor_y_inst__192_/A1 VDD VDD VSS VSS gf180mcu_fd_sc_mcu7t5v0__xnor2_1
XFILLER_55_137 VDD VDD VSS VSS gf180mcu_fd_sc_mcu7t5v0__fill_2
Xwave_controller_x_inst__3511_ spi_regs_inst__1286_/B2 wave_controller_x_inst__3538_/A2
+ wave_controller_x_inst__3512_/A3 VDD VDD VSS VSS gf180mcu_fd_sc_mcu7t5v0__nor2_1
XFILLER_64_660 VDD VDD VSS VSS gf180mcu_fd_sc_mcu7t5v0__fillcap_4
XFILLER_70_107 VDD VDD VSS VSS gf180mcu_fd_sc_mcu7t5v0__fillcap_16
Xwave_controller_x_inst__3442_ wave_controller_x_inst__3465_/B wave_controller_x_inst__3439_/I
+ wave_controller_x_inst__3471_/B wave_controller_x_inst__3443_/B2 VDD VDD VSS VSS
+ gf180mcu_fd_sc_mcu7t5v0__oai21_1
XFILLER_34_28 VDD VDD VSS VSS gf180mcu_fd_sc_mcu7t5v0__fillcap_4
XFILLER_36_384 VDD VDD VSS VSS gf180mcu_fd_sc_mcu7t5v0__fill_1
XFILLER_58_1157 VDD VDD VSS VSS gf180mcu_fd_sc_mcu7t5v0__fillcap_16
XFILLER_63_170 VDD VDD VSS VSS gf180mcu_fd_sc_mcu7t5v0__fillcap_4
XTAP_TAPCELL_ROW_17_1_461 VDD VSS gf180mcu_fd_sc_mcu7t5v0__filltie
XFILLER_145_1116 VDD VDD VSS VSS gf180mcu_fd_sc_mcu7t5v0__fillcap_4
Xwave_controller_x_inst__3373_ wave_controller_x_inst__3373_/A1 wave_controller_x_inst__3381_/A1
+ wave_controller_x_inst__3289_/B wave_controller_x_inst__3373_/Z VDD VDD VSS VSS
+ gf180mcu_fd_sc_mcu7t5v0__or3_1
XTAP_TAPCELL_ROW_62_894 VDD VSS gf180mcu_fd_sc_mcu7t5v0__filltie
Xwave_controller_y_inst__2340_ wave_controller_y_inst__2338_/Z wave_controller_y_inst__2341_/A2
+ wave_controller_y_inst__2361_/B VDD VDD VSS VSS gf180mcu_fd_sc_mcu7t5v0__nand2_1
Xwave_controller_x_inst__2324_ fanout540/Z wave_controller_x_inst__2326_/A3 wave_controller_x_inst__2339_/B
+ VDD VDD VSS VSS gf180mcu_fd_sc_mcu7t5v0__or2_1
XFILLER_165_702 VDD VDD VSS VSS gf180mcu_fd_sc_mcu7t5v0__fillcap_64
XTAP_TAPCELL_ROW_137_2138 VDD VSS gf180mcu_fd_sc_mcu7t5v0__filltie
Xwave_controller_y_inst__2271_ spi_regs_inst__1109_/A1 spi_regs_inst__1109_/B2 wave_controller_y_inst__2286_/A2
+ VDD VDD VSS VSS gf180mcu_fd_sc_mcu7t5v0__xnor2_1
Xwave_controller_x_inst__2255_ wave_controller_x_inst__2239_/B wave_controller_x_inst__2259_/C
+ wave_controller_x_inst__2257_/A3 VDD VDD VSS VSS gf180mcu_fd_sc_mcu7t5v0__nand2_1
Xclkload5 clkload5/I clkload5/ZN VDD VDD VSS VSS gf180mcu_fd_sc_mcu7t5v0__inv_4
XFILLER_126_8 VDD VDD VSS VSS gf180mcu_fd_sc_mcu7t5v0__fill_1
XFILLER_149_286 VDD VDD VSS VSS gf180mcu_fd_sc_mcu7t5v0__fill_2
Xwave_controller_x_inst__2186_ wave_controller_x_inst__2186_/I wave_controller_x_inst__2188_/B1
+ VDD VDD VSS VSS gf180mcu_fd_sc_mcu7t5v0__clkinv_1
XFILLER_118_684 VDD VDD VSS VSS gf180mcu_fd_sc_mcu7t5v0__fill_2
XFILLER_124_109 VDD VDD VSS VSS gf180mcu_fd_sc_mcu7t5v0__fill_1
XFILLER_3_406 VDD VDD VSS VSS gf180mcu_fd_sc_mcu7t5v0__fill_1
XTAP_TAPCELL_ROW_150_2349 VDD VSS gf180mcu_fd_sc_mcu7t5v0__filltie
XFILLER_133_632 VDD VDD VSS VSS gf180mcu_fd_sc_mcu7t5v0__fillcap_8
XFILLER_145_492 VDD VDD VSS VSS gf180mcu_fd_sc_mcu7t5v0__fillcap_32
XFILLER_59_14 VDD VDD VSS VSS gf180mcu_fd_sc_mcu7t5v0__fill_1
XTAP_TAPCELL_ROW_115_1768 VDD VSS gf180mcu_fd_sc_mcu7t5v0__filltie
XTAP_TAPCELL_ROW_115_1779 VDD VSS gf180mcu_fd_sc_mcu7t5v0__filltie
XTAP_TAPCELL_ROW_40_1_628 VDD VSS gf180mcu_fd_sc_mcu7t5v0__filltie
Xwave_controller_y_inst_fanout314 wave_controller_y_inst__2905_/ZN wave_controller_y_inst__3494_/A1
+ VDD VDD VSS VSS gf180mcu_fd_sc_mcu7t5v0__dlyb_1
XFILLER_160_473 VDD VDD VSS VSS gf180mcu_fd_sc_mcu7t5v0__fill_2
XFILLER_105_389 VDD VDD VSS VSS gf180mcu_fd_sc_mcu7t5v0__fill_2
XFILLER_133_698 VDD VDD VSS VSS gf180mcu_fd_sc_mcu7t5v0__fill_2
XTAP_TAPCELL_ROW_70_1031 VDD VSS gf180mcu_fd_sc_mcu7t5v0__filltie
XFILLER_101_562 VDD VDD VSS VSS gf180mcu_fd_sc_mcu7t5v0__fill_1
XFILLER_115_97 VDD VDD VSS VSS gf180mcu_fd_sc_mcu7t5v0__fill_1
XFILLER_46_115 VDD VDD VSS VSS gf180mcu_fd_sc_mcu7t5v0__fillcap_4
XFILLER_75_925 VDD VDD VSS VSS gf180mcu_fd_sc_mcu7t5v0__fillcap_4
XTAP_TAPCELL_ROW_165_2592 VDD VSS gf180mcu_fd_sc_mcu7t5v0__filltie
Xwave_controller_y_inst__1986_ wave_controller_y_inst__1986_/A1 wave_controller_y_inst__1986_/A2
+ wave_controller_y_inst__1986_/A3 wave_controller_y_inst__1986_/B wave_controller_y_inst__1988_/A2
+ VDD VDD VSS VSS gf180mcu_fd_sc_mcu7t5v0__oai31_1
XFILLER_74_457 VDD VDD VSS VSS gf180mcu_fd_sc_mcu7t5v0__fillcap_16
Xwave_controller_y_inst__3725_ wave_controller_y_inst__3725_/D fanout546/Z clkload2/I
+ wave_controller_y_inst__3725_/Q VDD VDD VSS VSS gf180mcu_fd_sc_mcu7t5v0__dffrnq_1
Xwave_controller_x_inst__3709_ wave_controller_x_inst__3709_/D wave_controller_x_inst__3712_/RN
+ clkbuf_leaf_31_clk/Z wave_controller_x_inst__3709_/Q VDD VDD VSS VSS gf180mcu_fd_sc_mcu7t5v0__dffrnq_1
XFILLER_27_340 VDD VDD VSS VSS gf180mcu_fd_sc_mcu7t5v0__fillcap_4
XFILLER_74_479 VDD VDD VSS VSS gf180mcu_fd_sc_mcu7t5v0__fill_1
Xwave_controller_y_inst__3656_ wave_controller_y_inst__3656_/D wave_controller_y_inst__3708_/RN
+ clkload21/I spi_regs_inst__1353_/A1 VDD VDD VSS VSS gf180mcu_fd_sc_mcu7t5v0__dffrnq_1
XFILLER_131_63 VDD VDD VSS VSS gf180mcu_fd_sc_mcu7t5v0__fillcap_4
XFILLER_15_524 VDD VDD VSS VSS gf180mcu_fd_sc_mcu7t5v0__fillcap_16
XFILLER_54_170 VDD VDD VSS VSS gf180mcu_fd_sc_mcu7t5v0__fillcap_4
XFILLER_82_490 VDD VDD VSS VSS gf180mcu_fd_sc_mcu7t5v0__fillcap_4
Xwave_controller_y_inst__2607_ wave_controller_y_inst__2607_/A1 wave_controller_y_inst__2606_/I
+ wave_controller_y_inst__2610_/A1 VDD VDD VSS VSS gf180mcu_fd_sc_mcu7t5v0__nand2_1
Xwave_controller_y_inst__3587_ wave_controller_y_inst__3587_/A1 wave_controller_y_inst__3588_/S
+ wave_controller_y_inst__3587_/B wave_controller_y_inst__3664_/D VDD VDD VSS VSS
+ gf180mcu_fd_sc_mcu7t5v0__oai21_1
XFILLER_30_527 VDD VDD VSS VSS gf180mcu_fd_sc_mcu7t5v0__fillcap_16
Xwave_controller_y_inst__2538_ wave_controller_y_inst__3515_/B2 wave_controller_y_inst__2537_/Z
+ wave_controller_y_inst__2561_/A2 VDD VDD VSS VSS gf180mcu_fd_sc_mcu7t5v0__nor2_1
Xsignal_processor_x_inst__246_ signal_processor_x_inst__246_/D fanout587/Z clkload24/I
+ signal_processor_x_inst__246_/Q VDD VDD VSS VSS gf180mcu_fd_sc_mcu7t5v0__dffrnq_1
XFILLER_128_404 VDD VDD VSS VSS gf180mcu_fd_sc_mcu7t5v0__fill_2
XFILLER_156_713 VDD VDD VSS VSS gf180mcu_fd_sc_mcu7t5v0__fillcap_4
Xwave_controller_y_inst__2469_ wave_controller_y_inst__2758_/B wave_controller_y_inst__2467_/Z
+ spi_regs_inst__1101_/B2 VDD VDD VSS VSS gf180mcu_fd_sc_mcu7t5v0__xnor2_1
XFILLER_128_415 VDD VDD VSS VSS gf180mcu_fd_sc_mcu7t5v0__fillcap_16
XFILLER_155_212 VDD VDD VSS VSS gf180mcu_fd_sc_mcu7t5v0__fill_1
Xsignal_processor_x_inst__177_ signal_processor_x_inst__177_/A1 signal_processor_x_inst__187_/A1
+ signal_processor_x_inst__237_/D VDD VDD VSS VSS gf180mcu_fd_sc_mcu7t5v0__nor2_1
XFILLER_155_245 VDD VDD VSS VSS gf180mcu_fd_sc_mcu7t5v0__fillcap_32
XTAP_TAPCELL_ROW_26_1_529 VDD VSS gf180mcu_fd_sc_mcu7t5v0__filltie
Xspi_regs_inst__1130_ spi_regs_inst__1130_/A1 spi_regs_inst_wire297/Z spi_regs_inst__1342_/A2
+ spi_regs_inst__1585_/Q spi_regs_inst__1165_/A1 VDD VDD VSS VSS gf180mcu_fd_sc_mcu7t5v0__aoi22_1
Xchip_core_672 bidir_sl[9] VDD VDD VSS VSS gf180mcu_fd_sc_mcu7t5v0__tiel
Xchip_core_661 bidir_pu[7] VDD VDD VSS VSS gf180mcu_fd_sc_mcu7t5v0__tiel
Xchip_core_650 bidir_pd[5] VDD VDD VSS VSS gf180mcu_fd_sc_mcu7t5v0__tiel
XFILLER_109_673 VDD VDD VSS VSS gf180mcu_fd_sc_mcu7t5v0__fillcap_8
XFILLER_137_982 VDD VDD VSS VSS gf180mcu_fd_sc_mcu7t5v0__fillcap_64
Xchip_core_683 bidir_oe[6] VDD VDD VSS VSS gf180mcu_fd_sc_mcu7t5v0__tieh
XFILLER_108_172 VDD VDD VSS VSS gf180mcu_fd_sc_mcu7t5v0__fill_2
XFILLER_152_941 VDD VDD VSS VSS gf180mcu_fd_sc_mcu7t5v0__fillcap_4
XTAP_TAPCELL_ROW_34_1_586 VDD VSS gf180mcu_fd_sc_mcu7t5v0__filltie
Xspi_regs_inst__1061_ spi_regs_inst__1591_/Q spi_regs_inst__1240_/A2 spi_regs_inst_wire207/Z
+ spi_regs_inst__1470_/Q spi_regs_inst__1062_/A4 VDD VDD VSS VSS gf180mcu_fd_sc_mcu7t5v0__aoi22_1
XFILLER_123_142 VDD VDD VSS VSS gf180mcu_fd_sc_mcu7t5v0__fillcap_32
XFILLER_120_860 VDD VDD VSS VSS gf180mcu_fd_sc_mcu7t5v0__fill_2
XFILLER_66_947 VDD VDD VSS VSS gf180mcu_fd_sc_mcu7t5v0__fillcap_64
XTAP_TAPCELL_ROW_88_1325 VDD VSS gf180mcu_fd_sc_mcu7t5v0__filltie
XTAP_TAPCELL_ROW_88_1336 VDD VSS gf180mcu_fd_sc_mcu7t5v0__filltie
Xspi_regs_inst__0914_ spi_regs_inst__1630_/Q spi_regs_inst__1370_/A1 spi_regs_inst__0909_/Z
+ spi_regs_inst__1024_/A1 VDD VDD VSS VSS gf180mcu_fd_sc_mcu7t5v0__nand3_1
XFILLER_52_107 VDD VDD VSS VSS gf180mcu_fd_sc_mcu7t5v0__fillcap_4
XFILLER_65_468 VDD VDD VSS VSS gf180mcu_fd_sc_mcu7t5v0__fillcap_8
Xspi_regs_inst__0845_ spi_regs_inst__1584_/Q spi_regs_inst__1439_/I1 spi_regs_inst__0849_/S
+ spi_regs_inst__1584_/D VDD VDD VSS VSS gf180mcu_fd_sc_mcu7t5v0__mux2_2
XFILLER_18_395 VDD VDD VSS VSS gf180mcu_fd_sc_mcu7t5v0__fillcap_16
XFILLER_61_652 VDD VDD VSS VSS gf180mcu_fd_sc_mcu7t5v0__fill_2
Xspi_regs_inst__0776_ spi_regs_inst__1531_/Q spi_regs_inst__1408_/I1 spi_regs_inst__0778_/S
+ spi_regs_inst__1531_/D VDD VDD VSS VSS gf180mcu_fd_sc_mcu7t5v0__mux2_2
XPHY_EDGE_ROW_36_1_Right_35 VDD VSS gf180mcu_fd_sc_mcu7t5v0__endcap
XFILLER_105_1122 VDD VDD VSS VSS gf180mcu_fd_sc_mcu7t5v0__fillcap_32
XFILLER_147_702 VDD VDD VSS VSS gf180mcu_fd_sc_mcu7t5v0__fillcap_4
XFILLER_60_195 VDD VDD VSS VSS gf180mcu_fd_sc_mcu7t5v0__fill_2
XFILLER_92_1081 VDD VDD VSS VSS gf180mcu_fd_sc_mcu7t5v0__fillcap_4
XFILLER_119_426 VDD VDD VSS VSS gf180mcu_fd_sc_mcu7t5v0__fillcap_4
XFILLER_147_746 VDD VDD VSS VSS gf180mcu_fd_sc_mcu7t5v0__fill_2
Xwave_controller_x_inst__2040_ wave_controller_x_inst__2114_/B wave_controller_x_inst__2092_/B
+ wave_controller_x_inst__2050_/A1 VDD VDD VSS VSS gf180mcu_fd_sc_mcu7t5v0__nand2_1
Xspi_regs_inst__1328_ spi_regs_inst__1328_/A1 spi_regs_inst__1328_/A2 spi_regs_inst__1328_/A3
+ spi_regs_inst__1328_/A4 spi_regs_inst__1328_/Z VDD VDD VSS VSS gf180mcu_fd_sc_mcu7t5v0__and4_1
XFILLER_127_470 VDD VDD VSS VSS gf180mcu_fd_sc_mcu7t5v0__fillcap_8
XFILLER_161_204 VDD VDD VSS VSS gf180mcu_fd_sc_mcu7t5v0__fill_1
XFILLER_115_632 VDD VDD VSS VSS gf180mcu_fd_sc_mcu7t5v0__fillcap_8
XFILLER_127_492 VDD VDD VSS VSS gf180mcu_fd_sc_mcu7t5v0__fillcap_32
XFILLER_161_248 VDD VDD VSS VSS gf180mcu_fd_sc_mcu7t5v0__fill_2
XTAP_TAPCELL_ROW_132_2057 VDD VSS gf180mcu_fd_sc_mcu7t5v0__filltie
Xspi_regs_inst_wire202 spi_regs_inst_wire202/I spi_regs_inst__1441_/S VDD VDD VSS
+ VSS gf180mcu_fd_sc_mcu7t5v0__buf_2
Xspi_regs_inst__1259_ spi_regs_inst__1587_/Q spi_regs_inst__1342_/A2 spi_regs_inst_wire214/Z
+ spi_regs_inst__1259_/B2 spi_regs_inst__1263_/A1 VDD VDD VSS VSS gf180mcu_fd_sc_mcu7t5v0__aoi22_1
XFILLER_115_676 VDD VDD VSS VSS gf180mcu_fd_sc_mcu7t5v0__fill_1
XFILLER_88_516 VDD VDD VSS VSS gf180mcu_fd_sc_mcu7t5v0__fillcap_8
XFILLER_130_613 VDD VDD VSS VSS gf180mcu_fd_sc_mcu7t5v0__fillcap_4
XFILLER_142_495 VDD VDD VSS VSS gf180mcu_fd_sc_mcu7t5v0__fill_2
XFILLER_88_527 VDD VDD VSS VSS gf180mcu_fd_sc_mcu7t5v0__fillcap_8
Xwave_controller_x_inst__2942_ wave_controller_x_inst__3715_/Q fanout534/Z wave_controller_x_inst__2942_/Z
+ VDD VDD VSS VSS gf180mcu_fd_sc_mcu7t5v0__xor2_1
XFILLER_102_348 VDD VDD VSS VSS gf180mcu_fd_sc_mcu7t5v0__fillcap_8
XFILLER_152_18 VDD VDD VSS VSS gf180mcu_fd_sc_mcu7t5v0__fillcap_8
Xwave_controller_x_inst__2873_ wave_controller_x_inst__2870_/Z wave_controller_x_inst__2873_/A2
+ wave_controller_x_inst__2879_/A2 wave_controller_x_inst__2874_/A2 VDD VDD VSS VSS
+ gf180mcu_fd_sc_mcu7t5v0__nor3_1
XFILLER_68_251 VDD VDD VSS VSS gf180mcu_fd_sc_mcu7t5v0__fill_2
XTAP_TAPCELL_ROW_110_1687 VDD VSS gf180mcu_fd_sc_mcu7t5v0__filltie
XTAP_TAPCELL_ROW_110_1698 VDD VSS gf180mcu_fd_sc_mcu7t5v0__filltie
Xwave_controller_y_inst__1840_ spi_regs_inst__1033_/C2 wave_controller_y_inst__2254_/A1
+ VDD VDD VSS VSS gf180mcu_fd_sc_mcu7t5v0__clkinv_1
Xwave_controller_x_inst__1824_ fanout523/Z wave_controller_x_inst__2952_/A2 VDD VDD
+ VSS VSS gf180mcu_fd_sc_mcu7t5v0__clkinv_1
Xsignal_processor_y_inst__209_ signal_processor_y_inst__215_/A1 signal_processor_y_inst__209_/A2
+ signal_processor_y_inst__209_/B signal_processor_y_inst__223_/D VDD VDD VSS VSS
+ gf180mcu_fd_sc_mcu7t5v0__oai21_1
XFILLER_83_276 VDD VDD VSS VSS gf180mcu_fd_sc_mcu7t5v0__fillcap_4
XTAP_TAPCELL_ROW_67_975 VDD VSS gf180mcu_fd_sc_mcu7t5v0__filltie
XTAP_TAPCELL_ROW_67_986 VDD VSS gf180mcu_fd_sc_mcu7t5v0__filltie
Xwave_controller_y_inst__3510_ wave_controller_y_inst__3706_/Q wave_controller_y_inst__3528_/A2
+ wave_controller_y_inst__3512_/A2 VDD VDD VSS VSS gf180mcu_fd_sc_mcu7t5v0__nor2_1
XFILLER_71_438 VDD VDD VSS VSS gf180mcu_fd_sc_mcu7t5v0__fillcap_8
Xwave_controller_y_inst__3441_ wave_controller_y_inst__3441_/A1 wave_controller_y_inst__3439_/I
+ wave_controller_y_inst__3441_/B wave_controller_y_inst__3441_/C wave_controller_y_inst__3443_/B1
+ VDD VDD VSS VSS gf180mcu_fd_sc_mcu7t5v0__aoi211_1
Xwave_controller_x_inst__3425_ spi_regs_inst__1094_/A1 wave_controller_x_inst__3454_/A2
+ wave_controller_x_inst__3426_/A3 VDD VDD VSS VSS gf180mcu_fd_sc_mcu7t5v0__nor2_1
XFILLER_12_527 VDD VDD VSS VSS gf180mcu_fd_sc_mcu7t5v0__fill_2
Xwave_controller_y_inst__3372_ wave_controller_y_inst__3384_/A2 wave_controller_y_inst__3371_/Z
+ wave_controller_y_inst__3372_/Z VDD VDD VSS VSS gf180mcu_fd_sc_mcu7t5v0__or2_1
Xwave_controller_y_inst__2323_ wave_controller_y_inst_wire128/Z wave_controller_y_inst__2322_/Z
+ wave_controller_y_inst__2326_/A3 VDD VDD VSS VSS gf180mcu_fd_sc_mcu7t5v0__xnor2_1
Xwave_controller_x_inst__3356_ wave_controller_x_inst__3354_/Z wave_controller_x_inst__3394_/A3
+ wave_controller_x_inst__3356_/Z VDD VDD VSS VSS gf180mcu_fd_sc_mcu7t5v0__or2_1
XFILLER_71_1154 VDD VDD VSS VSS gf180mcu_fd_sc_mcu7t5v0__fillcap_16
XPHY_EDGE_ROW_0_1_Right_52 VDD VSS gf180mcu_fd_sc_mcu7t5v0__endcap
Xwave_controller_x_inst__3287_ wave_controller_x_inst__3704_/Q spi_regs_inst__1544_/Q
+ wave_controller_x_inst__3288_/I VDD VDD VSS VSS gf180mcu_fd_sc_mcu7t5v0__xor2_1
Xwave_controller_x_inst__2307_ wave_controller_x_inst__2304_/Z wave_controller_x_inst__2306_/I
+ wave_controller_x_inst__2343_/A1 VDD VDD VSS VSS gf180mcu_fd_sc_mcu7t5v0__xnor2_1
XFILLER_137_223 VDD VDD VSS VSS gf180mcu_fd_sc_mcu7t5v0__fillcap_16
XTAP_TAPCELL_ROW_117_1808 VDD VSS gf180mcu_fd_sc_mcu7t5v0__filltie
Xwave_controller_y_inst__2254_ wave_controller_y_inst__2254_/A1 spi_regs_inst__1034_/A1
+ wave_controller_y_inst__2254_/Z VDD VDD VSS VSS gf180mcu_fd_sc_mcu7t5v0__xor2_1
Xwave_controller_x_inst__2238_ wave_controller_x_inst__2259_/C wave_controller_x_inst__2257_/A2
+ wave_controller_x_inst__2242_/A2 VDD VDD VSS VSS gf180mcu_fd_sc_mcu7t5v0__nand2_1
XFILLER_106_610 VDD VDD VSS VSS gf180mcu_fd_sc_mcu7t5v0__fill_2
XFILLER_119_982 VDD VDD VSS VSS gf180mcu_fd_sc_mcu7t5v0__fillcap_64
XFILLER_137_278 VDD VDD VSS VSS gf180mcu_fd_sc_mcu7t5v0__fill_2
Xwave_controller_y_inst__2185_ wave_controller_y_inst__2187_/A1 wave_controller_y_inst__2184_/I
+ wave_controller_y_inst__2186_/I VDD VDD VSS VSS gf180mcu_fd_sc_mcu7t5v0__nor2_1
Xwave_controller_x_inst__2169_ wave_controller_x_inst__2157_/Z wave_controller_x_inst__2170_/A2
+ wave_controller_x_inst__2169_/B wave_controller_x_inst__2221_/A1 VDD VDD VSS VSS
+ gf180mcu_fd_sc_mcu7t5v0__oai21_1
XFILLER_134_941 VDD VDD VSS VSS gf180mcu_fd_sc_mcu7t5v0__fillcap_4
XFILLER_105_142 VDD VDD VSS VSS gf180mcu_fd_sc_mcu7t5v0__fillcap_8
XFILLER_152_259 VDD VDD VSS VSS gf180mcu_fd_sc_mcu7t5v0__fillcap_16
XTAP_TAPCELL_ROW_167_2632 VDD VSS gf180mcu_fd_sc_mcu7t5v0__filltie
XTAP_TAPCELL_ROW_167_2643 VDD VSS gf180mcu_fd_sc_mcu7t5v0__filltie
Xwave_controller_y_inst_fanout177 wave_controller_y_inst__3039_/ZN wave_controller_y_inst__3059_/A2
+ VDD VDD VSS VSS gf180mcu_fd_sc_mcu7t5v0__dlyb_1
XFILLER_86_34 VDD VDD VSS VSS gf180mcu_fd_sc_mcu7t5v0__fill_1
XFILLER_86_45 VDD VDD VSS VSS gf180mcu_fd_sc_mcu7t5v0__fillcap_4
XTAP_TAPCELL_ROW_167_2654 VDD VSS gf180mcu_fd_sc_mcu7t5v0__filltie
XFILLER_120_167 VDD VDD VSS VSS gf180mcu_fd_sc_mcu7t5v0__fill_2
XFILLER_120_189 VDD VDD VSS VSS gf180mcu_fd_sc_mcu7t5v0__fill_1
XFILLER_87_582 VDD VDD VSS VSS gf180mcu_fd_sc_mcu7t5v0__fill_1
XFILLER_101_370 VDD VDD VSS VSS gf180mcu_fd_sc_mcu7t5v0__fill_1
XFILLER_74_243 VDD VDD VSS VSS gf180mcu_fd_sc_mcu7t5v0__fill_2
Xwave_controller_y_inst__1969_ fanout505/Z wave_controller_y_inst__2226_/A1 wave_controller_y_inst__1981_/B
+ VDD VDD VSS VSS gf180mcu_fd_sc_mcu7t5v0__nor2_1
XFILLER_34_107 VDD VDD VSS VSS gf180mcu_fd_sc_mcu7t5v0__fillcap_32
Xwave_controller_y_inst__3708_ wave_controller_y_inst__3708_/D wave_controller_y_inst__3708_/RN
+ clkload11/I wave_controller_y_inst__3708_/Q VDD VDD VSS VSS gf180mcu_fd_sc_mcu7t5v0__dffrnq_1
XFILLER_71_972 VDD VDD VSS VSS gf180mcu_fd_sc_mcu7t5v0__fillcap_8
XTAP_TAPCELL_ROW_83_1244 VDD VSS gf180mcu_fd_sc_mcu7t5v0__filltie
Xwave_controller_y_inst__3639_ wave_controller_y_inst__3639_/D wave_controller_y_inst__3683_/RN
+ clkbuf_leaf_46_clk/Z spi_regs_inst__1216_/B2 VDD VDD VSS VSS gf180mcu_fd_sc_mcu7t5v0__dffrnq_1
Xclkbuf_leaf_54_clk clkbuf_leaf_3_clk/I clkload6/I VDD VDD VSS VSS gf180mcu_fd_sc_mcu7t5v0__clkbuf_8
XFILLER_163_1046 VDD VDD VSS VSS gf180mcu_fd_sc_mcu7t5v0__fillcap_4
XFILLER_42_173 VDD VDD VSS VSS gf180mcu_fd_sc_mcu7t5v0__fill_2
XFILLER_76_1087 VDD VDD VSS VSS gf180mcu_fd_sc_mcu7t5v0__fillcap_64
XFILLER_129_702 VDD VDD VSS VSS gf180mcu_fd_sc_mcu7t5v0__fillcap_4
XFILLER_70_493 VDD VDD VSS VSS gf180mcu_fd_sc_mcu7t5v0__fillcap_8
Xsignal_processor_x_inst__229_ signal_processor_x_inst__229_/D signal_processor_x_inst__242_/RN
+ clkload24/I signal_processor_x_inst__229_/Q VDD VDD VSS VSS gf180mcu_fd_sc_mcu7t5v0__dffrnq_1
XFILLER_128_223 VDD VDD VSS VSS gf180mcu_fd_sc_mcu7t5v0__fillcap_8
XFILLER_116_407 VDD VDD VSS VSS gf180mcu_fd_sc_mcu7t5v0__fill_2
XFILLER_156_587 VDD VDD VSS VSS gf180mcu_fd_sc_mcu7t5v0__fillcap_8
XFILLER_167_70 VDD VDD VSS VSS gf180mcu_fd_sc_mcu7t5v0__fillcap_32
XTAP_TAPCELL_ROW_1_1_338 VDD VSS gf180mcu_fd_sc_mcu7t5v0__filltie
Xwire462 wire462/I wire462/Z VDD VDD VSS VSS gf180mcu_fd_sc_mcu7t5v0__buf_3
XFILLER_109_492 VDD VDD VSS VSS gf180mcu_fd_sc_mcu7t5v0__fillcap_16
Xspi_regs_inst__1113_ spi_regs_inst__1113_/A1 spi_regs_inst__1113_/A2 spi_regs_inst__1113_/A3
+ spi_regs_inst__1124_/A1 VDD VDD VSS VSS gf180mcu_fd_sc_mcu7t5v0__nor3_1
XFILLER_124_440 VDD VDD VSS VSS gf180mcu_fd_sc_mcu7t5v0__fill_2
XFILLER_125_974 VDD VDD VSS VSS gf180mcu_fd_sc_mcu7t5v0__fillcap_4
XFILLER_98_803 VDD VDD VSS VSS gf180mcu_fd_sc_mcu7t5v0__fill_2
Xspi_regs_inst__1044_ spi_regs_inst__1044_/A1 spi_regs_inst_wire247/Z spi_regs_inst_wire242/I
+ spi_regs_inst__1507_/Q spi_regs_inst__1100_/A2 spi_regs_inst__1044_/C2 spi_regs_inst__1048_/A2
+ VDD VDD VSS VSS gf180mcu_fd_sc_mcu7t5v0__aoi222_1
XFILLER_111_178 VDD VDD VSS VSS gf180mcu_fd_sc_mcu7t5v0__fillcap_8
XFILLER_18_2 VDD VDD VSS VSS gf180mcu_fd_sc_mcu7t5v0__fillcap_32
XFILLER_78_593 VDD VDD VSS VSS gf180mcu_fd_sc_mcu7t5v0__fill_2
XFILLER_38_457 VDD VDD VSS VSS gf180mcu_fd_sc_mcu7t5v0__fillcap_8
XFILLER_81_714 VDD VDD VSS VSS gf180mcu_fd_sc_mcu7t5v0__fill_2
XFILLER_25_118 VDD VDD VSS VSS gf180mcu_fd_sc_mcu7t5v0__fill_1
XFILLER_80_202 VDD VDD VSS VSS gf180mcu_fd_sc_mcu7t5v0__fillcap_4
XFILLER_80_224 VDD VDD VSS VSS gf180mcu_fd_sc_mcu7t5v0__fillcap_16
XTAP_TAPCELL_ROW_64_934 VDD VSS gf180mcu_fd_sc_mcu7t5v0__filltie
Xspi_regs_inst__0828_ spi_regs_inst__1570_/Q spi_regs_inst__1377_/I1 spi_regs_inst__0834_/S
+ spi_regs_inst__1570_/D VDD VDD VSS VSS gf180mcu_fd_sc_mcu7t5v0__mux2_2
Xclkbuf_leaf_45_clk clkbuf_3_2__f_clk/Z clkload11/I VDD VDD VSS VSS gf180mcu_fd_sc_mcu7t5v0__clkbuf_8
XFILLER_33_162 VDD VDD VSS VSS gf180mcu_fd_sc_mcu7t5v0__fill_1
XFILLER_55_1116 VDD VDD VSS VSS gf180mcu_fd_sc_mcu7t5v0__fillcap_4
Xwave_controller_x_inst__3210_ wave_controller_x_inst__3209_/B wave_controller_x_inst__3207_/Z
+ wave_controller_x_inst__3210_/A3 wave_controller_x_inst__3241_/B1 VDD VDD VSS VSS
+ gf180mcu_fd_sc_mcu7t5v0__nand3_1
Xspi_regs_inst__0759_ spi_regs_inst__0827_/A1 spi_regs_inst__1652_/Q spi_regs_inst__1404_/A2
+ spi_regs_inst__0767_/S VDD VDD VSS VSS gf180mcu_fd_sc_mcu7t5v0__nor3_2
XFILLER_119_212 VDD VDD VSS VSS gf180mcu_fd_sc_mcu7t5v0__fill_2
Xwave_controller_x_inst__3141_ wave_controller_x_inst__3128_/I wave_controller_x_inst__3228_/A1
+ wave_controller_x_inst__3141_/B wave_controller_x_inst__3225_/A1 VDD VDD VSS VSS
+ gf180mcu_fd_sc_mcu7t5v0__aoi21_1
Xwave_controller_x_inst__3072_ wave_controller_x_inst__3312_/A1 wave_controller_x_inst__3090_/B1
+ wave_controller_x_inst__3071_/Z wave_controller_x_inst__2762_/I wave_controller_x_inst__3712_/D
+ VDD VDD VSS VSS gf180mcu_fd_sc_mcu7t5v0__oai22_1
XFILLER_147_18 VDD VDD VSS VSS gf180mcu_fd_sc_mcu7t5v0__fillcap_8
Xwave_controller_x_inst__2023_ fanout532/Z spi_regs_inst__1108_/B2 wave_controller_x_inst__2023_/A3
+ spi_regs_inst__1102_/A1 VDD VDD VSS VSS gf180mcu_fd_sc_mcu7t5v0__xor3_1
XFILLER_135_749 VDD VDD VSS VSS gf180mcu_fd_sc_mcu7t5v0__fill_1
XFILLER_150_719 VDD VDD VSS VSS gf180mcu_fd_sc_mcu7t5v0__fillcap_16
XFILLER_0_206 VDD VDD VSS VSS gf180mcu_fd_sc_mcu7t5v0__fillcap_4
XFILLER_88_302 VDD VDD VSS VSS gf180mcu_fd_sc_mcu7t5v0__fillcap_8
XTAP_TAPCELL_ROW_112_1727 VDD VSS gf180mcu_fd_sc_mcu7t5v0__filltie
XFILLER_102_123 VDD VDD VSS VSS gf180mcu_fd_sc_mcu7t5v0__fill_2
XFILLER_88_346 VDD VDD VSS VSS gf180mcu_fd_sc_mcu7t5v0__fill_2
XTAP_TAPCELL_ROW_149_2340 VDD VSS gf180mcu_fd_sc_mcu7t5v0__filltie
Xwave_controller_y_inst__2941_ wave_controller_y_inst__1783_/I wave_controller_y_inst__1816_/I
+ wave_controller_y_inst__2994_/A1 VDD VDD VSS VSS gf180mcu_fd_sc_mcu7t5v0__nor2_1
Xwave_controller_x_inst__2925_ wave_controller_x_inst__3589_/I0 spi_regs_inst__1108_/B2
+ wave_controller_x_inst__2929_/S wave_controller_x_inst__3687_/D VDD VDD VSS VSS
+ gf180mcu_fd_sc_mcu7t5v0__mux2_2
Xwave_controller_y_inst__2872_ wave_controller_y_inst__3696_/Q wave_controller_y_inst__3462_/B2
+ wave_controller_y_inst__2879_/A2 VDD VDD VSS VSS gf180mcu_fd_sc_mcu7t5v0__nor2_1
XFILLER_116_1081 VDD VDD VSS VSS gf180mcu_fd_sc_mcu7t5v0__fillcap_4
XFILLER_29_446 VDD VDD VSS VSS gf180mcu_fd_sc_mcu7t5v0__fill_1
XFILLER_56_37 VDD VDD VSS VSS gf180mcu_fd_sc_mcu7t5v0__fill_2
Xwave_controller_y_inst__1823_ wave_controller_y_inst__1823_/I wave_controller_y_inst__3387_/A1
+ VDD VDD VSS VSS gf180mcu_fd_sc_mcu7t5v0__clkinv_1
Xwave_controller_x_inst__2856_ wave_controller_x_inst__2768_/Z wave_controller_x_inst__2889_/A2
+ wave_controller_x_inst__2856_/Z VDD VDD VSS VSS gf180mcu_fd_sc_mcu7t5v0__or2_1
XTAP_TAPCELL_ROW_162_2551 VDD VSS gf180mcu_fd_sc_mcu7t5v0__filltie
Xwave_controller_x_inst__2787_ wave_controller_x_inst__2787_/I wave_controller_x_inst__2817_/A2
+ VDD VDD VSS VSS gf180mcu_fd_sc_mcu7t5v0__clkinv_1
Xwave_controller_x_inst__1807_ spi_regs_inst__1539_/Q wave_controller_x_inst__3338_/A2
+ VDD VDD VSS VSS gf180mcu_fd_sc_mcu7t5v0__clkinv_1
XFILLER_16_107 VDD VDD VSS VSS gf180mcu_fd_sc_mcu7t5v0__fill_2
XFILLER_16_118 VDD VDD VSS VSS gf180mcu_fd_sc_mcu7t5v0__fillcap_8
XFILLER_44_416 VDD VDD VSS VSS gf180mcu_fd_sc_mcu7t5v0__fillcap_8
XFILLER_71_224 VDD VDD VSS VSS gf180mcu_fd_sc_mcu7t5v0__fill_2
XTAP_TAPCELL_ROW_127_1970 VDD VSS gf180mcu_fd_sc_mcu7t5v0__filltie
XTAP_TAPCELL_ROW_25_1_517 VDD VSS gf180mcu_fd_sc_mcu7t5v0__filltie
Xwave_controller_x_inst_fanout69 wave_controller_x_inst_wire75/I wave_controller_x_inst__2929_/S
+ VDD VDD VSS VSS gf180mcu_fd_sc_mcu7t5v0__dlyb_1
Xclkbuf_leaf_36_clk clkbuf_3_6__f_clk/Z clkbuf_leaf_36_clk/Z VDD VDD VSS VSS gf180mcu_fd_sc_mcu7t5v0__clkbuf_8
XFILLER_24_162 VDD VDD VSS VSS gf180mcu_fd_sc_mcu7t5v0__fill_1
XFILLER_71_268 VDD VDD VSS VSS gf180mcu_fd_sc_mcu7t5v0__fillcap_4
Xwave_controller_y_inst__3424_ wave_controller_y_inst__3693_/Q wave_controller_y_inst__3424_/A2
+ wave_controller_y_inst__3426_/A2 VDD VDD VSS VSS gf180mcu_fd_sc_mcu7t5v0__nor2_1
Xwave_controller_x_inst__3408_ fanout402/Z _10_/A2 wave_controller_x_inst__3410_/A1
+ VDD VDD VSS VSS gf180mcu_fd_sc_mcu7t5v0__nand2_1
XFILLER_12_368 VDD VDD VSS VSS gf180mcu_fd_sc_mcu7t5v0__fill_2
XFILLER_8_317 VDD VDD VSS VSS gf180mcu_fd_sc_mcu7t5v0__fillcap_8
Xwave_controller_y_inst__3355_ wave_controller_y_inst__3355_/A1 wave_controller_y_inst__3359_/A1
+ wave_controller_y_inst__3355_/B wave_controller_y_inst__3394_/A3 VDD VDD VSS VSS
+ gf180mcu_fd_sc_mcu7t5v0__aoi21_1
Xwave_controller_x_inst__3339_ wave_controller_x_inst__3402_/C wave_controller_x_inst__3402_/A2
+ wave_controller_x_inst__3344_/A1 VDD VDD VSS VSS gf180mcu_fd_sc_mcu7t5v0__nand2_1
XFILLER_122_2 VDD VDD VSS VSS gf180mcu_fd_sc_mcu7t5v0__fillcap_32
XFILLER_123_1052 VDD VDD VSS VSS gf180mcu_fd_sc_mcu7t5v0__fillcap_64
Xwave_controller_y_inst__3286_ wave_controller_y_inst__3286_/A1 wave_controller_y_inst__3286_/A2
+ wave_controller_y_inst__3286_/B wave_controller_y_inst__3381_/A1 VDD VDD VSS VSS
+ gf180mcu_fd_sc_mcu7t5v0__aoi21_1
Xwave_controller_y_inst__2306_ wave_controller_y_inst__2306_/I wave_controller_y_inst__2342_/A2
+ VDD VDD VSS VSS gf180mcu_fd_sc_mcu7t5v0__clkinv_1
XFILLER_138_565 VDD VDD VSS VSS gf180mcu_fd_sc_mcu7t5v0__fill_2
Xwave_controller_y_inst__2237_ spi_regs_inst__1354_/A1 wave_controller_y_inst__2789_/A1
+ wave_controller_y_inst__2257_/A2 VDD VDD VSS VSS gf180mcu_fd_sc_mcu7t5v0__nand2_1
XFILLER_4_523 VDD VDD VSS VSS gf180mcu_fd_sc_mcu7t5v0__fill_2
XFILLER_125_259 VDD VDD VSS VSS gf180mcu_fd_sc_mcu7t5v0__fill_2
Xwave_controller_y_inst__2168_ wave_controller_y_inst__2168_/A1 wave_controller_y_inst__2168_/A2
+ wave_controller_y_inst__2168_/B wave_controller_y_inst__2222_/B1 VDD VDD VSS VSS
+ gf180mcu_fd_sc_mcu7t5v0__aoi21_1
XFILLER_137_84 VDD VDD VSS VSS gf180mcu_fd_sc_mcu7t5v0__fill_1
Xwave_controller_y_inst__2099_ wave_controller_y_inst__2099_/A1 wave_controller_y_inst__2099_/A2
+ wave_controller_y_inst__2117_/A2 VDD VDD VSS VSS gf180mcu_fd_sc_mcu7t5v0__nand2_1
XFILLER_121_432 VDD VDD VSS VSS gf180mcu_fd_sc_mcu7t5v0__fill_1
XFILLER_97_66 VDD VDD VSS VSS gf180mcu_fd_sc_mcu7t5v0__fillcap_4
XFILLER_121_454 VDD VDD VSS VSS gf180mcu_fd_sc_mcu7t5v0__fill_2
XFILLER_153_50 VDD VDD VSS VSS gf180mcu_fd_sc_mcu7t5v0__fillcap_8
XFILLER_67_508 VDD VDD VSS VSS gf180mcu_fd_sc_mcu7t5v0__fillcap_8
XFILLER_79_368 VDD VDD VSS VSS gf180mcu_fd_sc_mcu7t5v0__fillcap_8
Xwave_controller_x_inst_fanout541 fanout540/I wave_controller_x_inst__2981_/A2 VDD
+ VDD VSS VSS gf180mcu_fd_sc_mcu7t5v0__dlyb_1
XFILLER_75_574 VDD VDD VSS VSS gf180mcu_fd_sc_mcu7t5v0__fill_1
XFILLER_47_298 VDD VDD VSS VSS gf180mcu_fd_sc_mcu7t5v0__fillcap_8
XFILLER_62_224 VDD VDD VSS VSS gf180mcu_fd_sc_mcu7t5v0__fillcap_4
XFILLER_90_522 VDD VDD VSS VSS gf180mcu_fd_sc_mcu7t5v0__fill_2
XTAP_TAPCELL_ROW_19_1_475 VDD VSS gf180mcu_fd_sc_mcu7t5v0__filltie
XFILLER_63_758 VDD VDD VSS VSS gf180mcu_fd_sc_mcu7t5v0__fillcap_8
Xspi_regs_inst__1662_ spi_regs_inst__1662_/D spi_regs_inst__1662_/RN clkbuf_leaf_6_clk/Z
+ spi_regs_inst__1662_/Q VDD VDD VSS VSS gf180mcu_fd_sc_mcu7t5v0__dffrnq_1
Xclkbuf_leaf_27_clk clkbuf_3_6__f_clk/Z clkload29/I VDD VDD VSS VSS gf180mcu_fd_sc_mcu7t5v0__clkbuf_8
Xspi_regs_inst__1593_ spi_regs_inst__1593_/D spi_regs_inst__1610_/RN clkload17/I spi_regs_inst__1593_/Q
+ VDD VDD VSS VSS gf180mcu_fd_sc_mcu7t5v0__dffrnq_1
XFILLER_94_6 VDD VDD VSS VSS gf180mcu_fd_sc_mcu7t5v0__fillcap_4
XFILLER_30_154 VDD VDD VSS VSS gf180mcu_fd_sc_mcu7t5v0__fill_1
XFILLER_129_543 VDD VDD VSS VSS gf180mcu_fd_sc_mcu7t5v0__fill_1
XFILLER_11_390 VDD VDD VSS VSS gf180mcu_fd_sc_mcu7t5v0__fill_2
XFILLER_144_502 VDD VDD VSS VSS gf180mcu_fd_sc_mcu7t5v0__fillcap_4
XFILLER_102_1169 VDD VDD VSS VSS gf180mcu_fd_sc_mcu7t5v0__fill_1
XFILLER_144_524 VDD VDD VSS VSS gf180mcu_fd_sc_mcu7t5v0__fill_1
XTAP_TAPCELL_ROW_96_1468 VDD VSS gf180mcu_fd_sc_mcu7t5v0__filltie
XTAP_TAPCELL_ROW_96_1457 VDD VSS gf180mcu_fd_sc_mcu7t5v0__filltie
XFILLER_98_622 VDD VDD VSS VSS gf180mcu_fd_sc_mcu7t5v0__fill_2
XFILLER_112_421 VDD VDD VSS VSS gf180mcu_fd_sc_mcu7t5v0__fill_2
XFILLER_140_730 VDD VDD VSS VSS gf180mcu_fd_sc_mcu7t5v0__fillcap_4
XFILLER_97_121 VDD VDD VSS VSS gf180mcu_fd_sc_mcu7t5v0__fill_1
Xspi_regs_inst__1027_ spi_regs_inst__1027_/A1 spi_regs_inst__1027_/A2 spi_regs_inst__1146_/B1
+ VDD VDD VSS VSS gf180mcu_fd_sc_mcu7t5v0__nor2_1
XFILLER_97_176 VDD VDD VSS VSS gf180mcu_fd_sc_mcu7t5v0__fillcap_32
Xwave_controller_x_inst__3690_ wave_controller_x_inst__3690_/D wave_controller_x_inst__3690_/RN
+ clkbuf_leaf_22_clk/Z spi_regs_inst__1252_/B2 VDD VDD VSS VSS gf180mcu_fd_sc_mcu7t5v0__dffrnq_1
Xwave_controller_x_inst__2710_ wave_controller_x_inst__2646_/B wave_controller_x_inst__2681_/C
+ wave_controller_x_inst__2710_/A3 wave_controller_x_inst__2712_/A2 wave_controller_x_inst__2713_/A2
+ VDD VDD VSS VSS gf180mcu_fd_sc_mcu7t5v0__nand4_1
XFILLER_94_872 VDD VDD VSS VSS gf180mcu_fd_sc_mcu7t5v0__fill_2
XPHY_EDGE_ROW_12_1_Left_179 VDD VSS gf180mcu_fd_sc_mcu7t5v0__endcap
Xwave_controller_x_inst__2641_ max_cap463/Z wave_controller_x_inst__2640_/Z wave_controller_x_inst__2664_/A2
+ VDD VDD VSS VSS gf180mcu_fd_sc_mcu7t5v0__nand2_1
XFILLER_93_393 VDD VDD VSS VSS gf180mcu_fd_sc_mcu7t5v0__fill_1
Xwave_controller_x_inst__2572_ max_cap465/I wave_controller_x_inst__2570_/Z wave_controller_x_inst__2572_/Z
+ VDD VDD VSS VSS gf180mcu_fd_sc_mcu7t5v0__xor2_1
Xclkbuf_leaf_18_clk clkbuf_3_4__f_clk/Z clkload25/I VDD VDD VSS VSS gf180mcu_fd_sc_mcu7t5v0__clkbuf_8
XTAP_TAPCELL_ROW_140_2189 VDD VSS gf180mcu_fd_sc_mcu7t5v0__filltie
Xwave_controller_y_inst__3140_ wave_controller_y_inst__3142_/B wave_controller_y_inst__3141_/B
+ VDD VDD VSS VSS gf180mcu_fd_sc_mcu7t5v0__clkinv_1
Xwave_controller_x_inst__3124_ wave_controller_x_inst__3290_/A1 spi_regs_inst__1524_/Q
+ wave_controller_x_inst__3146_/C VDD VDD VSS VSS gf180mcu_fd_sc_mcu7t5v0__nand2_1
Xwave_controller_y_inst__3071_ wave_controller_y_inst__3712_/Q wave_controller_y_inst__1819_/I
+ wave_controller_y_inst__3071_/A3 wave_controller_y_inst__3071_/Z VDD VDD VSS VSS
+ gf180mcu_fd_sc_mcu7t5v0__xor3_1
XFILLER_162_321 VDD VDD VSS VSS gf180mcu_fd_sc_mcu7t5v0__fill_2
Xwave_controller_y_inst__2022_ wave_controller_y_inst__2024_/A1 wave_controller_y_inst__2017_/Z
+ wave_controller_y_inst__2023_/A3 VDD VDD VSS VSS gf180mcu_fd_sc_mcu7t5v0__nor2_1
Xwave_controller_x_inst__3055_ wave_controller_x_inst__2951_/I wave_controller_x_inst__3055_/A2
+ wave_controller_x_inst__3055_/B wave_controller_x_inst__3057_/B1 VDD VDD VSS VSS
+ gf180mcu_fd_sc_mcu7t5v0__aoi21_1
XFILLER_135_557 VDD VDD VSS VSS gf180mcu_fd_sc_mcu7t5v0__fill_2
XFILLER_162_332 VDD VDD VSS VSS gf180mcu_fd_sc_mcu7t5v0__fillcap_8
Xwave_controller_x_inst__2006_ fanout537/Z spi_regs_inst__1277_/A1 wave_controller_x_inst__2006_/A3
+ spi_regs_inst__1279_/B2 VDD VDD VSS VSS gf180mcu_fd_sc_mcu7t5v0__xor3_1
XFILLER_104_933 VDD VDD VSS VSS gf180mcu_fd_sc_mcu7t5v0__fillcap_8
XFILLER_150_527 VDD VDD VSS VSS gf180mcu_fd_sc_mcu7t5v0__fillcap_4
XFILLER_162_387 VDD VDD VSS VSS gf180mcu_fd_sc_mcu7t5v0__fillcap_16
XFILLER_1_504 VDD VDD VSS VSS gf180mcu_fd_sc_mcu7t5v0__fill_2
XFILLER_143_590 VDD VDD VSS VSS gf180mcu_fd_sc_mcu7t5v0__fillcap_8
XFILLER_157_1170 VDD VDD VSS VSS gf180mcu_fd_sc_mcu7t5v0__fillcap_4
XFILLER_77_806 VDD VDD VSS VSS gf180mcu_fd_sc_mcu7t5v0__fill_1
XFILLER_77_839 VDD VDD VSS VSS gf180mcu_fd_sc_mcu7t5v0__fill_1
XFILLER_89_699 VDD VDD VSS VSS gf180mcu_fd_sc_mcu7t5v0__fill_1
Xspi_regs_inst_fanout338 spi_regs_inst__1030_/A1 spi_regs_inst__1021_/A1 VDD VDD VSS
+ VSS gf180mcu_fd_sc_mcu7t5v0__dlyb_1
XFILLER_131_796 VDD VDD VSS VSS gf180mcu_fd_sc_mcu7t5v0__fill_2
Xwave_controller_y_inst__2924_ wave_controller_y_inst__3004_/B wave_controller_y_inst_wire323/Z
+ wave_controller_y_inst__3589_/I0 VDD VDD VSS VSS gf180mcu_fd_sc_mcu7t5v0__nor2_1
Xwave_controller_x_inst__2908_ wave_controller_x_inst__2908_/A1 wave_controller_x_inst__2933_/A2
+ wave_controller_x_inst__2908_/B1 wave_controller_x_inst__2764_/Z wave_controller_x_inst__3722_/D
+ VDD VDD VSS VSS gf180mcu_fd_sc_mcu7t5v0__oai22_1
XFILLER_29_243 VDD VDD VSS VSS gf180mcu_fd_sc_mcu7t5v0__fill_2
XFILLER_57_552 VDD VDD VSS VSS gf180mcu_fd_sc_mcu7t5v0__fillcap_8
XPHY_EDGE_ROW_150_Right_150 VDD VSS gf180mcu_fd_sc_mcu7t5v0__endcap
Xwave_controller_y_inst__2855_ wave_controller_y_inst__2855_/A1 wave_controller_y_inst__2897_/A3
+ wave_controller_y_inst__2855_/B wave_controller_y_inst__2889_/A2 VDD VDD VSS VSS
+ gf180mcu_fd_sc_mcu7t5v0__aoi21_1
Xwave_controller_x_inst__2839_ wave_controller_x_inst__2839_/A1 wave_controller_x_inst__2839_/A2
+ wave_controller_x_inst__2839_/B wave_controller_x_inst__2852_/A1 VDD VDD VSS VSS
+ gf180mcu_fd_sc_mcu7t5v0__oai21_1
XFILLER_17_416 VDD VDD VSS VSS gf180mcu_fd_sc_mcu7t5v0__fillcap_4
XFILLER_72_522 VDD VDD VSS VSS gf180mcu_fd_sc_mcu7t5v0__fill_2
XFILLER_84_382 VDD VDD VSS VSS gf180mcu_fd_sc_mcu7t5v0__fill_2
Xwave_controller_y_inst__2786_ wave_controller_y_inst__2786_/A1 wave_controller_y_inst__2805_/S
+ wave_controller_y_inst__2786_/B wave_controller_y_inst__2787_/I VDD VDD VSS VSS
+ gf180mcu_fd_sc_mcu7t5v0__oai21_1
Xwave_controller_y_inst__1806_ wave_controller_y_inst__1806_/I wave_controller_y_inst__3340_/A1
+ VDD VDD VSS VSS gf180mcu_fd_sc_mcu7t5v0__clkinv_1
XFILLER_60_728 VDD VDD VSS VSS gf180mcu_fd_sc_mcu7t5v0__fillcap_4
XFILLER_72_588 VDD VDD VSS VSS gf180mcu_fd_sc_mcu7t5v0__fillcap_4
XTAP_TAPCELL_ROW_55_786 VDD VSS gf180mcu_fd_sc_mcu7t5v0__filltie
XFILLER_158_605 VDD VDD VSS VSS gf180mcu_fd_sc_mcu7t5v0__fillcap_4
XFILLER_73_1046 VDD VDD VSS VSS gf180mcu_fd_sc_mcu7t5v0__fillcap_4
XTAP_TAPCELL_ROW_80_1203 VDD VSS gf180mcu_fd_sc_mcu7t5v0__filltie
XFILLER_12_121 VDD VDD VSS VSS gf180mcu_fd_sc_mcu7t5v0__fill_1
XFILLER_158_627 VDD VDD VSS VSS gf180mcu_fd_sc_mcu7t5v0__fillcap_32
XFILLER_40_430 VDD VDD VSS VSS gf180mcu_fd_sc_mcu7t5v0__fill_2
XFILLER_40_452 VDD VDD VSS VSS gf180mcu_fd_sc_mcu7t5v0__fill_2
Xwave_controller_y_inst__3407_ wave_controller_y_inst__3407_/A1 wave_controller_y_inst__2923_/S
+ wave_controller_y_inst__3407_/B wave_controller_y_inst__3618_/D VDD VDD VSS VSS
+ gf180mcu_fd_sc_mcu7t5v0__aoi21_1
XFILLER_12_165 VDD VDD VSS VSS gf180mcu_fd_sc_mcu7t5v0__fillcap_8
Xwave_controller_y_inst__3338_ wave_controller_y_inst__1806_/I wave_controller_y_inst__3338_/A2
+ wave_controller_y_inst__3338_/B wave_controller_y_inst__3402_/A2 VDD VDD VSS VSS
+ gf180mcu_fd_sc_mcu7t5v0__oai21_1
XFILLER_138_362 VDD VDD VSS VSS gf180mcu_fd_sc_mcu7t5v0__fillcap_4
XFILLER_126_524 VDD VDD VSS VSS gf180mcu_fd_sc_mcu7t5v0__fill_1
XFILLER_126_535 VDD VDD VSS VSS gf180mcu_fd_sc_mcu7t5v0__fillcap_4
XFILLER_138_395 VDD VDD VSS VSS gf180mcu_fd_sc_mcu7t5v0__fill_2
Xwave_controller_y_inst__3269_ wave_controller_y_inst__1792_/I wave_controller_y_inst__3365_/A2
+ wave_controller_y_inst__3303_/A1 VDD VDD VSS VSS gf180mcu_fd_sc_mcu7t5v0__nand2_1
XFILLER_153_332 VDD VDD VSS VSS gf180mcu_fd_sc_mcu7t5v0__fill_2
XFILLER_154_877 VDD VDD VSS VSS gf180mcu_fd_sc_mcu7t5v0__fillcap_64
XTAP_TAPCELL_ROW_78_1165 VDD VSS gf180mcu_fd_sc_mcu7t5v0__filltie
XFILLER_153_387 VDD VDD VSS VSS gf180mcu_fd_sc_mcu7t5v0__fill_2
XFILLER_99_419 VDD VDD VSS VSS gf180mcu_fd_sc_mcu7t5v0__fill_1
Xsignal_processor_y_inst__190_ signal_processor_y_inst__242_/Q signal_processor_y_inst__190_/A2
+ signal_processor_y_inst__191_/B VDD VDD VSS VSS gf180mcu_fd_sc_mcu7t5v0__nand2_1
XFILLER_80_1017 VDD VDD VSS VSS gf180mcu_fd_sc_mcu7t5v0__fillcap_64
XTAP_TAPCELL_ROW_91_1376 VDD VSS gf180mcu_fd_sc_mcu7t5v0__filltie
XFILLER_110_947 VDD VDD VSS VSS gf180mcu_fd_sc_mcu7t5v0__fillcap_64
XFILLER_79_176 VDD VDD VSS VSS gf180mcu_fd_sc_mcu7t5v0__fill_1
XPHY_EDGE_ROW_45_1_Right_44 VDD VSS gf180mcu_fd_sc_mcu7t5v0__endcap
Xwave_controller_x_inst_fanout371 wave_controller_x_inst__2092_/C wave_controller_x_inst__2125_/C
+ VDD VDD VSS VSS gf180mcu_fd_sc_mcu7t5v0__dlyb_1
XFILLER_35_224 VDD VDD VSS VSS gf180mcu_fd_sc_mcu7t5v0__fillcap_16
XFILLER_63_555 VDD VDD VSS VSS gf180mcu_fd_sc_mcu7t5v0__fillcap_4
XFILLER_91_842 VDD VDD VSS VSS gf180mcu_fd_sc_mcu7t5v0__fillcap_8
XFILLER_63_566 VDD VDD VSS VSS gf180mcu_fd_sc_mcu7t5v0__fill_1
Xspi_regs_inst__1645_ spi_regs_inst__1645_/D fanout566/Z clkload13/I spi_regs_inst__1645_/Q
+ VDD VDD VSS VSS gf180mcu_fd_sc_mcu7t5v0__dffrnq_1
Xspi_regs_inst__1576_ spi_regs_inst__1576_/D fanout566/Z clkload17/I spi_regs_inst__1576_/Q
+ VDD VDD VSS VSS gf180mcu_fd_sc_mcu7t5v0__dffrnq_1
XFILLER_148_148 VDD VDD VSS VSS gf180mcu_fd_sc_mcu7t5v0__fillcap_16
XFILLER_85_2 VDD VDD VSS VSS gf180mcu_fd_sc_mcu7t5v0__fillcap_16
XFILLER_117_524 VDD VDD VSS VSS gf180mcu_fd_sc_mcu7t5v0__fillcap_4
XFILLER_144_310 VDD VDD VSS VSS gf180mcu_fd_sc_mcu7t5v0__fillcap_4
XFILLER_156_170 VDD VDD VSS VSS gf180mcu_fd_sc_mcu7t5v0__fillcap_4
XFILLER_156_181 VDD VDD VSS VSS gf180mcu_fd_sc_mcu7t5v0__fill_2
XFILLER_144_354 VDD VDD VSS VSS gf180mcu_fd_sc_mcu7t5v0__fillcap_8
XFILLER_132_505 VDD VDD VSS VSS gf180mcu_fd_sc_mcu7t5v0__fill_1
XFILLER_132_527 VDD VDD VSS VSS gf180mcu_fd_sc_mcu7t5v0__fillcap_32
Xclkbuf_leaf_7_clk clkbuf_leaf_8_clk/I clkbuf_leaf_7_clk/Z VDD VDD VSS VSS gf180mcu_fd_sc_mcu7t5v0__clkbuf_8
XTAP_TAPCELL_ROW_32_1_573 VDD VSS gf180mcu_fd_sc_mcu7t5v0__filltie
XTAP_TAPCELL_ROW_129_2007 VDD VSS gf180mcu_fd_sc_mcu7t5v0__filltie
Xfanout627 input5/Z wire628/I VDD VDD VSS VSS gf180mcu_fd_sc_mcu7t5v0__dlyb_1
Xfanout616 fanout620/Z fanout616/Z VDD VDD VSS VSS gf180mcu_fd_sc_mcu7t5v0__dlyb_1
XFILLER_140_571 VDD VDD VSS VSS gf180mcu_fd_sc_mcu7t5v0__fill_2
XFILLER_98_485 VDD VDD VSS VSS gf180mcu_fd_sc_mcu7t5v0__fill_2
XFILLER_100_457 VDD VDD VSS VSS gf180mcu_fd_sc_mcu7t5v0__fillcap_16
XFILLER_85_168 VDD VDD VSS VSS gf180mcu_fd_sc_mcu7t5v0__fill_1
XFILLER_26_202 VDD VDD VSS VSS gf180mcu_fd_sc_mcu7t5v0__fillcap_4
XFILLER_82_831 VDD VDD VSS VSS gf180mcu_fd_sc_mcu7t5v0__fill_1
XTAP_TAPCELL_ROW_142_2218 VDD VSS gf180mcu_fd_sc_mcu7t5v0__filltie
Xwave_controller_y_inst__2640_ wave_controller_y_inst__3391_/A1 wave_controller_y_inst__2636_/Z
+ wave_controller_y_inst__2640_/A3 wave_controller_y_inst__2640_/Z VDD VDD VSS VSS
+ gf180mcu_fd_sc_mcu7t5v0__xor3_1
Xwave_controller_x_inst__3673_ wave_controller_x_inst__3673_/D wave_controller_x_inst__3701_/RN
+ clkload31/I spi_regs_inst__1193_/B2 VDD VDD VSS VSS gf180mcu_fd_sc_mcu7t5v0__dffrnq_1
XTAP_TAPCELL_ROW_107_1637 VDD VSS gf180mcu_fd_sc_mcu7t5v0__filltie
XTAP_TAPCELL_ROW_107_1648 VDD VSS gf180mcu_fd_sc_mcu7t5v0__filltie
Xwave_controller_x_inst__2624_ wave_controller_x_inst__2981_/A2 wave_controller_x_inst__3530_/B2
+ wave_controller_x_inst__2621_/Z wave_controller_x_inst__2625_/I VDD VDD VSS VSS
+ gf180mcu_fd_sc_mcu7t5v0__xor3_1
XFILLER_26_279 VDD VDD VSS VSS gf180mcu_fd_sc_mcu7t5v0__fillcap_8
XFILLER_54_577 VDD VDD VSS VSS gf180mcu_fd_sc_mcu7t5v0__fill_2
XFILLER_81_352 VDD VDD VSS VSS gf180mcu_fd_sc_mcu7t5v0__fillcap_4
Xwave_controller_y_inst__2571_ spi_regs_inst__1045_/B2 wave_controller_y_inst__2570_/Z
+ wave_controller_y_inst__2591_/A2 VDD VDD VSS VSS gf180mcu_fd_sc_mcu7t5v0__nand2_1
Xwave_controller_x_inst__2555_ wave_controller_x_inst__2555_/A1 wave_controller_x_inst__2555_/A2
+ wave_controller_x_inst__2555_/B1 wave_controller_x_inst_wire182/Z wave_controller_x_inst__2555_/C
+ wave_controller_x_inst_wire169/I VDD VDD VSS VSS gf180mcu_fd_sc_mcu7t5v0__oai221_1
XFILLER_148_1169 VDD VDD VSS VSS gf180mcu_fd_sc_mcu7t5v0__fill_1
XFILLER_139_104 VDD VDD VSS VSS gf180mcu_fd_sc_mcu7t5v0__fillcap_16
XTAP_TAPCELL_ROW_120_1859 VDD VSS gf180mcu_fd_sc_mcu7t5v0__filltie
Xwave_controller_x_inst__2486_ wave_controller_x_inst__2793_/I0 wave_controller_x_inst__3509_/B2
+ wave_controller_x_inst__2501_/A1 VDD VDD VSS VSS gf180mcu_fd_sc_mcu7t5v0__nor2_1
XFILLER_139_137 VDD VDD VSS VSS gf180mcu_fd_sc_mcu7t5v0__fill_2
XFILLER_22_463 VDD VDD VSS VSS gf180mcu_fd_sc_mcu7t5v0__fillcap_16
XTAP_TAPCELL_ROW_157_2461 VDD VSS gf180mcu_fd_sc_mcu7t5v0__filltie
XTAP_TAPCELL_ROW_157_2472 VDD VSS gf180mcu_fd_sc_mcu7t5v0__filltie
XFILLER_120_1011 VDD VDD VSS VSS gf180mcu_fd_sc_mcu7t5v0__fillcap_4
XFILLER_154_107 VDD VDD VSS VSS gf180mcu_fd_sc_mcu7t5v0__fillcap_64
XFILLER_155_608 VDD VDD VSS VSS gf180mcu_fd_sc_mcu7t5v0__fill_1
Xwave_controller_y_inst__3123_ wave_controller_y_inst__3705_/Q wave_controller_y_inst__3143_/A2
+ wave_controller_y_inst__3218_/B VDD VDD VSS VSS gf180mcu_fd_sc_mcu7t5v0__nor2_1
XFILLER_108_535 VDD VDD VSS VSS gf180mcu_fd_sc_mcu7t5v0__fill_2
XFILLER_136_833 VDD VDD VSS VSS gf180mcu_fd_sc_mcu7t5v0__fillcap_16
Xwave_controller_x_inst__3107_ wave_controller_x_inst__1783_/I spi_regs_inst__1534_/Q
+ wave_controller_x_inst__3107_/Z VDD VDD VSS VSS gf180mcu_fd_sc_mcu7t5v0__xor2_1
XFILLER_136_877 VDD VDD VSS VSS gf180mcu_fd_sc_mcu7t5v0__fillcap_64
Xwave_controller_y_inst__3054_ wave_controller_y_inst__3568_/A1 wave_controller_y_inst__3059_/A2
+ wave_controller_y_inst__3053_/Z wave_controller_y_inst_wire147/Z wave_controller_y_inst__3706_/D
+ VDD VDD VSS VSS gf180mcu_fd_sc_mcu7t5v0__oai22_1
Xwave_controller_x_inst__3038_ wave_controller_x_inst__2895_/C wave_controller_x_inst__3038_/A2
+ wave_controller_x_inst__3700_/D VDD VDD VSS VSS gf180mcu_fd_sc_mcu7t5v0__nor2_1
XFILLER_108_579 VDD VDD VSS VSS gf180mcu_fd_sc_mcu7t5v0__fill_1
XFILLER_118_53 VDD VDD VSS VSS gf180mcu_fd_sc_mcu7t5v0__fillcap_4
XFILLER_135_387 VDD VDD VSS VSS gf180mcu_fd_sc_mcu7t5v0__fillcap_4
XFILLER_150_313 VDD VDD VSS VSS gf180mcu_fd_sc_mcu7t5v0__fill_2
XFILLER_163_696 VDD VDD VSS VSS gf180mcu_fd_sc_mcu7t5v0__fillcap_4
XTAP_TAPCELL_ROW_18_1_463 VDD VSS gf180mcu_fd_sc_mcu7t5v0__filltie
Xwave_controller_y_inst__2005_ fanout516/Z wave_controller_y_inst__2349_/A1 wave_controller_y_inst__2009_/B
+ VDD VDD VSS VSS gf180mcu_fd_sc_mcu7t5v0__nand2_1
XFILLER_116_590 VDD VDD VSS VSS gf180mcu_fd_sc_mcu7t5v0__fillcap_4
XFILLER_78_57 VDD VDD VSS VSS gf180mcu_fd_sc_mcu7t5v0__fill_2
Xwave_controller_x_inst_wire113 wave_controller_x_inst_wire113/I wave_controller_x_inst_wire113/Z
+ VDD VDD VSS VSS gf180mcu_fd_sc_mcu7t5v0__buf_1
XTAP_TAPCELL_ROW_73_1084 VDD VSS gf180mcu_fd_sc_mcu7t5v0__filltie
XFILLER_104_785 VDD VDD VSS VSS gf180mcu_fd_sc_mcu7t5v0__fill_1
XFILLER_1_378 VDD VDD VSS VSS gf180mcu_fd_sc_mcu7t5v0__fill_1
Xwave_controller_y_inst__2907_ wave_controller_y_inst__3700_/Q wave_controller_y_inst__3454_/A2
+ wave_controller_y_inst__3419_/C wave_controller_y_inst__3723_/Q wave_controller_y_inst__2907_/C
+ wave_controller_y_inst__2908_/B1 VDD VDD VSS VSS gf180mcu_fd_sc_mcu7t5v0__aoi221_1
XFILLER_45_500 VDD VDD VSS VSS gf180mcu_fd_sc_mcu7t5v0__fillcap_4
XFILLER_58_883 VDD VDD VSS VSS gf180mcu_fd_sc_mcu7t5v0__fill_1
XFILLER_64_319 VDD VDD VSS VSS gf180mcu_fd_sc_mcu7t5v0__fill_1
XFILLER_27_72 VDD VDD VSS VSS gf180mcu_fd_sc_mcu7t5v0__fill_2
XFILLER_73_842 VDD VDD VSS VSS gf180mcu_fd_sc_mcu7t5v0__fillcap_16
XFILLER_91_138 VDD VDD VSS VSS gf180mcu_fd_sc_mcu7t5v0__fill_2
Xwave_controller_y_inst__2838_ wave_controller_y_inst__2838_/A1 wave_controller_y_inst__2838_/A2
+ wave_controller_y_inst__2838_/B wave_controller_y_inst__2839_/B VDD VDD VSS VSS
+ gf180mcu_fd_sc_mcu7t5v0__aoi21_1
XFILLER_17_268 VDD VDD VSS VSS gf180mcu_fd_sc_mcu7t5v0__fillcap_8
XFILLER_27_83 VDD VDD VSS VSS gf180mcu_fd_sc_mcu7t5v0__fillcap_16
XFILLER_73_897 VDD VDD VSS VSS gf180mcu_fd_sc_mcu7t5v0__fillcap_4
Xwave_controller_y_inst__2769_ spi_regs_inst__1234_/A1 wave_controller_y_inst__2902_/B2
+ wave_controller_y_inst__2770_/B VDD VDD VSS VSS gf180mcu_fd_sc_mcu7t5v0__nand2_1
XFILLER_9_401 VDD VDD VSS VSS gf180mcu_fd_sc_mcu7t5v0__fill_1
Xspi_regs_inst__1430_ spi_regs_inst__1500_/Q spi_regs_inst__1430_/I1 spi_regs_inst__1436_/S
+ spi_regs_inst__1500_/D VDD VDD VSS VSS gf180mcu_fd_sc_mcu7t5v0__mux2_2
Xspi_regs_inst__1361_ spi_regs_inst__1648_/Q spi_regs_inst__1074_/Z spi_regs_inst__1362_/A3
+ VDD VDD VSS VSS gf180mcu_fd_sc_mcu7t5v0__nor2_1
XFILLER_40_282 VDD VDD VSS VSS gf180mcu_fd_sc_mcu7t5v0__fillcap_4
Xspi_regs_inst__1292_ spi_regs_inst__1554_/Q spi_regs_inst__1292_/A2 spi_regs_inst_wire269/Z
+ spi_regs_inst__1533_/Q spi_regs_inst__1294_/A3 VDD VDD VSS VSS gf180mcu_fd_sc_mcu7t5v0__aoi22_1
XFILLER_154_641 VDD VDD VSS VSS gf180mcu_fd_sc_mcu7t5v0__fillcap_4
XTAP_TAPCELL_ROW_93_1416 VDD VSS gf180mcu_fd_sc_mcu7t5v0__filltie
XTAP_TAPCELL_ROW_93_1405 VDD VSS gf180mcu_fd_sc_mcu7t5v0__filltie
XFILLER_126_387 VDD VDD VSS VSS gf180mcu_fd_sc_mcu7t5v0__fillcap_4
XFILLER_142_825 VDD VDD VSS VSS gf180mcu_fd_sc_mcu7t5v0__fillcap_4
XFILLER_141_346 VDD VDD VSS VSS gf180mcu_fd_sc_mcu7t5v0__fillcap_4
XFILLER_68_603 VDD VDD VSS VSS gf180mcu_fd_sc_mcu7t5v0__fill_1
XFILLER_68_614 VDD VDD VSS VSS gf180mcu_fd_sc_mcu7t5v0__fillcap_4
Xsignal_processor_y_inst__242_ signal_processor_y_inst__242_/D _17_/B _21_/CLK signal_processor_y_inst__242_/Q
+ VDD VDD VSS VSS gf180mcu_fd_sc_mcu7t5v0__dffrnq_1
Xsignal_processor_y_inst__173_ signal_processor_y_inst__187_/A1 signal_processor_y_inst__213_/A2
+ signal_processor_y_inst__235_/D VDD VDD VSS VSS gf180mcu_fd_sc_mcu7t5v0__nor2_1
XFILLER_110_799 VDD VDD VSS VSS gf180mcu_fd_sc_mcu7t5v0__fillcap_4
XFILLER_95_488 VDD VDD VSS VSS gf180mcu_fd_sc_mcu7t5v0__fill_2
XFILLER_63_352 VDD VDD VSS VSS gf180mcu_fd_sc_mcu7t5v0__fill_2
XFILLER_23_216 VDD VDD VSS VSS gf180mcu_fd_sc_mcu7t5v0__fill_1
XFILLER_51_536 VDD VDD VSS VSS gf180mcu_fd_sc_mcu7t5v0__fill_1
Xwave_controller_y_inst_load_slew80 wave_controller_y_inst__3419_/C wave_controller_y_inst__3489_/A2
+ VDD VDD VSS VSS gf180mcu_fd_sc_mcu7t5v0__buf_2
Xwave_controller_x_inst__2340_ wave_controller_x_inst__2338_/Z wave_controller_x_inst__2341_/A2
+ wave_controller_x_inst__2361_/B VDD VDD VSS VSS gf180mcu_fd_sc_mcu7t5v0__nand2_1
Xspi_regs_inst__1628_ spi_regs_inst__1628_/D fanout582/Z clkbuf_leaf_14_clk/Z spi_regs_inst__1628_/Q
+ VDD VDD VSS VSS gf180mcu_fd_sc_mcu7t5v0__dffrnq_1
XTAP_TAPCELL_ROW_102_1556 VDD VSS gf180mcu_fd_sc_mcu7t5v0__filltie
XTAP_TAPCELL_ROW_102_1567 VDD VSS gf180mcu_fd_sc_mcu7t5v0__filltie
Xwave_controller_x_inst__2271_ spi_regs_inst__1100_/B2 spi_regs_inst__1090_/A1 wave_controller_x_inst__2286_/A2
+ VDD VDD VSS VSS gf180mcu_fd_sc_mcu7t5v0__xnor2_1
Xspi_regs_inst__1559_ spi_regs_inst__1559_/D fanout561/Z clkload9/I spi_regs_inst__1559_/Q
+ VDD VDD VSS VSS gf180mcu_fd_sc_mcu7t5v0__dffrnq_1
XFILLER_104_1017 VDD VDD VSS VSS gf180mcu_fd_sc_mcu7t5v0__fillcap_64
XFILLER_149_468 VDD VDD VSS VSS gf180mcu_fd_sc_mcu7t5v0__fill_1
XFILLER_165_906 VDD VDD VSS VSS gf180mcu_fd_sc_mcu7t5v0__fillcap_4
XFILLER_31_282 VDD VDD VSS VSS gf180mcu_fd_sc_mcu7t5v0__fillcap_32
XFILLER_118_877 VDD VDD VSS VSS gf180mcu_fd_sc_mcu7t5v0__fillcap_4
XFILLER_132_302 VDD VDD VSS VSS gf180mcu_fd_sc_mcu7t5v0__fill_1
XFILLER_155_18 VDD VDD VSS VSS gf180mcu_fd_sc_mcu7t5v0__fillcap_4
XTAP_TAPCELL_ROW_135_2099 VDD VSS gf180mcu_fd_sc_mcu7t5v0__filltie
XTAP_TAPCELL_ROW_152_2380 VDD VSS gf180mcu_fd_sc_mcu7t5v0__filltie
XTAP_TAPCELL_ROW_152_2391 VDD VSS gf180mcu_fd_sc_mcu7t5v0__filltie
Xwave_controller_y_inst_fanout518 fanout519/I wave_controller_y_inst__1821_/I VDD
+ VDD VSS VSS gf180mcu_fd_sc_mcu7t5v0__dlyb_1
XFILLER_160_644 VDD VDD VSS VSS gf180mcu_fd_sc_mcu7t5v0__fillcap_16
XFILLER_132_368 VDD VDD VSS VSS gf180mcu_fd_sc_mcu7t5v0__fillcap_4
XFILLER_132_379 VDD VDD VSS VSS gf180mcu_fd_sc_mcu7t5v0__fillcap_4
XFILLER_87_901 VDD VDD VSS VSS gf180mcu_fd_sc_mcu7t5v0__fill_2
XFILLER_99_772 VDD VDD VSS VSS gf180mcu_fd_sc_mcu7t5v0__fillcap_16
Xfanout402 fanout402/I fanout402/Z VDD VDD VSS VSS gf180mcu_fd_sc_mcu7t5v0__dlyb_1
XFILLER_154_1151 VDD VDD VSS VSS gf180mcu_fd_sc_mcu7t5v0__fillcap_4
Xwave_controller_y_inst__3741_ spi_regs_inst__1090_/B2 spi_regs_inst__1085_/A1 VDD
+ VDD VSS VSS gf180mcu_fd_sc_mcu7t5v0__buf_1
Xwave_controller_x_inst__1986_ wave_controller_x_inst__1986_/A1 wave_controller_x_inst__1986_/A2
+ wave_controller_x_inst__1986_/A3 wave_controller_x_inst__1986_/B wave_controller_x_inst__1988_/A2
+ VDD VDD VSS VSS gf180mcu_fd_sc_mcu7t5v0__oai31_1
XFILLER_101_788 VDD VDD VSS VSS gf180mcu_fd_sc_mcu7t5v0__fillcap_8
XFILLER_27_500 VDD VDD VSS VSS gf180mcu_fd_sc_mcu7t5v0__fill_2
XFILLER_46_308 VDD VDD VSS VSS gf180mcu_fd_sc_mcu7t5v0__fillcap_4
XFILLER_58_168 VDD VDD VSS VSS gf180mcu_fd_sc_mcu7t5v0__fill_1
XTAP_TAPCELL_ROW_57_815 VDD VSS gf180mcu_fd_sc_mcu7t5v0__filltie
Xwave_controller_y_inst_max_cap424 spi_regs_inst__1078_/A1 wave_controller_y_inst__2844_/A1
+ VDD VDD VSS VSS gf180mcu_fd_sc_mcu7t5v0__buf_2
Xwave_controller_x_inst__3725_ wave_controller_x_inst__3725_/D fanout590/Z clkload24/I
+ wave_controller_x_inst__3725_/Q VDD VDD VSS VSS gf180mcu_fd_sc_mcu7t5v0__dffrnq_1
XFILLER_100_287 VDD VDD VSS VSS gf180mcu_fd_sc_mcu7t5v0__fillcap_4
XFILLER_55_831 VDD VDD VSS VSS gf180mcu_fd_sc_mcu7t5v0__fill_2
XFILLER_55_842 VDD VDD VSS VSS gf180mcu_fd_sc_mcu7t5v0__fill_1
Xwave_controller_y_inst__3672_ wave_controller_y_inst__3672_/D wave_controller_y_inst__3673_/RN
+ clkbuf_leaf_35_clk/Z spi_regs_inst__1159_/A1 VDD VDD VSS VSS gf180mcu_fd_sc_mcu7t5v0__dffrnq_1
Xwave_controller_x_inst__3656_ wave_controller_x_inst__3656_/D wave_controller_x_inst__3704_/RN
+ clkload35/I max_cap457/I VDD VDD VSS VSS gf180mcu_fd_sc_mcu7t5v0__dffrnq_1
XFILLER_104_99 VDD VDD VSS VSS gf180mcu_fd_sc_mcu7t5v0__fillcap_4
XFILLER_54_363 VDD VDD VSS VSS gf180mcu_fd_sc_mcu7t5v0__fillcap_16
Xwave_controller_y_inst__2623_ wave_controller_y_inst__1821_/I wave_controller_y_inst__2621_/Z
+ wave_controller_y_inst__2623_/Z VDD VDD VSS VSS gf180mcu_fd_sc_mcu7t5v0__and2_1
Xwave_controller_x_inst__2607_ wave_controller_x_inst__2607_/A1 wave_controller_x_inst__2606_/I
+ wave_controller_x_inst__2610_/A1 VDD VDD VSS VSS gf180mcu_fd_sc_mcu7t5v0__nand2_1
XFILLER_120_32 VDD VDD VSS VSS gf180mcu_fd_sc_mcu7t5v0__fill_2
XTAP_TAPCELL_ROW_159_2501 VDD VSS gf180mcu_fd_sc_mcu7t5v0__filltie
Xwave_controller_y_inst__2554_ wave_controller_y_inst__2555_/A1 wave_controller_y_inst__2555_/A2
+ wave_controller_y_inst__2556_/B VDD VDD VSS VSS gf180mcu_fd_sc_mcu7t5v0__nor2_1
Xwave_controller_x_inst__3587_ wave_controller_x_inst__3587_/A1 wave_controller_x_inst__3585_/S
+ wave_controller_x_inst__3587_/B wave_controller_x_inst__3664_/D VDD VDD VSS VSS
+ gf180mcu_fd_sc_mcu7t5v0__oai21_1
XFILLER_80_14 VDD VDD VSS VSS gf180mcu_fd_sc_mcu7t5v0__fillcap_4
Xwave_controller_x_inst__2538_ wave_controller_x_inst__3515_/B2 wave_controller_x_inst__2537_/Z
+ wave_controller_x_inst__2561_/A2 VDD VDD VSS VSS gf180mcu_fd_sc_mcu7t5v0__nor2_1
XFILLER_120_87 VDD VDD VSS VSS gf180mcu_fd_sc_mcu7t5v0__fillcap_16
XFILLER_161_1122 VDD VDD VSS VSS gf180mcu_fd_sc_mcu7t5v0__fillcap_32
Xwave_controller_y_inst__2485_ wave_controller_y_inst__2497_/A1 wave_controller_y_inst__2497_/A2
+ wave_controller_y_inst__2498_/A2 VDD VDD VSS VSS gf180mcu_fd_sc_mcu7t5v0__nand2_1
Xwave_controller_x_inst__2469_ wave_controller_x_inst__2758_/B wave_controller_x_inst__2467_/Z
+ spi_regs_inst_wire132/I VDD VDD VSS VSS gf180mcu_fd_sc_mcu7t5v0__xnor2_1
Xsignal_processor_x_inst__193_ signal_processor_x_inst__171_/Z signal_processor_x_inst__193_/A2
+ signal_processor_x_inst__238_/Q signal_processor_x_inst__193_/C signal_processor_x_inst__195_/A2
+ VDD VDD VSS VSS gf180mcu_fd_sc_mcu7t5v0__oai211_1
XFILLER_127_129 VDD VDD VSS VSS gf180mcu_fd_sc_mcu7t5v0__fill_1
XFILLER_109_844 VDD VDD VSS VSS gf180mcu_fd_sc_mcu7t5v0__fill_1
XFILLER_136_630 VDD VDD VSS VSS gf180mcu_fd_sc_mcu7t5v0__fill_1
XFILLER_148_490 VDD VDD VSS VSS gf180mcu_fd_sc_mcu7t5v0__fillcap_4
XPHY_EDGE_ROW_37_1_Left_204 VDD VSS gf180mcu_fd_sc_mcu7t5v0__endcap
Xwave_controller_y_inst__3106_ wave_controller_y_inst__3320_/A1 spi_regs_inst__1597_/Q
+ wave_controller_y_inst__3170_/B VDD VDD VSS VSS gf180mcu_fd_sc_mcu7t5v0__nand2_1
XFILLER_136_663 VDD VDD VSS VSS gf180mcu_fd_sc_mcu7t5v0__fill_2
XFILLER_151_600 VDD VDD VSS VSS gf180mcu_fd_sc_mcu7t5v0__fillcap_4
XTAP_TAPCELL_ROW_75_1113 VDD VSS gf180mcu_fd_sc_mcu7t5v0__filltie
Xwave_controller_y_inst__3037_ wave_controller_y_inst__3700_/Q wave_controller_y_inst__3557_/B1
+ wave_controller_y_inst__3494_/A1 wave_controller_y_inst__3557_/A1 wave_controller_y_inst__3038_/A2
+ VDD VDD VSS VSS gf180mcu_fd_sc_mcu7t5v0__oai22_1
XFILLER_108_387 VDD VDD VSS VSS gf180mcu_fd_sc_mcu7t5v0__fillcap_8
XFILLER_89_78 VDD VDD VSS VSS gf180mcu_fd_sc_mcu7t5v0__fill_1
XFILLER_123_368 VDD VDD VSS VSS gf180mcu_fd_sc_mcu7t5v0__fillcap_4
XFILLER_151_677 VDD VDD VSS VSS gf180mcu_fd_sc_mcu7t5v0__fill_2
XFILLER_1_142 VDD VDD VSS VSS gf180mcu_fd_sc_mcu7t5v0__fillcap_64
XTAP_TAPCELL_ROW_49_1_702 VDD VSS gf180mcu_fd_sc_mcu7t5v0__filltie
Xwave_controller_x_inst_wire94 wave_controller_x_inst_wire94/I wave_controller_x_inst_wire94/Z
+ VDD VDD VSS VSS gf180mcu_fd_sc_mcu7t5v0__clkbuf_1
XFILLER_132_891 VDD VDD VSS VSS gf180mcu_fd_sc_mcu7t5v0__fill_1
XFILLER_151_699 VDD VDD VSS VSS gf180mcu_fd_sc_mcu7t5v0__fill_1
XFILLER_77_422 VDD VDD VSS VSS gf180mcu_fd_sc_mcu7t5v0__fillcap_8
XFILLER_89_282 VDD VDD VSS VSS gf180mcu_fd_sc_mcu7t5v0__fill_2
XFILLER_89_293 VDD VDD VSS VSS gf180mcu_fd_sc_mcu7t5v0__fillcap_16
XFILLER_93_904 VDD VDD VSS VSS gf180mcu_fd_sc_mcu7t5v0__fillcap_4
Xspi_regs_inst__0930_ spi_regs_inst__1013_/A1 spi_regs_inst__1028_/A1 spi_regs_inst__0931_/B1
+ VDD VDD VSS VSS gf180mcu_fd_sc_mcu7t5v0__nor2_1
XFILLER_49_168 VDD VDD VSS VSS gf180mcu_fd_sc_mcu7t5v0__fill_2
XFILLER_65_628 VDD VDD VSS VSS gf180mcu_fd_sc_mcu7t5v0__fill_2
XFILLER_93_937 VDD VDD VSS VSS gf180mcu_fd_sc_mcu7t5v0__fillcap_32
Xspi_regs_inst__0861_ spi_regs_inst__1598_/Q spi_regs_inst__1412_/I1 spi_regs_inst__0861_/S
+ spi_regs_inst__1598_/D VDD VDD VSS VSS gf180mcu_fd_sc_mcu7t5v0__mux2_2
XFILLER_161_72 VDD VDD VSS VSS gf180mcu_fd_sc_mcu7t5v0__fillcap_64
XFILLER_58_691 VDD VDD VSS VSS gf180mcu_fd_sc_mcu7t5v0__fill_2
XFILLER_64_127 VDD VDD VSS VSS gf180mcu_fd_sc_mcu7t5v0__fillcap_4
XFILLER_166_1011 VDD VDD VSS VSS gf180mcu_fd_sc_mcu7t5v0__fillcap_4
XFILLER_45_352 VDD VDD VSS VSS gf180mcu_fd_sc_mcu7t5v0__fillcap_4
XFILLER_79_1052 VDD VDD VSS VSS gf180mcu_fd_sc_mcu7t5v0__fillcap_64
XFILLER_92_469 VDD VDD VSS VSS gf180mcu_fd_sc_mcu7t5v0__fillcap_16
XTAP_TAPCELL_ROW_23_1_504 VDD VSS gf180mcu_fd_sc_mcu7t5v0__filltie
Xspi_regs_inst__0792_ spi_regs_inst__1543_/Q spi_regs_inst__1416_/I0 spi_regs_inst__0795_/S
+ spi_regs_inst__1543_/D VDD VDD VSS VSS gf180mcu_fd_sc_mcu7t5v0__mux2_2
XTAP_TAPCELL_ROW_86_1297 VDD VSS gf180mcu_fd_sc_mcu7t5v0__filltie
XFILLER_72_193 VDD VDD VSS VSS gf180mcu_fd_sc_mcu7t5v0__fill_2
XTAP_TAPCELL_ROW_31_1_561 VDD VSS gf180mcu_fd_sc_mcu7t5v0__filltie
XFILLER_20_208 VDD VDD VSS VSS gf180mcu_fd_sc_mcu7t5v0__fillcap_4
XFILLER_60_377 VDD VDD VSS VSS gf180mcu_fd_sc_mcu7t5v0__fillcap_8
XFILLER_60_399 VDD VDD VSS VSS gf180mcu_fd_sc_mcu7t5v0__fill_2
Xspi_regs_inst__1413_ spi_regs_inst__1653_/Q spi_regs_inst__1652_/Q spi_regs_inst__1422_/A2
+ spi_regs_inst__1437_/A3 spi_regs_inst__1421_/S VDD VDD VSS VSS gf180mcu_fd_sc_mcu7t5v0__or4_1
XFILLER_13_282 VDD VDD VSS VSS gf180mcu_fd_sc_mcu7t5v0__fillcap_8
XFILLER_147_906 VDD VDD VSS VSS gf180mcu_fd_sc_mcu7t5v0__fillcap_4
XFILLER_159_766 VDD VDD VSS VSS gf180mcu_fd_sc_mcu7t5v0__fillcap_4
XFILLER_118_107 VDD VDD VSS VSS gf180mcu_fd_sc_mcu7t5v0__fillcap_32
XFILLER_146_427 VDD VDD VSS VSS gf180mcu_fd_sc_mcu7t5v0__fillcap_4
Xspi_regs_inst__1344_ spi_regs_inst__1344_/A1 spi_regs_inst__1344_/A2 spi_regs_inst__1344_/A3
+ spi_regs_inst__1345_/C VDD VDD VSS VSS gf180mcu_fd_sc_mcu7t5v0__nand3_1
Xspi_regs_inst__1275_ spi_regs_inst__1275_/A1 spi_regs_inst__1312_/B1 spi_regs_inst__1345_/A2
+ spi_regs_inst__1275_/B2 spi_regs_inst__1280_/A1 VDD VDD VSS VSS gf180mcu_fd_sc_mcu7t5v0__aoi22_1
Xclkload34 clkload34/I clkload34/ZN VDD VDD VSS VSS gf180mcu_fd_sc_mcu7t5v0__inv_3
Xclkload23 clkload23/I clkload23/ZN VDD VDD VSS VSS gf180mcu_fd_sc_mcu7t5v0__clkinv_2
Xclkload12 clkload12/I clkload12/ZN VDD VDD VSS VSS gf180mcu_fd_sc_mcu7t5v0__inv_4
XFILLER_126_140 VDD VDD VSS VSS gf180mcu_fd_sc_mcu7t5v0__fill_2
XPHY_EDGE_ROW_21_1_Left_188 VDD VSS gf180mcu_fd_sc_mcu7t5v0__endcap
XFILLER_115_836 VDD VDD VSS VSS gf180mcu_fd_sc_mcu7t5v0__fillcap_4
XFILLER_5_492 VDD VDD VSS VSS gf180mcu_fd_sc_mcu7t5v0__fillcap_4
XFILLER_138_1157 VDD VDD VSS VSS gf180mcu_fd_sc_mcu7t5v0__fillcap_16
XFILLER_69_912 VDD VDD VSS VSS gf180mcu_fd_sc_mcu7t5v0__fillcap_64
Xsignal_processor_y_inst__225_ signal_processor_y_inst__225_/D fanout557/Z clkload2/I
+ spi_regs_inst__1050_/C2 VDD VDD VSS VSS gf180mcu_fd_sc_mcu7t5v0__dffrnq_1
XFILLER_68_433 VDD VDD VSS VSS gf180mcu_fd_sc_mcu7t5v0__fill_1
Xwave_controller_x_inst__1840_ spi_regs_inst__1068_/B2 wave_controller_x_inst__2254_/A1
+ VDD VDD VSS VSS gf180mcu_fd_sc_mcu7t5v0__clkinv_1
XFILLER_56_617 VDD VDD VSS VSS gf180mcu_fd_sc_mcu7t5v0__fillcap_4
Xsignal_processor_y_inst__156_ signal_processor_y_inst__202_/A2 signal_processor_y_inst__229_/Q
+ signal_processor_y_inst__231_/Q signal_processor_y_inst__129_/Z signal_processor_y_inst__163_/A2
+ VDD VDD VSS VSS gf180mcu_fd_sc_mcu7t5v0__nand4_1
Xwave_controller_x_inst__3510_ wave_controller_x_inst__3706_/Q wave_controller_x_inst__3537_/A2
+ wave_controller_x_inst__3512_/A2 VDD VDD VSS VSS gf180mcu_fd_sc_mcu7t5v0__nor2_1
Xwave_controller_x_inst__3441_ wave_controller_x_inst__3441_/A1 wave_controller_x_inst__3439_/I
+ wave_controller_x_inst__3441_/B wave_controller_x_inst__3441_/C wave_controller_x_inst__3443_/B1
+ VDD VDD VSS VSS gf180mcu_fd_sc_mcu7t5v0__aoi211_1
XFILLER_110_1087 VDD VDD VSS VSS gf180mcu_fd_sc_mcu7t5v0__fillcap_64
XFILLER_34_18 VDD VDD VSS VSS gf180mcu_fd_sc_mcu7t5v0__fill_2
XTAP_TAPCELL_ROW_17_1_462 VDD VSS gf180mcu_fd_sc_mcu7t5v0__filltie
Xwave_controller_x_inst__3372_ wave_controller_x_inst__3384_/A2 wave_controller_x_inst__3371_/Z
+ wave_controller_x_inst__3372_/Z VDD VDD VSS VSS gf180mcu_fd_sc_mcu7t5v0__or2_1
Xwave_controller_x_inst__2323_ wave_controller_x_inst__2323_/A1 wave_controller_x_inst__2322_/Z
+ wave_controller_x_inst__2326_/A3 VDD VDD VSS VSS gf180mcu_fd_sc_mcu7t5v0__xnor2_1
XFILLER_149_254 VDD VDD VSS VSS gf180mcu_fd_sc_mcu7t5v0__fill_2
XTAP_TAPCELL_ROW_137_2139 VDD VSS gf180mcu_fd_sc_mcu7t5v0__filltie
XTAP_TAPCELL_ROW_154_2420 VDD VSS gf180mcu_fd_sc_mcu7t5v0__filltie
XTAP_TAPCELL_ROW_62_895 VDD VSS gf180mcu_fd_sc_mcu7t5v0__filltie
Xwave_controller_y_inst__2270_ wave_controller_y_inst__2270_/A1 wave_controller_y_inst__2270_/A2
+ wave_controller_y_inst__2346_/A1 VDD VDD VSS VSS gf180mcu_fd_sc_mcu7t5v0__nand2_1
Xwave_controller_x_inst__2254_ wave_controller_x_inst__2254_/A1 wire456/Z wave_controller_x_inst__2254_/Z
+ VDD VDD VSS VSS gf180mcu_fd_sc_mcu7t5v0__xor2_1
Xclkload6 clkload6/I clkload6/ZN VDD VDD VSS VSS gf180mcu_fd_sc_mcu7t5v0__inv_3
XFILLER_118_652 VDD VDD VSS VSS gf180mcu_fd_sc_mcu7t5v0__fillcap_8
Xwave_controller_x_inst__2185_ wave_controller_x_inst__2187_/A1 wave_controller_x_inst__2184_/I
+ wave_controller_x_inst__2186_/I VDD VDD VSS VSS gf180mcu_fd_sc_mcu7t5v0__nor2_1
XFILLER_105_302 VDD VDD VSS VSS gf180mcu_fd_sc_mcu7t5v0__fill_2
XTAP_TAPCELL_ROW_115_1769 VDD VSS gf180mcu_fd_sc_mcu7t5v0__filltie
XTAP_TAPCELL_ROW_40_1_629 VDD VSS gf180mcu_fd_sc_mcu7t5v0__filltie
Xwave_controller_y_inst_fanout315 wave_controller_y_inst__2905_/ZN wave_controller_y_inst__3493_/A1
+ VDD VDD VSS VSS gf180mcu_fd_sc_mcu7t5v0__dlyb_1
XFILLER_121_839 VDD VDD VSS VSS gf180mcu_fd_sc_mcu7t5v0__fill_1
XFILLER_59_422 VDD VDD VSS VSS gf180mcu_fd_sc_mcu7t5v0__fill_1
XFILLER_115_43 VDD VDD VSS VSS gf180mcu_fd_sc_mcu7t5v0__fillcap_16
XFILLER_59_455 VDD VDD VSS VSS gf180mcu_fd_sc_mcu7t5v0__fill_1
XTAP_TAPCELL_ROW_70_1032 VDD VSS gf180mcu_fd_sc_mcu7t5v0__filltie
XFILLER_19_319 VDD VDD VSS VSS gf180mcu_fd_sc_mcu7t5v0__fill_1
XFILLER_74_403 VDD VDD VSS VSS gf180mcu_fd_sc_mcu7t5v0__fillcap_4
Xwave_controller_y_inst__1985_ wave_controller_y_inst__1985_/I wave_controller_y_inst__1988_/A1
+ VDD VDD VSS VSS gf180mcu_fd_sc_mcu7t5v0__clkinv_1
Xwave_controller_x_inst__1969_ fanout526/Z wave_controller_x_inst__2226_/A1 wave_controller_x_inst__1981_/B
+ VDD VDD VSS VSS gf180mcu_fd_sc_mcu7t5v0__nor2_1
XFILLER_86_285 VDD VDD VSS VSS gf180mcu_fd_sc_mcu7t5v0__fill_1
XTAP_TAPCELL_ROW_165_2593 VDD VSS gf180mcu_fd_sc_mcu7t5v0__filltie
Xwave_controller_y_inst__3724_ wave_controller_y_inst__3724_/D fanout544/Z clkbuf_leaf_0_clk/Z
+ _94_/I VDD VDD VSS VSS gf180mcu_fd_sc_mcu7t5v0__dffrnq_1
Xwave_controller_x_inst__3708_ wave_controller_x_inst__3708_/D wave_controller_x_inst__3710_/RN
+ clkbuf_leaf_31_clk/Z wave_controller_x_inst__3708_/Q VDD VDD VSS VSS gf180mcu_fd_sc_mcu7t5v0__dffrnq_1
XFILLER_131_20 VDD VDD VSS VSS gf180mcu_fd_sc_mcu7t5v0__fill_1
Xwave_controller_y_inst__3655_ wave_controller_y_inst__3655_/D wave_controller_y_inst__3708_/RN
+ clkload19/I spi_regs_inst__1316_/A1 VDD VDD VSS VSS gf180mcu_fd_sc_mcu7t5v0__dffrnq_1
Xsignal_processor_x_inst_fanout398 fanout399/Z signal_processor_x_inst__128_/A1 VDD
+ VDD VSS VSS gf180mcu_fd_sc_mcu7t5v0__dlyb_1
Xwave_controller_y_inst__2606_ wave_controller_y_inst__2606_/I wave_controller_y_inst__2633_/B
+ VDD VDD VSS VSS gf180mcu_fd_sc_mcu7t5v0__clkinv_1
Xwave_controller_x_inst__3639_ wave_controller_x_inst__3639_/D wave_controller_x_inst__3682_/RN
+ clkload34/I spi_regs_inst__1186_/B2 VDD VDD VSS VSS gf180mcu_fd_sc_mcu7t5v0__dffrnq_1
XFILLER_152_2 VDD VDD VSS VSS gf180mcu_fd_sc_mcu7t5v0__fillcap_16
XFILLER_70_631 VDD VDD VSS VSS gf180mcu_fd_sc_mcu7t5v0__fillcap_8
Xwave_controller_y_inst_wire150 wave_controller_y_inst_wire151/Z wave_controller_y_inst_wire150/Z
+ VDD VDD VSS VSS gf180mcu_fd_sc_mcu7t5v0__buf_1
Xwave_controller_y_inst__3586_ max_cap425/I wave_controller_y_inst__3588_/S wave_controller_y_inst__3587_/B
+ VDD VDD VSS VSS gf180mcu_fd_sc_mcu7t5v0__nand2_1
XFILLER_24_51 VDD VDD VSS VSS gf180mcu_fd_sc_mcu7t5v0__fill_1
XFILLER_70_675 VDD VDD VSS VSS gf180mcu_fd_sc_mcu7t5v0__fillcap_4
XFILLER_91_68 VDD VDD VSS VSS gf180mcu_fd_sc_mcu7t5v0__fill_2
Xwave_controller_y_inst__2537_ fanout505/Z wave_controller_y_inst__2537_/A2 wave_controller_y_inst__2537_/A3
+ wave_controller_y_inst__2537_/Z VDD VDD VSS VSS gf180mcu_fd_sc_mcu7t5v0__xor3_1
Xsignal_processor_x_inst__245_ signal_processor_x_inst__245_/D fanout595/Z clkbuf_leaf_20_clk/Z
+ signal_processor_x_inst__245_/Q VDD VDD VSS VSS gf180mcu_fd_sc_mcu7t5v0__dffrnq_1
XFILLER_129_906 VDD VDD VSS VSS gf180mcu_fd_sc_mcu7t5v0__fillcap_4
Xwave_controller_y_inst__2468_ wave_controller_y_inst__2758_/B wave_controller_y_inst__2467_/Z
+ wave_controller_y_inst__2482_/B VDD VDD VSS VSS gf180mcu_fd_sc_mcu7t5v0__nor2_1
XFILLER_10_241 VDD VDD VSS VSS gf180mcu_fd_sc_mcu7t5v0__fillcap_4
Xsignal_processor_x_inst__176_ signal_processor_x_inst__187_/A1 signal_processor_x_inst__175_/Z
+ signal_processor_x_inst__236_/D VDD VDD VSS VSS gf180mcu_fd_sc_mcu7t5v0__nor2_1
Xwave_controller_y_inst__2399_ wave_controller_y_inst__2399_/A1 spi_regs_inst__1078_/A1
+ wave_controller_y_inst__2399_/Z VDD VDD VSS VSS gf180mcu_fd_sc_mcu7t5v0__and2_1
Xchip_core_673 input_pd VDD VDD VSS VSS gf180mcu_fd_sc_mcu7t5v0__tiel
Xchip_core_662 bidir_pu[8] VDD VDD VSS VSS gf180mcu_fd_sc_mcu7t5v0__tiel
Xchip_core_651 bidir_pd[6] VDD VDD VSS VSS gf180mcu_fd_sc_mcu7t5v0__tiel
Xchip_core_640 bidir_ie[8] VDD VDD VSS VSS gf180mcu_fd_sc_mcu7t5v0__tiel
XFILLER_143_419 VDD VDD VSS VSS gf180mcu_fd_sc_mcu7t5v0__fill_1
XFILLER_155_279 VDD VDD VSS VSS gf180mcu_fd_sc_mcu7t5v0__fill_1
Xspi_regs_inst__1060_ spi_regs_inst__1060_/A1 spi_regs_inst__1185_/B1 spi_regs_inst__1325_/A2
+ spi_regs_inst_wire148/Z spi_regs_inst__1062_/A3 VDD VDD VSS VSS gf180mcu_fd_sc_mcu7t5v0__aoi22_1
Xchip_core_684 bidir_oe[7] VDD VDD VSS VSS gf180mcu_fd_sc_mcu7t5v0__tieh
XTAP_TAPCELL_ROW_34_1_587 VDD VSS gf180mcu_fd_sc_mcu7t5v0__filltie
XFILLER_111_338 VDD VDD VSS VSS gf180mcu_fd_sc_mcu7t5v0__fill_2
XFILLER_92_222 VDD VDD VSS VSS gf180mcu_fd_sc_mcu7t5v0__fill_1
XTAP_TAPCELL_ROW_88_1326 VDD VSS gf180mcu_fd_sc_mcu7t5v0__filltie
XTAP_TAPCELL_ROW_88_1337 VDD VSS gf180mcu_fd_sc_mcu7t5v0__filltie
Xspi_regs_inst__0913_ spi_regs_inst__0913_/A1 spi_regs_inst__0913_/A2 spi_regs_inst__1630_/D
+ VDD VDD VSS VSS gf180mcu_fd_sc_mcu7t5v0__nand2_1
XFILLER_1_66 VDD VDD VSS VSS gf180mcu_fd_sc_mcu7t5v0__fillcap_4
XFILLER_53_609 VDD VDD VSS VSS gf180mcu_fd_sc_mcu7t5v0__fill_2
XFILLER_92_255 VDD VDD VSS VSS gf180mcu_fd_sc_mcu7t5v0__fill_2
Xspi_regs_inst__0844_ spi_regs_inst__1583_/Q spi_regs_inst__1438_/I1 spi_regs_inst__0849_/S
+ spi_regs_inst__1583_/D VDD VDD VSS VSS gf180mcu_fd_sc_mcu7t5v0__mux2_2
Xspi_regs_inst__0775_ spi_regs_inst__1530_/Q spi_regs_inst__1379_/I1 spi_regs_inst__0778_/S
+ spi_regs_inst__1530_/D VDD VDD VSS VSS gf180mcu_fd_sc_mcu7t5v0__mux2_2
XFILLER_33_377 VDD VDD VSS VSS gf180mcu_fd_sc_mcu7t5v0__fillcap_16
XFILLER_60_174 VDD VDD VSS VSS gf180mcu_fd_sc_mcu7t5v0__fill_1
XFILLER_53_1022 VDD VDD VSS VSS gf180mcu_fd_sc_mcu7t5v0__fillcap_32
XFILLER_159_574 VDD VDD VSS VSS gf180mcu_fd_sc_mcu7t5v0__fillcap_4
XFILLER_135_909 VDD VDD VSS VSS gf180mcu_fd_sc_mcu7t5v0__fill_1
Xspi_regs_inst__1327_ spi_regs_inst__1327_/A1 spi_regs_inst__1327_/A2 spi_regs_inst__1327_/A3
+ spi_regs_inst__1327_/A4 spi_regs_inst__1328_/A4 VDD VDD VSS VSS gf180mcu_fd_sc_mcu7t5v0__nor4_1
XFILLER_115_644 VDD VDD VSS VSS gf180mcu_fd_sc_mcu7t5v0__fill_1
XTAP_TAPCELL_ROW_132_2047 VDD VSS gf180mcu_fd_sc_mcu7t5v0__filltie
XTAP_TAPCELL_ROW_132_2058 VDD VSS gf180mcu_fd_sc_mcu7t5v0__filltie
Xspi_regs_inst_wire214 spi_regs_inst_wire214/I spi_regs_inst_wire214/Z VDD VDD VSS
+ VSS gf180mcu_fd_sc_mcu7t5v0__buf_2
Xspi_regs_inst__1258_ spi_regs_inst__1258_/A1 spi_regs_inst__1258_/A2 spi_regs_inst__1258_/A3
+ spi_regs_inst__1258_/A4 spi_regs_inst__1264_/A3 VDD VDD VSS VSS gf180mcu_fd_sc_mcu7t5v0__nand4_1
XFILLER_115_655 VDD VDD VSS VSS gf180mcu_fd_sc_mcu7t5v0__fillcap_8
XFILLER_142_441 VDD VDD VSS VSS gf180mcu_fd_sc_mcu7t5v0__fillcap_8
Xspi_regs_inst_wire247 spi_regs_inst_wire247/I spi_regs_inst_wire247/Z VDD VDD VSS
+ VSS gf180mcu_fd_sc_mcu7t5v0__buf_2
Xspi_regs_inst__1189_ spi_regs_inst__1189_/A1 spi_regs_inst__1189_/A2 spi_regs_inst__1189_/B1
+ spi_regs_inst__1189_/B2 spi_regs_inst__1191_/A3 VDD VDD VSS VSS gf180mcu_fd_sc_mcu7t5v0__aoi22_1
XFILLER_103_839 VDD VDD VSS VSS gf180mcu_fd_sc_mcu7t5v0__fill_1
XFILLER_115_699 VDD VDD VSS VSS gf180mcu_fd_sc_mcu7t5v0__fill_1
Xwave_controller_x_inst__2941_ wave_controller_x_inst__1783_/I fanout534/Z wave_controller_x_inst__2994_/A1
+ VDD VDD VSS VSS gf180mcu_fd_sc_mcu7t5v0__nor2_1
Xspi_regs_inst_wire269 spi_regs_inst_wire269/I spi_regs_inst_wire269/Z VDD VDD VSS
+ VSS gf180mcu_fd_sc_mcu7t5v0__buf_2
XFILLER_64_1151 VDD VDD VSS VSS gf180mcu_fd_sc_mcu7t5v0__fillcap_4
XFILLER_64_1173 VDD VDD VSS VSS gf180mcu_fd_sc_mcu7t5v0__fill_1
Xwave_controller_x_inst__2872_ wave_controller_x_inst__3696_/Q wave_controller_x_inst__3462_/B2
+ wave_controller_x_inst__2879_/A2 VDD VDD VSS VSS gf180mcu_fd_sc_mcu7t5v0__nor2_1
XFILLER_151_1154 VDD VDD VSS VSS gf180mcu_fd_sc_mcu7t5v0__fillcap_16
XFILLER_56_403 VDD VDD VSS VSS gf180mcu_fd_sc_mcu7t5v0__fillcap_8
XTAP_TAPCELL_ROW_110_1688 VDD VSS gf180mcu_fd_sc_mcu7t5v0__filltie
XTAP_TAPCELL_ROW_110_1699 VDD VSS gf180mcu_fd_sc_mcu7t5v0__filltie
Xwave_controller_x_inst__1823_ fanout521/Z wave_controller_x_inst__3387_/A1 VDD VDD
+ VSS VSS gf180mcu_fd_sc_mcu7t5v0__clkinv_1
Xsignal_processor_y_inst__208_ spi_regs_inst__1154_/B2 signal_processor_y_inst__212_/A2
+ signal_processor_y_inst__209_/B VDD VDD VSS VSS gf180mcu_fd_sc_mcu7t5v0__nand2_1
XFILLER_110_371 VDD VDD VSS VSS gf180mcu_fd_sc_mcu7t5v0__fillcap_8
XFILLER_56_425 VDD VDD VSS VSS gf180mcu_fd_sc_mcu7t5v0__fillcap_4
XFILLER_84_745 VDD VDD VSS VSS gf180mcu_fd_sc_mcu7t5v0__fillcap_4
XFILLER_96_594 VDD VDD VSS VSS gf180mcu_fd_sc_mcu7t5v0__fill_1
Xsignal_processor_y_inst__139_ signal_processor_y_inst__237_/Q signal_processor_y_inst__141_/A2
+ signal_processor_y_inst__146_/A2 VDD VDD VSS VSS gf180mcu_fd_sc_mcu7t5v0__nand2_1
XFILLER_56_469 VDD VDD VSS VSS gf180mcu_fd_sc_mcu7t5v0__fill_1
XFILLER_84_789 VDD VDD VSS VSS gf180mcu_fd_sc_mcu7t5v0__fill_1
XTAP_TAPCELL_ROW_67_976 VDD VSS gf180mcu_fd_sc_mcu7t5v0__filltie
XTAP_TAPCELL_ROW_67_987 VDD VSS gf180mcu_fd_sc_mcu7t5v0__filltie
XFILLER_36_193 VDD VDD VSS VSS gf180mcu_fd_sc_mcu7t5v0__fillcap_8
Xwave_controller_y_inst__3440_ wave_controller_y_inst__3440_/A1 wave_controller_y_inst__3419_/C
+ wave_controller_y_inst__3494_/A2 wave_controller_y_inst__3440_/B2 wave_controller_y_inst__3489_/C
+ wave_controller_y_inst__3441_/B VDD VDD VSS VSS gf180mcu_fd_sc_mcu7t5v0__aoi221_1
Xwave_controller_x_inst__3424_ wave_controller_x_inst__3693_/Q wave_controller_x_inst__2892_/Z
+ wave_controller_x_inst__3426_/A2 VDD VDD VSS VSS gf180mcu_fd_sc_mcu7t5v0__nor2_1
XFILLER_101_56 VDD VDD VSS VSS gf180mcu_fd_sc_mcu7t5v0__fill_1
Xwave_controller_y_inst__3371_ wave_controller_y_inst__3371_/A1 wave_controller_y_inst__3375_/A2
+ wave_controller_y_inst__3292_/B wave_controller_y_inst__3371_/Z VDD VDD VSS VSS
+ gf180mcu_fd_sc_mcu7t5v0__and3_1
Xwave_controller_x_inst__3355_ wave_controller_x_inst__3355_/A1 wave_controller_x_inst__3359_/A1
+ wave_controller_x_inst__3355_/B wave_controller_x_inst__3394_/A3 VDD VDD VSS VSS
+ gf180mcu_fd_sc_mcu7t5v0__aoi21_1
XFILLER_51_174 VDD VDD VSS VSS gf180mcu_fd_sc_mcu7t5v0__fillcap_8
XFILLER_71_1122 VDD VDD VSS VSS gf180mcu_fd_sc_mcu7t5v0__fillcap_32
XPHY_EDGE_ROW_6_1_Left_173 VDD VSS gf180mcu_fd_sc_mcu7t5v0__endcap
Xwave_controller_y_inst__2322_ wave_controller_y_inst__2349_/C max_cap426/Z wave_controller_y_inst__2322_/Z
+ VDD VDD VSS VSS gf180mcu_fd_sc_mcu7t5v0__xor2_1
Xwave_controller_x_inst__2306_ wave_controller_x_inst__2306_/I wave_controller_x_inst__2342_/A2
+ VDD VDD VSS VSS gf180mcu_fd_sc_mcu7t5v0__clkinv_1
Xwave_controller_y_inst__2253_ wave_controller_y_inst__2254_/A1 spi_regs_inst__1034_/A1
+ wave_controller_y_inst__2272_/B VDD VDD VSS VSS gf180mcu_fd_sc_mcu7t5v0__nor2_1
Xwave_controller_x_inst__3286_ wave_controller_x_inst__3286_/A1 wave_controller_x_inst__3286_/A2
+ wave_controller_x_inst__3286_/B wave_controller_x_inst__3381_/A1 VDD VDD VSS VSS
+ gf180mcu_fd_sc_mcu7t5v0__aoi21_1
XFILLER_126_909 VDD VDD VSS VSS gf180mcu_fd_sc_mcu7t5v0__fillcap_32
XTAP_TAPCELL_ROW_117_1809 VDD VSS gf180mcu_fd_sc_mcu7t5v0__filltie
Xwave_controller_x_inst__2237_ spi_regs_inst__1343_/B2 wave_controller_x_inst__2789_/A1
+ wave_controller_x_inst__2257_/A2 VDD VDD VSS VSS gf180mcu_fd_sc_mcu7t5v0__nand2_1
XFILLER_153_717 VDD VDD VSS VSS gf180mcu_fd_sc_mcu7t5v0__fillcap_8
Xwave_controller_y_inst__2184_ wave_controller_y_inst__2184_/I wave_controller_y_inst__2188_/A2
+ VDD VDD VSS VSS gf180mcu_fd_sc_mcu7t5v0__clkinv_1
Xwave_controller_x_inst__2168_ wave_controller_x_inst__2168_/A1 wave_controller_x_inst__2168_/A2
+ wave_controller_x_inst__2168_/B wave_controller_x_inst__2222_/B1 VDD VDD VSS VSS
+ gf180mcu_fd_sc_mcu7t5v0__aoi21_1
XFILLER_105_110 VDD VDD VSS VSS gf180mcu_fd_sc_mcu7t5v0__fill_2
XPHY_EDGE_ROW_89_Left_256 VDD VSS gf180mcu_fd_sc_mcu7t5v0__endcap
Xwave_controller_x_inst__2099_ wave_controller_x_inst__2099_/A1 wave_controller_x_inst__2099_/A2
+ wave_controller_x_inst__2117_/A2 VDD VDD VSS VSS gf180mcu_fd_sc_mcu7t5v0__nand2_1
XFILLER_105_154 VDD VDD VSS VSS gf180mcu_fd_sc_mcu7t5v0__fill_2
XFILLER_126_53 VDD VDD VSS VSS gf180mcu_fd_sc_mcu7t5v0__fillcap_4
XFILLER_161_772 VDD VDD VSS VSS gf180mcu_fd_sc_mcu7t5v0__fillcap_64
XTAP_TAPCELL_ROW_167_2633 VDD VSS gf180mcu_fd_sc_mcu7t5v0__filltie
XTAP_TAPCELL_ROW_30_1_560 VDD VSS gf180mcu_fd_sc_mcu7t5v0__filltie
XFILLER_120_124 VDD VDD VSS VSS gf180mcu_fd_sc_mcu7t5v0__fill_1
XFILLER_121_647 VDD VDD VSS VSS gf180mcu_fd_sc_mcu7t5v0__fill_1
XFILLER_156_1087 VDD VDD VSS VSS gf180mcu_fd_sc_mcu7t5v0__fillcap_64
XTAP_TAPCELL_ROW_167_2644 VDD VSS gf180mcu_fd_sc_mcu7t5v0__filltie
XTAP_TAPCELL_ROW_167_2655 VDD VSS gf180mcu_fd_sc_mcu7t5v0__filltie
XFILLER_47_447 VDD VDD VSS VSS gf180mcu_fd_sc_mcu7t5v0__fill_2
XFILLER_59_274 VDD VDD VSS VSS gf180mcu_fd_sc_mcu7t5v0__fillcap_4
XFILLER_75_734 VDD VDD VSS VSS gf180mcu_fd_sc_mcu7t5v0__fillcap_8
XFILLER_19_84 VDD VDD VSS VSS gf180mcu_fd_sc_mcu7t5v0__fill_1
XFILLER_63_918 VDD VDD VSS VSS gf180mcu_fd_sc_mcu7t5v0__fill_1
XFILLER_74_255 VDD VDD VSS VSS gf180mcu_fd_sc_mcu7t5v0__fillcap_4
XPHY_EDGE_ROW_98_Left_265 VDD VSS gf180mcu_fd_sc_mcu7t5v0__endcap
Xwave_controller_y_inst__3707_ wave_controller_y_inst__3707_/D wave_controller_y_inst__3708_/RN
+ clkload19/I wave_controller_y_inst__3707_/Q VDD VDD VSS VSS gf180mcu_fd_sc_mcu7t5v0__dffrnq_1
Xwave_controller_y_inst__1968_ wave_controller_y_inst__1973_/A2 wave_controller_y_inst__1967_/Z
+ spi_regs_inst__1278_/B2 VDD VDD VSS VSS gf180mcu_fd_sc_mcu7t5v0__and2_1
Xspi_regs_inst_load_slew204 spi_regs_inst__1435_/S spi_regs_inst__1436_/S VDD VDD
+ VSS VSS gf180mcu_fd_sc_mcu7t5v0__buf_4
XFILLER_76_1000 VDD VDD VSS VSS gf180mcu_fd_sc_mcu7t5v0__fillcap_8
Xwave_controller_y_inst__1899_ wave_controller_y_inst__3699_/Q wave_controller_y_inst__3489_/A1
+ VDD VDD VSS VSS gf180mcu_fd_sc_mcu7t5v0__clkinv_1
XFILLER_15_344 VDD VDD VSS VSS gf180mcu_fd_sc_mcu7t5v0__fillcap_4
XFILLER_35_50 VDD VDD VSS VSS gf180mcu_fd_sc_mcu7t5v0__fillcap_16
XFILLER_71_940 VDD VDD VSS VSS gf180mcu_fd_sc_mcu7t5v0__fillcap_32
XTAP_TAPCELL_ROW_83_1245 VDD VSS gf180mcu_fd_sc_mcu7t5v0__filltie
Xwave_controller_y_inst__3638_ wave_controller_y_inst__3638_/D wave_controller_y_inst__3699_/RN
+ clkbuf_leaf_46_clk/Z max_cap432/I VDD VDD VSS VSS gf180mcu_fd_sc_mcu7t5v0__dffrnq_1
XFILLER_15_366 VDD VDD VSS VSS gf180mcu_fd_sc_mcu7t5v0__fillcap_16
XFILLER_35_72 VDD VDD VSS VSS gf180mcu_fd_sc_mcu7t5v0__fillcap_8
XFILLER_70_461 VDD VDD VSS VSS gf180mcu_fd_sc_mcu7t5v0__fill_1
Xwave_controller_y_inst__3569_ wave_controller_y_inst__3600_/I0 max_cap427/Z wave_controller_y_inst__3584_/S
+ wave_controller_y_inst__3654_/D VDD VDD VSS VSS gf180mcu_fd_sc_mcu7t5v0__mux2_2
XFILLER_30_314 VDD VDD VSS VSS gf180mcu_fd_sc_mcu7t5v0__fill_1
XFILLER_30_325 VDD VDD VSS VSS gf180mcu_fd_sc_mcu7t5v0__fillcap_8
XFILLER_11_550 VDD VDD VSS VSS gf180mcu_fd_sc_mcu7t5v0__fillcap_4
Xsignal_processor_x_inst__228_ signal_processor_x_inst__228_/D fanout582/Z clkload10/I
+ spi_regs_inst__1200_/B2 VDD VDD VSS VSS gf180mcu_fd_sc_mcu7t5v0__dffrnq_1
XFILLER_156_544 VDD VDD VSS VSS gf180mcu_fd_sc_mcu7t5v0__fillcap_4
Xsignal_processor_x_inst__159_ signal_processor_x_inst__187_/A1 signal_processor_x_inst__158_/Z
+ signal_processor_x_inst__231_/D VDD VDD VSS VSS gf180mcu_fd_sc_mcu7t5v0__nor2_1
XTAP_TAPCELL_ROW_1_1_339 VDD VSS gf180mcu_fd_sc_mcu7t5v0__filltie
Xspi_regs_inst__1112_ spi_regs_inst__1112_/A1 spi_regs_inst__1324_/B1 spi_regs_inst_wire218/Z
+ spi_regs_inst__1112_/B2 spi_regs_inst__1115_/A4 VDD VDD VSS VSS gf180mcu_fd_sc_mcu7t5v0__aoi22_1
XFILLER_137_780 VDD VDD VSS VSS gf180mcu_fd_sc_mcu7t5v0__fill_2
XPHY_EDGE_ROW_164_Right_164 VDD VSS gf180mcu_fd_sc_mcu7t5v0__endcap
XTAP_TAPCELL_ROW_16_1_450 VDD VSS gf180mcu_fd_sc_mcu7t5v0__filltie
Xspi_regs_inst__1043_ spi_regs_inst__1620_/Q spi_regs_inst__1182_/B1 spi_regs_inst_wire210/I
+ spi_regs_inst_wire112/Z spi_regs_inst__1049_/A3 VDD VDD VSS VSS gf180mcu_fd_sc_mcu7t5v0__aoi22_1
XFILLER_135_1116 VDD VDD VSS VSS gf180mcu_fd_sc_mcu7t5v0__fillcap_4
XFILLER_151_282 VDD VDD VSS VSS gf180mcu_fd_sc_mcu7t5v0__fillcap_4
XFILLER_66_734 VDD VDD VSS VSS gf180mcu_fd_sc_mcu7t5v0__fill_1
XFILLER_66_756 VDD VDD VSS VSS gf180mcu_fd_sc_mcu7t5v0__fill_2
XFILLER_38_469 VDD VDD VSS VSS gf180mcu_fd_sc_mcu7t5v0__fill_2
XFILLER_53_406 VDD VDD VSS VSS gf180mcu_fd_sc_mcu7t5v0__fill_2
XFILLER_53_439 VDD VDD VSS VSS gf180mcu_fd_sc_mcu7t5v0__fill_2
XTAP_TAPCELL_ROW_64_935 VDD VSS gf180mcu_fd_sc_mcu7t5v0__filltie
XFILLER_80_247 VDD VDD VSS VSS gf180mcu_fd_sc_mcu7t5v0__fillcap_4
Xspi_regs_inst__0827_ spi_regs_inst__0827_/A1 spi_regs_inst__0827_/A2 spi_regs_inst__0827_/A3
+ spi_regs_inst__0827_/A4 spi_regs_inst__0835_/S VDD VDD VSS VSS gf180mcu_fd_sc_mcu7t5v0__nor4_2
XFILLER_61_472 VDD VDD VSS VSS gf180mcu_fd_sc_mcu7t5v0__fillcap_4
Xspi_regs_inst__0758_ spi_regs_inst__0798_/A3 spi_regs_inst__0808_/A3 spi_regs_inst__1404_/A2
+ VDD VDD VSS VSS gf180mcu_fd_sc_mcu7t5v0__nand2_1
XFILLER_119_202 VDD VDD VSS VSS gf180mcu_fd_sc_mcu7t5v0__fill_1
XFILLER_147_500 VDD VDD VSS VSS gf180mcu_fd_sc_mcu7t5v0__fillcap_4
XFILLER_21_358 VDD VDD VSS VSS gf180mcu_fd_sc_mcu7t5v0__fill_1
Xwave_controller_x_inst__3140_ wave_controller_x_inst__3142_/B wave_controller_x_inst__3141_/B
+ VDD VDD VSS VSS gf180mcu_fd_sc_mcu7t5v0__clkinv_1
XFILLER_147_522 VDD VDD VSS VSS gf180mcu_fd_sc_mcu7t5v0__fill_2
XFILLER_147_544 VDD VDD VSS VSS gf180mcu_fd_sc_mcu7t5v0__fillcap_4
Xwave_controller_x_inst__3071_ wave_controller_x_inst__3712_/Q wave_controller_x_inst__3244_/B2
+ wave_controller_x_inst__3071_/A3 wave_controller_x_inst__3071_/Z VDD VDD VSS VSS
+ gf180mcu_fd_sc_mcu7t5v0__xor3_1
XFILLER_107_419 VDD VDD VSS VSS gf180mcu_fd_sc_mcu7t5v0__fill_1
Xwave_controller_x_inst__2022_ wave_controller_x_inst__2024_/A1 wave_controller_x_inst__2017_/Z
+ wave_controller_x_inst__2023_/A3 VDD VDD VSS VSS gf180mcu_fd_sc_mcu7t5v0__nor2_1
XFILLER_135_739 VDD VDD VSS VSS gf180mcu_fd_sc_mcu7t5v0__fillcap_8
XPHY_EDGE_ROW_131_Right_131 VDD VSS gf180mcu_fd_sc_mcu7t5v0__endcap
XTAP_TAPCELL_ROW_112_1717 VDD VSS gf180mcu_fd_sc_mcu7t5v0__filltie
XFILLER_131_912 VDD VDD VSS VSS gf180mcu_fd_sc_mcu7t5v0__fillcap_64
XFILLER_143_772 VDD VDD VSS VSS gf180mcu_fd_sc_mcu7t5v0__fillcap_8
XFILLER_88_314 VDD VDD VSS VSS gf180mcu_fd_sc_mcu7t5v0__fill_1
XTAP_TAPCELL_ROW_112_1728 VDD VSS gf180mcu_fd_sc_mcu7t5v0__filltie
XFILLER_130_433 VDD VDD VSS VSS gf180mcu_fd_sc_mcu7t5v0__fillcap_4
XTAP_TAPCELL_ROW_149_2330 VDD VSS gf180mcu_fd_sc_mcu7t5v0__filltie
XTAP_TAPCELL_ROW_149_2341 VDD VSS gf180mcu_fd_sc_mcu7t5v0__filltie
Xwave_controller_y_inst__2940_ wave_controller_y_inst__1783_/I wave_controller_y_inst__1816_/I
+ wave_controller_y_inst__2994_/B VDD VDD VSS VSS gf180mcu_fd_sc_mcu7t5v0__nand2_1
Xwave_controller_x_inst__2924_ wave_controller_x_inst__3004_/B wave_controller_x_inst__3406_/A1
+ wave_controller_x_inst__3589_/I0 VDD VDD VSS VSS gf180mcu_fd_sc_mcu7t5v0__nor2_1
XFILLER_97_870 VDD VDD VSS VSS gf180mcu_fd_sc_mcu7t5v0__fill_2
Xwave_controller_y_inst__2871_ wave_controller_y_inst__3458_/A1 spi_regs_inst__1262_/A1
+ wave_controller_y_inst__2873_/A2 VDD VDD VSS VSS gf180mcu_fd_sc_mcu7t5v0__nor2_1
XFILLER_29_436 VDD VDD VSS VSS gf180mcu_fd_sc_mcu7t5v0__fillcap_8
XFILLER_69_594 VDD VDD VSS VSS gf180mcu_fd_sc_mcu7t5v0__fill_2
Xwave_controller_y_inst__1822_ wave_controller_y_inst__3212_/B wave_controller_y_inst__2979_/A2
+ VDD VDD VSS VSS gf180mcu_fd_sc_mcu7t5v0__clkinv_1
Xwave_controller_x_inst__2855_ wave_controller_x_inst__2855_/A1 wave_controller_x_inst__2897_/A3
+ wave_controller_x_inst__2855_/B wave_controller_x_inst__2889_/A2 VDD VDD VSS VSS
+ gf180mcu_fd_sc_mcu7t5v0__aoi21_1
XFILLER_56_233 VDD VDD VSS VSS gf180mcu_fd_sc_mcu7t5v0__fillcap_8
XFILLER_56_255 VDD VDD VSS VSS gf180mcu_fd_sc_mcu7t5v0__fillcap_4
XTAP_TAPCELL_ROW_162_2552 VDD VSS gf180mcu_fd_sc_mcu7t5v0__filltie
Xwave_controller_x_inst__2786_ wave_controller_x_inst__2786_/A1 wave_controller_x_inst__2805_/S
+ wave_controller_x_inst__2786_/B wave_controller_x_inst__2787_/I VDD VDD VSS VSS
+ gf180mcu_fd_sc_mcu7t5v0__oai21_1
Xwave_controller_x_inst__1806_ wave_controller_x_inst__1806_/I wave_controller_x_inst__3090_/B2
+ VDD VDD VSS VSS gf180mcu_fd_sc_mcu7t5v0__clkinv_1
XFILLER_72_737 VDD VDD VSS VSS gf180mcu_fd_sc_mcu7t5v0__fillcap_4
XFILLER_84_597 VDD VDD VSS VSS gf180mcu_fd_sc_mcu7t5v0__fillcap_16
XTAP_TAPCELL_ROW_127_1971 VDD VSS gf180mcu_fd_sc_mcu7t5v0__filltie
XTAP_TAPCELL_ROW_25_1_518 VDD VSS gf180mcu_fd_sc_mcu7t5v0__filltie
XFILLER_112_55 VDD VDD VSS VSS gf180mcu_fd_sc_mcu7t5v0__fill_1
XFILLER_37_480 VDD VDD VSS VSS gf180mcu_fd_sc_mcu7t5v0__fillcap_8
XPHY_EDGE_ROW_46_1_Left_213 VDD VSS gf180mcu_fd_sc_mcu7t5v0__endcap
XFILLER_24_130 VDD VDD VSS VSS gf180mcu_fd_sc_mcu7t5v0__fill_1
XFILLER_72_26 VDD VDD VSS VSS gf180mcu_fd_sc_mcu7t5v0__fill_2
XFILLER_72_37 VDD VDD VSS VSS gf180mcu_fd_sc_mcu7t5v0__fillcap_8
Xwave_controller_y_inst__3423_ wave_controller_y_inst__3423_/A1 wave_controller_y_inst__3557_/B1
+ wave_controller_y_inst__3423_/B1 wave_controller_y_inst__3423_/B2 wave_controller_y_inst__3620_/D
+ VDD VDD VSS VSS gf180mcu_fd_sc_mcu7t5v0__oai22_1
Xwave_controller_x_inst__3407_ wave_controller_x_inst__3407_/A1 wave_controller_x_inst__2923_/S
+ wave_controller_x_inst__3407_/B wave_controller_x_inst__3618_/D VDD VDD VSS VSS
+ gf180mcu_fd_sc_mcu7t5v0__aoi21_1
XFILLER_24_174 VDD VDD VSS VSS gf180mcu_fd_sc_mcu7t5v0__fill_1
Xwave_controller_y_inst__3354_ wave_controller_y_inst__3355_/A1 wave_controller_y_inst__3359_/A1
+ wave_controller_y_inst__3355_/B wave_controller_y_inst__3354_/Z VDD VDD VSS VSS
+ gf180mcu_fd_sc_mcu7t5v0__and3_1
Xwave_controller_x_inst__3338_ wave_controller_x_inst__1806_/I wave_controller_x_inst__3338_/A2
+ wave_controller_x_inst__3338_/B wave_controller_x_inst__3402_/A2 VDD VDD VSS VSS
+ gf180mcu_fd_sc_mcu7t5v0__oai21_1
XFILLER_8_329 VDD VDD VSS VSS gf180mcu_fd_sc_mcu7t5v0__fill_1
Xwave_controller_y_inst__3285_ wave_controller_y_inst__3285_/I wave_controller_y_inst__3286_/B
+ VDD VDD VSS VSS gf180mcu_fd_sc_mcu7t5v0__clkinv_1
Xwave_controller_y_inst__2305_ spi_regs_inst__1109_/B2 wave_controller_y_inst__2305_/A2
+ wave_controller_y_inst__2305_/B wave_controller_y_inst__2306_/I VDD VDD VSS VSS
+ gf180mcu_fd_sc_mcu7t5v0__aoi21_1
Xwave_controller_x_inst__3269_ wave_controller_x_inst__1792_/I wave_controller_x_inst__3365_/A2
+ wave_controller_x_inst__3303_/A1 VDD VDD VSS VSS gf180mcu_fd_sc_mcu7t5v0__nand2_1
XFILLER_126_717 VDD VDD VSS VSS gf180mcu_fd_sc_mcu7t5v0__fillcap_4
XFILLER_126_728 VDD VDD VSS VSS gf180mcu_fd_sc_mcu7t5v0__fillcap_4
XFILLER_165_352 VDD VDD VSS VSS gf180mcu_fd_sc_mcu7t5v0__fillcap_16
Xwave_controller_y_inst__2236_ wave_controller_y_inst__2236_/A1 spi_regs_inst__1353_/A1
+ wave_controller_y_inst__2259_/A2 VDD VDD VSS VSS gf180mcu_fd_sc_mcu7t5v0__nor2_1
XFILLER_115_2 VDD VDD VSS VSS gf180mcu_fd_sc_mcu7t5v0__fillcap_16
XFILLER_125_216 VDD VDD VSS VSS gf180mcu_fd_sc_mcu7t5v0__fill_2
Xwave_controller_y_inst__2167_ wave_controller_y_inst__2169_/B wave_controller_y_inst__2168_/B
+ VDD VDD VSS VSS gf180mcu_fd_sc_mcu7t5v0__clkinv_1
XFILLER_134_783 VDD VDD VSS VSS gf180mcu_fd_sc_mcu7t5v0__fillcap_4
Xwave_controller_y_inst__2098_ wave_controller_y_inst__2098_/A1 wave_controller_y_inst__2098_/A2
+ wave_controller_y_inst__2098_/B wave_controller_y_inst__2144_/B wave_controller_y_inst__2099_/A2
+ VDD VDD VSS VSS gf180mcu_fd_sc_mcu7t5v0__oai211_1
XFILLER_121_422 VDD VDD VSS VSS gf180mcu_fd_sc_mcu7t5v0__fillcap_4
XFILLER_133_282 VDD VDD VSS VSS gf180mcu_fd_sc_mcu7t5v0__fillcap_8
XFILLER_121_477 VDD VDD VSS VSS gf180mcu_fd_sc_mcu7t5v0__fillcap_8
XFILLER_82_1081 VDD VDD VSS VSS gf180mcu_fd_sc_mcu7t5v0__fillcap_4
XFILLER_153_62 VDD VDD VSS VSS gf180mcu_fd_sc_mcu7t5v0__fill_2
XFILLER_75_553 VDD VDD VSS VSS gf180mcu_fd_sc_mcu7t5v0__fillcap_4
XFILLER_63_726 VDD VDD VSS VSS gf180mcu_fd_sc_mcu7t5v0__fillcap_32
XFILLER_46_93 VDD VDD VSS VSS gf180mcu_fd_sc_mcu7t5v0__fill_2
XFILLER_62_247 VDD VDD VSS VSS gf180mcu_fd_sc_mcu7t5v0__fillcap_4
XFILLER_90_545 VDD VDD VSS VSS gf180mcu_fd_sc_mcu7t5v0__fillcap_4
XPHY_EDGE_ROW_30_1_Left_197 VDD VSS gf180mcu_fd_sc_mcu7t5v0__endcap
XTAP_TAPCELL_ROW_19_1_476 VDD VSS gf180mcu_fd_sc_mcu7t5v0__filltie
Xspi_regs_inst__1661_ spi_regs_inst__1661_/D fanout560/Z clkbuf_leaf_6_clk/Z spi_regs_inst__1661_/Q
+ VDD VDD VSS VSS gf180mcu_fd_sc_mcu7t5v0__dffrnq_1
Xspi_regs_inst__1592_ spi_regs_inst__1592_/D spi_regs_inst__1649_/RN clkload12/I spi_regs_inst__1592_/Q
+ VDD VDD VSS VSS gf180mcu_fd_sc_mcu7t5v0__dffrnq_1
XTAP_TAPCELL_ROW_9_1_400 VDD VSS gf180mcu_fd_sc_mcu7t5v0__filltie
XFILLER_15_196 VDD VDD VSS VSS gf180mcu_fd_sc_mcu7t5v0__fill_2
XFILLER_129_500 VDD VDD VSS VSS gf180mcu_fd_sc_mcu7t5v0__fillcap_4
XFILLER_157_842 VDD VDD VSS VSS gf180mcu_fd_sc_mcu7t5v0__fillcap_64
XFILLER_11_380 VDD VDD VSS VSS gf180mcu_fd_sc_mcu7t5v0__fillcap_4
XFILLER_7_340 VDD VDD VSS VSS gf180mcu_fd_sc_mcu7t5v0__fill_2
XTAP_TAPCELL_ROW_96_1458 VDD VSS gf180mcu_fd_sc_mcu7t5v0__filltie
XPHY_EDGE_ROW_17_1_Right_16 VDD VSS gf180mcu_fd_sc_mcu7t5v0__endcap
XTAP_TAPCELL_ROW_96_1469 VDD VSS gf180mcu_fd_sc_mcu7t5v0__filltie
XFILLER_113_901 VDD VDD VSS VSS gf180mcu_fd_sc_mcu7t5v0__fill_1
XFILLER_113_912 VDD VDD VSS VSS gf180mcu_fd_sc_mcu7t5v0__fillcap_64
XFILLER_125_772 VDD VDD VSS VSS gf180mcu_fd_sc_mcu7t5v0__fillcap_16
Xspi_regs_inst__1026_ spi_regs_inst__1030_/A1 spi_regs_inst__1028_/A2 spi_regs_inst__1146_/A2
+ VDD VDD VSS VSS gf180mcu_fd_sc_mcu7t5v0__nor2_1
XFILLER_112_433 VDD VDD VSS VSS gf180mcu_fd_sc_mcu7t5v0__fillcap_4
XFILLER_30_2 VDD VDD VSS VSS gf180mcu_fd_sc_mcu7t5v0__fillcap_32
XFILLER_86_807 VDD VDD VSS VSS gf180mcu_fd_sc_mcu7t5v0__fillcap_16
XFILLER_98_645 VDD VDD VSS VSS gf180mcu_fd_sc_mcu7t5v0__fill_2
XFILLER_98_667 VDD VDD VSS VSS gf180mcu_fd_sc_mcu7t5v0__fillcap_4
XFILLER_112_477 VDD VDD VSS VSS gf180mcu_fd_sc_mcu7t5v0__fill_1
XFILLER_61_1154 VDD VDD VSS VSS gf180mcu_fd_sc_mcu7t5v0__fillcap_16
XFILLER_66_520 VDD VDD VSS VSS gf180mcu_fd_sc_mcu7t5v0__fillcap_4
Xwave_controller_x_inst__2640_ wave_controller_x_inst__3391_/A1 wave_controller_x_inst__2636_/Z
+ wave_controller_x_inst__2640_/A3 wave_controller_x_inst__2640_/Z VDD VDD VSS VSS
+ gf180mcu_fd_sc_mcu7t5v0__xor3_1
XFILLER_54_726 VDD VDD VSS VSS gf180mcu_fd_sc_mcu7t5v0__fillcap_8
XFILLER_54_737 VDD VDD VSS VSS gf180mcu_fd_sc_mcu7t5v0__fill_1
XFILLER_66_597 VDD VDD VSS VSS gf180mcu_fd_sc_mcu7t5v0__fillcap_4
XTAP_TAPCELL_ROW_144_2260 VDD VSS gf180mcu_fd_sc_mcu7t5v0__filltie
Xwave_controller_x_inst__2571_ max_cap465/Z wave_controller_x_inst__2570_/Z wave_controller_x_inst__2591_/A2
+ VDD VDD VSS VSS gf180mcu_fd_sc_mcu7t5v0__nand2_1
XFILLER_38_299 VDD VDD VSS VSS gf180mcu_fd_sc_mcu7t5v0__fill_2
XFILLER_53_236 VDD VDD VSS VSS gf180mcu_fd_sc_mcu7t5v0__fill_2
XTAP_TAPCELL_ROW_140_2179 VDD VSS gf180mcu_fd_sc_mcu7t5v0__filltie
Xanalog_block_inst_analog_wave_mixer_x_inst__0_ _93_/I analog[1] analog[2] VDD VDD
+ VSS VSS gf180mcu_fd_sc_mcu7t5v0__and2_1
XFILLER_42_18 VDD VDD VSS VSS gf180mcu_fd_sc_mcu7t5v0__fillcap_8
XTAP_TAPCELL_ROW_122_1890 VDD VSS gf180mcu_fd_sc_mcu7t5v0__filltie
Xwave_controller_x_inst__3123_ wave_controller_x_inst__3705_/Q wave_controller_x_inst__3143_/A2
+ wave_controller_x_inst__3218_/B VDD VDD VSS VSS gf180mcu_fd_sc_mcu7t5v0__nor2_1
XFILLER_147_352 VDD VDD VSS VSS gf180mcu_fd_sc_mcu7t5v0__fillcap_16
XFILLER_159_190 VDD VDD VSS VSS gf180mcu_fd_sc_mcu7t5v0__fillcap_8
XFILLER_21_199 VDD VDD VSS VSS gf180mcu_fd_sc_mcu7t5v0__fill_2
Xwave_controller_y_inst__3070_ wave_controller_y_inst__3712_/Q wave_controller_y_inst__3408_/A1
+ wave_controller_y_inst__3610_/A2 VDD VDD VSS VSS gf180mcu_fd_sc_mcu7t5v0__nand2_1
Xwave_controller_y_inst__2021_ wave_controller_y_inst__3400_/A1 wave_controller_y_inst__2399_/A1
+ wave_controller_y_inst__2024_/B VDD VDD VSS VSS gf180mcu_fd_sc_mcu7t5v0__nand2_1
Xwave_controller_x_inst__3054_ wave_controller_x_inst__3568_/A1 wave_controller_x_inst__3069_/B1
+ wave_controller_x_inst__3053_/Z wave_controller_x_inst_wire166/Z wave_controller_x_inst__3706_/D
+ VDD VDD VSS VSS gf180mcu_fd_sc_mcu7t5v0__oai22_1
XFILLER_101_8 VDD VDD VSS VSS gf180mcu_fd_sc_mcu7t5v0__fill_1
Xwave_controller_x_inst__2005_ fanout537/Z wave_controller_x_inst__2349_/A1 wave_controller_x_inst__2009_/B
+ VDD VDD VSS VSS gf180mcu_fd_sc_mcu7t5v0__nand2_1
XFILLER_103_422 VDD VDD VSS VSS gf180mcu_fd_sc_mcu7t5v0__fillcap_8
XFILLER_115_282 VDD VDD VSS VSS gf180mcu_fd_sc_mcu7t5v0__fill_1
XFILLER_1_549 VDD VDD VSS VSS gf180mcu_fd_sc_mcu7t5v0__fillcap_4
XFILLER_103_455 VDD VDD VSS VSS gf180mcu_fd_sc_mcu7t5v0__fill_1
XFILLER_107_88 VDD VDD VSS VSS gf180mcu_fd_sc_mcu7t5v0__fillcap_8
XFILLER_130_241 VDD VDD VSS VSS gf180mcu_fd_sc_mcu7t5v0__fillcap_4
XFILLER_131_753 VDD VDD VSS VSS gf180mcu_fd_sc_mcu7t5v0__fillcap_8
XFILLER_153_1046 VDD VDD VSS VSS gf180mcu_fd_sc_mcu7t5v0__fillcap_4
XFILLER_49_509 VDD VDD VSS VSS gf180mcu_fd_sc_mcu7t5v0__fill_1
XFILLER_66_1087 VDD VDD VSS VSS gf180mcu_fd_sc_mcu7t5v0__fillcap_64
XFILLER_89_689 VDD VDD VSS VSS gf180mcu_fd_sc_mcu7t5v0__fillcap_8
Xwave_controller_y_inst__2923_ wave_controller_y_inst__3082_/B spi_regs_inst__0974_/B2
+ wave_controller_y_inst__2923_/S wave_controller_y_inst__3686_/D VDD VDD VSS VSS
+ gf180mcu_fd_sc_mcu7t5v0__mux2_2
Xspi_regs_inst_fanout339 spi_regs_inst__1009_/A1 spi_regs_inst__1032_/A1 VDD VDD VSS
+ VSS gf180mcu_fd_sc_mcu7t5v0__dlyb_1
XFILLER_130_274 VDD VDD VSS VSS gf180mcu_fd_sc_mcu7t5v0__fillcap_4
XFILLER_130_296 VDD VDD VSS VSS gf180mcu_fd_sc_mcu7t5v0__fillcap_4
XFILLER_76_317 VDD VDD VSS VSS gf180mcu_fd_sc_mcu7t5v0__fillcap_16
XFILLER_88_177 VDD VDD VSS VSS gf180mcu_fd_sc_mcu7t5v0__fillcap_4
Xwave_controller_x_inst__2907_ wave_controller_x_inst__3700_/Q wave_controller_x_inst__3454_/A2
+ wave_controller_x_inst_wire84/Z wave_controller_x_inst__3723_/Q wave_controller_x_inst__2907_/C
+ wave_controller_x_inst__2908_/B1 VDD VDD VSS VSS gf180mcu_fd_sc_mcu7t5v0__aoi221_1
Xwave_controller_y_inst__2854_ wave_controller_y_inst__2775_/Z wave_controller_y_inst__2854_/A2
+ wave_controller_y_inst__2854_/A3 wave_controller_y_inst__2854_/B wave_controller_y_inst__2897_/A3
+ VDD VDD VSS VSS gf180mcu_fd_sc_mcu7t5v0__oai31_1
Xwave_controller_x_inst__2838_ wave_controller_x_inst__2838_/A1 wave_controller_x_inst__2838_/A2
+ wave_controller_x_inst__2838_/B wave_controller_x_inst__2839_/B VDD VDD VSS VSS
+ gf180mcu_fd_sc_mcu7t5v0__aoi21_1
XFILLER_84_361 VDD VDD VSS VSS gf180mcu_fd_sc_mcu7t5v0__fill_1
Xwave_controller_y_inst__2785_ spi_regs_inst__1045_/B2 wave_controller_y_inst__2805_/S
+ wave_controller_y_inst__2786_/B VDD VDD VSS VSS gf180mcu_fd_sc_mcu7t5v0__nand2_1
Xwave_controller_y_inst__1805_ wave_controller_y_inst__2124_/B wave_controller_y_inst__1945_/A1
+ VDD VDD VSS VSS gf180mcu_fd_sc_mcu7t5v0__inv_1
XFILLER_44_247 VDD VDD VSS VSS gf180mcu_fd_sc_mcu7t5v0__fillcap_16
XFILLER_83_69 VDD VDD VSS VSS gf180mcu_fd_sc_mcu7t5v0__fill_1
Xwave_controller_x_inst__2769_ spi_regs_inst__1225_/A1 wave_controller_x_inst__2902_/B2
+ wave_controller_x_inst__2770_/B VDD VDD VSS VSS gf180mcu_fd_sc_mcu7t5v0__nand2_1
XFILLER_25_494 VDD VDD VSS VSS gf180mcu_fd_sc_mcu7t5v0__fill_1
XTAP_TAPCELL_ROW_55_787 VDD VSS gf180mcu_fd_sc_mcu7t5v0__filltie
XTAP_TAPCELL_ROW_80_1204 VDD VSS gf180mcu_fd_sc_mcu7t5v0__filltie
XFILLER_160_1017 VDD VDD VSS VSS gf180mcu_fd_sc_mcu7t5v0__fillcap_64
Xwave_controller_y_inst__3406_ wave_controller_y_inst__3407_/B wave_controller_y_inst__3406_/A2
+ wave_controller_y_inst__3406_/A3 wave_controller_y_inst__3406_/B wave_controller_y_inst__3617_/D
+ VDD VDD VSS VSS gf180mcu_fd_sc_mcu7t5v0__oai31_1
XFILLER_12_177 VDD VDD VSS VSS gf180mcu_fd_sc_mcu7t5v0__fillcap_32
XFILLER_139_842 VDD VDD VSS VSS gf180mcu_fd_sc_mcu7t5v0__fillcap_4
Xwave_controller_y_inst__3337_ wave_controller_y_inst__3337_/A1 wave_controller_y_inst__3335_/Z
+ wave_controller_y_inst__3337_/B wave_controller_y_inst__3402_/A1 VDD VDD VSS VSS
+ gf180mcu_fd_sc_mcu7t5v0__aoi21_1
XFILLER_154_801 VDD VDD VSS VSS gf180mcu_fd_sc_mcu7t5v0__fillcap_4
XFILLER_166_661 VDD VDD VSS VSS gf180mcu_fd_sc_mcu7t5v0__fillcap_4
Xwave_controller_y_inst__3268_ wave_controller_y_inst__3268_/I wave_controller_y_inst__3314_/B
+ VDD VDD VSS VSS gf180mcu_fd_sc_mcu7t5v0__clkinv_1
XTAP_TAPCELL_ROW_78_1166 VDD VSS gf180mcu_fd_sc_mcu7t5v0__filltie
Xwave_controller_y_inst__3199_ wave_controller_y_inst__3245_/A1 wave_controller_y_inst__3245_/A2
+ wave_controller_y_inst__3246_/B1 VDD VDD VSS VSS gf180mcu_fd_sc_mcu7t5v0__nor2_1
Xwave_controller_y_inst__2219_ wave_controller_y_inst__2192_/Z wave_controller_y_inst__2203_/Z
+ wave_controller_y_inst__2222_/C VDD VDD VSS VSS gf180mcu_fd_sc_mcu7t5v0__and2_1
XFILLER_101_1170 VDD VDD VSS VSS gf180mcu_fd_sc_mcu7t5v0__fillcap_4
XFILLER_107_772 VDD VDD VSS VSS gf180mcu_fd_sc_mcu7t5v0__fill_1
XFILLER_141_539 VDD VDD VSS VSS gf180mcu_fd_sc_mcu7t5v0__fillcap_4
XFILLER_68_807 VDD VDD VSS VSS gf180mcu_fd_sc_mcu7t5v0__fillcap_16
XTAP_TAPCELL_ROW_91_1377 VDD VSS gf180mcu_fd_sc_mcu7t5v0__filltie
XFILLER_122_797 VDD VDD VSS VSS gf180mcu_fd_sc_mcu7t5v0__fillcap_8
XFILLER_48_531 VDD VDD VSS VSS gf180mcu_fd_sc_mcu7t5v0__fill_1
XFILLER_82_309 VDD VDD VSS VSS gf180mcu_fd_sc_mcu7t5v0__fillcap_4
Xwave_controller_x_inst_fanout383 wave_controller_x_inst__3560_/A1 wave_controller_x_inst__3279_/A1
+ VDD VDD VSS VSS gf180mcu_fd_sc_mcu7t5v0__dlyb_1
XFILLER_35_203 VDD VDD VSS VSS gf180mcu_fd_sc_mcu7t5v0__fillcap_4
XFILLER_63_523 VDD VDD VSS VSS gf180mcu_fd_sc_mcu7t5v0__fillcap_32
Xspi_regs_inst__1644_ spi_regs_inst__1644_/D fanout566/Z clkload17/I spi_regs_inst__1644_/Q
+ VDD VDD VSS VSS gf180mcu_fd_sc_mcu7t5v0__dffrnq_1
XFILLER_16_483 VDD VDD VSS VSS gf180mcu_fd_sc_mcu7t5v0__fill_1
XFILLER_50_239 VDD VDD VSS VSS gf180mcu_fd_sc_mcu7t5v0__fillcap_4
XFILLER_31_442 VDD VDD VSS VSS gf180mcu_fd_sc_mcu7t5v0__fillcap_16
Xspi_regs_inst__1575_ spi_regs_inst__1575_/D fanout564/Z clkbuf_leaf_9_clk/Z spi_regs_inst__1575_/Q
+ VDD VDD VSS VSS gf180mcu_fd_sc_mcu7t5v0__dffrnq_1
XFILLER_148_116 VDD VDD VSS VSS gf180mcu_fd_sc_mcu7t5v0__fillcap_32
XFILLER_106_1081 VDD VDD VSS VSS gf180mcu_fd_sc_mcu7t5v0__fillcap_4
XFILLER_129_352 VDD VDD VSS VSS gf180mcu_fd_sc_mcu7t5v0__fillcap_4
XFILLER_78_2 VDD VDD VSS VSS gf180mcu_fd_sc_mcu7t5v0__fillcap_16
XFILLER_117_536 VDD VDD VSS VSS gf180mcu_fd_sc_mcu7t5v0__fillcap_16
XFILLER_145_812 VDD VDD VSS VSS gf180mcu_fd_sc_mcu7t5v0__fillcap_16
XFILLER_157_683 VDD VDD VSS VSS gf180mcu_fd_sc_mcu7t5v0__fillcap_16
XFILLER_113_720 VDD VDD VSS VSS gf180mcu_fd_sc_mcu7t5v0__fill_1
XTAP_TAPCELL_ROW_32_1_574 VDD VSS gf180mcu_fd_sc_mcu7t5v0__filltie
XFILLER_98_442 VDD VDD VSS VSS gf180mcu_fd_sc_mcu7t5v0__fillcap_4
XFILLER_99_976 VDD VDD VSS VSS gf180mcu_fd_sc_mcu7t5v0__fillcap_4
XTAP_TAPCELL_ROW_129_2008 VDD VSS gf180mcu_fd_sc_mcu7t5v0__filltie
Xstate_machine_inst__39_ state_machine_inst__39_/D fanout585/Z clkbuf_leaf_13_clk/Z
+ spi_regs_inst__1079_/B2 VDD VDD VSS VSS gf180mcu_fd_sc_mcu7t5v0__dffrnq_1
Xspi_regs_inst__1009_ spi_regs_inst__1009_/A1 spi_regs_inst__1025_/A2 spi_regs_inst__1151_/B1
+ VDD VDD VSS VSS gf180mcu_fd_sc_mcu7t5v0__nor2_1
XFILLER_100_403 VDD VDD VSS VSS gf180mcu_fd_sc_mcu7t5v0__fillcap_4
XFILLER_140_594 VDD VDD VSS VSS gf180mcu_fd_sc_mcu7t5v0__fill_1
XFILLER_58_317 VDD VDD VSS VSS gf180mcu_fd_sc_mcu7t5v0__fillcap_8
XFILLER_58_339 VDD VDD VSS VSS gf180mcu_fd_sc_mcu7t5v0__fillcap_4
Xwave_controller_x_inst__3741_ spi_regs_inst__1112_/A1 spi_regs_inst__1083_/B2 VDD
+ VDD VSS VSS gf180mcu_fd_sc_mcu7t5v0__buf_1
XFILLER_85_158 VDD VDD VSS VSS gf180mcu_fd_sc_mcu7t5v0__fillcap_8
Xwave_controller_x_inst__3672_ wave_controller_x_inst__3672_/D wave_controller_x_inst__3701_/RN
+ clkload31/I spi_regs_inst__1128_/B2 VDD VDD VSS VSS gf180mcu_fd_sc_mcu7t5v0__dffrnq_1
XFILLER_113_1052 VDD VDD VSS VSS gf180mcu_fd_sc_mcu7t5v0__fillcap_64
XTAP_TAPCELL_ROW_142_2219 VDD VSS gf180mcu_fd_sc_mcu7t5v0__filltie
Xwave_controller_x_inst__2623_ fanout540/Z wave_controller_x_inst__2621_/Z wave_controller_x_inst__2623_/Z
+ VDD VDD VSS VSS gf180mcu_fd_sc_mcu7t5v0__and2_1
XFILLER_54_523 VDD VDD VSS VSS gf180mcu_fd_sc_mcu7t5v0__fill_2
XFILLER_54_545 VDD VDD VSS VSS gf180mcu_fd_sc_mcu7t5v0__fill_2
XFILLER_66_383 VDD VDD VSS VSS gf180mcu_fd_sc_mcu7t5v0__fill_2
XTAP_TAPCELL_ROW_107_1638 VDD VSS gf180mcu_fd_sc_mcu7t5v0__filltie
XTAP_TAPCELL_ROW_107_1649 VDD VSS gf180mcu_fd_sc_mcu7t5v0__filltie
XFILLER_26_247 VDD VDD VSS VSS gf180mcu_fd_sc_mcu7t5v0__fillcap_32
XFILLER_53_17 VDD VDD VSS VSS gf180mcu_fd_sc_mcu7t5v0__fillcap_8
XFILLER_82_865 VDD VDD VSS VSS gf180mcu_fd_sc_mcu7t5v0__fillcap_4
XTAP_TAPCELL_ROW_124_1930 VDD VSS gf180mcu_fd_sc_mcu7t5v0__filltie
Xwave_controller_y_inst__2570_ fanout502/Z wave_controller_y_inst__2566_/Z wave_controller_y_inst__2570_/A3
+ wave_controller_y_inst__2570_/Z VDD VDD VSS VSS gf180mcu_fd_sc_mcu7t5v0__xor3_1
Xwave_controller_x_inst__2554_ wave_controller_x_inst__2555_/A1 wave_controller_x_inst__2555_/A2
+ wave_controller_x_inst__2556_/B VDD VDD VSS VSS gf180mcu_fd_sc_mcu7t5v0__nor2_1
Xwave_controller_x_inst__2485_ wave_controller_x_inst__2497_/A1 wave_controller_x_inst__2497_/A2
+ wave_controller_x_inst__2498_/A2 VDD VDD VSS VSS gf180mcu_fd_sc_mcu7t5v0__nand2_1
XFILLER_34_280 VDD VDD VSS VSS gf180mcu_fd_sc_mcu7t5v0__fill_2
XTAP_TAPCELL_ROW_120_1849 VDD VSS gf180mcu_fd_sc_mcu7t5v0__filltie
XTAP_TAPCELL_ROW_157_2462 VDD VSS gf180mcu_fd_sc_mcu7t5v0__filltie
XTAP_TAPCELL_ROW_157_2473 VDD VSS gf180mcu_fd_sc_mcu7t5v0__filltie
Xwave_controller_y_inst__3122_ wave_controller_y_inst__3706_/Q wave_controller_y_inst__3122_/A2
+ wave_controller_y_inst__3147_/B VDD VDD VSS VSS gf180mcu_fd_sc_mcu7t5v0__nand2_1
Xwave_controller_x_inst__3106_ wave_controller_x_inst__3320_/A1 spi_regs_inst__1534_/Q
+ wave_controller_x_inst__3170_/B VDD VDD VSS VSS gf180mcu_fd_sc_mcu7t5v0__nand2_1
XFILLER_108_547 VDD VDD VSS VSS gf180mcu_fd_sc_mcu7t5v0__fillcap_4
Xwave_controller_y_inst__3053_ wave_controller_y_inst__3706_/Q wave_controller_y_inst__1825_/I
+ wave_controller_y_inst__3053_/A3 wave_controller_y_inst__3053_/Z VDD VDD VSS VSS
+ gf180mcu_fd_sc_mcu7t5v0__xor3_1
Xwave_controller_x_inst__3037_ wave_controller_x_inst__3700_/Q wave_controller_x_inst__3557_/B1
+ wave_controller_x_inst__3494_/A1 wave_controller_x_inst__3557_/A1 wave_controller_x_inst__3038_/A2
+ VDD VDD VSS VSS gf180mcu_fd_sc_mcu7t5v0__oai22_1
XTAP_TAPCELL_ROW_18_1_464 VDD VSS gf180mcu_fd_sc_mcu7t5v0__filltie
Xwave_controller_y_inst__2004_ fanout516/Z wave_controller_y_inst__2349_/A1 wave_controller_y_inst__2009_/A3
+ VDD VDD VSS VSS gf180mcu_fd_sc_mcu7t5v0__nor2_1
XFILLER_104_731 VDD VDD VSS VSS gf180mcu_fd_sc_mcu7t5v0__fillcap_4
XFILLER_103_252 VDD VDD VSS VSS gf180mcu_fd_sc_mcu7t5v0__fillcap_8
XFILLER_1_346 VDD VDD VSS VSS gf180mcu_fd_sc_mcu7t5v0__fillcap_4
XFILLER_1_368 VDD VDD VSS VSS gf180mcu_fd_sc_mcu7t5v0__fillcap_8
XTAP_TAPCELL_ROW_73_1074 VDD VSS gf180mcu_fd_sc_mcu7t5v0__filltie
Xwave_controller_x_inst_wire169 wave_controller_x_inst_wire169/I wave_controller_x_inst_wire169/Z
+ VDD VDD VSS VSS gf180mcu_fd_sc_mcu7t5v0__buf_1
XFILLER_77_648 VDD VDD VSS VSS gf180mcu_fd_sc_mcu7t5v0__fillcap_4
XFILLER_89_486 VDD VDD VSS VSS gf180mcu_fd_sc_mcu7t5v0__fillcap_4
XTAP_TAPCELL_ROW_73_1085 VDD VSS gf180mcu_fd_sc_mcu7t5v0__filltie
XFILLER_103_296 VDD VDD VSS VSS gf180mcu_fd_sc_mcu7t5v0__fill_1
Xwave_controller_y_inst__2906_ wave_controller_y_inst__3700_/Q wave_controller_y_inst__3419_/B
+ wave_controller_y_inst__2907_/C VDD VDD VSS VSS gf180mcu_fd_sc_mcu7t5v0__nor2_1
XFILLER_134_97 VDD VDD VSS VSS gf180mcu_fd_sc_mcu7t5v0__fill_2
XFILLER_58_895 VDD VDD VSS VSS gf180mcu_fd_sc_mcu7t5v0__fill_1
XFILLER_76_169 VDD VDD VSS VSS gf180mcu_fd_sc_mcu7t5v0__fillcap_4
Xwave_controller_y_inst__2837_ wave_controller_y_inst__3320_/A1 wave_controller_y_inst__2837_/A2
+ wave_controller_y_inst__2837_/B1 wave_controller_y_inst__3080_/A1 wave_controller_y_inst__2838_/A2
+ VDD VDD VSS VSS gf180mcu_fd_sc_mcu7t5v0__oai22_1
XFILLER_73_832 VDD VDD VSS VSS gf180mcu_fd_sc_mcu7t5v0__fillcap_8
XFILLER_72_342 VDD VDD VSS VSS gf180mcu_fd_sc_mcu7t5v0__fillcap_8
Xwave_controller_y_inst__2768_ wave_controller_y_inst__3420_/A1 spi_regs_inst__1054_/B2
+ wave_controller_y_inst__2768_/Z VDD VDD VSS VSS gf180mcu_fd_sc_mcu7t5v0__xor2_1
XFILLER_72_375 VDD VDD VSS VSS gf180mcu_fd_sc_mcu7t5v0__fill_1
Xwave_controller_y_inst__2699_ wave_controller_y_inst__2844_/A1 spi_regs_inst__1121_/A1
+ wave_controller_y_inst__2699_/Z VDD VDD VSS VSS gf180mcu_fd_sc_mcu7t5v0__xor2_1
XFILLER_158_403 VDD VDD VSS VSS gf180mcu_fd_sc_mcu7t5v0__fillcap_8
XFILLER_40_261 VDD VDD VSS VSS gf180mcu_fd_sc_mcu7t5v0__fill_1
XFILLER_43_72 VDD VDD VSS VSS gf180mcu_fd_sc_mcu7t5v0__fillcap_8
XFILLER_9_435 VDD VDD VSS VSS gf180mcu_fd_sc_mcu7t5v0__fillcap_8
Xspi_regs_inst__1360_ spi_regs_inst__1360_/A1 spi_regs_inst__1360_/A2 spi_regs_inst__1360_/A3
+ spi_regs_inst__1360_/A4 spi_regs_inst__1360_/Z VDD VDD VSS VSS gf180mcu_fd_sc_mcu7t5v0__and4_1
XFILLER_159_72 VDD VDD VSS VSS gf180mcu_fd_sc_mcu7t5v0__fillcap_64
XFILLER_9_468 VDD VDD VSS VSS gf180mcu_fd_sc_mcu7t5v0__fillcap_8
Xspi_regs_inst__1291_ spi_regs_inst__1291_/A1 spi_regs_inst_wire88/Z spi_regs_inst__1291_/A3
+ spi_regs_inst__1291_/A4 spi_regs_inst__1295_/A3 VDD VDD VSS VSS gf180mcu_fd_sc_mcu7t5v0__nand4_1
XFILLER_127_834 VDD VDD VSS VSS gf180mcu_fd_sc_mcu7t5v0__fillcap_4
XFILLER_126_333 VDD VDD VSS VSS gf180mcu_fd_sc_mcu7t5v0__fillcap_8
XFILLER_64_8 VDD VDD VSS VSS gf180mcu_fd_sc_mcu7t5v0__fillcap_16
XTAP_TAPCELL_ROW_93_1406 VDD VSS gf180mcu_fd_sc_mcu7t5v0__filltie
XFILLER_142_804 VDD VDD VSS VSS gf180mcu_fd_sc_mcu7t5v0__fill_1
XTAP_TAPCELL_ROW_93_1417 VDD VSS gf180mcu_fd_sc_mcu7t5v0__filltie
XFILLER_153_174 VDD VDD VSS VSS gf180mcu_fd_sc_mcu7t5v0__fillcap_16
XFILLER_99_228 VDD VDD VSS VSS gf180mcu_fd_sc_mcu7t5v0__fill_1
Xsignal_processor_y_inst__241_ signal_processor_y_inst__241_/D _17_/B clkload2/I signal_processor_y_inst__241_/Q
+ VDD VDD VSS VSS gf180mcu_fd_sc_mcu7t5v0__dffrnq_1
XFILLER_96_913 VDD VDD VSS VSS gf180mcu_fd_sc_mcu7t5v0__fillcap_8
Xsignal_processor_y_inst__172_ signal_processor_y_inst__235_/Q signal_processor_y_inst__172_/A2
+ signal_processor_y_inst__213_/A2 VDD VDD VSS VSS gf180mcu_fd_sc_mcu7t5v0__xnor2_1
XFILLER_110_767 VDD VDD VSS VSS gf180mcu_fd_sc_mcu7t5v0__fill_2
XFILLER_67_125 VDD VDD VSS VSS gf180mcu_fd_sc_mcu7t5v0__fillcap_8
XFILLER_95_467 VDD VDD VSS VSS gf180mcu_fd_sc_mcu7t5v0__fill_1
Xwave_controller_x_inst_fanout180 wave_controller_x_inst__3090_/B1 wave_controller_x_inst__3069_/B1
+ VDD VDD VSS VSS gf180mcu_fd_sc_mcu7t5v0__dlyb_1
XFILLER_63_331 VDD VDD VSS VSS gf180mcu_fd_sc_mcu7t5v0__fillcap_16
XFILLER_64_832 VDD VDD VSS VSS gf180mcu_fd_sc_mcu7t5v0__fill_2
XFILLER_75_180 VDD VDD VSS VSS gf180mcu_fd_sc_mcu7t5v0__fillcap_8
XFILLER_76_681 VDD VDD VSS VSS gf180mcu_fd_sc_mcu7t5v0__fill_1
XFILLER_63_397 VDD VDD VSS VSS gf180mcu_fd_sc_mcu7t5v0__fillcap_4
XFILLER_147_1170 VDD VDD VSS VSS gf180mcu_fd_sc_mcu7t5v0__fillcap_4
XFILLER_16_291 VDD VDD VSS VSS gf180mcu_fd_sc_mcu7t5v0__fillcap_8
Xspi_regs_inst__1627_ spi_regs_inst__1627_/D spi_regs_inst__1659_/RN clkload8/I spi_regs_inst__1627_/Q
+ VDD VDD VSS VSS gf180mcu_fd_sc_mcu7t5v0__dffrnq_1
XFILLER_149_436 VDD VDD VSS VSS gf180mcu_fd_sc_mcu7t5v0__fill_1
XFILLER_31_250 VDD VDD VSS VSS gf180mcu_fd_sc_mcu7t5v0__fill_1
XTAP_TAPCELL_ROW_102_1557 VDD VSS gf180mcu_fd_sc_mcu7t5v0__filltie
XTAP_TAPCELL_ROW_102_1568 VDD VSS gf180mcu_fd_sc_mcu7t5v0__filltie
Xwave_controller_x_inst__2270_ wave_controller_x_inst__2270_/A1 wave_controller_x_inst__2270_/A2
+ wave_controller_x_inst__2346_/A1 VDD VDD VSS VSS gf180mcu_fd_sc_mcu7t5v0__nand2_1
Xspi_regs_inst__1558_ spi_regs_inst__1558_/D spi_regs_inst__1662_/RN clkbuf_leaf_7_clk/Z
+ spi_regs_inst__1558_/Q VDD VDD VSS VSS gf180mcu_fd_sc_mcu7t5v0__dffrnq_1
XTAP_TAPCELL_ROW_139_2170 VDD VSS gf180mcu_fd_sc_mcu7t5v0__filltie
Xclkbuf_3_2__f_clk clkbuf_0_clk/Z clkbuf_3_2__f_clk/Z VDD VDD VSS VSS gf180mcu_fd_sc_mcu7t5v0__clkbuf_16
XFILLER_117_311 VDD VDD VSS VSS gf180mcu_fd_sc_mcu7t5v0__fill_1
Xspi_regs_inst__1489_ spi_regs_inst__1489_/D fanout615/Z clkbuf_leaf_36_clk/Z spi_regs_inst__1489_/Q
+ VDD VDD VSS VSS gf180mcu_fd_sc_mcu7t5v0__dffrnq_1
XFILLER_129_171 VDD VDD VSS VSS gf180mcu_fd_sc_mcu7t5v0__fill_2
XTAP_TAPCELL_ROW_152_2381 VDD VSS gf180mcu_fd_sc_mcu7t5v0__filltie
XTAP_TAPCELL_ROW_152_2392 VDD VSS gf180mcu_fd_sc_mcu7t5v0__filltie
XFILLER_117_388 VDD VDD VSS VSS gf180mcu_fd_sc_mcu7t5v0__fill_2
XFILLER_144_174 VDD VDD VSS VSS gf180mcu_fd_sc_mcu7t5v0__fill_1
XFILLER_160_667 VDD VDD VSS VSS gf180mcu_fd_sc_mcu7t5v0__fillcap_64
XFILLER_63_1046 VDD VDD VSS VSS gf180mcu_fd_sc_mcu7t5v0__fillcap_4
XFILLER_87_924 VDD VDD VSS VSS gf180mcu_fd_sc_mcu7t5v0__fillcap_4
XFILLER_113_594 VDD VDD VSS VSS gf180mcu_fd_sc_mcu7t5v0__fill_1
XFILLER_59_648 VDD VDD VSS VSS gf180mcu_fd_sc_mcu7t5v0__fill_2
XFILLER_87_979 VDD VDD VSS VSS gf180mcu_fd_sc_mcu7t5v0__fill_1
Xwave_controller_y_inst__3740_ spi_regs_inst__1065_/B2 spi_regs_inst__1065_/A1 VDD
+ VDD VSS VSS gf180mcu_fd_sc_mcu7t5v0__buf_1
Xwave_controller_x_inst__1985_ wave_controller_x_inst__1985_/I wave_controller_x_inst__1988_/A1
+ VDD VDD VSS VSS gf180mcu_fd_sc_mcu7t5v0__clkinv_1
XFILLER_104_34 VDD VDD VSS VSS gf180mcu_fd_sc_mcu7t5v0__fill_1
XFILLER_58_158 VDD VDD VSS VSS gf180mcu_fd_sc_mcu7t5v0__fillcap_8
XTAP_TAPCELL_ROW_57_816 VDD VSS gf180mcu_fd_sc_mcu7t5v0__filltie
Xwave_controller_x_inst__3724_ wave_controller_x_inst__3724_/D fanout595/Z clkbuf_leaf_20_clk/Z
+ _93_/I VDD VDD VSS VSS gf180mcu_fd_sc_mcu7t5v0__dffrnq_1
XFILLER_27_512 VDD VDD VSS VSS gf180mcu_fd_sc_mcu7t5v0__fillcap_8
XFILLER_73_139 VDD VDD VSS VSS gf180mcu_fd_sc_mcu7t5v0__fill_1
XPHY_EDGE_ROW_61_Left_228 VDD VSS gf180mcu_fd_sc_mcu7t5v0__endcap
Xwave_controller_y_inst__3671_ wave_controller_y_inst__3671_/D wave_controller_y_inst__3673_/RN
+ clkbuf_leaf_35_clk/Z spi_regs_inst__1090_/B2 VDD VDD VSS VSS gf180mcu_fd_sc_mcu7t5v0__dffrnq_1
Xwave_controller_x_inst__3655_ wave_controller_x_inst__3655_/D fanout619/Z clkload32/I
+ spi_regs_inst__1320_/A1 VDD VDD VSS VSS gf180mcu_fd_sc_mcu7t5v0__dffrnq_1
XFILLER_55_865 VDD VDD VSS VSS gf180mcu_fd_sc_mcu7t5v0__fillcap_4
XFILLER_55_876 VDD VDD VSS VSS gf180mcu_fd_sc_mcu7t5v0__fill_2
XFILLER_82_673 VDD VDD VSS VSS gf180mcu_fd_sc_mcu7t5v0__fill_1
Xwave_controller_y_inst__2622_ wave_controller_y_inst__1821_/I wave_controller_y_inst__2621_/Z
+ wave_controller_y_inst__2643_/B VDD VDD VSS VSS gf180mcu_fd_sc_mcu7t5v0__or2_1
Xwave_controller_x_inst__3586_ spi_regs_inst__1336_/A1 wave_controller_x_inst__3585_/S
+ wave_controller_x_inst__3587_/B VDD VDD VSS VSS gf180mcu_fd_sc_mcu7t5v0__nand2_1
Xwave_controller_x_inst__2606_ wave_controller_x_inst__2606_/I wave_controller_x_inst__2633_/B
+ VDD VDD VSS VSS gf180mcu_fd_sc_mcu7t5v0__clkinv_1
Xspi_regs_inst_max_cap307 spi_regs_inst__0824_/S spi_regs_inst__0826_/S VDD VDD VSS
+ VSS gf180mcu_fd_sc_mcu7t5v0__buf_2
XTAP_TAPCELL_ROW_159_2502 VDD VSS gf180mcu_fd_sc_mcu7t5v0__filltie
Xwave_controller_y_inst__2553_ wave_controller_y_inst__2519_/Z wave_controller_y_inst__2553_/A2
+ wave_controller_y_inst__2553_/A3 wave_controller_y_inst__2555_/B1 VDD VDD VSS VSS
+ gf180mcu_fd_sc_mcu7t5v0__nand3_1
Xwave_controller_x_inst__2537_ fanout526/Z wave_controller_x_inst__2537_/A2 wave_controller_x_inst__2537_/A3
+ wave_controller_x_inst__2537_/Z VDD VDD VSS VSS gf180mcu_fd_sc_mcu7t5v0__xor3_1
XFILLER_70_1017 VDD VDD VSS VSS gf180mcu_fd_sc_mcu7t5v0__fillcap_64
Xwave_controller_y_inst__2484_ wave_controller_y_inst__2481_/I wave_controller_y_inst__2509_/A2
+ wave_controller_y_inst__2498_/A1 VDD VDD VSS VSS gf180mcu_fd_sc_mcu7t5v0__nor2_1
Xwave_controller_x_inst__2468_ wave_controller_x_inst__2758_/B wave_controller_x_inst__2467_/Z
+ wave_controller_x_inst__2482_/B VDD VDD VSS VSS gf180mcu_fd_sc_mcu7t5v0__nor2_1
Xsignal_processor_x_inst__192_ signal_processor_x_inst__192_/A1 signal_processor_x_inst__192_/A2
+ signal_processor_x_inst__192_/B signal_processor_x_inst__234_/Q signal_processor_x_inst__196_/B1
+ VDD VDD VSS VSS gf180mcu_fd_sc_mcu7t5v0__oai211_1
XFILLER_128_609 VDD VDD VSS VSS gf180mcu_fd_sc_mcu7t5v0__fill_1
Xwave_controller_x_inst__2399_ wave_controller_x_inst__2399_/A1 max_cap451/Z wave_controller_x_inst__2399_/Z
+ VDD VDD VSS VSS gf180mcu_fd_sc_mcu7t5v0__and2_1
XFILLER_109_812 VDD VDD VSS VSS gf180mcu_fd_sc_mcu7t5v0__fill_2
XFILLER_6_427 VDD VDD VSS VSS gf180mcu_fd_sc_mcu7t5v0__fillcap_16
XPHY_EDGE_ROW_70_Left_237 VDD VSS gf180mcu_fd_sc_mcu7t5v0__endcap
Xwave_controller_y_inst__3105_ wave_controller_y_inst__3615_/Q wave_controller_y_inst__3105_/A2
+ wave_controller_y_inst__3257_/A1 VDD VDD VSS VSS gf180mcu_fd_sc_mcu7t5v0__nand2_1
XFILLER_135_152 VDD VDD VSS VSS gf180mcu_fd_sc_mcu7t5v0__fillcap_16
XFILLER_159_1052 VDD VDD VSS VSS gf180mcu_fd_sc_mcu7t5v0__fillcap_64
XTAP_TAPCELL_ROW_75_1114 VDD VSS gf180mcu_fd_sc_mcu7t5v0__filltie
Xwave_controller_y_inst__3036_ wave_controller_y_inst__3489_/A1 wave_controller_y_inst__3036_/A2
+ wave_controller_y_inst__3035_/Z wave_controller_y_inst_wire25/Z wave_controller_y_inst__3699_/D
+ VDD VDD VSS VSS gf180mcu_fd_sc_mcu7t5v0__oai22_1
XFILLER_163_483 VDD VDD VSS VSS gf180mcu_fd_sc_mcu7t5v0__fillcap_4
XFILLER_8_2 VDD VDD VSS VSS gf180mcu_fd_sc_mcu7t5v0__fillcap_32
Xwave_controller_x_inst_wire84 wave_controller_x_inst_wire84/I wave_controller_x_inst_wire84/Z
+ VDD VDD VSS VSS gf180mcu_fd_sc_mcu7t5v0__buf_2
Xwave_controller_x_inst_wire95 wave_controller_x_inst_wire95/I wave_controller_x_inst_wire95/Z
+ VDD VDD VSS VSS gf180mcu_fd_sc_mcu7t5v0__dlyb_1
XFILLER_132_881 VDD VDD VSS VSS gf180mcu_fd_sc_mcu7t5v0__fill_2
XFILLER_145_96 VDD VDD VSS VSS gf180mcu_fd_sc_mcu7t5v0__fillcap_8
XFILLER_150_177 VDD VDD VSS VSS gf180mcu_fd_sc_mcu7t5v0__fillcap_4
XFILLER_92_415 VDD VDD VSS VSS gf180mcu_fd_sc_mcu7t5v0__fill_1
XFILLER_93_927 VDD VDD VSS VSS gf180mcu_fd_sc_mcu7t5v0__fillcap_4
Xspi_regs_inst__0860_ spi_regs_inst__1597_/Q spi_regs_inst__1411_/I1 spi_regs_inst__0861_/S
+ spi_regs_inst__1597_/D VDD VDD VSS VSS gf180mcu_fd_sc_mcu7t5v0__mux2_2
XFILLER_92_437 VDD VDD VSS VSS gf180mcu_fd_sc_mcu7t5v0__fill_1
XTAP_TAPCELL_ROW_23_1_505 VDD VSS gf180mcu_fd_sc_mcu7t5v0__filltie
Xspi_regs_inst__0791_ spi_regs_inst__1542_/Q spi_regs_inst__1439_/I1 spi_regs_inst__0795_/S
+ spi_regs_inst__1542_/D VDD VDD VSS VSS gf180mcu_fd_sc_mcu7t5v0__mux2_2
XFILLER_61_846 VDD VDD VSS VSS gf180mcu_fd_sc_mcu7t5v0__fill_2
XTAP_TAPCELL_ROW_0_1_2670 VDD VSS gf180mcu_fd_sc_mcu7t5v0__filltie
XTAP_TAPCELL_ROW_86_1298 VDD VSS gf180mcu_fd_sc_mcu7t5v0__filltie
XFILLER_61_868 VDD VDD VSS VSS gf180mcu_fd_sc_mcu7t5v0__fill_1
XPHY_EDGE_ROW_26_1_Right_25 VDD VSS gf180mcu_fd_sc_mcu7t5v0__endcap
XTAP_TAPCELL_ROW_31_1_562 VDD VSS gf180mcu_fd_sc_mcu7t5v0__filltie
XFILLER_60_367 VDD VDD VSS VSS gf180mcu_fd_sc_mcu7t5v0__fill_1
Xspi_regs_inst__1412_ fanout511/Z spi_regs_inst__1412_/I1 spi_regs_inst__1412_/S spi_regs_inst__1485_/D
+ VDD VDD VSS VSS gf180mcu_fd_sc_mcu7t5v0__mux2_2
XFILLER_13_294 VDD VDD VSS VSS gf180mcu_fd_sc_mcu7t5v0__fill_1
XPHY_EDGE_ROW_109_Left_276 VDD VSS gf180mcu_fd_sc_mcu7t5v0__endcap
XFILLER_9_276 VDD VDD VSS VSS gf180mcu_fd_sc_mcu7t5v0__fillcap_4
Xspi_regs_inst__1343_ spi_regs_inst__1343_/A1 spi_regs_inst__1343_/A2 spi_regs_inst_wire226/Z
+ spi_regs_inst__1343_/B2 spi_regs_inst__1344_/A3 VDD VDD VSS VSS gf180mcu_fd_sc_mcu7t5v0__aoi22_1
XFILLER_127_642 VDD VDD VSS VSS gf180mcu_fd_sc_mcu7t5v0__fillcap_4
XFILLER_158_299 VDD VDD VSS VSS gf180mcu_fd_sc_mcu7t5v0__fill_1
Xspi_regs_inst__1274_ spi_regs_inst__1274_/A1 spi_regs_inst_wire288/Z spi_regs_inst_wire249/Z
+ fanout535/Z spi_regs_inst__1291_/A1 VDD VDD VSS VSS gf180mcu_fd_sc_mcu7t5v0__aoi22_1
Xclkload35 clkload35/I clkload35/ZN VDD VDD VSS VSS gf180mcu_fd_sc_mcu7t5v0__inv_2
Xclkload24 clkload24/I clkload24/Z VDD VDD VSS VSS gf180mcu_fd_sc_mcu7t5v0__clkbuf_2
Xclkload13 clkload13/I clkload13/ZN VDD VDD VSS VSS gf180mcu_fd_sc_mcu7t5v0__inv_4
XFILLER_115_804 VDD VDD VSS VSS gf180mcu_fd_sc_mcu7t5v0__fillcap_16
XFILLER_127_675 VDD VDD VSS VSS gf180mcu_fd_sc_mcu7t5v0__fillcap_4
XFILLER_114_314 VDD VDD VSS VSS gf180mcu_fd_sc_mcu7t5v0__fill_1
XFILLER_115_848 VDD VDD VSS VSS gf180mcu_fd_sc_mcu7t5v0__fillcap_16
XFILLER_126_174 VDD VDD VSS VSS gf180mcu_fd_sc_mcu7t5v0__fill_1
XFILLER_130_807 VDD VDD VSS VSS gf180mcu_fd_sc_mcu7t5v0__fillcap_64
XFILLER_87_209 VDD VDD VSS VSS gf180mcu_fd_sc_mcu7t5v0__fill_1
XFILLER_141_188 VDD VDD VSS VSS gf180mcu_fd_sc_mcu7t5v0__fillcap_4
XFILLER_96_732 VDD VDD VSS VSS gf180mcu_fd_sc_mcu7t5v0__fill_2
Xsignal_processor_y_inst__224_ signal_processor_y_inst__224_/D fanout556/Z clkload7/I
+ spi_regs_inst__1178_/A1 VDD VDD VSS VSS gf180mcu_fd_sc_mcu7t5v0__dffrnq_1
XPHY_EDGE_ROW_118_Left_285 VDD VSS gf180mcu_fd_sc_mcu7t5v0__endcap
Xsignal_processor_y_inst__155_ signal_processor_y_inst__202_/A2 signal_processor_y_inst__229_/Q
+ signal_processor_y_inst__129_/Z signal_processor_y_inst__158_/A2 VDD VDD VSS VSS
+ gf180mcu_fd_sc_mcu7t5v0__nand3_1
XFILLER_110_1011 VDD VDD VSS VSS gf180mcu_fd_sc_mcu7t5v0__fillcap_4
XFILLER_110_597 VDD VDD VSS VSS gf180mcu_fd_sc_mcu7t5v0__fillcap_8
XFILLER_55_139 VDD VDD VSS VSS gf180mcu_fd_sc_mcu7t5v0__fill_1
XFILLER_36_353 VDD VDD VSS VSS gf180mcu_fd_sc_mcu7t5v0__fill_2
Xwave_controller_x_inst__3440_ wave_controller_x_inst__3440_/A1 wave_controller_x_inst_wire84/I
+ wave_controller_x_inst__3494_/A2 wave_controller_x_inst__3440_/B2 wave_controller_x_inst__3489_/C
+ wave_controller_x_inst__3441_/B VDD VDD VSS VSS gf180mcu_fd_sc_mcu7t5v0__aoi221_1
Xspi_regs_inst__0989_ spi_regs_inst__1002_/A2 spi_regs_inst__1019_/A2 spi_regs_inst__1245_/B1
+ VDD VDD VSS VSS gf180mcu_fd_sc_mcu7t5v0__nor2_1
XFILLER_36_364 VDD VDD VSS VSS gf180mcu_fd_sc_mcu7t5v0__fill_1
XFILLER_91_492 VDD VDD VSS VSS gf180mcu_fd_sc_mcu7t5v0__fill_2
Xwave_controller_x_inst__3371_ wave_controller_x_inst__3371_/A1 wave_controller_x_inst__3375_/A2
+ wave_controller_x_inst__3292_/B wave_controller_x_inst__3371_/Z VDD VDD VSS VSS
+ gf180mcu_fd_sc_mcu7t5v0__and3_1
XPHY_EDGE_ROW_127_Left_294 VDD VSS gf180mcu_fd_sc_mcu7t5v0__endcap
Xwave_controller_x_inst__2322_ wave_controller_x_inst__2349_/C max_cap453/Z wave_controller_x_inst__2322_/Z
+ VDD VDD VSS VSS gf180mcu_fd_sc_mcu7t5v0__xor2_1
XTAP_TAPCELL_ROW_154_2410 VDD VSS gf180mcu_fd_sc_mcu7t5v0__filltie
XTAP_TAPCELL_ROW_62_896 VDD VSS gf180mcu_fd_sc_mcu7t5v0__filltie
Xwave_controller_x_inst__2253_ wave_controller_x_inst__2254_/A1 wire456/Z wave_controller_x_inst__2272_/B
+ VDD VDD VSS VSS gf180mcu_fd_sc_mcu7t5v0__nor2_1
XFILLER_149_288 VDD VDD VSS VSS gf180mcu_fd_sc_mcu7t5v0__fill_1
XTAP_TAPCELL_ROW_154_2421 VDD VSS gf180mcu_fd_sc_mcu7t5v0__filltie
Xclkload7 clkload7/I clkload7/Z VDD VDD VSS VSS gf180mcu_fd_sc_mcu7t5v0__clkbuf_2
XFILLER_164_236 VDD VDD VSS VSS gf180mcu_fd_sc_mcu7t5v0__fill_2
XFILLER_164_247 VDD VDD VSS VSS gf180mcu_fd_sc_mcu7t5v0__fillcap_4
XTAP_TAPCELL_ROW_119_1840 VDD VSS gf180mcu_fd_sc_mcu7t5v0__filltie
Xwave_controller_x_inst__2184_ wave_controller_x_inst__2184_/I wave_controller_x_inst__2188_/A2
+ VDD VDD VSS VSS gf180mcu_fd_sc_mcu7t5v0__clkinv_1
XFILLER_118_664 VDD VDD VSS VSS gf180mcu_fd_sc_mcu7t5v0__fill_1
XFILLER_118_675 VDD VDD VSS VSS gf180mcu_fd_sc_mcu7t5v0__fillcap_4
XFILLER_118_686 VDD VDD VSS VSS gf180mcu_fd_sc_mcu7t5v0__fill_1
XFILLER_132_111 VDD VDD VSS VSS gf180mcu_fd_sc_mcu7t5v0__fill_1
XFILLER_160_442 VDD VDD VSS VSS gf180mcu_fd_sc_mcu7t5v0__fillcap_4
XFILLER_161_976 VDD VDD VSS VSS gf180mcu_fd_sc_mcu7t5v0__fillcap_4
XFILLER_132_166 VDD VDD VSS VSS gf180mcu_fd_sc_mcu7t5v0__fillcap_8
XFILLER_132_177 VDD VDD VSS VSS gf180mcu_fd_sc_mcu7t5v0__fillcap_16
XFILLER_59_412 VDD VDD VSS VSS gf180mcu_fd_sc_mcu7t5v0__fillcap_8
XFILLER_87_710 VDD VDD VSS VSS gf180mcu_fd_sc_mcu7t5v0__fillcap_4
XTAP_TAPCELL_ROW_70_1033 VDD VSS gf180mcu_fd_sc_mcu7t5v0__filltie
XFILLER_59_478 VDD VDD VSS VSS gf180mcu_fd_sc_mcu7t5v0__fillcap_8
Xwave_controller_y_inst__1984_ fanout501/Z spi_regs_inst__1109_/A1 wave_controller_y_inst__1985_/I
+ VDD VDD VSS VSS gf180mcu_fd_sc_mcu7t5v0__xor2_1
Xwave_controller_x_inst__1968_ wave_controller_x_inst__1973_/A2 wave_controller_x_inst__1967_/Z
+ spi_regs_inst__1283_/B2 VDD VDD VSS VSS gf180mcu_fd_sc_mcu7t5v0__and2_1
XTAP_TAPCELL_ROW_165_2594 VDD VSS gf180mcu_fd_sc_mcu7t5v0__filltie
Xwave_controller_y_inst__3723_ wave_controller_y_inst__3723_/D wave_controller_y_inst__3739_/RN
+ clkload16/I wave_controller_y_inst__3723_/Q VDD VDD VSS VSS gf180mcu_fd_sc_mcu7t5v0__dffrnq_1
Xwave_controller_x_inst__3707_ wave_controller_x_inst__3707_/D wave_controller_x_inst__3707_/RN
+ clkload35/I wave_controller_x_inst__3707_/Q VDD VDD VSS VSS gf180mcu_fd_sc_mcu7t5v0__dffrnq_1
Xwave_controller_y_inst__3654_ wave_controller_y_inst__3654_/D wave_controller_y_inst__3703_/RN
+ clkload21/I max_cap427/I VDD VDD VSS VSS gf180mcu_fd_sc_mcu7t5v0__dffrnq_1
Xwave_controller_x_inst__1899_ wave_controller_x_inst__3699_/Q wave_controller_x_inst__3489_/A1
+ VDD VDD VSS VSS gf180mcu_fd_sc_mcu7t5v0__clkinv_1
XFILLER_27_364 VDD VDD VSS VSS gf180mcu_fd_sc_mcu7t5v0__fillcap_8
XFILLER_42_312 VDD VDD VSS VSS gf180mcu_fd_sc_mcu7t5v0__fill_2
XFILLER_55_673 VDD VDD VSS VSS gf180mcu_fd_sc_mcu7t5v0__fill_1
XFILLER_83_982 VDD VDD VSS VSS gf180mcu_fd_sc_mcu7t5v0__fillcap_64
Xwave_controller_y_inst__2605_ wave_controller_y_inst__2576_/I wave_controller_y_inst__2609_/A1
+ wave_controller_y_inst__2591_/Z wave_controller_y_inst__2606_/I VDD VDD VSS VSS
+ gf180mcu_fd_sc_mcu7t5v0__nor3_1
Xwave_controller_x_inst__3638_ wave_controller_x_inst__3638_/D wave_controller_x_inst__3682_/RN
+ clkload34/I max_cap464/I VDD VDD VSS VSS gf180mcu_fd_sc_mcu7t5v0__dffrnq_1
XFILLER_15_548 VDD VDD VSS VSS gf180mcu_fd_sc_mcu7t5v0__fillcap_4
XFILLER_42_345 VDD VDD VSS VSS gf180mcu_fd_sc_mcu7t5v0__fill_2
Xwave_controller_y_inst_wire151 wave_controller_y_inst_wire151/I wave_controller_y_inst_wire151/Z
+ VDD VDD VSS VSS gf180mcu_fd_sc_mcu7t5v0__buf_2
Xwave_controller_y_inst__3585_ wave_controller_y_inst__3585_/I0 spi_regs_inst__1321_/A1
+ wave_controller_y_inst__3591_/S wave_controller_y_inst__3663_/D VDD VDD VSS VSS
+ gf180mcu_fd_sc_mcu7t5v0__mux2_2
Xwave_controller_x_inst__3569_ wave_controller_x_inst__3600_/I0 max_cap458/I wave_controller_x_inst__3569_/S
+ wave_controller_x_inst__3654_/D VDD VDD VSS VSS gf180mcu_fd_sc_mcu7t5v0__mux2_2
XFILLER_42_367 VDD VDD VSS VSS gf180mcu_fd_sc_mcu7t5v0__fillcap_8
Xwave_controller_y_inst__2536_ fanout505/Z wave_controller_y_inst__2536_/A2 wave_controller_y_inst__2561_/A1
+ VDD VDD VSS VSS gf180mcu_fd_sc_mcu7t5v0__nor2_1
Xsignal_processor_x_inst__244_ signal_processor_x_inst__244_/D fanout595/Z clkbuf_leaf_19_clk/Z
+ wave_controller_x_inst__1891_/I VDD VDD VSS VSS gf180mcu_fd_sc_mcu7t5v0__dffrnq_1
XPHY_EDGE_ROW_145_Right_145 VDD VSS gf180mcu_fd_sc_mcu7t5v0__endcap
Xwave_controller_y_inst__2467_ wave_controller_y_inst__3500_/B2 wave_controller_y_inst__2467_/A2
+ wave_controller_y_inst__2467_/Z VDD VDD VSS VSS gf180mcu_fd_sc_mcu7t5v0__xor2_1
Xsignal_processor_x_inst__175_ signal_processor_x_inst__236_/Q signal_processor_x_inst__175_/A2
+ signal_processor_x_inst__175_/Z VDD VDD VSS VSS gf180mcu_fd_sc_mcu7t5v0__xor2_1
XFILLER_156_737 VDD VDD VSS VSS gf180mcu_fd_sc_mcu7t5v0__fillcap_8
Xchip_core_630 bidir_cs[5] VDD VDD VSS VSS gf180mcu_fd_sc_mcu7t5v0__tiel
Xwave_controller_y_inst__2398_ wave_controller_y_inst__2399_/A1 spi_regs_inst__1078_/A1
+ wave_controller_y_inst__2412_/B VDD VDD VSS VSS gf180mcu_fd_sc_mcu7t5v0__nor2_1
Xchip_core_663 bidir_pu[9] VDD VDD VSS VSS gf180mcu_fd_sc_mcu7t5v0__tiel
Xchip_core_652 bidir_pd[7] VDD VDD VSS VSS gf180mcu_fd_sc_mcu7t5v0__tiel
Xchip_core_641 bidir_ie[9] VDD VDD VSS VSS gf180mcu_fd_sc_mcu7t5v0__tiel
Xchip_core_685 bidir_oe[8] VDD VDD VSS VSS gf180mcu_fd_sc_mcu7t5v0__tieh
Xchip_core_674 input_pu VDD VDD VSS VSS gf180mcu_fd_sc_mcu7t5v0__tiel
XFILLER_108_174 VDD VDD VSS VSS gf180mcu_fd_sc_mcu7t5v0__fill_1
XFILLER_123_111 VDD VDD VSS VSS gf180mcu_fd_sc_mcu7t5v0__fillcap_16
XFILLER_112_807 VDD VDD VSS VSS gf180mcu_fd_sc_mcu7t5v0__fillcap_4
XFILLER_124_667 VDD VDD VSS VSS gf180mcu_fd_sc_mcu7t5v0__fillcap_8
XTAP_TAPCELL_ROW_34_1_588 VDD VSS gf180mcu_fd_sc_mcu7t5v0__filltie
Xwave_controller_y_inst__3019_ wave_controller_y_inst__3408_/A1 wave_controller_y_inst__3025_/A3
+ wave_controller_y_inst__3021_/B1 VDD VDD VSS VSS gf180mcu_fd_sc_mcu7t5v0__nand2_1
XFILLER_105_881 VDD VDD VSS VSS gf180mcu_fd_sc_mcu7t5v0__fillcap_16
XFILLER_2_452 VDD VDD VSS VSS gf180mcu_fd_sc_mcu7t5v0__fill_2
XFILLER_97_529 VDD VDD VSS VSS gf180mcu_fd_sc_mcu7t5v0__fillcap_4
XFILLER_104_391 VDD VDD VSS VSS gf180mcu_fd_sc_mcu7t5v0__fill_2
XFILLER_77_220 VDD VDD VSS VSS gf180mcu_fd_sc_mcu7t5v0__fill_1
XFILLER_78_798 VDD VDD VSS VSS gf180mcu_fd_sc_mcu7t5v0__fillcap_4
XFILLER_93_702 VDD VDD VSS VSS gf180mcu_fd_sc_mcu7t5v0__fillcap_8
Xspi_regs_inst__0912_ spi_regs_inst__1630_/Q spi_regs_inst__0912_/A2 spi_regs_inst__0912_/B
+ spi_regs_inst__0913_/A2 VDD VDD VSS VSS gf180mcu_fd_sc_mcu7t5v0__oai21_1
X_21_ _21_/D _21_/CLK _21_/Q VDD VDD VSS VSS gf180mcu_fd_sc_mcu7t5v0__dffq_1
XFILLER_120_895 VDD VDD VSS VSS gf180mcu_fd_sc_mcu7t5v0__fill_1
XFILLER_65_448 VDD VDD VSS VSS gf180mcu_fd_sc_mcu7t5v0__fillcap_4
XFILLER_77_297 VDD VDD VSS VSS gf180mcu_fd_sc_mcu7t5v0__fillcap_16
XTAP_TAPCELL_ROW_88_1327 VDD VSS gf180mcu_fd_sc_mcu7t5v0__filltie
Xspi_regs_inst__0843_ spi_regs_inst__0880_/A2 spi_regs_inst__1395_/A1 spi_regs_inst__0851_/S
+ VDD VDD VSS VSS gf180mcu_fd_sc_mcu7t5v0__nor2_2
XFILLER_18_375 VDD VDD VSS VSS gf180mcu_fd_sc_mcu7t5v0__fillcap_8
XFILLER_92_278 VDD VDD VSS VSS gf180mcu_fd_sc_mcu7t5v0__fill_2
XFILLER_92_289 VDD VDD VSS VSS gf180mcu_fd_sc_mcu7t5v0__fillcap_16
Xspi_regs_inst__0774_ spi_regs_inst__1529_/Q spi_regs_inst__1448_/I1 spi_regs_inst__0778_/S
+ spi_regs_inst__1529_/D VDD VDD VSS VSS gf180mcu_fd_sc_mcu7t5v0__mux2_2
XFILLER_61_632 VDD VDD VSS VSS gf180mcu_fd_sc_mcu7t5v0__fillcap_16
XFILLER_73_492 VDD VDD VSS VSS gf180mcu_fd_sc_mcu7t5v0__fill_2
XFILLER_57_1170 VDD VDD VSS VSS gf180mcu_fd_sc_mcu7t5v0__fillcap_4
XFILLER_144_1151 VDD VDD VSS VSS gf180mcu_fd_sc_mcu7t5v0__fillcap_4
XFILLER_159_586 VDD VDD VSS VSS gf180mcu_fd_sc_mcu7t5v0__fill_1
XFILLER_159_597 VDD VDD VSS VSS gf180mcu_fd_sc_mcu7t5v0__fillcap_4
XFILLER_53_1056 VDD VDD VSS VSS gf180mcu_fd_sc_mcu7t5v0__fillcap_32
XPHY_EDGE_ROW_112_Right_112 VDD VSS gf180mcu_fd_sc_mcu7t5v0__endcap
XFILLER_147_748 VDD VDD VSS VSS gf180mcu_fd_sc_mcu7t5v0__fill_1
Xspi_regs_inst__1326_ spi_regs_inst__1326_/A1 spi_regs_inst__1326_/A2 spi_regs_inst__1326_/A3
+ spi_regs_inst__1326_/A4 spi_regs_inst__1327_/A4 VDD VDD VSS VSS gf180mcu_fd_sc_mcu7t5v0__nand4_1
XFILLER_146_269 VDD VDD VSS VSS gf180mcu_fd_sc_mcu7t5v0__fill_2
XFILLER_60_2 VDD VDD VSS VSS gf180mcu_fd_sc_mcu7t5v0__fillcap_8
XFILLER_161_228 VDD VDD VSS VSS gf180mcu_fd_sc_mcu7t5v0__fillcap_4
XTAP_TAPCELL_ROW_132_2048 VDD VSS gf180mcu_fd_sc_mcu7t5v0__filltie
XTAP_TAPCELL_ROW_132_2059 VDD VSS gf180mcu_fd_sc_mcu7t5v0__filltie
Xspi_regs_inst__1257_ spi_regs_inst__1257_/A1 spi_regs_inst_wire241/Z spi_regs_inst__1257_/B1
+ spi_regs_inst_wire18/Z spi_regs_inst__1258_/A4 VDD VDD VSS VSS gf180mcu_fd_sc_mcu7t5v0__aoi22_1
XFILLER_115_667 VDD VDD VSS VSS gf180mcu_fd_sc_mcu7t5v0__fill_2
XFILLER_142_453 VDD VDD VSS VSS gf180mcu_fd_sc_mcu7t5v0__fill_2
XFILLER_143_976 VDD VDD VSS VSS gf180mcu_fd_sc_mcu7t5v0__fillcap_4
Xspi_regs_inst_wire226 spi_regs_inst_wire227/Z spi_regs_inst_wire226/Z VDD VDD VSS
+ VSS gf180mcu_fd_sc_mcu7t5v0__buf_2
Xspi_regs_inst__1188_ spi_regs_inst__1489_/Q spi_regs_inst_wire299/I spi_regs_inst__1281_/B1
+ spi_regs_inst__1573_/Q spi_regs_inst__1188_/C1 spi_regs_inst__1245_/B1 spi_regs_inst__1191_/A2
+ VDD VDD VSS VSS gf180mcu_fd_sc_mcu7t5v0__aoi222_1
XFILLER_102_317 VDD VDD VSS VSS gf180mcu_fd_sc_mcu7t5v0__fillcap_8
XFILLER_114_177 VDD VDD VSS VSS gf180mcu_fd_sc_mcu7t5v0__fillcap_8
XFILLER_130_626 VDD VDD VSS VSS gf180mcu_fd_sc_mcu7t5v0__fillcap_16
Xwave_controller_x_inst__2940_ wave_controller_x_inst__1783_/I fanout534/Z wave_controller_x_inst__2994_/B
+ VDD VDD VSS VSS gf180mcu_fd_sc_mcu7t5v0__nand2_1
XFILLER_151_1122 VDD VDD VSS VSS gf180mcu_fd_sc_mcu7t5v0__fillcap_32
XFILLER_69_754 VDD VDD VSS VSS gf180mcu_fd_sc_mcu7t5v0__fillcap_16
Xwave_controller_x_inst__2871_ wave_controller_x_inst__3458_/A1 spi_regs_inst__1239_/A1
+ wave_controller_x_inst__2873_/A2 VDD VDD VSS VSS gf180mcu_fd_sc_mcu7t5v0__nor2_1
Xsignal_processor_y_inst__207_ signal_processor_y_inst__215_/A1 signal_processor_y_inst__163_/Z
+ signal_processor_y_inst__207_/B signal_processor_y_inst__222_/D VDD VDD VSS VSS
+ gf180mcu_fd_sc_mcu7t5v0__oai21_1
XFILLER_68_253 VDD VDD VSS VSS gf180mcu_fd_sc_mcu7t5v0__fill_1
XFILLER_69_787 VDD VDD VSS VSS gf180mcu_fd_sc_mcu7t5v0__fillcap_8
XTAP_TAPCELL_ROW_110_1689 VDD VSS gf180mcu_fd_sc_mcu7t5v0__filltie
Xwave_controller_x_inst_load_slew162 wave_controller_x_inst__3542_/A1 wave_controller_x_inst__3539_/A1
+ VDD VDD VSS VSS gf180mcu_fd_sc_mcu7t5v0__buf_4
Xwave_controller_x_inst__1822_ fanout542/Z wave_controller_x_inst__2979_/A2 VDD VDD
+ VSS VSS gf180mcu_fd_sc_mcu7t5v0__clkinv_1
XFILLER_110_361 VDD VDD VSS VSS gf180mcu_fd_sc_mcu7t5v0__fill_2
XFILLER_110_383 VDD VDD VSS VSS gf180mcu_fd_sc_mcu7t5v0__fill_2
XFILLER_83_201 VDD VDD VSS VSS gf180mcu_fd_sc_mcu7t5v0__fill_2
XFILLER_83_212 VDD VDD VSS VSS gf180mcu_fd_sc_mcu7t5v0__fillcap_4
XFILLER_84_757 VDD VDD VSS VSS gf180mcu_fd_sc_mcu7t5v0__fillcap_8
Xsignal_processor_y_inst__138_ signal_processor_y_inst__202_/A2 signal_processor_y_inst__229_/Q
+ signal_processor_y_inst__203_/A1 signal_processor_y_inst__138_/A4 signal_processor_y_inst__140_/A2
+ VDD VDD VSS VSS gf180mcu_fd_sc_mcu7t5v0__nor4_1
XPHY_EDGE_ROW_58_Right_58 VDD VSS gf180mcu_fd_sc_mcu7t5v0__endcap
XTAP_TAPCELL_ROW_67_977 VDD VSS gf180mcu_fd_sc_mcu7t5v0__filltie
XFILLER_65_982 VDD VDD VSS VSS gf180mcu_fd_sc_mcu7t5v0__fillcap_64
XFILLER_71_418 VDD VDD VSS VSS gf180mcu_fd_sc_mcu7t5v0__fill_2
XTAP_TAPCELL_ROW_67_988 VDD VSS gf180mcu_fd_sc_mcu7t5v0__filltie
XFILLER_24_323 VDD VDD VSS VSS gf180mcu_fd_sc_mcu7t5v0__fillcap_4
XFILLER_80_941 VDD VDD VSS VSS gf180mcu_fd_sc_mcu7t5v0__fillcap_4
XPHY_EDGE_ROW_135_Left_302 VDD VSS gf180mcu_fd_sc_mcu7t5v0__endcap
Xwave_controller_x_inst__3423_ wave_controller_x_inst__3423_/A1 wave_controller_x_inst__3557_/B1
+ wave_controller_x_inst__3423_/B1 wave_controller_x_inst__3423_/B2 wave_controller_x_inst__3620_/D
+ VDD VDD VSS VSS gf180mcu_fd_sc_mcu7t5v0__oai22_1
XFILLER_51_131 VDD VDD VSS VSS gf180mcu_fd_sc_mcu7t5v0__fillcap_8
XFILLER_51_142 VDD VDD VSS VSS gf180mcu_fd_sc_mcu7t5v0__fillcap_32
Xwave_controller_y_inst__3370_ wave_controller_y_inst__1825_/I wave_controller_y_inst__3369_/Z
+ wave_controller_y_inst__3385_/C VDD VDD VSS VSS gf180mcu_fd_sc_mcu7t5v0__nand2_1
Xwave_controller_x_inst__3354_ wave_controller_x_inst__3355_/A1 wave_controller_x_inst__3359_/A1
+ wave_controller_x_inst__3355_/B wave_controller_x_inst__3354_/Z VDD VDD VSS VSS
+ gf180mcu_fd_sc_mcu7t5v0__and3_1
XFILLER_51_186 VDD VDD VSS VSS gf180mcu_fd_sc_mcu7t5v0__fill_2
XFILLER_61_39 VDD VDD VSS VSS gf180mcu_fd_sc_mcu7t5v0__fill_2
Xwave_controller_y_inst__2321_ wave_controller_y_inst__2349_/C max_cap426/Z wave_controller_y_inst__2333_/B
+ VDD VDD VSS VSS gf180mcu_fd_sc_mcu7t5v0__nor2_1
Xwave_controller_x_inst__2305_ spi_regs_inst__1090_/A1 wave_controller_x_inst__2305_/A2
+ wave_controller_x_inst__2305_/B wave_controller_x_inst__2306_/I VDD VDD VSS VSS
+ gf180mcu_fd_sc_mcu7t5v0__aoi21_1
XFILLER_138_737 VDD VDD VSS VSS gf180mcu_fd_sc_mcu7t5v0__fillcap_8
XFILLER_165_512 VDD VDD VSS VSS gf180mcu_fd_sc_mcu7t5v0__fill_2
Xwave_controller_y_inst__2252_ wave_controller_y_inst__2265_/A1 wave_controller_y_inst__2265_/A2
+ wave_controller_y_inst__2266_/A1 VDD VDD VSS VSS gf180mcu_fd_sc_mcu7t5v0__nor2_1
Xwave_controller_x_inst__3285_ wave_controller_x_inst__3285_/I wave_controller_x_inst__3286_/B
+ VDD VDD VSS VSS gf180mcu_fd_sc_mcu7t5v0__clkinv_1
XFILLER_165_556 VDD VDD VSS VSS gf180mcu_fd_sc_mcu7t5v0__fillcap_4
Xwave_controller_x_inst__2236_ wave_controller_x_inst__2236_/A1 max_cap457/Z wave_controller_x_inst__2259_/A2
+ VDD VDD VSS VSS gf180mcu_fd_sc_mcu7t5v0__nor2_1
XFILLER_153_729 VDD VDD VSS VSS gf180mcu_fd_sc_mcu7t5v0__fillcap_8
XPHY_EDGE_ROW_67_Right_67 VDD VSS gf180mcu_fd_sc_mcu7t5v0__endcap
Xwave_controller_y_inst__2183_ wave_controller_y_inst__2193_/A2 wave_controller_y_inst__2181_/Z
+ wave_controller_y_inst__2184_/I VDD VDD VSS VSS gf180mcu_fd_sc_mcu7t5v0__xor2_1
Xwave_controller_x_inst__2167_ wave_controller_x_inst__2169_/B wave_controller_x_inst__2168_/B
+ VDD VDD VSS VSS gf180mcu_fd_sc_mcu7t5v0__clkinv_1
XFILLER_106_612 VDD VDD VSS VSS gf180mcu_fd_sc_mcu7t5v0__fill_1
XFILLER_69_1052 VDD VDD VSS VSS gf180mcu_fd_sc_mcu7t5v0__fillcap_64
XPHY_EDGE_ROW_144_Left_311 VDD VSS gf180mcu_fd_sc_mcu7t5v0__endcap
XFILLER_105_122 VDD VDD VSS VSS gf180mcu_fd_sc_mcu7t5v0__fill_2
XFILLER_156_1011 VDD VDD VSS VSS gf180mcu_fd_sc_mcu7t5v0__fillcap_4
Xwave_controller_y_inst_fanout135 wave_controller_y_inst__3554_/B1 wave_controller_y_inst__3557_/B1
+ VDD VDD VSS VSS gf180mcu_fd_sc_mcu7t5v0__dlyb_1
Xwave_controller_x_inst__2098_ wave_controller_x_inst__2098_/A1 wave_controller_x_inst__2098_/A2
+ wave_controller_x_inst__2098_/B wave_controller_x_inst__2098_/C wave_controller_x_inst__2099_/A2
+ VDD VDD VSS VSS gf180mcu_fd_sc_mcu7t5v0__oai211_1
XFILLER_120_103 VDD VDD VSS VSS gf180mcu_fd_sc_mcu7t5v0__fill_2
XTAP_TAPCELL_ROW_167_2634 VDD VSS gf180mcu_fd_sc_mcu7t5v0__filltie
Xwave_controller_y_inst_fanout146 wave_controller_y_inst_wire147/I wave_controller_y_inst__2762_/I
+ VDD VDD VSS VSS gf180mcu_fd_sc_mcu7t5v0__dlyb_1
XFILLER_59_220 VDD VDD VSS VSS gf180mcu_fd_sc_mcu7t5v0__fillcap_4
XTAP_TAPCELL_ROW_167_2645 VDD VSS gf180mcu_fd_sc_mcu7t5v0__filltie
XTAP_TAPCELL_ROW_167_2656 VDD VSS gf180mcu_fd_sc_mcu7t5v0__filltie
XFILLER_87_562 VDD VDD VSS VSS gf180mcu_fd_sc_mcu7t5v0__fillcap_16
XFILLER_75_746 VDD VDD VSS VSS gf180mcu_fd_sc_mcu7t5v0__fill_1
XPHY_EDGE_ROW_76_Right_76 VDD VSS gf180mcu_fd_sc_mcu7t5v0__endcap
Xwave_controller_y_inst__1967_ wave_controller_y_inst__1967_/A1 wave_controller_y_inst__1967_/A2
+ wave_controller_y_inst__1966_/B wave_controller_y_inst__1967_/Z VDD VDD VSS VSS
+ gf180mcu_fd_sc_mcu7t5v0__or3_1
XFILLER_19_139 VDD VDD VSS VSS gf180mcu_fd_sc_mcu7t5v0__fill_1
XFILLER_63_908 VDD VDD VSS VSS gf180mcu_fd_sc_mcu7t5v0__fill_2
XFILLER_90_705 VDD VDD VSS VSS gf180mcu_fd_sc_mcu7t5v0__fillcap_16
Xwave_controller_y_inst__3706_ wave_controller_y_inst__3706_/D wave_controller_y_inst__3708_/RN
+ clkload19/I wave_controller_y_inst__3706_/Q VDD VDD VSS VSS gf180mcu_fd_sc_mcu7t5v0__dffrnq_1
XFILLER_142_86 VDD VDD VSS VSS gf180mcu_fd_sc_mcu7t5v0__fillcap_4
XFILLER_76_1012 VDD VDD VSS VSS gf180mcu_fd_sc_mcu7t5v0__fill_2
XPHY_EDGE_ROW_153_Left_320 VDD VSS gf180mcu_fd_sc_mcu7t5v0__endcap
Xwave_controller_y_inst__1898_ wave_controller_y_inst__3698_/Q wave_controller_y_inst__3479_/A1
+ VDD VDD VSS VSS gf180mcu_fd_sc_mcu7t5v0__clkinv_1
XFILLER_15_323 VDD VDD VSS VSS gf180mcu_fd_sc_mcu7t5v0__fillcap_4
XFILLER_167_1140 VDD VDD VSS VSS gf180mcu_fd_sc_mcu7t5v0__fillcap_8
XFILLER_55_481 VDD VDD VSS VSS gf180mcu_fd_sc_mcu7t5v0__fill_1
XFILLER_55_492 VDD VDD VSS VSS gf180mcu_fd_sc_mcu7t5v0__fill_2
Xwave_controller_y_inst__3637_ wave_controller_y_inst__3637_/D fanout575/Z clkload12/I
+ spi_regs_inst__1099_/B2 VDD VDD VSS VSS gf180mcu_fd_sc_mcu7t5v0__dffrnq_1
XFILLER_128_1157 VDD VDD VSS VSS gf180mcu_fd_sc_mcu7t5v0__fillcap_8
XFILLER_15_356 VDD VDD VSS VSS gf180mcu_fd_sc_mcu7t5v0__fill_2
XFILLER_42_131 VDD VDD VSS VSS gf180mcu_fd_sc_mcu7t5v0__fill_2
XTAP_TAPCELL_ROW_83_1246 VDD VSS gf180mcu_fd_sc_mcu7t5v0__filltie
Xwave_controller_y_inst__3568_ wave_controller_y_inst__3568_/A1 wave_controller_y_inst_wire323/I
+ wave_controller_y_inst__3600_/I0 VDD VDD VSS VSS gf180mcu_fd_sc_mcu7t5v0__nor2_1
Xwave_controller_y_inst__2519_ wave_controller_y_inst__2519_/A1 wave_controller_y_inst__2519_/A2
+ wave_controller_y_inst__2519_/Z VDD VDD VSS VSS gf180mcu_fd_sc_mcu7t5v0__and2_1
Xwave_controller_y_inst__3499_ spi_regs_inst__1097_/A1 wave_controller_y_inst__3529_/A2
+ wave_controller_y_inst__3500_/A3 VDD VDD VSS VSS gf180mcu_fd_sc_mcu7t5v0__nor2_1
Xsignal_processor_x_inst__227_ signal_processor_x_inst__227_/D fanout582/Z clkload10/I
+ spi_regs_inst__1135_/B2 VDD VDD VSS VSS gf180mcu_fd_sc_mcu7t5v0__dffrnq_1
XFILLER_156_523 VDD VDD VSS VSS gf180mcu_fd_sc_mcu7t5v0__fill_2
XFILLER_51_72 VDD VDD VSS VSS gf180mcu_fd_sc_mcu7t5v0__fillcap_16
XPHY_EDGE_ROW_85_Right_85 VDD VSS gf180mcu_fd_sc_mcu7t5v0__endcap
Xsignal_processor_x_inst__158_ signal_processor_x_inst__231_/Q signal_processor_x_inst__158_/A2
+ signal_processor_x_inst__158_/Z VDD VDD VSS VSS gf180mcu_fd_sc_mcu7t5v0__xor2_1
XFILLER_116_409 VDD VDD VSS VSS gf180mcu_fd_sc_mcu7t5v0__fill_1
Xspi_regs_inst__1111_ spi_regs_inst__1111_/A1 spi_regs_inst__1249_/A2 spi_regs_inst__1189_/A2
+ spi_regs_inst__1111_/B2 spi_regs_inst__1115_/A3 VDD VDD VSS VSS gf180mcu_fd_sc_mcu7t5v0__aoi22_1
XTAP_TAPCELL_ROW_16_1_451 VDD VSS gf180mcu_fd_sc_mcu7t5v0__filltie
Xspi_regs_inst__1042_ spi_regs_inst__1562_/Q spi_regs_inst__1135_/A2 spi_regs_inst_wire254/Z
+ spi_regs_inst__1578_/Q spi_regs_inst__1049_/A2 VDD VDD VSS VSS gf180mcu_fd_sc_mcu7t5v0__aoi22_1
XFILLER_100_1087 VDD VDD VSS VSS gf180mcu_fd_sc_mcu7t5v0__fillcap_64
XFILLER_111_158 VDD VDD VSS VSS gf180mcu_fd_sc_mcu7t5v0__fillcap_4
XPHY_EDGE_ROW_94_Right_94 VDD VSS gf180mcu_fd_sc_mcu7t5v0__endcap
XFILLER_65_212 VDD VDD VSS VSS gf180mcu_fd_sc_mcu7t5v0__fillcap_8
XFILLER_65_256 VDD VDD VSS VSS gf180mcu_fd_sc_mcu7t5v0__fillcap_16
XFILLER_53_418 VDD VDD VSS VSS gf180mcu_fd_sc_mcu7t5v0__fillcap_4
XFILLER_81_738 VDD VDD VSS VSS gf180mcu_fd_sc_mcu7t5v0__fillcap_8
XTAP_TAPCELL_ROW_64_925 VDD VSS gf180mcu_fd_sc_mcu7t5v0__filltie
XTAP_TAPCELL_ROW_64_936 VDD VSS gf180mcu_fd_sc_mcu7t5v0__filltie
Xspi_regs_inst__0826_ spi_regs_inst__1445_/I1 spi_regs_inst__1569_/Q spi_regs_inst__0826_/S
+ spi_regs_inst__1569_/D VDD VDD VSS VSS gf180mcu_fd_sc_mcu7t5v0__mux2_2
XFILLER_33_142 VDD VDD VSS VSS gf180mcu_fd_sc_mcu7t5v0__fillcap_16
Xspi_regs_inst__0757_ spi_regs_inst__1650_/Q spi_regs_inst__1651_/Q spi_regs_inst__0827_/A3
+ spi_regs_inst__0808_/A3 VDD VDD VSS VSS gf180mcu_fd_sc_mcu7t5v0__nor3_1
XFILLER_33_197 VDD VDD VSS VSS gf180mcu_fd_sc_mcu7t5v0__fill_2
XFILLER_166_309 VDD VDD VSS VSS gf180mcu_fd_sc_mcu7t5v0__fillcap_4
XFILLER_119_214 VDD VDD VSS VSS gf180mcu_fd_sc_mcu7t5v0__fill_1
XFILLER_119_225 VDD VDD VSS VSS gf180mcu_fd_sc_mcu7t5v0__fill_1
XFILLER_159_394 VDD VDD VSS VSS gf180mcu_fd_sc_mcu7t5v0__fill_2
Xwave_controller_x_inst__3070_ wave_controller_x_inst__3712_/Q fanout404/Z wave_controller_x_inst__3610_/A2
+ VDD VDD VSS VSS gf180mcu_fd_sc_mcu7t5v0__nand2_1
XFILLER_147_556 VDD VDD VSS VSS gf180mcu_fd_sc_mcu7t5v0__fillcap_4
Xwave_controller_x_inst__2021_ fanout532/Z wave_controller_x_inst__2399_/A1 wave_controller_x_inst__2024_/B
+ VDD VDD VSS VSS gf180mcu_fd_sc_mcu7t5v0__nand2_1
XFILLER_128_792 VDD VDD VSS VSS gf180mcu_fd_sc_mcu7t5v0__fillcap_4
Xspi_regs_inst__1309_ spi_regs_inst_wire27/Z spi_regs_inst__1309_/A2 spi_regs_inst_wire233/Z
+ spi_regs_inst__1309_/B2 spi_regs_inst_wire228/Z spi_regs_inst__1309_/C2 spi_regs_inst__1328_/A2
+ VDD VDD VSS VSS gf180mcu_fd_sc_mcu7t5v0__aoi222_1
XFILLER_162_559 VDD VDD VSS VSS gf180mcu_fd_sc_mcu7t5v0__fillcap_8
XFILLER_115_486 VDD VDD VSS VSS gf180mcu_fd_sc_mcu7t5v0__fillcap_4
XFILLER_143_784 VDD VDD VSS VSS gf180mcu_fd_sc_mcu7t5v0__fill_2
XFILLER_89_838 VDD VDD VSS VSS gf180mcu_fd_sc_mcu7t5v0__fill_2
XTAP_TAPCELL_ROW_112_1718 VDD VSS gf180mcu_fd_sc_mcu7t5v0__filltie
XTAP_TAPCELL_ROW_112_1729 VDD VSS gf180mcu_fd_sc_mcu7t5v0__filltie
XFILLER_88_326 VDD VDD VSS VSS gf180mcu_fd_sc_mcu7t5v0__fillcap_8
XFILLER_88_348 VDD VDD VSS VSS gf180mcu_fd_sc_mcu7t5v0__fill_1
XTAP_TAPCELL_ROW_149_2331 VDD VSS gf180mcu_fd_sc_mcu7t5v0__filltie
XTAP_TAPCELL_ROW_149_2342 VDD VSS gf180mcu_fd_sc_mcu7t5v0__filltie
Xwave_controller_x_inst__2923_ wave_controller_x_inst__3082_/B spi_regs_inst__1052_/B2
+ wave_controller_x_inst__2923_/S wave_controller_x_inst__3686_/D VDD VDD VSS VSS
+ gf180mcu_fd_sc_mcu7t5v0__mux2_2
XFILLER_69_562 VDD VDD VSS VSS gf180mcu_fd_sc_mcu7t5v0__fillcap_32
Xwave_controller_y_inst__2870_ wave_controller_y_inst__3697_/Q spi_regs_inst__1270_/A1
+ wave_controller_y_inst__2870_/Z VDD VDD VSS VSS gf180mcu_fd_sc_mcu7t5v0__xor2_1
XFILLER_111_681 VDD VDD VSS VSS gf180mcu_fd_sc_mcu7t5v0__fillcap_8
XFILLER_56_17 VDD VDD VSS VSS gf180mcu_fd_sc_mcu7t5v0__fillcap_4
XFILLER_56_201 VDD VDD VSS VSS gf180mcu_fd_sc_mcu7t5v0__fillcap_32
Xwave_controller_y_inst__1821_ wave_controller_y_inst__1821_/I wave_controller_y_inst__3209_/B
+ VDD VDD VSS VSS gf180mcu_fd_sc_mcu7t5v0__clkinv_1
Xwave_controller_x_inst__2854_ wave_controller_x_inst__2775_/Z wave_controller_x_inst__2854_/A2
+ wave_controller_x_inst__2854_/A3 wave_controller_x_inst__2854_/B wave_controller_x_inst__2897_/A3
+ VDD VDD VSS VSS gf180mcu_fd_sc_mcu7t5v0__oai31_1
XFILLER_56_39 VDD VDD VSS VSS gf180mcu_fd_sc_mcu7t5v0__fill_1
XFILLER_72_705 VDD VDD VSS VSS gf180mcu_fd_sc_mcu7t5v0__fillcap_8
XFILLER_84_565 VDD VDD VSS VSS gf180mcu_fd_sc_mcu7t5v0__fillcap_16
XTAP_TAPCELL_ROW_162_2542 VDD VSS gf180mcu_fd_sc_mcu7t5v0__filltie
XTAP_TAPCELL_ROW_162_2553 VDD VSS gf180mcu_fd_sc_mcu7t5v0__filltie
Xwave_controller_x_inst__2785_ max_cap465/Z wave_controller_x_inst__2805_/S wave_controller_x_inst__2786_/B
+ VDD VDD VSS VSS gf180mcu_fd_sc_mcu7t5v0__nand2_1
Xwave_controller_x_inst__1805_ wave_controller_x_inst__2124_/B wave_controller_x_inst__1945_/A1
+ VDD VDD VSS VSS gf180mcu_fd_sc_mcu7t5v0__inv_1
XFILLER_16_109 VDD VDD VSS VSS gf180mcu_fd_sc_mcu7t5v0__fill_1
XFILLER_71_204 VDD VDD VSS VSS gf180mcu_fd_sc_mcu7t5v0__fillcap_4
XTAP_TAPCELL_ROW_127_1972 VDD VSS gf180mcu_fd_sc_mcu7t5v0__filltie
XTAP_TAPCELL_ROW_25_1_519 VDD VSS gf180mcu_fd_sc_mcu7t5v0__filltie
XFILLER_37_492 VDD VDD VSS VSS gf180mcu_fd_sc_mcu7t5v0__fillcap_32
XFILLER_65_790 VDD VDD VSS VSS gf180mcu_fd_sc_mcu7t5v0__fillcap_16
XFILLER_72_749 VDD VDD VSS VSS gf180mcu_fd_sc_mcu7t5v0__fillcap_32
XFILLER_72_49 VDD VDD VSS VSS gf180mcu_fd_sc_mcu7t5v0__fill_2
XTAP_TAPCELL_ROW_33_1_576 VDD VSS gf180mcu_fd_sc_mcu7t5v0__filltie
Xwave_controller_y_inst__3422_ wave_controller_y_inst__3465_/B wave_controller_y_inst__3417_/I
+ wave_controller_y_inst__3491_/B wave_controller_y_inst__3423_/B2 VDD VDD VSS VSS
+ gf180mcu_fd_sc_mcu7t5v0__oai21_1
Xwave_controller_x_inst__3406_ wave_controller_x_inst__3406_/A1 wave_controller_x_inst__3406_/A2
+ wave_controller_x_inst__3406_/A3 wave_controller_x_inst__3406_/B wave_controller_x_inst__3617_/D
+ VDD VDD VSS VSS gf180mcu_fd_sc_mcu7t5v0__oai31_1
Xwave_controller_y_inst__3353_ wave_controller_y_inst__3714_/Q spi_regs_inst__1612_/Q
+ wave_controller_y_inst__3355_/B VDD VDD VSS VSS gf180mcu_fd_sc_mcu7t5v0__xor2_1
XFILLER_12_337 VDD VDD VSS VSS gf180mcu_fd_sc_mcu7t5v0__fill_2
Xwave_controller_y_inst__2304_ spi_regs_inst__1139_/B2 wave_controller_y_inst__2302_/Z
+ wave_controller_y_inst__2304_/Z VDD VDD VSS VSS gf180mcu_fd_sc_mcu7t5v0__xor2_1
Xwave_controller_x_inst__3337_ wave_controller_x_inst__3337_/A1 wave_controller_x_inst__3335_/Z
+ wave_controller_x_inst__3337_/B wave_controller_x_inst__3402_/A1 VDD VDD VSS VSS
+ gf180mcu_fd_sc_mcu7t5v0__aoi21_1
XFILLER_162_1081 VDD VDD VSS VSS gf180mcu_fd_sc_mcu7t5v0__fillcap_4
Xwave_controller_y_inst__3284_ wave_controller_y_inst__3703_/Q spi_regs_inst__1601_/Q
+ wave_controller_y_inst__3285_/I VDD VDD VSS VSS gf180mcu_fd_sc_mcu7t5v0__xnor2_1
Xwave_controller_x_inst__3268_ wave_controller_x_inst__3268_/I wave_controller_x_inst__3314_/B
+ VDD VDD VSS VSS gf180mcu_fd_sc_mcu7t5v0__clkinv_1
XFILLER_165_331 VDD VDD VSS VSS gf180mcu_fd_sc_mcu7t5v0__fill_1
Xwave_controller_y_inst__2235_ wave_controller_y_inst__2259_/C wave_controller_y_inst__2260_/C
+ VDD VDD VSS VSS gf180mcu_fd_sc_mcu7t5v0__clkinv_1
Xwave_controller_x_inst__2219_ wave_controller_x_inst__2192_/Z wave_controller_x_inst__2203_/Z
+ wave_controller_x_inst__2222_/C VDD VDD VSS VSS gf180mcu_fd_sc_mcu7t5v0__and2_1
XFILLER_165_397 VDD VDD VSS VSS gf180mcu_fd_sc_mcu7t5v0__fill_2
Xwave_controller_y_inst__2166_ spi_regs_inst__1159_/A1 max_cap429/I wave_controller_y_inst__2169_/B
+ VDD VDD VSS VSS gf180mcu_fd_sc_mcu7t5v0__xnor2_1
Xwave_controller_x_inst__3199_ wave_controller_x_inst__3245_/A1 wave_controller_x_inst__3245_/A2
+ wave_controller_x_inst__3246_/B1 VDD VDD VSS VSS gf180mcu_fd_sc_mcu7t5v0__nor2_1
XFILLER_106_420 VDD VDD VSS VSS gf180mcu_fd_sc_mcu7t5v0__fill_1
XFILLER_107_965 VDD VDD VSS VSS gf180mcu_fd_sc_mcu7t5v0__fillcap_8
XFILLER_108_2 VDD VDD VSS VSS gf180mcu_fd_sc_mcu7t5v0__fillcap_16
Xwave_controller_y_inst__2097_ wave_controller_y_inst__2058_/C wave_controller_y_inst__2049_/Z
+ wave_controller_y_inst__2098_/B VDD VDD VSS VSS gf180mcu_fd_sc_mcu7t5v0__nand2_1
XFILLER_79_326 VDD VDD VSS VSS gf180mcu_fd_sc_mcu7t5v0__fillcap_8
XPHY_EDGE_ROW_35_1_Right_34 VDD VSS gf180mcu_fd_sc_mcu7t5v0__endcap
XFILLER_121_489 VDD VDD VSS VSS gf180mcu_fd_sc_mcu7t5v0__fill_1
XFILLER_47_201 VDD VDD VSS VSS gf180mcu_fd_sc_mcu7t5v0__fillcap_8
XFILLER_87_370 VDD VDD VSS VSS gf180mcu_fd_sc_mcu7t5v0__fillcap_4
XFILLER_87_381 VDD VDD VSS VSS gf180mcu_fd_sc_mcu7t5v0__fill_1
XFILLER_88_893 VDD VDD VSS VSS gf180mcu_fd_sc_mcu7t5v0__fillcap_4
XFILLER_47_223 VDD VDD VSS VSS gf180mcu_fd_sc_mcu7t5v0__fillcap_4
XFILLER_47_234 VDD VDD VSS VSS gf180mcu_fd_sc_mcu7t5v0__fillcap_4
Xwave_controller_y_inst__2999_ wave_controller_y_inst__2987_/Z wave_controller_y_inst__2990_/Z
+ wave_controller_y_inst__3001_/A3 wave_controller_y_inst__3000_/A3 VDD VDD VSS VSS
+ gf180mcu_fd_sc_mcu7t5v0__nor3_1
XFILLER_47_278 VDD VDD VSS VSS gf180mcu_fd_sc_mcu7t5v0__fill_2
XFILLER_75_587 VDD VDD VSS VSS gf180mcu_fd_sc_mcu7t5v0__fillcap_4
XFILLER_90_524 VDD VDD VSS VSS gf180mcu_fd_sc_mcu7t5v0__fill_1
XTAP_TAPCELL_ROW_19_1_477 VDD VSS gf180mcu_fd_sc_mcu7t5v0__filltie
Xspi_regs_inst__1660_ spi_regs_inst__1660_/D spi_regs_inst__1662_/RN clkbuf_leaf_6_clk/Z
+ spi_regs_inst__1660_/Q VDD VDD VSS VSS gf180mcu_fd_sc_mcu7t5v0__dffrnq_1
XFILLER_15_120 VDD VDD VSS VSS gf180mcu_fd_sc_mcu7t5v0__fill_2
Xspi_regs_inst__1591_ spi_regs_inst__1591_/D spi_regs_inst__1649_/RN clkload12/I spi_regs_inst__1591_/Q
+ VDD VDD VSS VSS gf180mcu_fd_sc_mcu7t5v0__dffrnq_1
XTAP_TAPCELL_ROW_9_1_401 VDD VSS gf180mcu_fd_sc_mcu7t5v0__filltie
XFILLER_30_134 VDD VDD VSS VSS gf180mcu_fd_sc_mcu7t5v0__fillcap_4
XFILLER_54_1151 VDD VDD VSS VSS gf180mcu_fd_sc_mcu7t5v0__fillcap_4
XFILLER_54_1173 VDD VDD VSS VSS gf180mcu_fd_sc_mcu7t5v0__fill_1
XFILLER_141_1154 VDD VDD VSS VSS gf180mcu_fd_sc_mcu7t5v0__fillcap_16
XFILLER_156_353 VDD VDD VSS VSS gf180mcu_fd_sc_mcu7t5v0__fillcap_16
XFILLER_7_330 VDD VDD VSS VSS gf180mcu_fd_sc_mcu7t5v0__fillcap_4
XFILLER_7_66 VDD VDD VSS VSS gf180mcu_fd_sc_mcu7t5v0__fillcap_4
XTAP_TAPCELL_ROW_96_1459 VDD VSS gf180mcu_fd_sc_mcu7t5v0__filltie
XFILLER_131_209 VDD VDD VSS VSS gf180mcu_fd_sc_mcu7t5v0__fill_1
Xspi_regs_inst__1025_ spi_regs_inst__1030_/A1 spi_regs_inst__1025_/A2 spi_regs_inst__1189_/B1
+ VDD VDD VSS VSS gf180mcu_fd_sc_mcu7t5v0__nor2_1
XFILLER_112_423 VDD VDD VSS VSS gf180mcu_fd_sc_mcu7t5v0__fill_1
XFILLER_61_1122 VDD VDD VSS VSS gf180mcu_fd_sc_mcu7t5v0__fillcap_32
XFILLER_23_2 VDD VDD VSS VSS gf180mcu_fd_sc_mcu7t5v0__fillcap_64
XFILLER_94_874 VDD VDD VSS VSS gf180mcu_fd_sc_mcu7t5v0__fill_1
XTAP_TAPCELL_ROW_144_2250 VDD VSS gf180mcu_fd_sc_mcu7t5v0__filltie
XTAP_TAPCELL_ROW_144_2261 VDD VSS gf180mcu_fd_sc_mcu7t5v0__filltie
Xwave_controller_x_inst__2570_ fanout523/Z wave_controller_x_inst__2566_/Z wave_controller_x_inst__2570_/A3
+ wave_controller_x_inst__2570_/Z VDD VDD VSS VSS gf180mcu_fd_sc_mcu7t5v0__xor3_1
XFILLER_19_492 VDD VDD VSS VSS gf180mcu_fd_sc_mcu7t5v0__fillcap_4
XTAP_TAPCELL_ROW_109_1680 VDD VSS gf180mcu_fd_sc_mcu7t5v0__filltie
XFILLER_34_451 VDD VDD VSS VSS gf180mcu_fd_sc_mcu7t5v0__fillcap_4
Xspi_regs_inst__0809_ spi_regs_inst__1653_/Q spi_regs_inst__1652_/Q spi_regs_inst__0862_/A2
+ spi_regs_inst__0814_/S VDD VDD VSS VSS gf180mcu_fd_sc_mcu7t5v0__nor3_1
XFILLER_146_1087 VDD VDD VSS VSS gf180mcu_fd_sc_mcu7t5v0__fillcap_64
XTAP_TAPCELL_ROW_122_1891 VDD VSS gf180mcu_fd_sc_mcu7t5v0__filltie
Xwave_controller_x_inst__3122_ wave_controller_x_inst__3706_/Q wave_controller_x_inst__3122_/A2
+ wave_controller_x_inst__3147_/B VDD VDD VSS VSS gf180mcu_fd_sc_mcu7t5v0__nand2_1
Xwave_controller_x_inst__3053_ wave_controller_x_inst__3706_/Q wave_controller_x_inst__3236_/B
+ wave_controller_x_inst__3053_/A3 wave_controller_x_inst__3053_/Z VDD VDD VSS VSS
+ gf180mcu_fd_sc_mcu7t5v0__xor3_1
XFILLER_107_228 VDD VDD VSS VSS gf180mcu_fd_sc_mcu7t5v0__fillcap_8
Xwave_controller_y_inst__2020_ wave_controller_y_inst__3400_/A1 wave_controller_y_inst__2399_/A1
+ wave_controller_y_inst__2024_/A3 VDD VDD VSS VSS gf180mcu_fd_sc_mcu7t5v0__nor2_1
Xwave_controller_x_inst__2004_ fanout537/Z wave_controller_x_inst__2349_/A1 wave_controller_x_inst__2009_/A3
+ VDD VDD VSS VSS gf180mcu_fd_sc_mcu7t5v0__nor2_1
XFILLER_135_559 VDD VDD VSS VSS gf180mcu_fd_sc_mcu7t5v0__fill_1
XFILLER_162_323 VDD VDD VSS VSS gf180mcu_fd_sc_mcu7t5v0__fill_1
XFILLER_116_751 VDD VDD VSS VSS gf180mcu_fd_sc_mcu7t5v0__fill_2
XFILLER_131_710 VDD VDD VSS VSS gf180mcu_fd_sc_mcu7t5v0__fillcap_4
XFILLER_1_506 VDD VDD VSS VSS gf180mcu_fd_sc_mcu7t5v0__fill_1
XFILLER_66_1011 VDD VDD VSS VSS gf180mcu_fd_sc_mcu7t5v0__fillcap_4
XFILLER_131_721 VDD VDD VSS VSS gf180mcu_fd_sc_mcu7t5v0__fillcap_32
XFILLER_88_123 VDD VDD VSS VSS gf180mcu_fd_sc_mcu7t5v0__fillcap_4
XFILLER_89_624 VDD VDD VSS VSS gf180mcu_fd_sc_mcu7t5v0__fillcap_4
XFILLER_89_657 VDD VDD VSS VSS gf180mcu_fd_sc_mcu7t5v0__fill_1
Xwave_controller_x_inst_wire329 wave_controller_x_inst__2052_/Z wave_controller_x_inst__2144_/B
+ VDD VDD VSS VSS gf180mcu_fd_sc_mcu7t5v0__clkbuf_2
Xwave_controller_y_inst__2922_ wave_controller_y_inst__3081_/B wave_controller_y_inst__3407_/B
+ wave_controller_y_inst__3082_/B VDD VDD VSS VSS gf180mcu_fd_sc_mcu7t5v0__nor2_1
XFILLER_85_830 VDD VDD VSS VSS gf180mcu_fd_sc_mcu7t5v0__fillcap_4
Xwave_controller_x_inst__2906_ wave_controller_x_inst__3700_/Q wave_controller_x_inst__3419_/B
+ wave_controller_x_inst__2907_/C VDD VDD VSS VSS gf180mcu_fd_sc_mcu7t5v0__nor2_1
XFILLER_29_245 VDD VDD VSS VSS gf180mcu_fd_sc_mcu7t5v0__fill_1
XFILLER_85_863 VDD VDD VSS VSS gf180mcu_fd_sc_mcu7t5v0__fillcap_4
Xwave_controller_y_inst__2853_ wave_controller_y_inst__2854_/A2 wave_controller_y_inst__2854_/A3
+ wave_controller_y_inst__2898_/A3 VDD VDD VSS VSS gf180mcu_fd_sc_mcu7t5v0__nor2_1
Xwave_controller_x_inst__2837_ wave_controller_x_inst__3078_/A1 wave_controller_x_inst__2837_/A2
+ wave_controller_x_inst__2837_/B1 wave_controller_x_inst__3080_/A1 wave_controller_x_inst__2838_/A2
+ VDD VDD VSS VSS gf180mcu_fd_sc_mcu7t5v0__oai22_1
Xwave_controller_y_inst__2784_ spi_regs_inst__1199_/A1 wave_controller_y_inst__2831_/A2
+ wave_controller_y_inst__2784_/B wave_controller_y_inst__2835_/A2 VDD VDD VSS VSS
+ gf180mcu_fd_sc_mcu7t5v0__oai21_1
Xwave_controller_y_inst__1804_ wave_controller_y_inst__3611_/Q wave_controller_y_inst__3096_/A1
+ VDD VDD VSS VSS gf180mcu_fd_sc_mcu7t5v0__clkinv_1
XFILLER_57_598 VDD VDD VSS VSS gf180mcu_fd_sc_mcu7t5v0__fill_2
XFILLER_72_524 VDD VDD VSS VSS gf180mcu_fd_sc_mcu7t5v0__fill_1
XFILLER_84_384 VDD VDD VSS VSS gf180mcu_fd_sc_mcu7t5v0__fill_1
Xwave_controller_x_inst__2768_ wave_controller_x_inst__3420_/A1 spi_regs_inst__1050_/B2
+ wave_controller_x_inst__2768_/Z VDD VDD VSS VSS gf180mcu_fd_sc_mcu7t5v0__xor2_1
XTAP_TAPCELL_ROW_55_777 VDD VSS gf180mcu_fd_sc_mcu7t5v0__filltie
Xwave_controller_x_inst__2699_ max_cap451/I spi_regs_inst__1119_/A1 wave_controller_x_inst__2699_/Z
+ VDD VDD VSS VSS gf180mcu_fd_sc_mcu7t5v0__xor2_1
XFILLER_25_484 VDD VDD VSS VSS gf180mcu_fd_sc_mcu7t5v0__fillcap_4
XTAP_TAPCELL_ROW_55_788 VDD VSS gf180mcu_fd_sc_mcu7t5v0__filltie
XTAP_TAPCELL_ROW_80_1205 VDD VSS gf180mcu_fd_sc_mcu7t5v0__filltie
Xwave_controller_y_inst__3405_ fanout389/Z spi_regs_inst__1290_/A1 wave_controller_y_inst__3406_/B
+ VDD VDD VSS VSS gf180mcu_fd_sc_mcu7t5v0__nand2_1
XFILLER_125_1116 VDD VDD VSS VSS gf180mcu_fd_sc_mcu7t5v0__fillcap_4
XFILLER_40_454 VDD VDD VSS VSS gf180mcu_fd_sc_mcu7t5v0__fill_1
XFILLER_157_139 VDD VDD VSS VSS gf180mcu_fd_sc_mcu7t5v0__fill_1
Xwave_controller_y_inst__3336_ wave_controller_y_inst__3336_/A1 wave_controller_y_inst__3336_/A2
+ wave_controller_y_inst__3345_/A3 VDD VDD VSS VSS gf180mcu_fd_sc_mcu7t5v0__nand2_1
XFILLER_32_41 VDD VDD VSS VSS gf180mcu_fd_sc_mcu7t5v0__fill_2
Xwave_controller_y_inst__3267_ wave_controller_y_inst__3713_/Q spi_regs_inst__1611_/Q
+ wave_controller_y_inst__3268_/I VDD VDD VSS VSS gf180mcu_fd_sc_mcu7t5v0__xor2_1
Xwave_controller_y_inst__2218_ wave_controller_y_inst__2226_/A1 spi_regs_inst__1316_/A1
+ wave_controller_y_inst__2239_/B VDD VDD VSS VSS gf180mcu_fd_sc_mcu7t5v0__nor2_1
XFILLER_138_397 VDD VDD VSS VSS gf180mcu_fd_sc_mcu7t5v0__fill_1
XFILLER_4_311 VDD VDD VSS VSS gf180mcu_fd_sc_mcu7t5v0__fillcap_4
XTAP_TAPCELL_ROW_78_1156 VDD VSS gf180mcu_fd_sc_mcu7t5v0__filltie
XTAP_TAPCELL_ROW_78_1167 VDD VSS gf180mcu_fd_sc_mcu7t5v0__filltie
Xwave_controller_y_inst__3198_ wave_controller_y_inst__3198_/A1 wave_controller_y_inst__3198_/A2
+ wave_controller_y_inst__3245_/A2 VDD VDD VSS VSS gf180mcu_fd_sc_mcu7t5v0__xnor2_1
XFILLER_153_389 VDD VDD VSS VSS gf180mcu_fd_sc_mcu7t5v0__fill_1
Xwave_controller_y_inst__2149_ wave_controller_y_inst__2149_/A1 wave_controller_y_inst__2149_/A2
+ wave_controller_y_inst__2149_/B wave_controller_y_inst__2151_/A2 VDD VDD VSS VSS
+ gf180mcu_fd_sc_mcu7t5v0__oai21_1
XFILLER_4_399 VDD VDD VSS VSS gf180mcu_fd_sc_mcu7t5v0__fillcap_4
XFILLER_121_220 VDD VDD VSS VSS gf180mcu_fd_sc_mcu7t5v0__fill_1
XFILLER_122_776 VDD VDD VSS VSS gf180mcu_fd_sc_mcu7t5v0__fill_2
XTAP_TAPCELL_ROW_91_1378 VDD VSS gf180mcu_fd_sc_mcu7t5v0__filltie
XFILLER_94_104 VDD VDD VSS VSS gf180mcu_fd_sc_mcu7t5v0__fill_1
XFILLER_75_340 VDD VDD VSS VSS gf180mcu_fd_sc_mcu7t5v0__fillcap_4
XPHY_EDGE_ROW_1_1_Right_0 VDD VSS gf180mcu_fd_sc_mcu7t5v0__endcap
XFILLER_90_343 VDD VDD VSS VSS gf180mcu_fd_sc_mcu7t5v0__fillcap_8
XFILLER_91_866 VDD VDD VSS VSS gf180mcu_fd_sc_mcu7t5v0__fill_2
Xspi_regs_inst__1643_ spi_regs_inst__1643_/D wire594/I clkload18/I spi_regs_inst__1643_/Q
+ VDD VDD VSS VSS gf180mcu_fd_sc_mcu7t5v0__dffrnq_1
XFILLER_16_473 VDD VDD VSS VSS gf180mcu_fd_sc_mcu7t5v0__fillcap_8
XFILLER_90_376 VDD VDD VSS VSS gf180mcu_fd_sc_mcu7t5v0__fillcap_8
XFILLER_90_387 VDD VDD VSS VSS gf180mcu_fd_sc_mcu7t5v0__fillcap_8
XFILLER_149_618 VDD VDD VSS VSS gf180mcu_fd_sc_mcu7t5v0__fillcap_8
Xspi_regs_inst__1574_ spi_regs_inst__1574_/D fanout564/Z clkbuf_leaf_9_clk/Z spi_regs_inst__1574_/Q
+ VDD VDD VSS VSS gf180mcu_fd_sc_mcu7t5v0__dffrnq_1
XFILLER_31_476 VDD VDD VSS VSS gf180mcu_fd_sc_mcu7t5v0__fillcap_8
XFILLER_129_342 VDD VDD VSS VSS gf180mcu_fd_sc_mcu7t5v0__fill_2
XFILLER_145_802 VDD VDD VSS VSS gf180mcu_fd_sc_mcu7t5v0__fillcap_4
XFILLER_104_209 VDD VDD VSS VSS gf180mcu_fd_sc_mcu7t5v0__fillcap_16
XFILLER_125_570 VDD VDD VSS VSS gf180mcu_fd_sc_mcu7t5v0__fill_1
XTAP_TAPCELL_ROW_32_1_575 VDD VSS gf180mcu_fd_sc_mcu7t5v0__filltie
XFILLER_112_231 VDD VDD VSS VSS gf180mcu_fd_sc_mcu7t5v0__fillcap_8
XFILLER_113_765 VDD VDD VSS VSS gf180mcu_fd_sc_mcu7t5v0__fillcap_4
XFILLER_140_540 VDD VDD VSS VSS gf180mcu_fd_sc_mcu7t5v0__fillcap_8
XFILLER_86_605 VDD VDD VSS VSS gf180mcu_fd_sc_mcu7t5v0__fillcap_8
XTAP_TAPCELL_ROW_129_2009 VDD VSS gf180mcu_fd_sc_mcu7t5v0__filltie
Xstate_machine_inst__38_ state_machine_inst__38_/D fanout585/Z clkbuf_leaf_14_clk/Z
+ spi_regs_inst__1058_/B2 VDD VDD VSS VSS gf180mcu_fd_sc_mcu7t5v0__dffrnq_1
Xspi_regs_inst__1008_ spi_regs_inst__1368_/A1 spi_regs_inst__1631_/Q spi_regs_inst__1008_/A3
+ spi_regs_inst__1025_/A2 VDD VDD VSS VSS gf180mcu_fd_sc_mcu7t5v0__nand3_1
XFILLER_39_510 VDD VDD VSS VSS gf180mcu_fd_sc_mcu7t5v0__fill_2
XFILLER_86_649 VDD VDD VSS VSS gf180mcu_fd_sc_mcu7t5v0__fillcap_16
XFILLER_98_487 VDD VDD VSS VSS gf180mcu_fd_sc_mcu7t5v0__fill_1
Xwave_controller_x_inst__3740_ spi_regs_inst__1033_/B2 spi_regs_inst__1034_/B2 VDD
+ VDD VSS VSS gf180mcu_fd_sc_mcu7t5v0__buf_1
XFILLER_112_297 VDD VDD VSS VSS gf180mcu_fd_sc_mcu7t5v0__fillcap_16
Xwave_controller_x_inst__3671_ wave_controller_x_inst__3671_/D wave_controller_x_inst__3701_/RN
+ clkload31/I spi_regs_inst__1112_/A1 VDD VDD VSS VSS gf180mcu_fd_sc_mcu7t5v0__dffrnq_1
XFILLER_82_800 VDD VDD VSS VSS gf180mcu_fd_sc_mcu7t5v0__fillcap_4
Xwave_controller_x_inst__2622_ fanout540/Z wave_controller_x_inst__2621_/Z wave_controller_x_inst__2643_/B
+ VDD VDD VSS VSS gf180mcu_fd_sc_mcu7t5v0__or2_1
XTAP_TAPCELL_ROW_107_1639 VDD VSS gf180mcu_fd_sc_mcu7t5v0__filltie
XTAP_TAPCELL_ROW_124_1920 VDD VSS gf180mcu_fd_sc_mcu7t5v0__filltie
XFILLER_93_192 VDD VDD VSS VSS gf180mcu_fd_sc_mcu7t5v0__fill_2
XTAP_TAPCELL_ROW_124_1931 VDD VSS gf180mcu_fd_sc_mcu7t5v0__filltie
Xwave_controller_x_inst__2553_ wave_controller_x_inst__2519_/Z wave_controller_x_inst__2553_/A2
+ wave_controller_x_inst__2553_/A3 wave_controller_x_inst__2555_/B1 VDD VDD VSS VSS
+ gf180mcu_fd_sc_mcu7t5v0__nand3_1
Xwave_controller_x_inst__2484_ wave_controller_x_inst__2481_/I wave_controller_x_inst__2509_/A2
+ wave_controller_x_inst__2498_/A1 VDD VDD VSS VSS gf180mcu_fd_sc_mcu7t5v0__nor2_1
XFILLER_139_139 VDD VDD VSS VSS gf180mcu_fd_sc_mcu7t5v0__fill_1
XTAP_TAPCELL_ROW_157_2463 VDD VSS gf180mcu_fd_sc_mcu7t5v0__filltie
XFILLER_22_487 VDD VDD VSS VSS gf180mcu_fd_sc_mcu7t5v0__fillcap_4
XFILLER_72_1081 VDD VDD VSS VSS gf180mcu_fd_sc_mcu7t5v0__fillcap_4
XTAP_TAPCELL_ROW_157_2474 VDD VSS gf180mcu_fd_sc_mcu7t5v0__filltie
Xwave_controller_y_inst__3121_ wave_controller_y_inst__3568_/A1 spi_regs_inst__1588_/Q
+ wave_controller_y_inst__3219_/C VDD VDD VSS VSS gf180mcu_fd_sc_mcu7t5v0__nor2_1
XFILLER_147_150 VDD VDD VSS VSS gf180mcu_fd_sc_mcu7t5v0__fill_1
Xwave_controller_x_inst__3105_ wave_controller_x_inst__3615_/Q wave_controller_x_inst__3105_/A2
+ wave_controller_x_inst__3257_/A1 VDD VDD VSS VSS gf180mcu_fd_sc_mcu7t5v0__nand2_1
XFILLER_108_537 VDD VDD VSS VSS gf180mcu_fd_sc_mcu7t5v0__fill_1
XFILLER_135_323 VDD VDD VSS VSS gf180mcu_fd_sc_mcu7t5v0__fill_1
XFILLER_135_345 VDD VDD VSS VSS gf180mcu_fd_sc_mcu7t5v0__fillcap_4
XFILLER_147_172 VDD VDD VSS VSS gf180mcu_fd_sc_mcu7t5v0__fill_2
XFILLER_163_632 VDD VDD VSS VSS gf180mcu_fd_sc_mcu7t5v0__fillcap_64
Xwave_controller_y_inst__3052_ wave_controller_y_inst__3290_/A1 wave_controller_y_inst__3059_/A2
+ wave_controller_y_inst__3052_/B1 wave_controller_y_inst__3052_/B2 wave_controller_y_inst__3705_/D
+ VDD VDD VSS VSS gf180mcu_fd_sc_mcu7t5v0__oai22_1
Xwave_controller_x_inst__3036_ wave_controller_x_inst__3489_/A1 wave_controller_x_inst__3036_/A2
+ wave_controller_x_inst__3035_/Z wave_controller_x_inst__3036_/B2 wave_controller_x_inst__3699_/D
+ VDD VDD VSS VSS gf180mcu_fd_sc_mcu7t5v0__oai22_1
XFILLER_135_356 VDD VDD VSS VSS gf180mcu_fd_sc_mcu7t5v0__fill_1
XFILLER_151_827 VDD VDD VSS VSS gf180mcu_fd_sc_mcu7t5v0__fillcap_8
XTAP_TAPCELL_ROW_18_1_465 VDD VSS gf180mcu_fd_sc_mcu7t5v0__filltie
Xwave_controller_y_inst__2003_ wave_controller_y_inst__2009_/A1 wave_controller_y_inst__2000_/Z
+ wave_controller_y_inst__2006_/A3 VDD VDD VSS VSS gf180mcu_fd_sc_mcu7t5v0__nor2_1
Xwave_controller_x_inst_wire115 wave_controller_x_inst_wire115/I wave_controller_x_inst_wire115/Z
+ VDD VDD VSS VSS gf180mcu_fd_sc_mcu7t5v0__clkbuf_1
XFILLER_77_605 VDD VDD VSS VSS gf180mcu_fd_sc_mcu7t5v0__fillcap_16
XFILLER_78_59 VDD VDD VSS VSS gf180mcu_fd_sc_mcu7t5v0__fill_1
XTAP_TAPCELL_ROW_73_1075 VDD VSS gf180mcu_fd_sc_mcu7t5v0__filltie
XFILLER_103_264 VDD VDD VSS VSS gf180mcu_fd_sc_mcu7t5v0__fill_1
XFILLER_131_562 VDD VDD VSS VSS gf180mcu_fd_sc_mcu7t5v0__fill_2
XFILLER_131_573 VDD VDD VSS VSS gf180mcu_fd_sc_mcu7t5v0__fill_2
XFILLER_76_115 VDD VDD VSS VSS gf180mcu_fd_sc_mcu7t5v0__fillcap_4
XTAP_TAPCELL_ROW_73_1086 VDD VSS gf180mcu_fd_sc_mcu7t5v0__filltie
XFILLER_131_595 VDD VDD VSS VSS gf180mcu_fd_sc_mcu7t5v0__fillcap_16
Xwave_controller_y_inst__2905_ wave_controller_y_inst__3700_/Q wave_controller_y_inst__3454_/A2
+ wave_controller_y_inst__2905_/ZN VDD VDD VSS VSS gf180mcu_fd_sc_mcu7t5v0__nand2_1
Xwave_controller_y_inst__2836_ wave_controller_y_inst__2838_/A1 wave_controller_y_inst__2826_/Z
+ wave_controller_y_inst__2834_/B wave_controller_y_inst__2835_/B wave_controller_y_inst__2838_/B
+ VDD VDD VSS VSS gf180mcu_fd_sc_mcu7t5v0__and4_1
XFILLER_27_52 VDD VDD VSS VSS gf180mcu_fd_sc_mcu7t5v0__fillcap_4
XFILLER_45_546 VDD VDD VSS VSS gf180mcu_fd_sc_mcu7t5v0__fillcap_8
XFILLER_57_384 VDD VDD VSS VSS gf180mcu_fd_sc_mcu7t5v0__fill_1
XFILLER_84_170 VDD VDD VSS VSS gf180mcu_fd_sc_mcu7t5v0__fillcap_4
XFILLER_84_181 VDD VDD VSS VSS gf180mcu_fd_sc_mcu7t5v0__fill_2
XFILLER_150_42 VDD VDD VSS VSS gf180mcu_fd_sc_mcu7t5v0__fillcap_16
XFILLER_27_74 VDD VDD VSS VSS gf180mcu_fd_sc_mcu7t5v0__fill_1
XFILLER_72_354 VDD VDD VSS VSS gf180mcu_fd_sc_mcu7t5v0__fill_2
XFILLER_72_365 VDD VDD VSS VSS gf180mcu_fd_sc_mcu7t5v0__fillcap_8
Xwave_controller_y_inst__2767_ wave_controller_y_inst__3420_/A1 spi_regs_inst__1054_/B2
+ wave_controller_y_inst__2882_/A1 VDD VDD VSS VSS gf180mcu_fd_sc_mcu7t5v0__nand2_1
XFILLER_60_527 VDD VDD VSS VSS gf180mcu_fd_sc_mcu7t5v0__fill_2
XFILLER_72_387 VDD VDD VSS VSS gf180mcu_fd_sc_mcu7t5v0__fillcap_8
Xwave_controller_y_inst__2698_ wave_controller_y_inst__2844_/A1 wave_controller_y_inst__3548_/B2
+ wave_controller_y_inst__2730_/A1 VDD VDD VSS VSS gf180mcu_fd_sc_mcu7t5v0__nor2_1
XFILLER_53_590 VDD VDD VSS VSS gf180mcu_fd_sc_mcu7t5v0__fill_1
XFILLER_43_84 VDD VDD VSS VSS gf180mcu_fd_sc_mcu7t5v0__fill_2
XFILLER_9_447 VDD VDD VSS VSS gf180mcu_fd_sc_mcu7t5v0__fill_1
Xwave_controller_y_inst__3319_ wave_controller_y_inst__3716_/Q wave_controller_y_inst__3332_/A2
+ wave_controller_y_inst__3320_/B VDD VDD VSS VSS gf180mcu_fd_sc_mcu7t5v0__nor2_1
Xspi_regs_inst__1290_ spi_regs_inst__1290_/A1 spi_regs_inst__1290_/A2 spi_regs_inst__1352_/A2
+ spi_regs_inst__1596_/Q spi_regs_inst__1291_/A4 VDD VDD VSS VSS gf180mcu_fd_sc_mcu7t5v0__aoi22_1
XFILLER_139_684 VDD VDD VSS VSS gf180mcu_fd_sc_mcu7t5v0__fill_2
XFILLER_167_993 VDD VDD VSS VSS gf180mcu_fd_sc_mcu7t5v0__fillcap_16
XPHY_EDGE_ROW_11_1_Left_178 VDD VSS gf180mcu_fd_sc_mcu7t5v0__endcap
XTAP_TAPCELL_ROW_93_1407 VDD VSS gf180mcu_fd_sc_mcu7t5v0__filltie
XFILLER_126_356 VDD VDD VSS VSS gf180mcu_fd_sc_mcu7t5v0__fill_2
XFILLER_153_142 VDD VDD VSS VSS gf180mcu_fd_sc_mcu7t5v0__fillcap_32
XTAP_TAPCELL_ROW_93_1418 VDD VSS gf180mcu_fd_sc_mcu7t5v0__filltie
XFILLER_4_34 VDD VDD VSS VSS gf180mcu_fd_sc_mcu7t5v0__fill_1
Xsignal_processor_y_inst__240_ signal_processor_y_inst__240_/D _17_/B _21_/CLK signal_processor_y_inst__240_/Q
+ VDD VDD VSS VSS gf180mcu_fd_sc_mcu7t5v0__dffrnq_1
XFILLER_150_871 VDD VDD VSS VSS gf180mcu_fd_sc_mcu7t5v0__fillcap_4
XFILLER_95_402 VDD VDD VSS VSS gf180mcu_fd_sc_mcu7t5v0__fill_2
XFILLER_96_947 VDD VDD VSS VSS gf180mcu_fd_sc_mcu7t5v0__fillcap_64
Xsignal_processor_y_inst__171_ signal_processor_y_inst__235_/Q signal_processor_y_inst__172_/A2
+ signal_processor_y_inst__171_/Z VDD VDD VSS VSS gf180mcu_fd_sc_mcu7t5v0__xor2_1
XFILLER_67_137 VDD VDD VSS VSS gf180mcu_fd_sc_mcu7t5v0__fill_2
XFILLER_110_779 VDD VDD VSS VSS gf180mcu_fd_sc_mcu7t5v0__fillcap_4
XFILLER_36_502 VDD VDD VSS VSS gf180mcu_fd_sc_mcu7t5v0__fillcap_4
Xwave_controller_x_inst_fanout181 wave_controller_x_inst__3039_/ZN wave_controller_x_inst__3090_/B1
+ VDD VDD VSS VSS gf180mcu_fd_sc_mcu7t5v0__dlyb_1
XFILLER_36_513 VDD VDD VSS VSS gf180mcu_fd_sc_mcu7t5v0__fillcap_8
XFILLER_48_373 VDD VDD VSS VSS gf180mcu_fd_sc_mcu7t5v0__fillcap_8
XFILLER_64_877 VDD VDD VSS VSS gf180mcu_fd_sc_mcu7t5v0__fillcap_4
XPHY_EDGE_ROW_159_Right_159 VDD VSS gf180mcu_fd_sc_mcu7t5v0__endcap
XFILLER_23_229 VDD VDD VSS VSS gf180mcu_fd_sc_mcu7t5v0__fill_1
XFILLER_51_549 VDD VDD VSS VSS gf180mcu_fd_sc_mcu7t5v0__fillcap_4
Xspi_regs_inst__1626_ spi_regs_inst__1626_/D spi_regs_inst__1659_/RN clkload8/I spi_regs_inst__1626_/Q
+ VDD VDD VSS VSS gf180mcu_fd_sc_mcu7t5v0__dffrnq_1
XFILLER_143_1046 VDD VDD VSS VSS gf180mcu_fd_sc_mcu7t5v0__fillcap_4
XFILLER_56_1087 VDD VDD VSS VSS gf180mcu_fd_sc_mcu7t5v0__fillcap_64
XFILLER_90_2 VDD VDD VSS VSS gf180mcu_fd_sc_mcu7t5v0__fillcap_8
XTAP_TAPCELL_ROW_102_1558 VDD VSS gf180mcu_fd_sc_mcu7t5v0__filltie
Xspi_regs_inst__1557_ spi_regs_inst__1557_/D fanout561/Z clkload9/I spi_regs_inst__1557_/Q
+ VDD VDD VSS VSS gf180mcu_fd_sc_mcu7t5v0__dffrnq_1
XFILLER_31_273 VDD VDD VSS VSS gf180mcu_fd_sc_mcu7t5v0__fillcap_4
XTAP_TAPCELL_ROW_139_2171 VDD VSS gf180mcu_fd_sc_mcu7t5v0__filltie
XFILLER_118_802 VDD VDD VSS VSS gf180mcu_fd_sc_mcu7t5v0__fill_2
XFILLER_118_824 VDD VDD VSS VSS gf180mcu_fd_sc_mcu7t5v0__fillcap_4
Xspi_regs_inst__1488_ spi_regs_inst__1488_/D fanout615/Z clkbuf_leaf_36_clk/Z fanout508/I
+ VDD VDD VSS VSS gf180mcu_fd_sc_mcu7t5v0__dffrnq_1
XFILLER_145_632 VDD VDD VSS VSS gf180mcu_fd_sc_mcu7t5v0__fillcap_4
XFILLER_145_643 VDD VDD VSS VSS gf180mcu_fd_sc_mcu7t5v0__fillcap_16
XFILLER_157_492 VDD VDD VSS VSS gf180mcu_fd_sc_mcu7t5v0__fillcap_16
XFILLER_8_480 VDD VDD VSS VSS gf180mcu_fd_sc_mcu7t5v0__fill_2
XFILLER_133_816 VDD VDD VSS VSS gf180mcu_fd_sc_mcu7t5v0__fillcap_4
XFILLER_160_613 VDD VDD VSS VSS gf180mcu_fd_sc_mcu7t5v0__fillcap_8
XTAP_TAPCELL_ROW_152_2382 VDD VSS gf180mcu_fd_sc_mcu7t5v0__filltie
XTAP_TAPCELL_ROW_152_2393 VDD VSS gf180mcu_fd_sc_mcu7t5v0__filltie
XFILLER_132_337 VDD VDD VSS VSS gf180mcu_fd_sc_mcu7t5v0__fillcap_16
XFILLER_99_763 VDD VDD VSS VSS gf180mcu_fd_sc_mcu7t5v0__fillcap_4
Xfanout404 _08_/ZN fanout404/Z VDD VDD VSS VSS gf180mcu_fd_sc_mcu7t5v0__dlyb_1
XFILLER_101_702 VDD VDD VSS VSS gf180mcu_fd_sc_mcu7t5v0__fill_1
XFILLER_113_562 VDD VDD VSS VSS gf180mcu_fd_sc_mcu7t5v0__fillcap_8
XFILLER_58_115 VDD VDD VSS VSS gf180mcu_fd_sc_mcu7t5v0__fill_1
XFILLER_59_627 VDD VDD VSS VSS gf180mcu_fd_sc_mcu7t5v0__fill_2
XFILLER_86_413 VDD VDD VSS VSS gf180mcu_fd_sc_mcu7t5v0__fillcap_8
XFILLER_100_212 VDD VDD VSS VSS gf180mcu_fd_sc_mcu7t5v0__fill_2
XFILLER_150_1017 VDD VDD VSS VSS gf180mcu_fd_sc_mcu7t5v0__fillcap_64
XFILLER_86_457 VDD VDD VSS VSS gf180mcu_fd_sc_mcu7t5v0__fill_1
Xwave_controller_x_inst__3723_ wave_controller_x_inst__3723_/D wave_controller_x_inst__3723_/RN
+ clkload27/I wave_controller_x_inst__3723_/Q VDD VDD VSS VSS gf180mcu_fd_sc_mcu7t5v0__dffrnq_1
Xwave_controller_x_inst__1984_ fanout521/Z spi_regs_inst__1100_/B2 wave_controller_x_inst__1985_/I
+ VDD VDD VSS VSS gf180mcu_fd_sc_mcu7t5v0__xor2_1
XFILLER_27_502 VDD VDD VSS VSS gf180mcu_fd_sc_mcu7t5v0__fill_1
XFILLER_39_340 VDD VDD VSS VSS gf180mcu_fd_sc_mcu7t5v0__fillcap_4
XTAP_TAPCELL_ROW_57_817 VDD VSS gf180mcu_fd_sc_mcu7t5v0__filltie
Xwave_controller_y_inst__3670_ wave_controller_y_inst__3670_/D fanout615/Z clkbuf_leaf_35_clk/Z
+ spi_regs_inst__1065_/B2 VDD VDD VSS VSS gf180mcu_fd_sc_mcu7t5v0__dffrnq_1
XFILLER_39_384 VDD VDD VSS VSS gf180mcu_fd_sc_mcu7t5v0__fillcap_16
XFILLER_54_321 VDD VDD VSS VSS gf180mcu_fd_sc_mcu7t5v0__fillcap_8
XFILLER_55_833 VDD VDD VSS VSS gf180mcu_fd_sc_mcu7t5v0__fill_1
XFILLER_66_181 VDD VDD VSS VSS gf180mcu_fd_sc_mcu7t5v0__fill_2
Xwave_controller_y_inst__2621_ wave_controller_y_inst__2615_/I wave_controller_y_inst_wire127/Z
+ wave_controller_y_inst__2621_/Z VDD VDD VSS VSS gf180mcu_fd_sc_mcu7t5v0__xor2_1
Xwave_controller_x_inst__3654_ wave_controller_x_inst__3654_/D wave_controller_x_inst__3706_/RN
+ clkload35/I max_cap458/I VDD VDD VSS VSS gf180mcu_fd_sc_mcu7t5v0__dffrnq_1
XPHY_EDGE_ROW_126_Right_126 VDD VSS gf180mcu_fd_sc_mcu7t5v0__endcap
Xwave_controller_x_inst__3585_ wave_controller_x_inst__3585_/I0 spi_regs_inst__1306_/A1
+ wave_controller_x_inst__3585_/S wave_controller_x_inst__3663_/D VDD VDD VSS VSS
+ gf180mcu_fd_sc_mcu7t5v0__mux2_2
Xwave_controller_x_inst__2605_ wave_controller_x_inst__2576_/I wave_controller_x_inst__2609_/A1
+ wave_controller_x_inst__2591_/Z wave_controller_x_inst__2606_/I VDD VDD VSS VSS
+ gf180mcu_fd_sc_mcu7t5v0__nor3_1
XFILLER_42_527 VDD VDD VSS VSS gf180mcu_fd_sc_mcu7t5v0__fillcap_16
XFILLER_54_387 VDD VDD VSS VSS gf180mcu_fd_sc_mcu7t5v0__fill_2
XTAP_TAPCELL_ROW_159_2503 VDD VSS gf180mcu_fd_sc_mcu7t5v0__filltie
Xwave_controller_y_inst__2552_ wave_controller_y_inst__2519_/Z wave_controller_y_inst__2553_/A2
+ wave_controller_y_inst__2553_/A3 wave_controller_y_inst__2552_/Z VDD VDD VSS VSS
+ gf180mcu_fd_sc_mcu7t5v0__and3_1
Xwave_controller_x_inst__2536_ fanout526/Z wave_controller_x_inst__2536_/A2 wave_controller_x_inst__2561_/A1
+ VDD VDD VSS VSS gf180mcu_fd_sc_mcu7t5v0__nor2_1
XFILLER_120_34 VDD VDD VSS VSS gf180mcu_fd_sc_mcu7t5v0__fill_1
XFILLER_120_45 VDD VDD VSS VSS gf180mcu_fd_sc_mcu7t5v0__fillcap_8
Xwave_controller_y_inst__2483_ wave_controller_y_inst__2482_/B wave_controller_y_inst__2483_/A2
+ wave_controller_y_inst__2483_/B1 wave_controller_y_inst__2509_/A2 spi_regs_inst_wire102/I
+ VDD VDD VSS VSS gf180mcu_fd_sc_mcu7t5v0__aoi22_1
XFILLER_22_240 VDD VDD VSS VSS gf180mcu_fd_sc_mcu7t5v0__fillcap_4
Xwave_controller_x_inst__2467_ wave_controller_x_inst__3500_/B2 wave_controller_x_inst__2467_/A2
+ wave_controller_x_inst__2467_/Z VDD VDD VSS VSS gf180mcu_fd_sc_mcu7t5v0__xor2_1
Xsignal_processor_x_inst__191_ signal_processor_x_inst__242_/Q signal_processor_x_inst__191_/A2
+ signal_processor_x_inst__185_/I signal_processor_x_inst__191_/B signal_processor_x_inst__242_/D
+ VDD VDD VSS VSS gf180mcu_fd_sc_mcu7t5v0__oai31_1
XFILLER_22_295 VDD VDD VSS VSS gf180mcu_fd_sc_mcu7t5v0__fillcap_4
XPHY_EDGE_ROW_44_1_Right_43 VDD VSS gf180mcu_fd_sc_mcu7t5v0__endcap
Xwave_controller_x_inst__2398_ wave_controller_x_inst__2399_/A1 max_cap451/Z wave_controller_x_inst__2412_/B
+ VDD VDD VSS VSS gf180mcu_fd_sc_mcu7t5v0__nor2_1
XFILLER_10_446 VDD VDD VSS VSS gf180mcu_fd_sc_mcu7t5v0__fill_1
XFILLER_10_457 VDD VDD VSS VSS gf180mcu_fd_sc_mcu7t5v0__fillcap_8
XFILLER_149_982 VDD VDD VSS VSS gf180mcu_fd_sc_mcu7t5v0__fillcap_64
XFILLER_155_418 VDD VDD VSS VSS gf180mcu_fd_sc_mcu7t5v0__fill_2
XFILLER_10_479 VDD VDD VSS VSS gf180mcu_fd_sc_mcu7t5v0__fillcap_4
XFILLER_164_941 VDD VDD VSS VSS gf180mcu_fd_sc_mcu7t5v0__fillcap_4
Xwave_controller_y_inst__3104_ wave_controller_y_inst__3098_/B fanout499/Z fanout389/Z
+ wave_controller_y_inst__3406_/A3 wave_controller_y_inst__3404_/B VDD VDD VSS VSS
+ gf180mcu_fd_sc_mcu7t5v0__nand4_1
XFILLER_135_142 VDD VDD VSS VSS gf180mcu_fd_sc_mcu7t5v0__fillcap_4
XTAP_TAPCELL_ROW_75_1115 VDD VSS gf180mcu_fd_sc_mcu7t5v0__filltie
Xwave_controller_y_inst__3035_ wave_controller_y_inst__3489_/A1 wave_controller_y_inst__3409_/A3
+ wave_controller_y_inst__3035_/Z VDD VDD VSS VSS gf180mcu_fd_sc_mcu7t5v0__xor2_1
Xwave_controller_x_inst__3019_ wave_controller_x_inst__2910_/B wave_controller_x_inst__3025_/A3
+ wave_controller_x_inst__3021_/B1 VDD VDD VSS VSS gf180mcu_fd_sc_mcu7t5v0__nand2_1
XFILLER_151_679 VDD VDD VSS VSS gf180mcu_fd_sc_mcu7t5v0__fill_1
Xwave_controller_x_inst_wire85 wave_controller_x_inst_wire85/I wave_controller_x_inst_wire85/Z
+ VDD VDD VSS VSS gf180mcu_fd_sc_mcu7t5v0__clkbuf_1
XFILLER_78_936 VDD VDD VSS VSS gf180mcu_fd_sc_mcu7t5v0__fill_2
XFILLER_78_947 VDD VDD VSS VSS gf180mcu_fd_sc_mcu7t5v0__fillcap_64
XFILLER_89_273 VDD VDD VSS VSS gf180mcu_fd_sc_mcu7t5v0__fill_1
XFILLER_64_107 VDD VDD VSS VSS gf180mcu_fd_sc_mcu7t5v0__fillcap_8
XFILLER_18_546 VDD VDD VSS VSS gf180mcu_fd_sc_mcu7t5v0__fillcap_4
XFILLER_57_181 VDD VDD VSS VSS gf180mcu_fd_sc_mcu7t5v0__fill_2
XFILLER_61_803 VDD VDD VSS VSS gf180mcu_fd_sc_mcu7t5v0__fillcap_4
XFILLER_73_652 VDD VDD VSS VSS gf180mcu_fd_sc_mcu7t5v0__fill_2
XTAP_TAPCELL_ROW_23_1_506 VDD VSS gf180mcu_fd_sc_mcu7t5v0__filltie
Xwave_controller_y_inst__2819_ wave_controller_y_inst__3163_/C wave_controller_y_inst__2819_/A2
+ wave_controller_y_inst__2816_/I wave_controller_y_inst__3305_/A1 wave_controller_y_inst__2820_/B2
+ VDD VDD VSS VSS gf180mcu_fd_sc_mcu7t5v0__aoi22_1
Xspi_regs_inst__0790_ spi_regs_inst__1541_/Q spi_regs_inst__1438_/I1 spi_regs_inst__0795_/S
+ spi_regs_inst__1541_/D VDD VDD VSS VSS gf180mcu_fd_sc_mcu7t5v0__mux2_2
XTAP_TAPCELL_ROW_0_1_2660 VDD VSS gf180mcu_fd_sc_mcu7t5v0__filltie
XTAP_TAPCELL_ROW_0_1_2671 VDD VSS gf180mcu_fd_sc_mcu7t5v0__filltie
XTAP_TAPCELL_ROW_86_1288 VDD VSS gf180mcu_fd_sc_mcu7t5v0__filltie
XFILLER_159_702 VDD VDD VSS VSS gf180mcu_fd_sc_mcu7t5v0__fillcap_64
XFILLER_72_195 VDD VDD VSS VSS gf180mcu_fd_sc_mcu7t5v0__fill_1
XTAP_TAPCELL_ROW_31_1_563 VDD VSS gf180mcu_fd_sc_mcu7t5v0__filltie
XTAP_TAPCELL_ROW_86_1299 VDD VSS gf180mcu_fd_sc_mcu7t5v0__filltie
Xspi_regs_inst__1411_ spi_regs_inst__1484_/Q spi_regs_inst__1411_/I1 spi_regs_inst__1412_/S
+ spi_regs_inst__1484_/D VDD VDD VSS VSS gf180mcu_fd_sc_mcu7t5v0__mux2_2
XFILLER_158_223 VDD VDD VSS VSS gf180mcu_fd_sc_mcu7t5v0__fillcap_16
Xspi_regs_inst__1342_ spi_regs_inst__1590_/Q spi_regs_inst__1342_/A2 spi_regs_inst__1342_/B1
+ spi_regs_inst__1342_/B2 spi_regs_inst__1344_/A2 VDD VDD VSS VSS gf180mcu_fd_sc_mcu7t5v0__aoi22_1
XFILLER_103_1052 VDD VDD VSS VSS gf180mcu_fd_sc_mcu7t5v0__fillcap_64
XFILLER_139_492 VDD VDD VSS VSS gf180mcu_fd_sc_mcu7t5v0__fillcap_16
Xspi_regs_inst__1273_ spi_regs_inst__1273_/A1 spi_regs_inst__1273_/A2 spi_regs_inst__1273_/A3
+ spi_regs_inst__1273_/A4 spi_regs_inst__1295_/A1 VDD VDD VSS VSS gf180mcu_fd_sc_mcu7t5v0__nand4_1
Xclkload25 clkload25/I clkload25/ZN VDD VDD VSS VSS gf180mcu_fd_sc_mcu7t5v0__inv_4
Xclkload14 clkload14/I clkload14/ZN VDD VDD VSS VSS gf180mcu_fd_sc_mcu7t5v0__inv_2
XFILLER_126_131 VDD VDD VSS VSS gf180mcu_fd_sc_mcu7t5v0__fillcap_4
Xclkload36 clkload36/I clkload36/ZN VDD VDD VSS VSS gf180mcu_fd_sc_mcu7t5v0__inv_2
XFILLER_114_304 VDD VDD VSS VSS gf180mcu_fd_sc_mcu7t5v0__fillcap_8
XTAP_TAPCELL_ROW_134_2090 VDD VSS gf180mcu_fd_sc_mcu7t5v0__filltie
Xspi_regs_inst_wire37 spi_regs_inst_wire37/I spi_regs_inst_wire37/Z VDD VDD VSS VSS
+ gf180mcu_fd_sc_mcu7t5v0__clkbuf_2
XFILLER_69_903 VDD VDD VSS VSS gf180mcu_fd_sc_mcu7t5v0__fillcap_4
XFILLER_79_80 VDD VDD VSS VSS gf180mcu_fd_sc_mcu7t5v0__fill_2
Xsignal_processor_y_inst__223_ signal_processor_y_inst__223_/D fanout558/Z clkload7/I
+ spi_regs_inst__1154_/B2 VDD VDD VSS VSS gf180mcu_fd_sc_mcu7t5v0__dffrnq_1
XFILLER_122_370 VDD VDD VSS VSS gf180mcu_fd_sc_mcu7t5v0__fillcap_8
XFILLER_68_446 VDD VDD VSS VSS gf180mcu_fd_sc_mcu7t5v0__fillcap_8
Xsignal_processor_y_inst__154_ signal_processor_y_inst__187_/B signal_processor_y_inst__154_/A2
+ signal_processor_y_inst__230_/D VDD VDD VSS VSS gf180mcu_fd_sc_mcu7t5v0__nor2_1
XFILLER_68_457 VDD VDD VSS VSS gf180mcu_fd_sc_mcu7t5v0__fill_1
XFILLER_68_479 VDD VDD VSS VSS gf180mcu_fd_sc_mcu7t5v0__fillcap_4
Xspi_regs_inst_fanout490 spi_regs_inst__1658_/Q spi_regs_inst__1378_/I1 VDD VDD VSS
+ VSS gf180mcu_fd_sc_mcu7t5v0__dlyb_1
XFILLER_55_129 VDD VDD VSS VSS gf180mcu_fd_sc_mcu7t5v0__fillcap_8
XFILLER_95_276 VDD VDD VSS VSS gf180mcu_fd_sc_mcu7t5v0__fillcap_4
XFILLER_95_298 VDD VDD VSS VSS gf180mcu_fd_sc_mcu7t5v0__fill_1
XFILLER_64_652 VDD VDD VSS VSS gf180mcu_fd_sc_mcu7t5v0__fillcap_8
XFILLER_97_1154 VDD VDD VSS VSS gf180mcu_fd_sc_mcu7t5v0__fillcap_16
Xspi_regs_inst__0988_ spi_regs_inst__1031_/A1 spi_regs_inst__1032_/A2 spi_regs_inst__1198_/A2
+ VDD VDD VSS VSS gf180mcu_fd_sc_mcu7t5v0__nor2_1
XFILLER_24_527 VDD VDD VSS VSS gf180mcu_fd_sc_mcu7t5v0__fill_2
XFILLER_36_387 VDD VDD VSS VSS gf180mcu_fd_sc_mcu7t5v0__fillcap_4
XFILLER_63_162 VDD VDD VSS VSS gf180mcu_fd_sc_mcu7t5v0__fillcap_8
XFILLER_51_346 VDD VDD VSS VSS gf180mcu_fd_sc_mcu7t5v0__fillcap_4
Xwave_controller_x_inst__3370_ fanout524/Z wave_controller_x_inst__3369_/Z wave_controller_x_inst__3385_/C
+ VDD VDD VSS VSS gf180mcu_fd_sc_mcu7t5v0__nand2_1
XFILLER_149_201 VDD VDD VSS VSS gf180mcu_fd_sc_mcu7t5v0__fill_2
XFILLER_149_212 VDD VDD VSS VSS gf180mcu_fd_sc_mcu7t5v0__fillcap_4
Xwave_controller_x_inst__2321_ wave_controller_x_inst__2349_/C max_cap453/Z wave_controller_x_inst__2333_/B
+ VDD VDD VSS VSS gf180mcu_fd_sc_mcu7t5v0__nor2_1
Xspi_regs_inst__1609_ spi_regs_inst__1609_/D spi_regs_inst__1610_/RN clkload13/I spi_regs_inst__1609_/Q
+ VDD VDD VSS VSS gf180mcu_fd_sc_mcu7t5v0__dffrnq_1
XTAP_TAPCELL_ROW_154_2411 VDD VSS gf180mcu_fd_sc_mcu7t5v0__filltie
XTAP_TAPCELL_ROW_62_897 VDD VSS gf180mcu_fd_sc_mcu7t5v0__filltie
Xwave_controller_x_inst__2252_ wave_controller_x_inst__2265_/A1 wave_controller_x_inst__2265_/A2
+ wave_controller_x_inst__2266_/A1 VDD VDD VSS VSS gf180mcu_fd_sc_mcu7t5v0__nor2_1
XTAP_TAPCELL_ROW_154_2422 VDD VSS gf180mcu_fd_sc_mcu7t5v0__filltie
Xwave_controller_x_inst__2183_ wave_controller_x_inst__2193_/A2 wave_controller_x_inst__2181_/Z
+ wave_controller_x_inst__2184_/I VDD VDD VSS VSS gf180mcu_fd_sc_mcu7t5v0__xor2_1
Xclkload8 clkload8/I clkload8/Z VDD VDD VSS VSS gf180mcu_fd_sc_mcu7t5v0__clkbuf_2
XFILLER_146_941 VDD VDD VSS VSS gf180mcu_fd_sc_mcu7t5v0__fillcap_4
XTAP_TAPCELL_ROW_119_1841 VDD VSS gf180mcu_fd_sc_mcu7t5v0__filltie
XFILLER_106_827 VDD VDD VSS VSS gf180mcu_fd_sc_mcu7t5v0__fill_1
XFILLER_160_421 VDD VDD VSS VSS gf180mcu_fd_sc_mcu7t5v0__fill_1
XFILLER_132_156 VDD VDD VSS VSS gf180mcu_fd_sc_mcu7t5v0__fillcap_4
XFILLER_99_582 VDD VDD VSS VSS gf180mcu_fd_sc_mcu7t5v0__fillcap_4
XTAP_TAPCELL_ROW_70_1034 VDD VSS gf180mcu_fd_sc_mcu7t5v0__filltie
XFILLER_115_67 VDD VDD VSS VSS gf180mcu_fd_sc_mcu7t5v0__fill_2
XFILLER_86_265 VDD VDD VSS VSS gf180mcu_fd_sc_mcu7t5v0__fillcap_16
XFILLER_87_788 VDD VDD VSS VSS gf180mcu_fd_sc_mcu7t5v0__fillcap_4
Xwave_controller_y_inst__1983_ wave_controller_y_inst__1986_/A2 wave_controller_y_inst__1983_/A2
+ spi_regs_inst_wire112/I VDD VDD VSS VSS gf180mcu_fd_sc_mcu7t5v0__xnor2_1
Xwave_controller_x_inst__1967_ wave_controller_x_inst__1967_/A1 wave_controller_x_inst__1967_/A2
+ wave_controller_x_inst__1966_/B wave_controller_x_inst__1967_/Z VDD VDD VSS VSS
+ gf180mcu_fd_sc_mcu7t5v0__or3_1
XFILLER_39_170 VDD VDD VSS VSS gf180mcu_fd_sc_mcu7t5v0__fill_2
XTAP_TAPCELL_ROW_165_2595 VDD VSS gf180mcu_fd_sc_mcu7t5v0__filltie
Xwave_controller_y_inst__3722_ wave_controller_y_inst__3722_/D wave_controller_y_inst__3739_/RN
+ clkload4/I wave_controller_y_inst__3722_/Q VDD VDD VSS VSS gf180mcu_fd_sc_mcu7t5v0__dffsnq_1
Xwave_controller_x_inst__3706_ wave_controller_x_inst__3706_/D wave_controller_x_inst__3706_/RN
+ clkload35/I wave_controller_x_inst__3706_/Q VDD VDD VSS VSS gf180mcu_fd_sc_mcu7t5v0__dffrnq_1
XFILLER_27_332 VDD VDD VSS VSS gf180mcu_fd_sc_mcu7t5v0__fillcap_8
Xwave_controller_y_inst__3653_ wave_controller_y_inst__3653_/D wave_controller_y_inst__3708_/RN
+ clkload21/I spi_regs_inst__1247_/A1 VDD VDD VSS VSS gf180mcu_fd_sc_mcu7t5v0__dffrnq_1
Xwave_controller_x_inst__3637_ wave_controller_x_inst__3637_/D wave_controller_x_inst__3710_/RN
+ clkbuf_leaf_31_clk/Z spi_regs_inst__1085_/C2 VDD VDD VSS VSS gf180mcu_fd_sc_mcu7t5v0__dffrnq_1
Xwave_controller_x_inst__1898_ wave_controller_x_inst__3698_/Q wave_controller_x_inst__3479_/A1
+ VDD VDD VSS VSS gf180mcu_fd_sc_mcu7t5v0__clkinv_1
XFILLER_131_55 VDD VDD VSS VSS gf180mcu_fd_sc_mcu7t5v0__fillcap_8
XFILLER_27_376 VDD VDD VSS VSS gf180mcu_fd_sc_mcu7t5v0__fill_2
XFILLER_54_151 VDD VDD VSS VSS gf180mcu_fd_sc_mcu7t5v0__fill_2
Xwave_controller_y_inst__2604_ wave_controller_y_inst__2604_/I wave_controller_y_inst__2612_/A1
+ VDD VDD VSS VSS gf180mcu_fd_sc_mcu7t5v0__clkinv_1
Xwave_controller_y_inst__3584_ wave_controller_y_inst__3584_/I0 spi_regs_inst__1275_/B2
+ wave_controller_y_inst__3584_/S wave_controller_y_inst__3662_/D VDD VDD VSS VSS
+ gf180mcu_fd_sc_mcu7t5v0__mux2_2
XFILLER_54_195 VDD VDD VSS VSS gf180mcu_fd_sc_mcu7t5v0__fill_1
Xwave_controller_y_inst__2535_ wave_controller_y_inst__2537_/A2 wave_controller_y_inst__2537_/A3
+ wave_controller_y_inst__2536_/A2 VDD VDD VSS VSS gf180mcu_fd_sc_mcu7t5v0__xnor2_1
Xwave_controller_x_inst__3568_ wave_controller_x_inst__3568_/A1 wave_controller_x_inst_wire333/Z
+ wave_controller_x_inst__3600_/I0 VDD VDD VSS VSS gf180mcu_fd_sc_mcu7t5v0__nor2_1
XFILLER_30_508 VDD VDD VSS VSS gf180mcu_fd_sc_mcu7t5v0__fillcap_4
XFILLER_42_379 VDD VDD VSS VSS gf180mcu_fd_sc_mcu7t5v0__fill_1
Xwave_controller_x_inst__3499_ max_cap467/Z wave_controller_x_inst__3538_/A2 wave_controller_x_inst__3500_/A3
+ VDD VDD VSS VSS gf180mcu_fd_sc_mcu7t5v0__nor2_1
Xwave_controller_x_inst__2519_ wave_controller_x_inst__2519_/A1 wave_controller_x_inst__2519_/A2
+ wave_controller_x_inst__2519_/Z VDD VDD VSS VSS gf180mcu_fd_sc_mcu7t5v0__and2_1
Xsignal_processor_x_inst__243_ signal_processor_x_inst__243_/D fanout587/Z clkload24/I
+ wave_controller_x_inst__1890_/I VDD VDD VSS VSS gf180mcu_fd_sc_mcu7t5v0__dffrnq_1
Xwave_controller_y_inst__2466_ spi_regs_inst__1097_/A1 wave_controller_y_inst__2467_/A2
+ wave_controller_y_inst__2482_/A1 VDD VDD VSS VSS gf180mcu_fd_sc_mcu7t5v0__nor2_1
Xsignal_processor_x_inst__174_ signal_processor_x_inst__236_/Q signal_processor_x_inst__175_/A2
+ signal_processor_x_inst__193_/A2 VDD VDD VSS VSS gf180mcu_fd_sc_mcu7t5v0__xnor2_1
XFILLER_156_705 VDD VDD VSS VSS gf180mcu_fd_sc_mcu7t5v0__fillcap_8
XFILLER_24_86 VDD VDD VSS VSS gf180mcu_fd_sc_mcu7t5v0__fillcap_16
Xwave_controller_y_inst__2397_ wave_controller_y_inst__2397_/A1 wave_controller_y_inst__2394_/Z
+ wave_controller_y_inst__2397_/B wave_controller_y_inst__2436_/A1 VDD VDD VSS VSS
+ gf180mcu_fd_sc_mcu7t5v0__oai21_1
XFILLER_109_632 VDD VDD VSS VSS gf180mcu_fd_sc_mcu7t5v0__fillcap_16
Xchip_core_664 bidir_sl[0] VDD VDD VSS VSS gf180mcu_fd_sc_mcu7t5v0__tiel
Xchip_core_653 bidir_pd[8] VDD VDD VSS VSS gf180mcu_fd_sc_mcu7t5v0__tiel
Xchip_core_642 bidir_oe[0] VDD VDD VSS VSS gf180mcu_fd_sc_mcu7t5v0__tiel
Xchip_core_631 bidir_cs[6] VDD VDD VSS VSS gf180mcu_fd_sc_mcu7t5v0__tiel
XFILLER_136_451 VDD VDD VSS VSS gf180mcu_fd_sc_mcu7t5v0__fillcap_4
XFILLER_156_30 VDD VDD VSS VSS gf180mcu_fd_sc_mcu7t5v0__fillcap_4
XFILLER_40_41 VDD VDD VSS VSS gf180mcu_fd_sc_mcu7t5v0__fill_2
XFILLER_6_247 VDD VDD VSS VSS gf180mcu_fd_sc_mcu7t5v0__fillcap_64
Xchip_core_686 bidir_oe[9] VDD VDD VSS VSS gf180mcu_fd_sc_mcu7t5v0__tieh
Xchip_core_675 bidir_cs[0] VDD VDD VSS VSS gf180mcu_fd_sc_mcu7t5v0__tieh
XFILLER_124_613 VDD VDD VSS VSS gf180mcu_fd_sc_mcu7t5v0__fillcap_4
XFILLER_108_197 VDD VDD VSS VSS gf180mcu_fd_sc_mcu7t5v0__fill_2
XFILLER_124_657 VDD VDD VSS VSS gf180mcu_fd_sc_mcu7t5v0__fillcap_8
XTAP_TAPCELL_ROW_34_1_589 VDD VSS gf180mcu_fd_sc_mcu7t5v0__filltie
Xwave_controller_y_inst__3018_ wave_controller_y_inst__3693_/Q wave_controller_y_inst__3692_/Q
+ wave_controller_y_inst__3694_/Q wave_controller_y_inst__3025_/A3 VDD VDD VSS VSS
+ gf180mcu_fd_sc_mcu7t5v0__nand3_1
Xwave_controller_y_inst_wire31 wave_controller_y_inst_wire31/I wave_controller_y_inst_wire31/Z
+ VDD VDD VSS VSS gf180mcu_fd_sc_mcu7t5v0__clkbuf_1
XFILLER_124_679 VDD VDD VSS VSS gf180mcu_fd_sc_mcu7t5v0__fill_2
XFILLER_137_1170 VDD VDD VSS VSS gf180mcu_fd_sc_mcu7t5v0__fillcap_4
XFILLER_78_733 VDD VDD VSS VSS gf180mcu_fd_sc_mcu7t5v0__fill_2
XFILLER_120_874 VDD VDD VSS VSS gf180mcu_fd_sc_mcu7t5v0__fill_1
XFILLER_78_766 VDD VDD VSS VSS gf180mcu_fd_sc_mcu7t5v0__fillcap_32
Xspi_regs_inst__0911_ spi_regs_inst__1630_/Q spi_regs_inst__0912_/A2 spi_regs_inst__0911_/B
+ spi_regs_inst__0912_/B VDD VDD VSS VSS gf180mcu_fd_sc_mcu7t5v0__aoi21_1
X_20_ _20_/D _21_/CLK _20_/Q VDD VDD VSS VSS gf180mcu_fd_sc_mcu7t5v0__dffq_1
XFILLER_18_310 VDD VDD VSS VSS gf180mcu_fd_sc_mcu7t5v0__fill_1
XTAP_TAPCELL_ROW_88_1328 VDD VSS gf180mcu_fd_sc_mcu7t5v0__filltie
XFILLER_58_490 VDD VDD VSS VSS gf180mcu_fd_sc_mcu7t5v0__fill_2
XFILLER_93_769 VDD VDD VSS VSS gf180mcu_fd_sc_mcu7t5v0__fill_1
Xspi_regs_inst__0842_ spi_regs_inst__0842_/A1 spi_regs_inst__0852_/A1 spi_regs_inst__1395_/A1
+ VDD VDD VSS VSS gf180mcu_fd_sc_mcu7t5v0__nand2_1
XFILLER_73_471 VDD VDD VSS VSS gf180mcu_fd_sc_mcu7t5v0__fill_2
Xspi_regs_inst__0773_ spi_regs_inst__1528_/Q spi_regs_inst__1447_/I1 spi_regs_inst__0780_/S
+ spi_regs_inst__1528_/D VDD VDD VSS VSS gf180mcu_fd_sc_mcu7t5v0__mux2_2
XFILLER_159_510 VDD VDD VSS VSS gf180mcu_fd_sc_mcu7t5v0__fill_1
XFILLER_60_187 VDD VDD VSS VSS gf180mcu_fd_sc_mcu7t5v0__fillcap_8
XFILLER_61_699 VDD VDD VSS VSS gf180mcu_fd_sc_mcu7t5v0__fill_1
Xspi_regs_inst__1325_ spi_regs_inst_wire90/Z spi_regs_inst__1325_/A2 spi_regs_inst__1357_/B
+ spi_regs_inst__1326_/A4 VDD VDD VSS VSS gf180mcu_fd_sc_mcu7t5v0__aoi21_1
Xspi_regs_inst__1256_ spi_regs_inst__1256_/A1 spi_regs_inst_wire222/Z spi_regs_inst__1345_/B1
+ spi_regs_inst__1256_/B2 spi_regs_inst__1258_/A3 VDD VDD VSS VSS gf180mcu_fd_sc_mcu7t5v0__aoi22_1
XTAP_TAPCELL_ROW_132_2049 VDD VSS gf180mcu_fd_sc_mcu7t5v0__filltie
Xspi_regs_inst_wire249 spi_regs_inst_wire249/I spi_regs_inst_wire249/Z VDD VDD VSS
+ VSS gf180mcu_fd_sc_mcu7t5v0__buf_2
Xspi_regs_inst_wire227 spi_regs_inst_wire227/I spi_regs_inst_wire227/Z VDD VDD VSS
+ VSS gf180mcu_fd_sc_mcu7t5v0__buf_2
Xspi_regs_inst__1187_ spi_regs_inst__1187_/A1 spi_regs_inst__1187_/A2 spi_regs_inst__1187_/A3
+ spi_regs_inst__1187_/A4 spi_regs_inst__1192_/A1 VDD VDD VSS VSS gf180mcu_fd_sc_mcu7t5v0__nand4_1
XTAP_TAPCELL_ROW_114_1760 VDD VSS gf180mcu_fd_sc_mcu7t5v0__filltie
XFILLER_102_329 VDD VDD VSS VSS gf180mcu_fd_sc_mcu7t5v0__fill_1
Xwave_controller_x_inst__2870_ wave_controller_x_inst__3697_/Q spi_regs_inst__1274_/A1
+ wave_controller_x_inst__2870_/Z VDD VDD VSS VSS gf180mcu_fd_sc_mcu7t5v0__xor2_1
Xsignal_processor_y_inst__206_ spi_regs_inst__1086_/B2 signal_processor_y_inst__212_/A2
+ signal_processor_y_inst__207_/B VDD VDD VSS VSS gf180mcu_fd_sc_mcu7t5v0__nand2_1
XFILLER_60_1017 VDD VDD VSS VSS gf180mcu_fd_sc_mcu7t5v0__fillcap_64
XFILLER_68_243 VDD VDD VSS VSS gf180mcu_fd_sc_mcu7t5v0__fill_2
XFILLER_84_714 VDD VDD VSS VSS gf180mcu_fd_sc_mcu7t5v0__fillcap_4
XFILLER_96_574 VDD VDD VSS VSS gf180mcu_fd_sc_mcu7t5v0__fill_1
Xwave_controller_x_inst__1821_ fanout540/Z wave_controller_x_inst__3209_/B VDD VDD
+ VSS VSS gf180mcu_fd_sc_mcu7t5v0__clkinv_1
XFILLER_111_896 VDD VDD VSS VSS gf180mcu_fd_sc_mcu7t5v0__fill_2
XFILLER_28_107 VDD VDD VSS VSS gf180mcu_fd_sc_mcu7t5v0__fillcap_16
XFILLER_68_298 VDD VDD VSS VSS gf180mcu_fd_sc_mcu7t5v0__fill_2
Xsignal_processor_y_inst__137_ signal_processor_y_inst__236_/Q signal_processor_y_inst__235_/Q
+ signal_processor_y_inst__138_/A4 VDD VDD VSS VSS gf180mcu_fd_sc_mcu7t5v0__nand2_1
Xinput1 bidir_in[0] input1/Z VDD VDD VSS VSS gf180mcu_fd_sc_mcu7t5v0__buf_1
XPHY_EDGE_ROW_36_1_Left_203 VDD VSS gf180mcu_fd_sc_mcu7t5v0__endcap
Xclkbuf_leaf_48_clk clkbuf_3_2__f_clk/Z clkload13/I VDD VDD VSS VSS gf180mcu_fd_sc_mcu7t5v0__clkbuf_8
XFILLER_83_268 VDD VDD VSS VSS gf180mcu_fd_sc_mcu7t5v0__fillcap_8
XTAP_TAPCELL_ROW_67_978 VDD VSS gf180mcu_fd_sc_mcu7t5v0__filltie
XTAP_TAPCELL_ROW_67_989 VDD VSS gf180mcu_fd_sc_mcu7t5v0__filltie
XFILLER_101_25 VDD VDD VSS VSS gf180mcu_fd_sc_mcu7t5v0__fill_2
XFILLER_149_1052 VDD VDD VSS VSS gf180mcu_fd_sc_mcu7t5v0__fillcap_64
XFILLER_64_493 VDD VDD VSS VSS gf180mcu_fd_sc_mcu7t5v0__fill_1
Xwave_controller_x_inst__3422_ wave_controller_x_inst__3465_/B wave_controller_x_inst__3417_/I
+ wave_controller_x_inst__3471_/B wave_controller_x_inst__3423_/B2 VDD VDD VSS VSS
+ gf180mcu_fd_sc_mcu7t5v0__oai21_1
Xwave_controller_x_inst__3353_ wave_controller_x_inst__1785_/I spi_regs_inst__1554_/Q
+ wave_controller_x_inst__3355_/B VDD VDD VSS VSS gf180mcu_fd_sc_mcu7t5v0__xor2_1
Xwave_controller_y_inst__2320_ wave_controller_y_inst__2320_/A1 wave_controller_y_inst__2320_/A2
+ wave_controller_y_inst__2320_/A3 wave_controller_y_inst__2320_/B wave_controller_y_inst_wire128/I
+ VDD VDD VSS VSS gf180mcu_fd_sc_mcu7t5v0__oai31_1
Xwave_controller_x_inst__2304_ max_cap455/Z wave_controller_x_inst__2302_/Z wave_controller_x_inst__2304_/Z
+ VDD VDD VSS VSS gf180mcu_fd_sc_mcu7t5v0__xor2_1
Xwave_controller_y_inst__2251_ wave_controller_y_inst__2249_/Z wave_controller_y_inst__2251_/A2
+ spi_regs_inst_wire91/I VDD VDD VSS VSS gf180mcu_fd_sc_mcu7t5v0__nor2_1
Xwave_controller_x_inst__3284_ wave_controller_x_inst__3703_/Q spi_regs_inst__1543_/Q
+ wave_controller_x_inst__3285_/I VDD VDD VSS VSS gf180mcu_fd_sc_mcu7t5v0__xnor2_1
XFILLER_138_749 VDD VDD VSS VSS gf180mcu_fd_sc_mcu7t5v0__fill_1
Xwave_controller_x_inst__2235_ wave_controller_x_inst__2259_/C wave_controller_x_inst__2260_/C
+ VDD VDD VSS VSS gf180mcu_fd_sc_mcu7t5v0__clkinv_1
XFILLER_118_440 VDD VDD VSS VSS gf180mcu_fd_sc_mcu7t5v0__fill_1
Xwave_controller_y_inst__2182_ max_cap429/I wave_controller_y_inst__2181_/Z wave_controller_y_inst__2201_/A2
+ VDD VDD VSS VSS gf180mcu_fd_sc_mcu7t5v0__nand2_1
Xwave_controller_x_inst__2166_ spi_regs_inst__1128_/B2 max_cap461/Z wave_controller_x_inst__2169_/B
+ VDD VDD VSS VSS gf180mcu_fd_sc_mcu7t5v0__xnor2_1
XFILLER_3_206 VDD VDD VSS VSS gf180mcu_fd_sc_mcu7t5v0__fillcap_4
Xwave_controller_x_inst__2097_ wave_controller_x_inst__2058_/C wave_controller_x_inst__2049_/Z
+ wave_controller_x_inst__2098_/B VDD VDD VSS VSS gf180mcu_fd_sc_mcu7t5v0__nand2_1
XFILLER_105_112 VDD VDD VSS VSS gf180mcu_fd_sc_mcu7t5v0__fill_1
XFILLER_105_156 VDD VDD VSS VSS gf180mcu_fd_sc_mcu7t5v0__fill_1
XFILLER_121_627 VDD VDD VSS VSS gf180mcu_fd_sc_mcu7t5v0__fill_2
XFILLER_126_33 VDD VDD VSS VSS gf180mcu_fd_sc_mcu7t5v0__fill_2
XFILLER_133_465 VDD VDD VSS VSS gf180mcu_fd_sc_mcu7t5v0__fill_2
Xwave_controller_y_inst_fanout136 wave_controller_y_inst_wire139/I wave_controller_y_inst__3554_/B1
+ VDD VDD VSS VSS gf180mcu_fd_sc_mcu7t5v0__dlyb_1
XFILLER_86_37 VDD VDD VSS VSS gf180mcu_fd_sc_mcu7t5v0__fillcap_8
XTAP_TAPCELL_ROW_167_2635 VDD VSS gf180mcu_fd_sc_mcu7t5v0__filltie
XTAP_TAPCELL_ROW_167_2646 VDD VSS gf180mcu_fd_sc_mcu7t5v0__filltie
XTAP_TAPCELL_ROW_167_2657 VDD VSS gf180mcu_fd_sc_mcu7t5v0__filltie
XFILLER_102_874 VDD VDD VSS VSS gf180mcu_fd_sc_mcu7t5v0__fill_1
XFILLER_75_714 VDD VDD VSS VSS gf180mcu_fd_sc_mcu7t5v0__fillcap_4
Xwave_controller_y_inst__1966_ wave_controller_y_inst__1967_/A1 wave_controller_y_inst__1967_/A2
+ wave_controller_y_inst__1966_/B wave_controller_y_inst__1973_/A2 VDD VDD VSS VSS
+ gf180mcu_fd_sc_mcu7t5v0__oai21_1
Xwave_controller_x_inst__2999_ wave_controller_x_inst__2987_/Z wave_controller_x_inst__2990_/Z
+ wave_controller_x_inst__3001_/A3 wave_controller_x_inst__3000_/A3 VDD VDD VSS VSS
+ gf180mcu_fd_sc_mcu7t5v0__nor3_1
XFILLER_142_65 VDD VDD VSS VSS gf180mcu_fd_sc_mcu7t5v0__fill_1
XFILLER_47_449 VDD VDD VSS VSS gf180mcu_fd_sc_mcu7t5v0__fill_1
XFILLER_75_769 VDD VDD VSS VSS gf180mcu_fd_sc_mcu7t5v0__fill_1
Xwave_controller_y_inst__3705_ wave_controller_y_inst__3705_/D wave_controller_y_inst__3708_/RN
+ clkload21/I wave_controller_y_inst__3705_/Q VDD VDD VSS VSS gf180mcu_fd_sc_mcu7t5v0__dffrnq_1
Xclkbuf_leaf_39_clk clkbuf_3_6__f_clk/Z clkbuf_leaf_39_clk/Z VDD VDD VSS VSS gf180mcu_fd_sc_mcu7t5v0__clkbuf_8
XFILLER_27_162 VDD VDD VSS VSS gf180mcu_fd_sc_mcu7t5v0__fill_1
XPHY_EDGE_ROW_20_1_Left_187 VDD VSS gf180mcu_fd_sc_mcu7t5v0__endcap
Xwave_controller_y_inst__1897_ wave_controller_y_inst__3696_/Q wave_controller_y_inst__3458_/A1
+ VDD VDD VSS VSS gf180mcu_fd_sc_mcu7t5v0__clkinv_1
Xwave_controller_y_inst__3636_ wave_controller_y_inst__3636_/D load_slew576/Z clkload19/I
+ spi_regs_inst__1045_/B2 VDD VDD VSS VSS gf180mcu_fd_sc_mcu7t5v0__dffrnq_1
XTAP_TAPCELL_ROW_83_1247 VDD VSS gf180mcu_fd_sc_mcu7t5v0__filltie
Xwave_controller_y_inst__3567_ wave_controller_y_inst_wire48/Z wave_controller_y_inst__3599_/A2
+ wave_controller_y_inst__3567_/B wave_controller_y_inst__3653_/D VDD VDD VSS VSS
+ gf180mcu_fd_sc_mcu7t5v0__oai21_1
XFILLER_128_1169 VDD VDD VSS VSS gf180mcu_fd_sc_mcu7t5v0__fill_1
XFILLER_42_165 VDD VDD VSS VSS gf180mcu_fd_sc_mcu7t5v0__fillcap_8
Xwave_controller_y_inst__2518_ wave_controller_y_inst__3566_/A1 wave_controller_y_inst__3509_/B2
+ wave_controller_y_inst__2518_/A3 wave_controller_y_inst__2519_/A2 VDD VDD VSS VSS
+ gf180mcu_fd_sc_mcu7t5v0__nand3_1
Xwave_controller_y_inst__3498_ wave_controller_y_inst__3702_/Q wave_controller_y_inst__3528_/A2
+ wave_controller_y_inst__3500_/A2 VDD VDD VSS VSS gf180mcu_fd_sc_mcu7t5v0__nor2_1
Xsignal_processor_x_inst__226_ signal_processor_x_inst__226_/D fanout583/Z clkload10/I
+ spi_regs_inst__1119_/B2 VDD VDD VSS VSS gf180mcu_fd_sc_mcu7t5v0__dffrnq_1
Xwave_controller_y_inst__2449_ wave_controller_y_inst__2446_/B wave_controller_y_inst__2449_/A2
+ wave_controller_y_inst__2449_/B1 wave_controller_y_inst__2449_/B2 wave_controller_y_inst__2449_/C
+ wave_controller_y_inst__2450_/A3 VDD VDD VSS VSS gf180mcu_fd_sc_mcu7t5v0__oai221_1
Xsignal_processor_x_inst__157_ signal_processor_x_inst__231_/Q signal_processor_x_inst__158_/A2
+ signal_processor_x_inst__192_/A1 VDD VDD VSS VSS gf180mcu_fd_sc_mcu7t5v0__xnor2_1
Xwire454 wire454/I wire454/Z VDD VDD VSS VSS gf180mcu_fd_sc_mcu7t5v0__buf_3
Xspi_regs_inst__1110_ spi_regs_inst__1563_/Q spi_regs_inst__1207_/A2 spi_regs_inst__1240_/A2
+ spi_regs_inst__1592_/Q spi_regs_inst__1114_/A4 VDD VDD VSS VSS gf180mcu_fd_sc_mcu7t5v0__aoi22_1
XFILLER_100_1011 VDD VDD VSS VSS gf180mcu_fd_sc_mcu7t5v0__fillcap_4
XTAP_TAPCELL_ROW_98_1490 VDD VSS gf180mcu_fd_sc_mcu7t5v0__filltie
XFILLER_125_966 VDD VDD VSS VSS gf180mcu_fd_sc_mcu7t5v0__fillcap_8
XFILLER_164_590 VDD VDD VSS VSS gf180mcu_fd_sc_mcu7t5v0__fillcap_4
XTAP_TAPCELL_ROW_16_1_452 VDD VSS gf180mcu_fd_sc_mcu7t5v0__filltie
Xspi_regs_inst__1041_ spi_regs_inst__1478_/Q spi_regs_inst__1314_/A2 spi_regs_inst__1224_/A2
+ spi_regs_inst__1041_/B2 spi_regs_inst__1070_/A2 VDD VDD VSS VSS gf180mcu_fd_sc_mcu7t5v0__aoi22_1
XFILLER_140_947 VDD VDD VSS VSS gf180mcu_fd_sc_mcu7t5v0__fillcap_64
XFILLER_152_796 VDD VDD VSS VSS gf180mcu_fd_sc_mcu7t5v0__fillcap_8
XTAP_TAPCELL_ROW_64_926 VDD VSS gf180mcu_fd_sc_mcu7t5v0__filltie
Xspi_regs_inst__0825_ spi_regs_inst__1444_/I1 spi_regs_inst__1568_/Q spi_regs_inst__0826_/S
+ spi_regs_inst__1568_/D VDD VDD VSS VSS gf180mcu_fd_sc_mcu7t5v0__mux2_2
XTAP_TAPCELL_ROW_64_937 VDD VSS gf180mcu_fd_sc_mcu7t5v0__filltie
XFILLER_94_1157 VDD VDD VSS VSS gf180mcu_fd_sc_mcu7t5v0__fillcap_16
Xspi_regs_inst__0756_ spi_regs_inst__1655_/Q spi_regs_inst__1654_/Q spi_regs_inst__1656_/Q
+ spi_regs_inst__0798_/A3 VDD VDD VSS VSS gf180mcu_fd_sc_mcu7t5v0__nor3_1
XFILLER_21_349 VDD VDD VSS VSS gf180mcu_fd_sc_mcu7t5v0__fill_1
XFILLER_162_505 VDD VDD VSS VSS gf180mcu_fd_sc_mcu7t5v0__fillcap_4
Xwave_controller_x_inst__2020_ fanout532/Z wave_controller_x_inst__2399_/A1 wave_controller_x_inst__2024_/A3
+ VDD VDD VSS VSS gf180mcu_fd_sc_mcu7t5v0__nor2_1
Xspi_regs_inst__1308_ _09_/A2 spi_regs_inst_wire263/Z spi_regs_inst__1308_/B1 spi_regs_inst__1308_/B2
+ spi_regs_inst__1323_/A1 VDD VDD VSS VSS gf180mcu_fd_sc_mcu7t5v0__aoi22_1
XFILLER_162_527 VDD VDD VSS VSS gf180mcu_fd_sc_mcu7t5v0__fillcap_32
Xspi_regs_inst__1239_ spi_regs_inst__1239_/A1 spi_regs_inst__1333_/A2 spi_regs_inst_wire286/I
+ spi_regs_inst__1603_/Q spi_regs_inst__1242_/A2 VDD VDD VSS VSS gf180mcu_fd_sc_mcu7t5v0__aoi22_1
XFILLER_103_605 VDD VDD VSS VSS gf180mcu_fd_sc_mcu7t5v0__fill_1
XFILLER_143_763 VDD VDD VSS VSS gf180mcu_fd_sc_mcu7t5v0__fillcap_4
XTAP_TAPCELL_ROW_112_1719 VDD VSS gf180mcu_fd_sc_mcu7t5v0__filltie
XFILLER_88_338 VDD VDD VSS VSS gf180mcu_fd_sc_mcu7t5v0__fill_2
XTAP_TAPCELL_ROW_149_2332 VDD VSS gf180mcu_fd_sc_mcu7t5v0__filltie
XTAP_TAPCELL_ROW_149_2343 VDD VSS gf180mcu_fd_sc_mcu7t5v0__filltie
Xwave_controller_x_inst__2922_ wave_controller_x_inst__3081_/B wave_controller_x_inst__3406_/A1
+ wave_controller_x_inst__3082_/B VDD VDD VSS VSS gf180mcu_fd_sc_mcu7t5v0__nor2_1
XFILLER_130_457 VDD VDD VSS VSS gf180mcu_fd_sc_mcu7t5v0__fillcap_16
Xwave_controller_x_inst__2853_ wave_controller_x_inst__2854_/A2 wave_controller_x_inst__2854_/A3
+ wave_controller_x_inst__2898_/A3 VDD VDD VSS VSS gf180mcu_fd_sc_mcu7t5v0__nor2_1
XFILLER_69_596 VDD VDD VSS VSS gf180mcu_fd_sc_mcu7t5v0__fill_1
XFILLER_84_511 VDD VDD VSS VSS gf180mcu_fd_sc_mcu7t5v0__fillcap_8
Xwave_controller_y_inst__1820_ fanout517/Z wave_controller_y_inst__3391_/A1 VDD VDD
+ VSS VSS gf180mcu_fd_sc_mcu7t5v0__clkinv_1
Xwave_controller_x_inst__1804_ wave_controller_x_inst__3611_/Q wave_controller_x_inst__3096_/A1
+ VDD VDD VSS VSS gf180mcu_fd_sc_mcu7t5v0__clkinv_1
XFILLER_110_181 VDD VDD VSS VSS gf180mcu_fd_sc_mcu7t5v0__fill_2
XFILLER_111_693 VDD VDD VSS VSS gf180mcu_fd_sc_mcu7t5v0__fill_2
XFILLER_99_1046 VDD VDD VSS VSS gf180mcu_fd_sc_mcu7t5v0__fillcap_4
XTAP_TAPCELL_ROW_162_2543 VDD VSS gf180mcu_fd_sc_mcu7t5v0__filltie
XTAP_TAPCELL_ROW_162_2554 VDD VSS gf180mcu_fd_sc_mcu7t5v0__filltie
Xwave_controller_x_inst__2784_ wire454/Z wave_controller_x_inst__2793_/S wave_controller_x_inst__2784_/B
+ wave_controller_x_inst__2835_/A2 VDD VDD VSS VSS gf180mcu_fd_sc_mcu7t5v0__oai21_1
XFILLER_72_717 VDD VDD VSS VSS gf180mcu_fd_sc_mcu7t5v0__fill_1
XFILLER_53_920 VDD VDD VSS VSS gf180mcu_fd_sc_mcu7t5v0__fillcap_32
XTAP_TAPCELL_ROW_127_1973 VDD VSS gf180mcu_fd_sc_mcu7t5v0__filltie
XTAP_TAPCELL_ROW_33_1_577 VDD VSS gf180mcu_fd_sc_mcu7t5v0__filltie
Xwave_controller_y_inst__3421_ wave_controller_y_inst__3417_/I wave_controller_y_inst__3441_/A1
+ wave_controller_y_inst__3421_/B wave_controller_y_inst__3421_/C wave_controller_y_inst__3423_/B1
+ VDD VDD VSS VSS gf180mcu_fd_sc_mcu7t5v0__aoi211_1
Xwave_controller_x_inst__3405_ fanout397/Z spi_regs_inst__1261_/A1 wave_controller_x_inst__3406_/B
+ VDD VDD VSS VSS gf180mcu_fd_sc_mcu7t5v0__nand2_1
Xwave_controller_y_inst__3352_ wave_controller_y_inst__3318_/Z wave_controller_y_inst__3352_/A2
+ wave_controller_y_inst__3352_/B wave_controller_y_inst__3396_/A1 VDD VDD VSS VSS
+ gf180mcu_fd_sc_mcu7t5v0__aoi21_1
Xwave_controller_y_inst__2303_ spi_regs_inst__1139_/B2 wave_controller_y_inst__2302_/Z
+ wave_controller_y_inst__2303_/Z VDD VDD VSS VSS gf180mcu_fd_sc_mcu7t5v0__and2_1
Xwave_controller_x_inst__3336_ wave_controller_x_inst__3336_/A1 wave_controller_x_inst__3336_/A2
+ wave_controller_x_inst__3345_/A3 VDD VDD VSS VSS gf180mcu_fd_sc_mcu7t5v0__nand2_1
Xwave_controller_y_inst__3283_ wave_controller_y_inst__2797_/C spi_regs_inst__1599_/Q
+ wave_controller_y_inst__3283_/B wave_controller_y_inst__3286_/A2 VDD VDD VSS VSS
+ gf180mcu_fd_sc_mcu7t5v0__oai21_1
Xwave_controller_x_inst__3267_ wave_controller_x_inst__3713_/Q spi_regs_inst__1553_/Q
+ wave_controller_x_inst__3268_/I VDD VDD VSS VSS gf180mcu_fd_sc_mcu7t5v0__xor2_1
XFILLER_166_877 VDD VDD VSS VSS gf180mcu_fd_sc_mcu7t5v0__fillcap_64
Xwave_controller_y_inst__2234_ wave_controller_y_inst__2236_/A1 spi_regs_inst__1353_/A1
+ wave_controller_y_inst__2259_/C VDD VDD VSS VSS gf180mcu_fd_sc_mcu7t5v0__nand2_1
Xwave_controller_x_inst__2218_ wave_controller_x_inst__2226_/A1 spi_regs_inst__1320_/A1
+ wave_controller_x_inst__2239_/B VDD VDD VSS VSS gf180mcu_fd_sc_mcu7t5v0__nor2_1
XFILLER_125_218 VDD VDD VSS VSS gf180mcu_fd_sc_mcu7t5v0__fill_1
Xwave_controller_y_inst__2165_ spi_regs_inst__1159_/A1 wave_controller_y_inst__2193_/A2
+ wave_controller_y_inst__2176_/A1 VDD VDD VSS VSS gf180mcu_fd_sc_mcu7t5v0__nand2_1
Xwave_controller_x_inst__3198_ wave_controller_x_inst__3198_/A1 wave_controller_x_inst__3198_/A2
+ wave_controller_x_inst__3245_/A2 VDD VDD VSS VSS gf180mcu_fd_sc_mcu7t5v0__xnor2_1
XFILLER_97_14 VDD VDD VSS VSS gf180mcu_fd_sc_mcu7t5v0__fill_2
Xwave_controller_x_inst__2149_ wave_controller_x_inst__2149_/A1 wave_controller_x_inst__2149_/A2
+ wave_controller_x_inst__2149_/B wave_controller_x_inst__2151_/A2 VDD VDD VSS VSS
+ gf180mcu_fd_sc_mcu7t5v0__oai21_1
XFILLER_106_476 VDD VDD VSS VSS gf180mcu_fd_sc_mcu7t5v0__fill_1
XFILLER_107_977 VDD VDD VSS VSS gf180mcu_fd_sc_mcu7t5v0__fill_2
XFILLER_97_25 VDD VDD VSS VSS gf180mcu_fd_sc_mcu7t5v0__fillcap_4
Xwave_controller_y_inst__2096_ wave_controller_y_inst__2079_/B wave_controller_y_inst__2096_/A2
+ wave_controller_y_inst__2098_/A2 VDD VDD VSS VSS gf180mcu_fd_sc_mcu7t5v0__nand2_1
XFILLER_121_413 VDD VDD VSS VSS gf180mcu_fd_sc_mcu7t5v0__fillcap_4
XFILLER_122_947 VDD VDD VSS VSS gf180mcu_fd_sc_mcu7t5v0__fillcap_64
XFILLER_88_872 VDD VDD VSS VSS gf180mcu_fd_sc_mcu7t5v0__fill_2
Xwave_controller_x_inst_fanout533 fanout532/I wave_controller_x_inst__2939_/A2 VDD
+ VDD VSS VSS gf180mcu_fd_sc_mcu7t5v0__dlyb_1
Xwave_controller_x_inst_fanout522 fanout521/I wave_controller_x_inst__3238_/A1 VDD
+ VDD VSS VSS gf180mcu_fd_sc_mcu7t5v0__dlyb_1
XFILLER_102_660 VDD VDD VSS VSS gf180mcu_fd_sc_mcu7t5v0__fillcap_4
XFILLER_134_1151 VDD VDD VSS VSS gf180mcu_fd_sc_mcu7t5v0__fillcap_4
XFILLER_75_500 VDD VDD VSS VSS gf180mcu_fd_sc_mcu7t5v0__fill_2
Xwave_controller_y_inst__2998_ wave_controller_y_inst__2938_/Z wave_controller_y_inst__2998_/A2
+ wave_controller_y_inst__2942_/Z wave_controller_y_inst__3001_/A3 VDD VDD VSS VSS
+ gf180mcu_fd_sc_mcu7t5v0__nand3_1
Xwave_controller_x_inst_fanout599 fanout601/Z wave_controller_x_inst__3735_/RN VDD
+ VDD VSS VSS gf180mcu_fd_sc_mcu7t5v0__dlyb_1
XFILLER_35_419 VDD VDD VSS VSS gf180mcu_fd_sc_mcu7t5v0__fill_1
Xwave_controller_y_inst__1949_ wave_controller_y_inst__3010_/B wave_controller_y_inst__3737_/Q
+ wave_controller_y_inst__3738_/D VDD VDD VSS VSS gf180mcu_fd_sc_mcu7t5v0__and2_1
XFILLER_55_290 VDD VDD VSS VSS gf180mcu_fd_sc_mcu7t5v0__fillcap_4
Xwave_controller_y_inst__3619_ wave_controller_y_inst__3619_/D wave_controller_y_inst__3696_/RN
+ clkbuf_leaf_46_clk/Z wire434/I VDD VDD VSS VSS gf180mcu_fd_sc_mcu7t5v0__dffrnq_1
Xspi_regs_inst__1590_ spi_regs_inst__1590_/D spi_regs_inst__1649_/RN clkload18/I spi_regs_inst__1590_/Q
+ VDD VDD VSS VSS gf180mcu_fd_sc_mcu7t5v0__dffrnq_1
XTAP_TAPCELL_ROW_9_1_402 VDD VSS gf180mcu_fd_sc_mcu7t5v0__filltie
XFILLER_43_496 VDD VDD VSS VSS gf180mcu_fd_sc_mcu7t5v0__fill_1
XFILLER_71_772 VDD VDD VSS VSS gf180mcu_fd_sc_mcu7t5v0__fill_1
XFILLER_15_198 VDD VDD VSS VSS gf180mcu_fd_sc_mcu7t5v0__fill_1
XFILLER_129_524 VDD VDD VSS VSS gf180mcu_fd_sc_mcu7t5v0__fill_1
XFILLER_141_1122 VDD VDD VSS VSS gf180mcu_fd_sc_mcu7t5v0__fillcap_32
XFILLER_156_321 VDD VDD VSS VSS gf180mcu_fd_sc_mcu7t5v0__fillcap_32
XFILLER_30_168 VDD VDD VSS VSS gf180mcu_fd_sc_mcu7t5v0__fill_2
Xsignal_processor_x_inst__209_ signal_processor_x_inst__211_/A1 signal_processor_x_inst__209_/A2
+ signal_processor_x_inst__209_/B signal_processor_x_inst__223_/D VDD VDD VSS VSS
+ gf180mcu_fd_sc_mcu7t5v0__oai21_1
XFILLER_7_342 VDD VDD VSS VSS gf180mcu_fd_sc_mcu7t5v0__fill_1
XFILLER_144_527 VDD VDD VSS VSS gf180mcu_fd_sc_mcu7t5v0__fillcap_16
XFILLER_156_387 VDD VDD VSS VSS gf180mcu_fd_sc_mcu7t5v0__fillcap_4
XFILLER_109_270 VDD VDD VSS VSS gf180mcu_fd_sc_mcu7t5v0__fillcap_8
XFILLER_152_560 VDD VDD VSS VSS gf180mcu_fd_sc_mcu7t5v0__fill_1
Xspi_regs_inst__1024_ spi_regs_inst__1024_/A1 spi_regs_inst__1027_/A1 spi_regs_inst__1225_/A2
+ VDD VDD VSS VSS gf180mcu_fd_sc_mcu7t5v0__nor2_1
XFILLER_125_796 VDD VDD VSS VSS gf180mcu_fd_sc_mcu7t5v0__fill_1
XPHY_EDGE_ROW_5_1_Left_172 VDD VSS gf180mcu_fd_sc_mcu7t5v0__endcap
XFILLER_16_2 VDD VDD VSS VSS gf180mcu_fd_sc_mcu7t5v0__fillcap_32
XFILLER_94_897 VDD VDD VSS VSS gf180mcu_fd_sc_mcu7t5v0__fill_1
XTAP_TAPCELL_ROW_144_2251 VDD VSS gf180mcu_fd_sc_mcu7t5v0__filltie
XFILLER_53_216 VDD VDD VSS VSS gf180mcu_fd_sc_mcu7t5v0__fillcap_8
XTAP_TAPCELL_ROW_109_1670 VDD VSS gf180mcu_fd_sc_mcu7t5v0__filltie
XTAP_TAPCELL_ROW_109_1681 VDD VSS gf180mcu_fd_sc_mcu7t5v0__filltie
XFILLER_146_1011 VDD VDD VSS VSS gf180mcu_fd_sc_mcu7t5v0__fillcap_4
XFILLER_59_1052 VDD VDD VSS VSS gf180mcu_fd_sc_mcu7t5v0__fillcap_64
Xspi_regs_inst__0808_ spi_regs_inst__1654_/Q spi_regs_inst__0808_/A2 spi_regs_inst__0808_/A3
+ spi_regs_inst__0862_/A2 VDD VDD VSS VSS gf180mcu_fd_sc_mcu7t5v0__nand3_1
XFILLER_34_485 VDD VDD VSS VSS gf180mcu_fd_sc_mcu7t5v0__fillcap_4
Xspi_regs_inst__0739_ spi_regs_inst__1632_/Q spi_regs_inst__1372_/A1 VDD VDD VSS VSS
+ gf180mcu_fd_sc_mcu7t5v0__clkinv_1
XFILLER_166_107 VDD VDD VSS VSS gf180mcu_fd_sc_mcu7t5v0__fillcap_64
XTAP_TAPCELL_ROW_122_1892 VDD VSS gf180mcu_fd_sc_mcu7t5v0__filltie
Xwave_controller_x_inst__3121_ wave_controller_x_inst__3568_/A1 spi_regs_inst__1525_/Q
+ wave_controller_x_inst__3219_/C VDD VDD VSS VSS gf180mcu_fd_sc_mcu7t5v0__nor2_1
XFILLER_148_877 VDD VDD VSS VSS gf180mcu_fd_sc_mcu7t5v0__fillcap_64
Xwave_controller_x_inst__3052_ wave_controller_x_inst__3290_/A1 wave_controller_x_inst__3069_/B1
+ wave_controller_x_inst__3052_/B1 wave_controller_x_inst__3052_/B2 wave_controller_x_inst__3705_/D
+ VDD VDD VSS VSS gf180mcu_fd_sc_mcu7t5v0__oai22_1
XFILLER_147_376 VDD VDD VSS VSS gf180mcu_fd_sc_mcu7t5v0__fillcap_4
XFILLER_163_836 VDD VDD VSS VSS gf180mcu_fd_sc_mcu7t5v0__fillcap_4
Xwave_controller_x_inst__2003_ wave_controller_x_inst__2009_/A1 wave_controller_x_inst__2000_/Z
+ wave_controller_x_inst__2006_/A3 VDD VDD VSS VSS gf180mcu_fd_sc_mcu7t5v0__nor2_1
XFILLER_104_947 VDD VDD VSS VSS gf180mcu_fd_sc_mcu7t5v0__fillcap_64
XFILLER_115_295 VDD VDD VSS VSS gf180mcu_fd_sc_mcu7t5v0__fillcap_8
XFILLER_118_1157 VDD VDD VSS VSS gf180mcu_fd_sc_mcu7t5v0__fillcap_16
Xwave_controller_y_inst__2921_ wave_controller_y_inst__2923_/S wave_controller_y_inst__3587_/A1
+ wave_controller_y_inst__2921_/B wave_controller_y_inst__3685_/D VDD VDD VSS VSS
+ gf180mcu_fd_sc_mcu7t5v0__oai21_1
Xwave_controller_x_inst__2905_ wave_controller_x_inst__3700_/Q wave_controller_x_inst__3454_/A2
+ wave_controller_x_inst__2905_/ZN VDD VDD VSS VSS gf180mcu_fd_sc_mcu7t5v0__nand2_1
XFILLER_131_788 VDD VDD VSS VSS gf180mcu_fd_sc_mcu7t5v0__fillcap_8
XFILLER_97_691 VDD VDD VSS VSS gf180mcu_fd_sc_mcu7t5v0__fillcap_8
Xwave_controller_y_inst__2852_ wave_controller_y_inst__2852_/A1 wave_controller_y_inst__2852_/A2
+ wave_controller_y_inst__2852_/B wave_controller_y_inst__2854_/A3 VDD VDD VSS VSS
+ gf180mcu_fd_sc_mcu7t5v0__aoi21_1
Xwave_controller_x_inst__2836_ wave_controller_x_inst__2838_/A1 wave_controller_x_inst__2826_/Z
+ wave_controller_x_inst__2834_/B wave_controller_x_inst__2835_/B wave_controller_x_inst__2838_/B
+ VDD VDD VSS VSS gf180mcu_fd_sc_mcu7t5v0__and4_1
XFILLER_85_875 VDD VDD VSS VSS gf180mcu_fd_sc_mcu7t5v0__fillcap_32
Xwave_controller_y_inst__2783_ wave_controller_y_inst__3530_/B2 wave_controller_y_inst__2831_/A2
+ wave_controller_y_inst__2784_/B VDD VDD VSS VSS gf180mcu_fd_sc_mcu7t5v0__nand2_1
Xwave_controller_y_inst__1803_ wave_controller_y_inst__3614_/Q wave_controller_y_inst__3102_/A1
+ VDD VDD VSS VSS gf180mcu_fd_sc_mcu7t5v0__clkinv_1
Xwave_controller_x_inst__2767_ wave_controller_x_inst__3420_/A1 spi_regs_inst__1050_/B2
+ wave_controller_x_inst__2882_/A1 VDD VDD VSS VSS gf180mcu_fd_sc_mcu7t5v0__nand2_1
XFILLER_44_238 VDD VDD VSS VSS gf180mcu_fd_sc_mcu7t5v0__fillcap_4
XFILLER_84_374 VDD VDD VSS VSS gf180mcu_fd_sc_mcu7t5v0__fillcap_8
XFILLER_25_452 VDD VDD VSS VSS gf180mcu_fd_sc_mcu7t5v0__fill_2
XFILLER_37_290 VDD VDD VSS VSS gf180mcu_fd_sc_mcu7t5v0__fillcap_4
XFILLER_53_750 VDD VDD VSS VSS gf180mcu_fd_sc_mcu7t5v0__fillcap_32
Xwave_controller_x_inst__2698_ max_cap451/I wave_controller_x_inst__3548_/B2 wave_controller_x_inst__2730_/A1
+ VDD VDD VSS VSS gf180mcu_fd_sc_mcu7t5v0__nor2_1
XTAP_TAPCELL_ROW_55_778 VDD VSS gf180mcu_fd_sc_mcu7t5v0__filltie
XTAP_TAPCELL_ROW_55_789 VDD VSS gf180mcu_fd_sc_mcu7t5v0__filltie
Xwave_controller_y_inst__3404_ wave_controller_y_inst__3404_/A1 wave_controller_y_inst__3404_/A2
+ wave_controller_y_inst__3404_/B wave_controller_y_inst__3616_/D VDD VDD VSS VSS
+ gf180mcu_fd_sc_mcu7t5v0__aoi21_1
XFILLER_12_135 VDD VDD VSS VSS gf180mcu_fd_sc_mcu7t5v0__fill_2
XFILLER_138_310 VDD VDD VSS VSS gf180mcu_fd_sc_mcu7t5v0__fillcap_4
XFILLER_139_811 VDD VDD VSS VSS gf180mcu_fd_sc_mcu7t5v0__fillcap_4
Xwave_controller_y_inst__3335_ wave_controller_y_inst__3336_/A1 wave_controller_y_inst__3336_/A2
+ wave_controller_y_inst__3335_/Z VDD VDD VSS VSS gf180mcu_fd_sc_mcu7t5v0__and2_1
Xwave_controller_x_inst__3319_ wave_controller_x_inst__1781_/I wave_controller_x_inst__3332_/A2
+ wave_controller_x_inst__3320_/B VDD VDD VSS VSS gf180mcu_fd_sc_mcu7t5v0__nor2_1
XFILLER_148_20 VDD VDD VSS VSS gf180mcu_fd_sc_mcu7t5v0__fill_1
Xwave_controller_y_inst__3266_ wave_controller_y_inst__3266_/A1 spi_regs_inst__1611_/Q
+ wave_controller_y_inst__3355_/A1 VDD VDD VSS VSS gf180mcu_fd_sc_mcu7t5v0__nand2_1
XFILLER_120_2 VDD VDD VSS VSS gf180mcu_fd_sc_mcu7t5v0__fillcap_8
XFILLER_126_527 VDD VDD VSS VSS gf180mcu_fd_sc_mcu7t5v0__fillcap_8
XFILLER_148_53 VDD VDD VSS VSS gf180mcu_fd_sc_mcu7t5v0__fillcap_4
XFILLER_32_97 VDD VDD VSS VSS gf180mcu_fd_sc_mcu7t5v0__fill_2
Xwave_controller_y_inst__2217_ wave_controller_y_inst__2226_/A1 spi_regs_inst__1316_/A1
+ wave_controller_y_inst__2259_/A1 VDD VDD VSS VSS gf180mcu_fd_sc_mcu7t5v0__nand2_1
XTAP_TAPCELL_ROW_78_1157 VDD VSS gf180mcu_fd_sc_mcu7t5v0__filltie
XTAP_TAPCELL_ROW_78_1168 VDD VSS gf180mcu_fd_sc_mcu7t5v0__filltie
Xwave_controller_y_inst__3197_ wave_controller_y_inst__3197_/A1 wave_controller_y_inst__3109_/Z
+ wave_controller_y_inst__3198_/A2 VDD VDD VSS VSS gf180mcu_fd_sc_mcu7t5v0__nor2_1
Xwave_controller_y_inst__2148_ wave_controller_y_inst__3732_/Q wave_controller_y_inst__2152_/A2
+ wave_controller_y_inst__2148_/Z VDD VDD VSS VSS gf180mcu_fd_sc_mcu7t5v0__xor2_1
XFILLER_122_722 VDD VDD VSS VSS gf180mcu_fd_sc_mcu7t5v0__fillcap_4
XFILLER_134_593 VDD VDD VSS VSS gf180mcu_fd_sc_mcu7t5v0__fill_2
Xwave_controller_y_inst__2079_ wave_controller_y_inst__2079_/A1 wave_controller_y_inst__2096_/A2
+ wave_controller_y_inst__2079_/B wave_controller_y_inst__2081_/A2 VDD VDD VSS VSS
+ gf180mcu_fd_sc_mcu7t5v0__aoi21_1
XTAP_TAPCELL_ROW_91_1379 VDD VSS gf180mcu_fd_sc_mcu7t5v0__filltie
XFILLER_48_500 VDD VDD VSS VSS gf180mcu_fd_sc_mcu7t5v0__fillcap_8
XFILLER_121_298 VDD VDD VSS VSS gf180mcu_fd_sc_mcu7t5v0__fillcap_8
XFILLER_76_831 VDD VDD VSS VSS gf180mcu_fd_sc_mcu7t5v0__fill_1
XFILLER_88_691 VDD VDD VSS VSS gf180mcu_fd_sc_mcu7t5v0__fill_2
XFILLER_94_149 VDD VDD VSS VSS gf180mcu_fd_sc_mcu7t5v0__fillcap_16
Xwave_controller_x_inst_fanout385 wave_controller_x_inst__3262_/A1 wave_controller_x_inst__3189_/C
+ VDD VDD VSS VSS gf180mcu_fd_sc_mcu7t5v0__dlyb_1
XFILLER_57_72 VDD VDD VSS VSS gf180mcu_fd_sc_mcu7t5v0__fill_2
XFILLER_91_823 VDD VDD VSS VSS gf180mcu_fd_sc_mcu7t5v0__fillcap_4
XFILLER_90_355 VDD VDD VSS VSS gf180mcu_fd_sc_mcu7t5v0__fill_1
Xspi_regs_inst__1642_ spi_regs_inst__1642_/D spi_regs_inst__1648_/RN clkload29/I spi_regs_inst__1642_/Q
+ VDD VDD VSS VSS gf180mcu_fd_sc_mcu7t5v0__dffrnq_1
XFILLER_91_1116 VDD VDD VSS VSS gf180mcu_fd_sc_mcu7t5v0__fillcap_4
Xspi_regs_inst__1573_ spi_regs_inst__1573_/D fanout566/Z clkload17/I spi_regs_inst__1573_/Q
+ VDD VDD VSS VSS gf180mcu_fd_sc_mcu7t5v0__dffrnq_1
XFILLER_43_282 VDD VDD VSS VSS gf180mcu_fd_sc_mcu7t5v0__fillcap_4
XFILLER_148_107 VDD VDD VSS VSS gf180mcu_fd_sc_mcu7t5v0__fill_2
XFILLER_31_488 VDD VDD VSS VSS gf180mcu_fd_sc_mcu7t5v0__fill_2
XFILLER_145_836 VDD VDD VSS VSS gf180mcu_fd_sc_mcu7t5v0__fillcap_4
XTAP_TAPCELL_ROW_24_1_508 VDD VSS gf180mcu_fd_sc_mcu7t5v0__filltie
XFILLER_99_912 VDD VDD VSS VSS gf180mcu_fd_sc_mcu7t5v0__fillcap_64
XPHY_EDGE_ROW_45_1_Left_212 VDD VSS gf180mcu_fd_sc_mcu7t5v0__endcap
XFILLER_113_733 VDD VDD VSS VSS gf180mcu_fd_sc_mcu7t5v0__fillcap_32
XFILLER_98_411 VDD VDD VSS VSS gf180mcu_fd_sc_mcu7t5v0__fill_2
XFILLER_98_422 VDD VDD VSS VSS gf180mcu_fd_sc_mcu7t5v0__fill_2
XFILLER_112_243 VDD VDD VSS VSS gf180mcu_fd_sc_mcu7t5v0__fill_2
XFILLER_140_552 VDD VDD VSS VSS gf180mcu_fd_sc_mcu7t5v0__fill_2
Xstate_machine_inst__37_ state_machine_inst__37_/A1 state_machine_inst__34_/B state_machine_inst__37_/B
+ _08_/I state_machine_inst__40_/D VDD VDD VSS VSS gf180mcu_fd_sc_mcu7t5v0__aoi211_1
Xspi_regs_inst__1007_ spi_regs_inst__1024_/A1 spi_regs_inst__1031_/A1 spi_regs_inst__1182_/B1
+ VDD VDD VSS VSS gf180mcu_fd_sc_mcu7t5v0__nor2_1
Xfanout619 fanout620/Z fanout619/Z VDD VDD VSS VSS gf180mcu_fd_sc_mcu7t5v0__dlyb_1
Xfanout608 wire628/I fanout608/Z VDD VDD VSS VSS gf180mcu_fd_sc_mcu7t5v0__dlyb_1
XFILLER_113_788 VDD VDD VSS VSS gf180mcu_fd_sc_mcu7t5v0__fillcap_4
XFILLER_39_500 VDD VDD VSS VSS gf180mcu_fd_sc_mcu7t5v0__fillcap_4
XFILLER_85_105 VDD VDD VSS VSS gf180mcu_fd_sc_mcu7t5v0__fill_1
XPHY_EDGE_ROW_107_Right_107 VDD VSS gf180mcu_fd_sc_mcu7t5v0__endcap
XFILLER_100_449 VDD VDD VSS VSS gf180mcu_fd_sc_mcu7t5v0__fillcap_4
XFILLER_152_1081 VDD VDD VSS VSS gf180mcu_fd_sc_mcu7t5v0__fillcap_4
XFILLER_67_842 VDD VDD VSS VSS gf180mcu_fd_sc_mcu7t5v0__fillcap_16
XFILLER_79_691 VDD VDD VSS VSS gf180mcu_fd_sc_mcu7t5v0__fillcap_8
Xwave_controller_x_inst__3670_ wave_controller_x_inst__3670_/D wave_controller_x_inst__3701_/RN
+ clkload31/I spi_regs_inst__1033_/B2 VDD VDD VSS VSS gf180mcu_fd_sc_mcu7t5v0__dffrnq_1
Xwave_controller_x_inst__2621_ wave_controller_x_inst__2615_/I wave_controller_x_inst__2621_/A2
+ wave_controller_x_inst__2621_/Z VDD VDD VSS VSS gf180mcu_fd_sc_mcu7t5v0__xor2_1
XFILLER_81_311 VDD VDD VSS VSS gf180mcu_fd_sc_mcu7t5v0__fillcap_4
XFILLER_82_823 VDD VDD VSS VSS gf180mcu_fd_sc_mcu7t5v0__fillcap_8
XFILLER_81_333 VDD VDD VSS VSS gf180mcu_fd_sc_mcu7t5v0__fillcap_16
XTAP_TAPCELL_ROW_124_1921 VDD VSS gf180mcu_fd_sc_mcu7t5v0__filltie
Xwave_controller_x_inst__2552_ wave_controller_x_inst__2519_/Z wave_controller_x_inst__2553_/A2
+ wave_controller_x_inst__2553_/A3 wave_controller_x_inst__2552_/Z VDD VDD VSS VSS
+ gf180mcu_fd_sc_mcu7t5v0__and3_1
Xwave_controller_x_inst__2483_ wave_controller_x_inst__2482_/B wave_controller_x_inst__2483_/A2
+ wave_controller_x_inst__2483_/B1 wave_controller_x_inst__2509_/A2 spi_regs_inst_wire106/I
+ VDD VDD VSS VSS gf180mcu_fd_sc_mcu7t5v0__aoi22_1
XTAP_TAPCELL_ROW_157_2464 VDD VSS gf180mcu_fd_sc_mcu7t5v0__filltie
XTAP_TAPCELL_ROW_157_2475 VDD VSS gf180mcu_fd_sc_mcu7t5v0__filltie
Xwave_controller_y_inst__3120_ wave_controller_y_inst__3568_/A1 spi_regs_inst__1588_/Q
+ wave_controller_y_inst__3218_/A1 VDD VDD VSS VSS gf180mcu_fd_sc_mcu7t5v0__nand2_1
Xwave_controller_x_inst__3104_ wave_controller_x_inst__3098_/B fanout499/Z fanout399/Z
+ wave_controller_x_inst__3406_/A3 wave_controller_x_inst__3404_/B VDD VDD VSS VSS
+ gf180mcu_fd_sc_mcu7t5v0__nand4_1
Xwave_controller_y_inst__3051_ wave_controller_y_inst__3062_/A1 wave_controller_y_inst__3051_/A2
+ wave_controller_y_inst__3052_/B2 VDD VDD VSS VSS gf180mcu_fd_sc_mcu7t5v0__nand2_1
XFILLER_108_527 VDD VDD VSS VSS gf180mcu_fd_sc_mcu7t5v0__fillcap_8
Xwave_controller_y_inst__2002_ wave_controller_y_inst__2000_/Z wave_controller_y_inst__2002_/A2
+ spi_regs_inst__1238_/B2 VDD VDD VSS VSS gf180mcu_fd_sc_mcu7t5v0__nor2_1
Xwave_controller_x_inst__3035_ wave_controller_x_inst__3489_/A1 wave_controller_x_inst__3409_/A3
+ wave_controller_x_inst__3035_/Z VDD VDD VSS VSS gf180mcu_fd_sc_mcu7t5v0__xor2_1
XFILLER_123_508 VDD VDD VSS VSS gf180mcu_fd_sc_mcu7t5v0__fill_2
XFILLER_135_379 VDD VDD VSS VSS gf180mcu_fd_sc_mcu7t5v0__fillcap_8
XTAP_TAPCELL_ROW_18_1_466 VDD VSS gf180mcu_fd_sc_mcu7t5v0__filltie
XFILLER_151_839 VDD VDD VSS VSS gf180mcu_fd_sc_mcu7t5v0__fill_1
XFILLER_89_400 VDD VDD VSS VSS gf180mcu_fd_sc_mcu7t5v0__fillcap_16
XFILLER_89_422 VDD VDD VSS VSS gf180mcu_fd_sc_mcu7t5v0__fillcap_64
XTAP_TAPCELL_ROW_73_1076 VDD VSS gf180mcu_fd_sc_mcu7t5v0__filltie
XTAP_TAPCELL_ROW_73_1087 VDD VSS gf180mcu_fd_sc_mcu7t5v0__filltie
Xwave_controller_y_inst__2904_ wave_controller_y_inst__2896_/B wave_controller_y_inst__2897_/Z
+ wave_controller_y_inst__2898_/Z wave_controller_y_inst__3419_/C VDD VDD VSS VSS
+ gf180mcu_fd_sc_mcu7t5v0__nor3_1
XFILLER_131_1154 VDD VDD VSS VSS gf180mcu_fd_sc_mcu7t5v0__fillcap_16
XFILLER_134_99 VDD VDD VSS VSS gf180mcu_fd_sc_mcu7t5v0__fill_1
XFILLER_57_352 VDD VDD VSS VSS gf180mcu_fd_sc_mcu7t5v0__fill_1
XFILLER_85_672 VDD VDD VSS VSS gf180mcu_fd_sc_mcu7t5v0__fillcap_16
Xwave_controller_y_inst__2835_ wave_controller_y_inst__3712_/Q wave_controller_y_inst__2835_/A2
+ wave_controller_y_inst__2835_/B wave_controller_y_inst__2835_/C wave_controller_y_inst__2839_/A2
+ VDD VDD VSS VSS gf180mcu_fd_sc_mcu7t5v0__oai211_1
Xwave_controller_x_inst__2819_ wave_controller_x_inst__3163_/C wave_controller_x_inst__2819_/A2
+ wave_controller_x_inst__2816_/I wave_controller_x_inst__3305_/A1 wave_controller_x_inst__2820_/B2
+ VDD VDD VSS VSS gf180mcu_fd_sc_mcu7t5v0__aoi22_1
XFILLER_72_311 VDD VDD VSS VSS gf180mcu_fd_sc_mcu7t5v0__fillcap_4
XPHY_EDGE_ROW_16_1_Right_15 VDD VSS gf180mcu_fd_sc_mcu7t5v0__endcap
Xwave_controller_y_inst__2766_ wave_controller_y_inst__3010_/B wave_controller_y_inst__3008_/A2
+ wave_controller_y_inst__2766_/ZN VDD VDD VSS VSS gf180mcu_fd_sc_mcu7t5v0__nand2_1
Xwave_controller_y_inst__2697_ wave_controller_y_inst__2697_/A1 wave_controller_y_inst__2697_/A2
+ spi_regs_inst__1353_/B2 VDD VDD VSS VSS gf180mcu_fd_sc_mcu7t5v0__xor2_1
XFILLER_13_422 VDD VDD VSS VSS gf180mcu_fd_sc_mcu7t5v0__fillcap_16
XFILLER_159_906 VDD VDD VSS VSS gf180mcu_fd_sc_mcu7t5v0__fillcap_4
XFILLER_25_282 VDD VDD VSS VSS gf180mcu_fd_sc_mcu7t5v0__fillcap_4
XFILLER_40_274 VDD VDD VSS VSS gf180mcu_fd_sc_mcu7t5v0__fillcap_8
Xwave_controller_y_inst__3318_ wave_controller_y_inst__3350_/A1 wave_controller_y_inst__3315_/Z
+ wave_controller_y_inst__3350_/B wave_controller_y_inst__3318_/Z VDD VDD VSS VSS
+ gf180mcu_fd_sc_mcu7t5v0__or3_1
XFILLER_166_493 VDD VDD VSS VSS gf180mcu_fd_sc_mcu7t5v0__fill_1
Xwave_controller_y_inst__3249_ wave_controller_y_inst__3175_/Z wave_controller_y_inst__3249_/A2
+ wave_controller_y_inst__3249_/Z VDD VDD VSS VSS gf180mcu_fd_sc_mcu7t5v0__xor2_1
XFILLER_154_677 VDD VDD VSS VSS gf180mcu_fd_sc_mcu7t5v0__fillcap_8
XTAP_TAPCELL_ROW_93_1419 VDD VSS gf180mcu_fd_sc_mcu7t5v0__filltie
XTAP_TAPCELL_ROW_93_1408 VDD VSS gf180mcu_fd_sc_mcu7t5v0__filltie
XFILLER_141_305 VDD VDD VSS VSS gf180mcu_fd_sc_mcu7t5v0__fill_2
XFILLER_153_198 VDD VDD VSS VSS gf180mcu_fd_sc_mcu7t5v0__fillcap_4
XFILLER_96_904 VDD VDD VSS VSS gf180mcu_fd_sc_mcu7t5v0__fill_1
XFILLER_122_574 VDD VDD VSS VSS gf180mcu_fd_sc_mcu7t5v0__fill_2
XFILLER_68_71 VDD VDD VSS VSS gf180mcu_fd_sc_mcu7t5v0__fill_1
Xsignal_processor_y_inst__170_ signal_processor_y_inst__187_/A1 signal_processor_y_inst__169_/Z
+ signal_processor_y_inst__234_/D VDD VDD VSS VSS gf180mcu_fd_sc_mcu7t5v0__nor2_1
XFILLER_136_1087 VDD VDD VSS VSS gf180mcu_fd_sc_mcu7t5v0__fillcap_64
XFILLER_67_116 VDD VDD VSS VSS gf180mcu_fd_sc_mcu7t5v0__fillcap_4
XFILLER_68_93 VDD VDD VSS VSS gf180mcu_fd_sc_mcu7t5v0__fillcap_8
Xwave_controller_x_inst_fanout160 wave_controller_x_inst__3542_/A1 wave_controller_x_inst__3557_/A1
+ VDD VDD VSS VSS gf180mcu_fd_sc_mcu7t5v0__dlyb_1
Xwave_controller_x_inst_fanout171 wave_controller_x_inst__2754_/A2 wave_controller_x_inst__2153_/A2
+ VDD VDD VSS VSS gf180mcu_fd_sc_mcu7t5v0__dlyb_1
XFILLER_48_363 VDD VDD VSS VSS gf180mcu_fd_sc_mcu7t5v0__fillcap_4
XFILLER_91_620 VDD VDD VSS VSS gf180mcu_fd_sc_mcu7t5v0__fill_1
XTAP_TAPCELL_ROW_141_2210 VDD VSS gf180mcu_fd_sc_mcu7t5v0__filltie
XFILLER_64_867 VDD VDD VSS VSS gf180mcu_fd_sc_mcu7t5v0__fillcap_8
XFILLER_23_208 VDD VDD VSS VSS gf180mcu_fd_sc_mcu7t5v0__fill_2
XFILLER_56_1011 VDD VDD VSS VSS gf180mcu_fd_sc_mcu7t5v0__fillcap_4
Xwave_controller_y_inst_load_slew50 wave_controller_y_inst__3579_/A1 wave_controller_y_inst__3584_/S
+ VDD VDD VSS VSS gf180mcu_fd_sc_mcu7t5v0__buf_4
XFILLER_16_271 VDD VDD VSS VSS gf180mcu_fd_sc_mcu7t5v0__fill_1
Xspi_regs_inst__1625_ spi_regs_inst__1625_/D spi_regs_inst__1659_/RN clkload8/I spi_regs_inst__1625_/Q
+ VDD VDD VSS VSS gf180mcu_fd_sc_mcu7t5v0__dffrnq_1
XTAP_TAPCELL_ROW_102_1559 VDD VSS gf180mcu_fd_sc_mcu7t5v0__filltie
Xspi_regs_inst__1556_ spi_regs_inst__1556_/D fanout589/Z clkload22/I spi_regs_inst__1556_/Q
+ VDD VDD VSS VSS gf180mcu_fd_sc_mcu7t5v0__dffrnq_1
XFILLER_149_449 VDD VDD VSS VSS gf180mcu_fd_sc_mcu7t5v0__fill_2
XTAP_TAPCELL_ROW_139_2172 VDD VSS gf180mcu_fd_sc_mcu7t5v0__filltie
XFILLER_117_302 VDD VDD VSS VSS gf180mcu_fd_sc_mcu7t5v0__fill_2
XFILLER_145_611 VDD VDD VSS VSS gf180mcu_fd_sc_mcu7t5v0__fill_2
Xspi_regs_inst__1487_ spi_regs_inst__1487_/D fanout615/Z clkbuf_leaf_36_clk/Z fanout509/I
+ VDD VDD VSS VSS gf180mcu_fd_sc_mcu7t5v0__dffrnq_1
XFILLER_129_173 VDD VDD VSS VSS gf180mcu_fd_sc_mcu7t5v0__fill_1
XFILLER_144_121 VDD VDD VSS VSS gf180mcu_fd_sc_mcu7t5v0__fill_1
XFILLER_145_666 VDD VDD VSS VSS gf180mcu_fd_sc_mcu7t5v0__fill_1
XTAP_TAPCELL_ROW_152_2383 VDD VSS gf180mcu_fd_sc_mcu7t5v0__filltie
XFILLER_133_839 VDD VDD VSS VSS gf180mcu_fd_sc_mcu7t5v0__fill_1
XFILLER_145_688 VDD VDD VSS VSS gf180mcu_fd_sc_mcu7t5v0__fill_2
XFILLER_160_625 VDD VDD VSS VSS gf180mcu_fd_sc_mcu7t5v0__fill_1
XFILLER_141_850 VDD VDD VSS VSS gf180mcu_fd_sc_mcu7t5v0__fill_2
XFILLER_144_198 VDD VDD VSS VSS gf180mcu_fd_sc_mcu7t5v0__fillcap_8
XFILLER_98_230 VDD VDD VSS VSS gf180mcu_fd_sc_mcu7t5v0__fill_1
XFILLER_115_1116 VDD VDD VSS VSS gf180mcu_fd_sc_mcu7t5v0__fillcap_4
XFILLER_154_1165 VDD VDD VSS VSS gf180mcu_fd_sc_mcu7t5v0__fillcap_4
XFILLER_59_606 VDD VDD VSS VSS gf180mcu_fd_sc_mcu7t5v0__fill_1
XFILLER_98_263 VDD VDD VSS VSS gf180mcu_fd_sc_mcu7t5v0__fill_2
Xwave_controller_x_inst__1983_ wave_controller_x_inst__1986_/A2 wave_controller_x_inst__1983_/A2
+ spi_regs_inst__1051_/B2 VDD VDD VSS VSS gf180mcu_fd_sc_mcu7t5v0__xnor2_1
Xwave_controller_x_inst__3722_ wave_controller_x_inst__3722_/D wave_controller_x_inst__3723_/RN
+ clkload27/I wave_controller_x_inst__3722_/Q VDD VDD VSS VSS gf180mcu_fd_sc_mcu7t5v0__dffsnq_1
XFILLER_39_352 VDD VDD VSS VSS gf180mcu_fd_sc_mcu7t5v0__fillcap_32
XFILLER_86_469 VDD VDD VSS VSS gf180mcu_fd_sc_mcu7t5v0__fillcap_16
XTAP_TAPCELL_ROW_57_818 VDD VSS gf180mcu_fd_sc_mcu7t5v0__filltie
XFILLER_67_694 VDD VDD VSS VSS gf180mcu_fd_sc_mcu7t5v0__fillcap_4
Xwave_controller_y_inst__2620_ wave_controller_y_inst_wire150/Z wave_controller_y_inst__2620_/A2
+ wave_controller_y_inst__2620_/A3 wave_controller_y_inst__2620_/B wave_controller_y_inst_wire127/I
+ VDD VDD VSS VSS gf180mcu_fd_sc_mcu7t5v0__oai31_1
Xwave_controller_x_inst__3653_ wave_controller_x_inst__3653_/D wave_controller_x_inst__3706_/RN
+ clkload36/I spi_regs_inst__1257_/A1 VDD VDD VSS VSS gf180mcu_fd_sc_mcu7t5v0__dffrnq_1
XFILLER_54_333 VDD VDD VSS VSS gf180mcu_fd_sc_mcu7t5v0__fill_2
XFILLER_54_355 VDD VDD VSS VSS gf180mcu_fd_sc_mcu7t5v0__fill_2
XFILLER_82_664 VDD VDD VSS VSS gf180mcu_fd_sc_mcu7t5v0__fill_1
Xwave_controller_x_inst__3584_ wave_controller_x_inst__3584_/I0 max_cap452/I wave_controller_x_inst__3588_/S
+ wave_controller_x_inst__3662_/D VDD VDD VSS VSS gf180mcu_fd_sc_mcu7t5v0__mux2_2
Xwave_controller_x_inst__2604_ wave_controller_x_inst__2604_/I wave_controller_x_inst__2612_/A1
+ VDD VDD VSS VSS gf180mcu_fd_sc_mcu7t5v0__clkinv_1
Xspi_regs_inst_max_cap309 spi_regs_inst__0806_/S spi_regs_inst__0803_/S VDD VDD VSS
+ VSS gf180mcu_fd_sc_mcu7t5v0__buf_3
XFILLER_70_815 VDD VDD VSS VSS gf180mcu_fd_sc_mcu7t5v0__fillcap_4
XTAP_TAPCELL_ROW_159_2504 VDD VSS gf180mcu_fd_sc_mcu7t5v0__filltie
Xwave_controller_y_inst__2551_ wave_controller_y_inst__2534_/B wave_controller_y_inst__2555_/C
+ wave_controller_y_inst__2553_/A3 VDD VDD VSS VSS gf180mcu_fd_sc_mcu7t5v0__nand2_1
Xwave_controller_y_inst_wire323 wave_controller_y_inst_wire323/I wave_controller_y_inst_wire323/Z
+ VDD VDD VSS VSS gf180mcu_fd_sc_mcu7t5v0__buf_4
Xwave_controller_x_inst__2535_ wave_controller_x_inst__2537_/A2 wave_controller_x_inst__2537_/A3
+ wave_controller_x_inst__2536_/A2 VDD VDD VSS VSS gf180mcu_fd_sc_mcu7t5v0__xnor2_1
XFILLER_70_859 VDD VDD VSS VSS gf180mcu_fd_sc_mcu7t5v0__fillcap_4
Xwave_controller_y_inst__2482_ wave_controller_y_inst__2482_/A1 wave_controller_y_inst__2479_/I
+ wave_controller_y_inst__2482_/B wave_controller_y_inst__2509_/A2 VDD VDD VSS VSS
+ gf180mcu_fd_sc_mcu7t5v0__aoi21_1
Xwave_controller_y_inst_wire356 wave_controller_y_inst__2037_/Z wave_controller_y_inst_wire356/Z
+ VDD VDD VSS VSS gf180mcu_fd_sc_mcu7t5v0__clkbuf_2
Xwave_controller_x_inst__2466_ max_cap467/I wave_controller_x_inst__2467_/A2 wave_controller_x_inst__2482_/A1
+ VDD VDD VSS VSS gf180mcu_fd_sc_mcu7t5v0__nor2_1
Xsignal_processor_x_inst__190_ signal_processor_x_inst__242_/Q signal_processor_x_inst__190_/A2
+ signal_processor_x_inst__191_/B VDD VDD VSS VSS gf180mcu_fd_sc_mcu7t5v0__nand2_1
XFILLER_10_403 VDD VDD VSS VSS gf180mcu_fd_sc_mcu7t5v0__fill_1
Xwave_controller_x_inst__2397_ wave_controller_x_inst_wire78/Z wave_controller_x_inst__2394_/Z
+ wave_controller_x_inst__2397_/B wave_controller_x_inst__2436_/A1 VDD VDD VSS VSS
+ gf180mcu_fd_sc_mcu7t5v0__oai21_1
XFILLER_13_66 VDD VDD VSS VSS gf180mcu_fd_sc_mcu7t5v0__fillcap_4
XFILLER_167_268 VDD VDD VSS VSS gf180mcu_fd_sc_mcu7t5v0__fillcap_4
XFILLER_108_313 VDD VDD VSS VSS gf180mcu_fd_sc_mcu7t5v0__fill_2
XFILLER_109_836 VDD VDD VSS VSS gf180mcu_fd_sc_mcu7t5v0__fillcap_4
Xwave_controller_y_inst__3103_ wave_controller_y_inst__3616_/Q wave_controller_y_inst__3615_/Q
+ wave_controller_y_inst__3406_/A3 VDD VDD VSS VSS gf180mcu_fd_sc_mcu7t5v0__nand2_1
XFILLER_163_430 VDD VDD VSS VSS gf180mcu_fd_sc_mcu7t5v0__fillcap_16
XTAP_TAPCELL_ROW_75_1116 VDD VSS gf180mcu_fd_sc_mcu7t5v0__filltie
Xwave_controller_y_inst__3034_ wave_controller_y_inst_wire25/Z wave_controller_y_inst__3034_/A2
+ wave_controller_y_inst__3034_/A3 wave_controller_y_inst__3034_/B1 wave_controller_y_inst__3479_/A1
+ wave_controller_y_inst__3698_/D VDD VDD VSS VSS gf180mcu_fd_sc_mcu7t5v0__oai32_1
Xwave_controller_x_inst__3018_ wave_controller_x_inst__3693_/Q wave_controller_x_inst__3692_/Q
+ wave_controller_x_inst__3694_/Q wave_controller_x_inst__3025_/A3 VDD VDD VSS VSS
+ gf180mcu_fd_sc_mcu7t5v0__nand3_1
XFILLER_151_636 VDD VDD VSS VSS gf180mcu_fd_sc_mcu7t5v0__fill_2
Xwave_controller_x_inst_wire75 wave_controller_x_inst_wire75/I wave_controller_x_inst_wire75/Z
+ VDD VDD VSS VSS gf180mcu_fd_sc_mcu7t5v0__buf_2
XFILLER_123_349 VDD VDD VSS VSS gf180mcu_fd_sc_mcu7t5v0__fill_1
XFILLER_132_872 VDD VDD VSS VSS gf180mcu_fd_sc_mcu7t5v0__fill_2
XFILLER_132_883 VDD VDD VSS VSS gf180mcu_fd_sc_mcu7t5v0__fill_1
XFILLER_131_393 VDD VDD VSS VSS gf180mcu_fd_sc_mcu7t5v0__fillcap_16
XFILLER_65_609 VDD VDD VSS VSS gf180mcu_fd_sc_mcu7t5v0__fill_2
XFILLER_85_480 VDD VDD VSS VSS gf180mcu_fd_sc_mcu7t5v0__fill_1
Xwave_controller_y_inst__2818_ wave_controller_y_inst__2818_/A1 wave_controller_y_inst__2818_/A2
+ wave_controller_y_inst__2818_/B wave_controller_y_inst__2820_/B1 VDD VDD VSS VSS
+ gf180mcu_fd_sc_mcu7t5v0__oai21_1
XFILLER_61_837 VDD VDD VSS VSS gf180mcu_fd_sc_mcu7t5v0__fill_2
XFILLER_73_686 VDD VDD VSS VSS gf180mcu_fd_sc_mcu7t5v0__fill_2
XFILLER_73_697 VDD VDD VSS VSS gf180mcu_fd_sc_mcu7t5v0__fill_2
XTAP_TAPCELL_ROW_0_1_2661 VDD VSS gf180mcu_fd_sc_mcu7t5v0__filltie
XTAP_TAPCELL_ROW_0_1_2672 VDD VSS gf180mcu_fd_sc_mcu7t5v0__filltie
XTAP_TAPCELL_ROW_23_1_507 VDD VSS gf180mcu_fd_sc_mcu7t5v0__filltie
XTAP_TAPCELL_ROW_86_1289 VDD VSS gf180mcu_fd_sc_mcu7t5v0__filltie
Xwave_controller_y_inst__2749_ wave_controller_y_inst__2749_/A1 wave_controller_y_inst__2752_/B2
+ wave_controller_y_inst__2749_/B wave_controller_y_inst__2750_/A2 VDD VDD VSS VSS
+ gf180mcu_fd_sc_mcu7t5v0__oai21_1
XFILLER_72_174 VDD VDD VSS VSS gf180mcu_fd_sc_mcu7t5v0__fill_1
XFILLER_158_213 VDD VDD VSS VSS gf180mcu_fd_sc_mcu7t5v0__fill_2
XTAP_TAPCELL_ROW_31_1_564 VDD VSS gf180mcu_fd_sc_mcu7t5v0__filltie
Xspi_regs_inst__1410_ fanout513/I spi_regs_inst__1410_/I1 spi_regs_inst__1410_/S spi_regs_inst__1483_/D
+ VDD VDD VSS VSS gf180mcu_fd_sc_mcu7t5v0__mux2_2
XFILLER_9_212 VDD VDD VSS VSS gf180mcu_fd_sc_mcu7t5v0__fillcap_64
Xspi_regs_inst__1341_ fanout511/Z spi_regs_inst__1341_/A2 spi_regs_inst_wire218/I
+ spi_regs_inst__1341_/B2 spi_regs_inst__1344_/A1 VDD VDD VSS VSS gf180mcu_fd_sc_mcu7t5v0__aoi22_1
XFILLER_70_94 VDD VDD VSS VSS gf180mcu_fd_sc_mcu7t5v0__fillcap_8
Xspi_regs_inst__1272_ spi_regs_inst__1612_/Q spi_regs_inst__1340_/B1 spi_regs_inst_wire210/Z
+ spi_regs_inst__1272_/B2 spi_regs_inst__1273_/A4 VDD VDD VSS VSS gf180mcu_fd_sc_mcu7t5v0__aoi22_1
Xclkload26 clkload26/I clkload26/ZN VDD VDD VSS VSS gf180mcu_fd_sc_mcu7t5v0__inv_2
Xclkload15 clkload15/I clkload15/Z VDD VDD VSS VSS gf180mcu_fd_sc_mcu7t5v0__clkbuf_2
XFILLER_154_452 VDD VDD VSS VSS gf180mcu_fd_sc_mcu7t5v0__fill_2
XFILLER_5_440 VDD VDD VSS VSS gf180mcu_fd_sc_mcu7t5v0__fillcap_16
XTAP_TAPCELL_ROW_134_2080 VDD VSS gf180mcu_fd_sc_mcu7t5v0__filltie
XTAP_TAPCELL_ROW_134_2091 VDD VSS gf180mcu_fd_sc_mcu7t5v0__filltie
Xspi_regs_inst_wire27 spi_regs_inst_wire27/I spi_regs_inst_wire27/Z VDD VDD VSS VSS
+ gf180mcu_fd_sc_mcu7t5v0__buf_2
XFILLER_141_135 VDD VDD VSS VSS gf180mcu_fd_sc_mcu7t5v0__fillcap_4
XFILLER_141_146 VDD VDD VSS VSS gf180mcu_fd_sc_mcu7t5v0__fill_1
Xspi_regs_inst_wire38 spi_regs_inst_wire38/I spi_regs_inst_wire38/Z VDD VDD VSS VSS
+ gf180mcu_fd_sc_mcu7t5v0__buf_2
XFILLER_123_872 VDD VDD VSS VSS gf180mcu_fd_sc_mcu7t5v0__fillcap_4
XFILLER_79_92 VDD VDD VSS VSS gf180mcu_fd_sc_mcu7t5v0__fill_2
Xsignal_processor_y_inst__222_ signal_processor_y_inst__222_/D fanout558/Z clkload7/I
+ spi_regs_inst__1086_/B2 VDD VDD VSS VSS gf180mcu_fd_sc_mcu7t5v0__dffrnq_1
XFILLER_110_522 VDD VDD VSS VSS gf180mcu_fd_sc_mcu7t5v0__fill_2
XFILLER_122_382 VDD VDD VSS VSS gf180mcu_fd_sc_mcu7t5v0__fill_2
XFILLER_95_233 VDD VDD VSS VSS gf180mcu_fd_sc_mcu7t5v0__fill_2
XFILLER_96_734 VDD VDD VSS VSS gf180mcu_fd_sc_mcu7t5v0__fill_1
Xsignal_processor_y_inst__153_ signal_processor_y_inst__252_/Q signal_processor_y_inst__230_/Q
+ signal_processor_y_inst__154_/A2 VDD VDD VSS VSS gf180mcu_fd_sc_mcu7t5v0__nor2_1
XFILLER_62_1081 VDD VDD VSS VSS gf180mcu_fd_sc_mcu7t5v0__fillcap_4
XFILLER_36_311 VDD VDD VSS VSS gf180mcu_fd_sc_mcu7t5v0__fillcap_4
XFILLER_97_1122 VDD VDD VSS VSS gf180mcu_fd_sc_mcu7t5v0__fillcap_32
Xspi_regs_inst__0987_ spi_regs_inst__1027_/A1 spi_regs_inst__1021_/A2 spi_regs_inst__1246_/B1
+ VDD VDD VSS VSS gf180mcu_fd_sc_mcu7t5v0__nor2_1
XFILLER_36_355 VDD VDD VSS VSS gf180mcu_fd_sc_mcu7t5v0__fill_1
XFILLER_64_664 VDD VDD VSS VSS gf180mcu_fd_sc_mcu7t5v0__fill_1
XFILLER_63_174 VDD VDD VSS VSS gf180mcu_fd_sc_mcu7t5v0__fill_2
Xwave_controller_x_inst__2320_ wave_controller_x_inst_wire170/Z wave_controller_x_inst__2320_/A2
+ wave_controller_x_inst__2320_/A3 wave_controller_x_inst__2320_/B wave_controller_x_inst__2323_/A1
+ VDD VDD VSS VSS gf180mcu_fd_sc_mcu7t5v0__oai31_1
Xspi_regs_inst__1608_ spi_regs_inst__1608_/D fanout566/Z clkload13/I spi_regs_inst__1608_/Q
+ VDD VDD VSS VSS gf180mcu_fd_sc_mcu7t5v0__dffrnq_1
XFILLER_149_246 VDD VDD VSS VSS gf180mcu_fd_sc_mcu7t5v0__fillcap_8
XTAP_TAPCELL_ROW_62_898 VDD VSS gf180mcu_fd_sc_mcu7t5v0__filltie
Xwave_controller_x_inst__2251_ wave_controller_x_inst__2249_/Z wave_controller_x_inst__2251_/A2
+ spi_regs_inst__1309_/B2 VDD VDD VSS VSS gf180mcu_fd_sc_mcu7t5v0__nor2_1
XFILLER_137_419 VDD VDD VSS VSS gf180mcu_fd_sc_mcu7t5v0__fill_1
XTAP_TAPCELL_ROW_154_2412 VDD VSS gf180mcu_fd_sc_mcu7t5v0__filltie
XTAP_TAPCELL_ROW_154_2423 VDD VSS gf180mcu_fd_sc_mcu7t5v0__filltie
Xwave_controller_x_inst__2182_ max_cap461/Z wave_controller_x_inst__2181_/Z wave_controller_x_inst__2201_/A2
+ VDD VDD VSS VSS gf180mcu_fd_sc_mcu7t5v0__nand2_1
Xspi_regs_inst__1539_ spi_regs_inst__1539_/D fanout590/Z clkload24/I spi_regs_inst__1539_/Q
+ VDD VDD VSS VSS gf180mcu_fd_sc_mcu7t5v0__dffrnq_1
Xclkload9 clkload9/I clkload9/Z VDD VDD VSS VSS gf180mcu_fd_sc_mcu7t5v0__clkbuf_2
XTAP_TAPCELL_ROW_119_1842 VDD VSS gf180mcu_fd_sc_mcu7t5v0__filltie
XFILLER_145_441 VDD VDD VSS VSS gf180mcu_fd_sc_mcu7t5v0__fillcap_16
XFILLER_132_102 VDD VDD VSS VSS gf180mcu_fd_sc_mcu7t5v0__fill_2
XFILLER_133_603 VDD VDD VSS VSS gf180mcu_fd_sc_mcu7t5v0__fillcap_16
XFILLER_145_485 VDD VDD VSS VSS gf180mcu_fd_sc_mcu7t5v0__fillcap_4
XFILLER_161_912 VDD VDD VSS VSS gf180mcu_fd_sc_mcu7t5v0__fillcap_64
XFILLER_105_338 VDD VDD VSS VSS gf180mcu_fd_sc_mcu7t5v0__fill_2
XFILLER_132_124 VDD VDD VSS VSS gf180mcu_fd_sc_mcu7t5v0__fill_1
XFILLER_114_872 VDD VDD VSS VSS gf180mcu_fd_sc_mcu7t5v0__fill_2
XFILLER_59_447 VDD VDD VSS VSS gf180mcu_fd_sc_mcu7t5v0__fillcap_8
XTAP_TAPCELL_ROW_70_1024 VDD VSS gf180mcu_fd_sc_mcu7t5v0__filltie
XTAP_TAPCELL_ROW_70_1035 VDD VSS gf180mcu_fd_sc_mcu7t5v0__filltie
XFILLER_115_79 VDD VDD VSS VSS gf180mcu_fd_sc_mcu7t5v0__fillcap_16
XFILLER_75_907 VDD VDD VSS VSS gf180mcu_fd_sc_mcu7t5v0__fill_2
XFILLER_86_244 VDD VDD VSS VSS gf180mcu_fd_sc_mcu7t5v0__fill_1
Xwave_controller_y_inst__3721_ wave_controller_y_inst__3721_/D wave_controller_y_inst__3721_/RN
+ clkload4/I wave_controller_y_inst__3721_/Q VDD VDD VSS VSS gf180mcu_fd_sc_mcu7t5v0__dffrnq_1
Xwave_controller_y_inst__1982_ wave_controller_y_inst__1986_/A1 wave_controller_y_inst__1986_/A3
+ wave_controller_y_inst__1983_/A2 VDD VDD VSS VSS gf180mcu_fd_sc_mcu7t5v0__nor2_1
Xwave_controller_x_inst__1966_ wave_controller_x_inst__1967_/A1 wave_controller_x_inst__1967_/A2
+ wave_controller_x_inst__1966_/B wave_controller_x_inst__1973_/A2 VDD VDD VSS VSS
+ gf180mcu_fd_sc_mcu7t5v0__oai21_1
XFILLER_27_300 VDD VDD VSS VSS gf180mcu_fd_sc_mcu7t5v0__fillcap_16
XTAP_TAPCELL_ROW_165_2596 VDD VSS gf180mcu_fd_sc_mcu7t5v0__filltie
Xwave_controller_x_inst__3705_ wave_controller_x_inst__3705_/D wave_controller_x_inst__3706_/RN
+ clkload35/I wave_controller_x_inst__3705_/Q VDD VDD VSS VSS gf180mcu_fd_sc_mcu7t5v0__dffrnq_1
Xwave_controller_x_inst__1897_ wave_controller_x_inst__3696_/Q wave_controller_x_inst__3458_/A1
+ VDD VDD VSS VSS gf180mcu_fd_sc_mcu7t5v0__clkinv_1
Xwave_controller_y_inst__3652_ wave_controller_y_inst__3652_/D wave_controller_y_inst__3673_/RN
+ clkload20/I spi_regs_inst__1218_/A1 VDD VDD VSS VSS gf180mcu_fd_sc_mcu7t5v0__dffrnq_1
Xwave_controller_x_inst__3636_ wave_controller_x_inst__3636_/D wave_controller_x_inst__3710_/RN
+ clkbuf_leaf_31_clk/Z max_cap465/I VDD VDD VSS VSS gf180mcu_fd_sc_mcu7t5v0__dffrnq_1
XFILLER_70_601 VDD VDD VSS VSS gf180mcu_fd_sc_mcu7t5v0__fill_1
Xwave_controller_y_inst__2603_ wave_controller_y_inst__2601_/Z wave_controller_y_inst__2631_/A2
+ wave_controller_y_inst__2604_/I VDD VDD VSS VSS gf180mcu_fd_sc_mcu7t5v0__xor2_1
Xwave_controller_y_inst_wire120 wave_controller_y_inst_wire120/I wave_controller_y_inst_wire120/Z
+ VDD VDD VSS VSS gf180mcu_fd_sc_mcu7t5v0__clkbuf_1
Xwave_controller_y_inst__3583_ wave_controller_y_inst__3583_/A1 wave_controller_y_inst__3591_/S
+ wave_controller_y_inst__3583_/B wave_controller_y_inst__3661_/D VDD VDD VSS VSS
+ gf180mcu_fd_sc_mcu7t5v0__oai21_1
XFILLER_131_67 VDD VDD VSS VSS gf180mcu_fd_sc_mcu7t5v0__fill_2
XFILLER_42_314 VDD VDD VSS VSS gf180mcu_fd_sc_mcu7t5v0__fill_1
XFILLER_54_174 VDD VDD VSS VSS gf180mcu_fd_sc_mcu7t5v0__fill_1
XFILLER_55_697 VDD VDD VSS VSS gf180mcu_fd_sc_mcu7t5v0__fill_2
XFILLER_82_494 VDD VDD VSS VSS gf180mcu_fd_sc_mcu7t5v0__fill_1
Xwave_controller_y_inst__2534_ wave_controller_y_inst__2555_/A1 wave_controller_y_inst__2534_/A2
+ wave_controller_y_inst__2534_/B wave_controller_y_inst__2537_/A3 VDD VDD VSS VSS
+ gf180mcu_fd_sc_mcu7t5v0__aoi21_1
Xwave_controller_y_inst_wire153 wave_controller_y_inst_wire153/I wave_controller_y_inst_wire153/Z
+ VDD VDD VSS VSS gf180mcu_fd_sc_mcu7t5v0__clkbuf_2
Xwave_controller_x_inst__3567_ wave_controller_x_inst__3569_/S wave_controller_x_inst__3599_/A2
+ wave_controller_x_inst__3567_/B wave_controller_x_inst__3653_/D VDD VDD VSS VSS
+ gf180mcu_fd_sc_mcu7t5v0__oai21_1
XFILLER_42_347 VDD VDD VSS VSS gf180mcu_fd_sc_mcu7t5v0__fill_1
XFILLER_70_667 VDD VDD VSS VSS gf180mcu_fd_sc_mcu7t5v0__fillcap_8
Xwave_controller_x_inst__3498_ wave_controller_x_inst__3702_/Q wave_controller_x_inst__3537_/A2
+ wave_controller_x_inst__3500_/A2 VDD VDD VSS VSS gf180mcu_fd_sc_mcu7t5v0__nor2_1
Xwave_controller_x_inst__2518_ wave_controller_x_inst__2793_/I0 wave_controller_x_inst__3509_/B2
+ wave_controller_x_inst__2518_/A3 wave_controller_x_inst__2519_/A2 VDD VDD VSS VSS
+ gf180mcu_fd_sc_mcu7t5v0__nand3_1
Xsignal_processor_x_inst__242_ signal_processor_x_inst__242_/D signal_processor_x_inst__242_/RN
+ clkload23/I signal_processor_x_inst__242_/Q VDD VDD VSS VSS gf180mcu_fd_sc_mcu7t5v0__dffrnq_1
Xwave_controller_y_inst__2465_ wave_controller_y_inst__2517_/A1 wave_controller_y_inst__2465_/A2
+ wave_controller_y_inst__2467_/A2 VDD VDD VSS VSS gf180mcu_fd_sc_mcu7t5v0__nor2_1
Xwave_controller_x_inst__2449_ wave_controller_x_inst__2446_/B wave_controller_x_inst__2449_/A2
+ wave_controller_x_inst__2449_/B1 wave_controller_x_inst__2449_/B2 wave_controller_x_inst__2449_/C
+ wave_controller_x_inst__2450_/A3 VDD VDD VSS VSS gf180mcu_fd_sc_mcu7t5v0__oai221_1
Xsignal_processor_x_inst__173_ signal_processor_x_inst__187_/A1 signal_processor_x_inst__213_/A2
+ signal_processor_x_inst__235_/D VDD VDD VSS VSS gf180mcu_fd_sc_mcu7t5v0__nor2_1
XFILLER_156_717 VDD VDD VSS VSS gf180mcu_fd_sc_mcu7t5v0__fill_1
Xwave_controller_y_inst__2396_ wave_controller_y_inst__2396_/A1 wave_controller_y_inst__2396_/A2
+ wave_controller_y_inst__2396_/B wave_controller_y_inst__2396_/C wave_controller_y_inst__2397_/B
+ VDD VDD VSS VSS gf180mcu_fd_sc_mcu7t5v0__aoi211_1
Xchip_core_654 bidir_pd[9] VDD VDD VSS VSS gf180mcu_fd_sc_mcu7t5v0__tiel
Xchip_core_643 bidir_oe[1] VDD VDD VSS VSS gf180mcu_fd_sc_mcu7t5v0__tiel
Xchip_core_632 bidir_cs[7] VDD VDD VSS VSS gf180mcu_fd_sc_mcu7t5v0__tiel
XFILLER_40_31 VDD VDD VSS VSS gf180mcu_fd_sc_mcu7t5v0__fillcap_4
Xchip_core_687 bidir_pu[0] VDD VDD VSS VSS gf180mcu_fd_sc_mcu7t5v0__tieh
Xchip_core_676 bidir_cs[1] VDD VDD VSS VSS gf180mcu_fd_sc_mcu7t5v0__tieh
Xchip_core_665 bidir_sl[1] VDD VDD VSS VSS gf180mcu_fd_sc_mcu7t5v0__tiel
XFILLER_124_625 VDD VDD VSS VSS gf180mcu_fd_sc_mcu7t5v0__fillcap_32
XFILLER_40_86 VDD VDD VSS VSS gf180mcu_fd_sc_mcu7t5v0__fillcap_16
XFILLER_123_135 VDD VDD VSS VSS gf180mcu_fd_sc_mcu7t5v0__fillcap_4
XFILLER_2_421 VDD VDD VSS VSS gf180mcu_fd_sc_mcu7t5v0__fill_2
Xwave_controller_y_inst__3017_ wave_controller_y_inst__3440_/A1 wave_controller_y_inst__3017_/A2
+ wave_controller_y_inst__3026_/A3 VDD VDD VSS VSS gf180mcu_fd_sc_mcu7t5v0__nor2_1
XFILLER_2_454 VDD VDD VSS VSS gf180mcu_fd_sc_mcu7t5v0__fill_1
XFILLER_77_200 VDD VDD VSS VSS gf180mcu_fd_sc_mcu7t5v0__fillcap_8
XFILLER_133_1046 VDD VDD VSS VSS gf180mcu_fd_sc_mcu7t5v0__fillcap_4
XFILLER_66_929 VDD VDD VSS VSS gf180mcu_fd_sc_mcu7t5v0__fillcap_16
Xspi_regs_inst__0910_ spi_regs_inst__1366_/A1 spi_regs_inst__1364_/A1 spi_regs_inst__0889_/B
+ spi_regs_inst__0912_/A2 VDD VDD VSS VSS gf180mcu_fd_sc_mcu7t5v0__nor3_1
XTAP_TAPCELL_ROW_88_1329 VDD VSS gf180mcu_fd_sc_mcu7t5v0__filltie
XFILLER_18_333 VDD VDD VSS VSS gf180mcu_fd_sc_mcu7t5v0__fill_1
XFILLER_92_247 VDD VDD VSS VSS gf180mcu_fd_sc_mcu7t5v0__fillcap_8
Xspi_regs_inst__0841_ spi_regs_inst__1582_/Q spi_regs_inst__1451_/I1 spi_regs_inst__0841_/S
+ spi_regs_inst__1582_/D VDD VDD VSS VSS gf180mcu_fd_sc_mcu7t5v0__mux2_2
XFILLER_45_163 VDD VDD VSS VSS gf180mcu_fd_sc_mcu7t5v0__fillcap_8
Xspi_regs_inst__0772_ spi_regs_inst__1446_/A1 spi_regs_inst__0772_/A2 spi_regs_inst__0780_/S
+ VDD VDD VSS VSS gf180mcu_fd_sc_mcu7t5v0__nor2_1
XFILLER_61_623 VDD VDD VSS VSS gf180mcu_fd_sc_mcu7t5v0__fillcap_4
XFILLER_60_177 VDD VDD VSS VSS gf180mcu_fd_sc_mcu7t5v0__fillcap_4
XFILLER_140_1017 VDD VDD VSS VSS gf180mcu_fd_sc_mcu7t5v0__fillcap_64
XFILLER_147_706 VDD VDD VSS VSS gf180mcu_fd_sc_mcu7t5v0__fill_2
XFILLER_159_566 VDD VDD VSS VSS gf180mcu_fd_sc_mcu7t5v0__fillcap_8
XTAP_TAPCELL_ROW_136_2120 VDD VSS gf180mcu_fd_sc_mcu7t5v0__filltie
XFILLER_128_942 VDD VDD VSS VSS gf180mcu_fd_sc_mcu7t5v0__fill_2
Xspi_regs_inst__1324_ spi_regs_inst__1605_/Q spi_regs_inst_wire286/Z spi_regs_inst__1324_/B1
+ spi_regs_inst__1324_/B2 spi_regs_inst__1326_/A3 VDD VDD VSS VSS gf180mcu_fd_sc_mcu7t5v0__aoi22_1
XFILLER_139_290 VDD VDD VSS VSS gf180mcu_fd_sc_mcu7t5v0__fill_1
XFILLER_155_761 VDD VDD VSS VSS gf180mcu_fd_sc_mcu7t5v0__fillcap_8
Xspi_regs_inst__1255_ spi_regs_inst__1566_/Q spi_regs_inst__1339_/A2 spi_regs_inst__1316_/B1
+ spi_regs_inst__1545_/Q spi_regs_inst__1258_/A2 VDD VDD VSS VSS gf180mcu_fd_sc_mcu7t5v0__aoi22_1
XFILLER_114_102 VDD VDD VSS VSS gf180mcu_fd_sc_mcu7t5v0__fill_2
XFILLER_115_625 VDD VDD VSS VSS gf180mcu_fd_sc_mcu7t5v0__fillcap_4
XFILLER_143_912 VDD VDD VSS VSS gf180mcu_fd_sc_mcu7t5v0__fillcap_64
XFILLER_155_772 VDD VDD VSS VSS gf180mcu_fd_sc_mcu7t5v0__fillcap_64
Xspi_regs_inst_wire228 spi_regs_inst_wire228/I spi_regs_inst_wire228/Z VDD VDD VSS
+ VSS gf180mcu_fd_sc_mcu7t5v0__buf_2
Xspi_regs_inst__1186_ fanout516/Z spi_regs_inst__1341_/A2 spi_regs_inst__1231_/B1
+ spi_regs_inst__1186_/B2 spi_regs_inst__1187_/A4 VDD VDD VSS VSS gf180mcu_fd_sc_mcu7t5v0__aoi22_1
XFILLER_114_168 VDD VDD VSS VSS gf180mcu_fd_sc_mcu7t5v0__fillcap_4
XFILLER_115_669 VDD VDD VSS VSS gf180mcu_fd_sc_mcu7t5v0__fill_1
XFILLER_130_617 VDD VDD VSS VSS gf180mcu_fd_sc_mcu7t5v0__fill_2
XFILLER_46_2 VDD VDD VSS VSS gf180mcu_fd_sc_mcu7t5v0__fillcap_16
XTAP_TAPCELL_ROW_114_1750 VDD VSS gf180mcu_fd_sc_mcu7t5v0__filltie
XTAP_TAPCELL_ROW_114_1761 VDD VSS gf180mcu_fd_sc_mcu7t5v0__filltie
XFILLER_111_831 VDD VDD VSS VSS gf180mcu_fd_sc_mcu7t5v0__fillcap_8
XFILLER_123_680 VDD VDD VSS VSS gf180mcu_fd_sc_mcu7t5v0__fill_2
XFILLER_69_723 VDD VDD VSS VSS gf180mcu_fd_sc_mcu7t5v0__fill_1
XFILLER_69_745 VDD VDD VSS VSS gf180mcu_fd_sc_mcu7t5v0__fill_2
Xsignal_processor_y_inst__205_ signal_processor_y_inst__215_/A1 signal_processor_y_inst__158_/Z
+ signal_processor_y_inst__205_/B signal_processor_y_inst__221_/D VDD VDD VSS VSS
+ gf180mcu_fd_sc_mcu7t5v0__oai21_1
XFILLER_111_842 VDD VDD VSS VSS gf180mcu_fd_sc_mcu7t5v0__fill_2
XFILLER_57_907 VDD VDD VSS VSS gf180mcu_fd_sc_mcu7t5v0__fill_2
Xwave_controller_x_inst__1820_ fanout539/Z wave_controller_x_inst__3391_/A1 VDD VDD
+ VSS VSS gf180mcu_fd_sc_mcu7t5v0__clkinv_1
XFILLER_110_363 VDD VDD VSS VSS gf180mcu_fd_sc_mcu7t5v0__fill_1
XFILLER_56_417 VDD VDD VSS VSS gf180mcu_fd_sc_mcu7t5v0__fillcap_8
XFILLER_68_266 VDD VDD VSS VSS gf180mcu_fd_sc_mcu7t5v0__fillcap_4
XFILLER_83_203 VDD VDD VSS VSS gf180mcu_fd_sc_mcu7t5v0__fill_1
XFILLER_84_737 VDD VDD VSS VSS gf180mcu_fd_sc_mcu7t5v0__fillcap_8
Xsignal_processor_y_inst__136_ signal_processor_y_inst__248_/Q signal_processor_y_inst__235_/Q
+ signal_processor_y_inst__161_/A2 signal_processor_y_inst__129_/Z signal_processor_y_inst__175_/A2
+ VDD VDD VSS VSS gf180mcu_fd_sc_mcu7t5v0__nand4_1
Xinput2 bidir_in[1] input2/Z VDD VDD VSS VSS gf180mcu_fd_sc_mcu7t5v0__buf_1
XTAP_TAPCELL_ROW_67_979 VDD VSS gf180mcu_fd_sc_mcu7t5v0__filltie
Xwave_controller_x_inst__3421_ wave_controller_x_inst__3417_/I wave_controller_x_inst__3441_/A1
+ wave_controller_x_inst__3421_/B wave_controller_x_inst__3421_/C wave_controller_x_inst__3423_/B1
+ VDD VDD VSS VSS gf180mcu_fd_sc_mcu7t5v0__aoi211_1
XFILLER_80_987 VDD VDD VSS VSS gf180mcu_fd_sc_mcu7t5v0__fillcap_16
XFILLER_91_291 VDD VDD VSS VSS gf180mcu_fd_sc_mcu7t5v0__fillcap_32
Xwave_controller_x_inst__3352_ wave_controller_x_inst__3318_/Z wave_controller_x_inst__3352_/A2
+ wave_controller_x_inst__3352_/B wave_controller_x_inst__3396_/A1 VDD VDD VSS VSS
+ gf180mcu_fd_sc_mcu7t5v0__aoi21_1
Xwave_controller_x_inst__3283_ wave_controller_x_inst__2797_/C spi_regs_inst__1541_/Q
+ wave_controller_x_inst__3283_/B wave_controller_x_inst__3286_/A2 VDD VDD VSS VSS
+ gf180mcu_fd_sc_mcu7t5v0__oai21_1
Xwave_controller_x_inst__2303_ max_cap455/Z wave_controller_x_inst__2302_/Z wave_controller_x_inst__2303_/Z
+ VDD VDD VSS VSS gf180mcu_fd_sc_mcu7t5v0__and2_1
Xwave_controller_y_inst__2250_ wave_controller_y_inst__2250_/A1 wave_controller_y_inst__2250_/A2
+ wave_controller_y_inst__2250_/B wave_controller_y_inst__2251_/A2 VDD VDD VSS VSS
+ gf180mcu_fd_sc_mcu7t5v0__aoi21_1
Xwave_controller_x_inst__2234_ wave_controller_x_inst__2236_/A1 max_cap457/Z wave_controller_x_inst__2259_/C
+ VDD VDD VSS VSS gf180mcu_fd_sc_mcu7t5v0__nand2_1
Xwave_controller_y_inst__2181_ spi_regs_inst__1486_/Q wave_controller_y_inst__2181_/A2
+ wave_controller_y_inst__2178_/Z wave_controller_y_inst__2181_/Z VDD VDD VSS VSS
+ gf180mcu_fd_sc_mcu7t5v0__xor3_1
Xwave_controller_x_inst__2165_ spi_regs_inst__1128_/B2 wave_controller_x_inst__2193_/A2
+ wave_controller_x_inst__2176_/A1 VDD VDD VSS VSS gf180mcu_fd_sc_mcu7t5v0__nand2_1
XFILLER_133_400 VDD VDD VSS VSS gf180mcu_fd_sc_mcu7t5v0__fillcap_4
Xwave_controller_x_inst__2096_ wave_controller_x_inst__2079_/B wave_controller_x_inst__2096_/A2
+ wave_controller_x_inst__2098_/A2 VDD VDD VSS VSS gf180mcu_fd_sc_mcu7t5v0__nand2_1
XFILLER_105_124 VDD VDD VSS VSS gf180mcu_fd_sc_mcu7t5v0__fill_1
XFILLER_106_647 VDD VDD VSS VSS gf180mcu_fd_sc_mcu7t5v0__fill_2
XFILLER_10_34 VDD VDD VSS VSS gf180mcu_fd_sc_mcu7t5v0__fill_1
XFILLER_133_422 VDD VDD VSS VSS gf180mcu_fd_sc_mcu7t5v0__fill_1
XFILLER_133_444 VDD VDD VSS VSS gf180mcu_fd_sc_mcu7t5v0__fillcap_4
XFILLER_133_477 VDD VDD VSS VSS gf180mcu_fd_sc_mcu7t5v0__fillcap_8
XFILLER_160_263 VDD VDD VSS VSS gf180mcu_fd_sc_mcu7t5v0__fill_1
XPHY_EDGE_ROW_25_1_Right_24 VDD VSS gf180mcu_fd_sc_mcu7t5v0__endcap
XTAP_TAPCELL_ROW_167_2625 VDD VSS gf180mcu_fd_sc_mcu7t5v0__filltie
XFILLER_87_520 VDD VDD VSS VSS gf180mcu_fd_sc_mcu7t5v0__fill_2
XPHY_EDGE_ROW_58_Left_225 VDD VSS gf180mcu_fd_sc_mcu7t5v0__endcap
XTAP_TAPCELL_ROW_167_2636 VDD VSS gf180mcu_fd_sc_mcu7t5v0__filltie
XTAP_TAPCELL_ROW_167_2647 VDD VSS gf180mcu_fd_sc_mcu7t5v0__filltie
XTAP_TAPCELL_ROW_167_2658 VDD VSS gf180mcu_fd_sc_mcu7t5v0__filltie
XFILLER_102_842 VDD VDD VSS VSS gf180mcu_fd_sc_mcu7t5v0__fill_2
XFILLER_86_49 VDD VDD VSS VSS gf180mcu_fd_sc_mcu7t5v0__fill_1
Xwave_controller_x_inst__2998_ wave_controller_x_inst__2938_/Z wave_controller_x_inst__2998_/A2
+ wave_controller_x_inst__2942_/Z wave_controller_x_inst__3001_/A3 VDD VDD VSS VSS
+ gf180mcu_fd_sc_mcu7t5v0__nand3_1
XFILLER_101_352 VDD VDD VSS VSS gf180mcu_fd_sc_mcu7t5v0__fillcap_16
XFILLER_142_22 VDD VDD VSS VSS gf180mcu_fd_sc_mcu7t5v0__fill_1
XFILLER_59_288 VDD VDD VSS VSS gf180mcu_fd_sc_mcu7t5v0__fillcap_4
Xwave_controller_y_inst__1965_ wave_controller_y_inst__3374_/B spi_regs_inst__1281_/A1
+ wave_controller_y_inst__1966_/B VDD VDD VSS VSS gf180mcu_fd_sc_mcu7t5v0__xor2_1
Xwave_controller_x_inst__1949_ fanout400/Z wave_controller_x_inst__3737_/Q wave_controller_x_inst__3738_/D
+ VDD VDD VSS VSS gf180mcu_fd_sc_mcu7t5v0__and2_1
XFILLER_74_247 VDD VDD VSS VSS gf180mcu_fd_sc_mcu7t5v0__fillcap_8
Xwave_controller_y_inst__3704_ wave_controller_y_inst__3704_/D fanout580/Z clkload20/I
+ wave_controller_y_inst__3704_/Q VDD VDD VSS VSS gf180mcu_fd_sc_mcu7t5v0__dffrnq_1
Xwave_controller_y_inst__3635_ wave_controller_y_inst__3635_/D wave_controller_y_inst__3708_/RN
+ clkload21/I spi_regs_inst__1343_/A1 VDD VDD VSS VSS gf180mcu_fd_sc_mcu7t5v0__dffrnq_1
Xwave_controller_y_inst__1896_ wave_controller_y_inst__3697_/Q wave_controller_y_inst__3469_/A1
+ VDD VDD VSS VSS gf180mcu_fd_sc_mcu7t5v0__clkinv_1
XFILLER_76_1014 VDD VDD VSS VSS gf180mcu_fd_sc_mcu7t5v0__fill_1
Xwave_controller_x_inst__3619_ wave_controller_x_inst__3619_/D wave_controller_x_inst__3723_/RN
+ clkload27/I _10_/A2 VDD VDD VSS VSS gf180mcu_fd_sc_mcu7t5v0__dffrnq_1
XFILLER_150_2 VDD VDD VSS VSS gf180mcu_fd_sc_mcu7t5v0__fillcap_16
XPHY_EDGE_ROW_67_Left_234 VDD VSS gf180mcu_fd_sc_mcu7t5v0__endcap
XTAP_TAPCELL_ROW_83_1248 VDD VSS gf180mcu_fd_sc_mcu7t5v0__filltie
Xwave_controller_y_inst__3566_ wave_controller_y_inst__3566_/A1 wave_controller_y_inst_wire48/Z
+ wave_controller_y_inst__3567_/B VDD VDD VSS VSS gf180mcu_fd_sc_mcu7t5v0__nand2_1
XFILLER_42_177 VDD VDD VSS VSS gf180mcu_fd_sc_mcu7t5v0__fillcap_32
Xwave_controller_y_inst__2517_ wave_controller_y_inst__2517_/A1 wave_controller_y_inst__2517_/A2
+ wave_controller_y_inst__2517_/B wave_controller_y_inst__2517_/C wave_controller_y_inst__2556_/A1
+ VDD VDD VSS VSS gf180mcu_fd_sc_mcu7t5v0__oai211_1
Xwave_controller_y_inst__3497_ wave_controller_y_inst__3497_/A1 wave_controller_y_inst_wire139/Z
+ wave_controller_y_inst__3497_/B1 wave_controller_y_inst__3497_/B2 wave_controller_y_inst__3628_/D
+ VDD VDD VSS VSS gf180mcu_fd_sc_mcu7t5v0__oai22_1
Xsignal_processor_x_inst__225_ signal_processor_x_inst__225_/D fanout582/Z clkbuf_leaf_14_clk/Z
+ spi_regs_inst__1040_/B2 VDD VDD VSS VSS gf180mcu_fd_sc_mcu7t5v0__dffrnq_1
XFILLER_129_706 VDD VDD VSS VSS gf180mcu_fd_sc_mcu7t5v0__fill_2
Xwave_controller_y_inst__2448_ wave_controller_y_inst__2432_/I wave_controller_y_inst__2445_/Z
+ wave_controller_y_inst__2449_/B1 VDD VDD VSS VSS gf180mcu_fd_sc_mcu7t5v0__nand2_1
XFILLER_129_739 VDD VDD VSS VSS gf180mcu_fd_sc_mcu7t5v0__fillcap_16
XFILLER_167_30 VDD VDD VSS VSS gf180mcu_fd_sc_mcu7t5v0__fillcap_4
Xsignal_processor_x_inst__156_ signal_processor_x_inst__202_/A2 signal_processor_x_inst__229_/Q
+ signal_processor_x_inst__231_/Q signal_processor_x_inst__129_/Z signal_processor_x_inst__163_/A2
+ VDD VDD VSS VSS gf180mcu_fd_sc_mcu7t5v0__nand4_1
XFILLER_144_709 VDD VDD VSS VSS gf180mcu_fd_sc_mcu7t5v0__fill_2
Xwave_controller_y_inst__2379_ wave_controller_y_inst__2379_/A1 spi_regs_inst__1045_/A1
+ wave_controller_y_inst__2379_/Z VDD VDD VSS VSS gf180mcu_fd_sc_mcu7t5v0__xor2_1
XFILLER_137_772 VDD VDD VSS VSS gf180mcu_fd_sc_mcu7t5v0__fillcap_8
Xspi_regs_inst__1040_ spi_regs_inst__1570_/Q spi_regs_inst__1347_/A2 spi_regs_inst__1200_/B1
+ spi_regs_inst__1040_/B2 spi_regs_inst__1070_/A1 VDD VDD VSS VSS gf180mcu_fd_sc_mcu7t5v0__aoi22_1
XTAP_TAPCELL_ROW_98_1491 VDD VSS gf180mcu_fd_sc_mcu7t5v0__filltie
XFILLER_136_282 VDD VDD VSS VSS gf180mcu_fd_sc_mcu7t5v0__fillcap_16
XFILLER_152_731 VDD VDD VSS VSS gf180mcu_fd_sc_mcu7t5v0__fillcap_4
XFILLER_87_1154 VDD VDD VSS VSS gf180mcu_fd_sc_mcu7t5v0__fillcap_16
XFILLER_124_477 VDD VDD VSS VSS gf180mcu_fd_sc_mcu7t5v0__fill_2
XFILLER_125_978 VDD VDD VSS VSS gf180mcu_fd_sc_mcu7t5v0__fill_2
XFILLER_98_807 VDD VDD VSS VSS gf180mcu_fd_sc_mcu7t5v0__fillcap_16
XPHY_EDGE_ROW_76_Left_243 VDD VSS gf180mcu_fd_sc_mcu7t5v0__endcap
XTAP_TAPCELL_ROW_16_1_453 VDD VSS gf180mcu_fd_sc_mcu7t5v0__filltie
XFILLER_66_704 VDD VDD VSS VSS gf180mcu_fd_sc_mcu7t5v0__fillcap_4
XFILLER_120_672 VDD VDD VSS VSS gf180mcu_fd_sc_mcu7t5v0__fillcap_4
XFILLER_66_737 VDD VDD VSS VSS gf180mcu_fd_sc_mcu7t5v0__fillcap_4
XFILLER_78_597 VDD VDD VSS VSS gf180mcu_fd_sc_mcu7t5v0__fillcap_16
XFILLER_93_523 VDD VDD VSS VSS gf180mcu_fd_sc_mcu7t5v0__fillcap_16
XFILLER_18_130 VDD VDD VSS VSS gf180mcu_fd_sc_mcu7t5v0__fillcap_4
XFILLER_80_206 VDD VDD VSS VSS gf180mcu_fd_sc_mcu7t5v0__fill_2
XFILLER_93_578 VDD VDD VSS VSS gf180mcu_fd_sc_mcu7t5v0__fillcap_4
XTAP_TAPCELL_ROW_64_927 VDD VSS gf180mcu_fd_sc_mcu7t5v0__filltie
Xspi_regs_inst__0824_ spi_regs_inst__1443_/I1 spi_regs_inst__1567_/Q spi_regs_inst__0824_/S
+ spi_regs_inst__1567_/D VDD VDD VSS VSS gf180mcu_fd_sc_mcu7t5v0__mux2_2
XFILLER_18_174 VDD VDD VSS VSS gf180mcu_fd_sc_mcu7t5v0__fill_1
XFILLER_18_185 VDD VDD VSS VSS gf180mcu_fd_sc_mcu7t5v0__fill_2
XPHY_EDGE_ROW_85_Left_252 VDD VSS gf180mcu_fd_sc_mcu7t5v0__endcap
XTAP_TAPCELL_ROW_64_938 VDD VSS gf180mcu_fd_sc_mcu7t5v0__filltie
XFILLER_61_431 VDD VDD VSS VSS gf180mcu_fd_sc_mcu7t5v0__fillcap_8
Xspi_regs_inst__0755_ spi_regs_inst__1384_/S spi_regs_inst__1454_/D VDD VDD VSS VSS
+ gf180mcu_fd_sc_mcu7t5v0__clkinv_1
XFILLER_159_352 VDD VDD VSS VSS gf180mcu_fd_sc_mcu7t5v0__fillcap_4
XFILLER_33_199 VDD VDD VSS VSS gf180mcu_fd_sc_mcu7t5v0__fill_1
XFILLER_147_536 VDD VDD VSS VSS gf180mcu_fd_sc_mcu7t5v0__fillcap_8
XFILLER_159_396 VDD VDD VSS VSS gf180mcu_fd_sc_mcu7t5v0__fill_1
Xspi_regs_inst__1307_ spi_regs_inst__1307_/A1 spi_regs_inst__1307_/A2 spi_regs_inst__1307_/A3
+ spi_regs_inst__1307_/A4 spi_regs_inst__1327_/A1 VDD VDD VSS VSS gf180mcu_fd_sc_mcu7t5v0__nand4_1
XFILLER_115_422 VDD VDD VSS VSS gf180mcu_fd_sc_mcu7t5v0__fillcap_64
XFILLER_127_271 VDD VDD VSS VSS gf180mcu_fd_sc_mcu7t5v0__fillcap_8
XPHY_EDGE_ROW_94_Left_261 VDD VSS gf180mcu_fd_sc_mcu7t5v0__endcap
Xspi_regs_inst__1238_ spi_regs_inst__1238_/A1 spi_regs_inst__1353_/B1 spi_regs_inst_wire210/Z
+ spi_regs_inst__1238_/B2 spi_regs_inst__1242_/A1 VDD VDD VSS VSS gf180mcu_fd_sc_mcu7t5v0__aoi22_1
XFILLER_143_786 VDD VDD VSS VSS gf180mcu_fd_sc_mcu7t5v0__fill_1
Xspi_regs_inst__1169_ spi_regs_inst__1169_/A1 spi_regs_inst__1254_/A2 spi_regs_inst__1169_/B1
+ spi_regs_inst__1169_/B2 spi_regs_inst__1170_/A4 VDD VDD VSS VSS gf180mcu_fd_sc_mcu7t5v0__aoi22_1
XFILLER_142_263 VDD VDD VSS VSS gf180mcu_fd_sc_mcu7t5v0__fill_2
XFILLER_88_317 VDD VDD VSS VSS gf180mcu_fd_sc_mcu7t5v0__fill_2
XTAP_TAPCELL_ROW_149_2333 VDD VSS gf180mcu_fd_sc_mcu7t5v0__filltie
Xwave_controller_x_inst__2921_ wave_controller_x_inst__2918_/S wave_controller_x_inst__3587_/A1
+ wave_controller_x_inst__2921_/B wave_controller_x_inst__3685_/D VDD VDD VSS VSS
+ gf180mcu_fd_sc_mcu7t5v0__oai21_1
XFILLER_69_553 VDD VDD VSS VSS gf180mcu_fd_sc_mcu7t5v0__fillcap_4
XFILLER_97_862 VDD VDD VSS VSS gf180mcu_fd_sc_mcu7t5v0__fillcap_8
Xwave_controller_x_inst__2852_ wave_controller_x_inst__2852_/A1 wave_controller_x_inst__2852_/A2
+ wave_controller_x_inst__2852_/B wave_controller_x_inst__2854_/A3 VDD VDD VSS VSS
+ gf180mcu_fd_sc_mcu7t5v0__aoi21_1
XFILLER_29_406 VDD VDD VSS VSS gf180mcu_fd_sc_mcu7t5v0__fill_1
XFILLER_96_361 VDD VDD VSS VSS gf180mcu_fd_sc_mcu7t5v0__fill_1
Xwave_controller_x_inst__1803_ wave_controller_x_inst__3614_/Q wave_controller_x_inst__3102_/A1
+ VDD VDD VSS VSS gf180mcu_fd_sc_mcu7t5v0__clkinv_1
XFILLER_56_247 VDD VDD VSS VSS gf180mcu_fd_sc_mcu7t5v0__fillcap_8
XFILLER_84_523 VDD VDD VSS VSS gf180mcu_fd_sc_mcu7t5v0__fill_2
XFILLER_84_534 VDD VDD VSS VSS gf180mcu_fd_sc_mcu7t5v0__fill_2
XTAP_TAPCELL_ROW_162_2544 VDD VSS gf180mcu_fd_sc_mcu7t5v0__filltie
XTAP_TAPCELL_ROW_162_2555 VDD VSS gf180mcu_fd_sc_mcu7t5v0__filltie
Xwave_controller_x_inst__2783_ wave_controller_x_inst__3530_/B2 wave_controller_x_inst__2793_/S
+ wave_controller_x_inst__2784_/B VDD VDD VSS VSS gf180mcu_fd_sc_mcu7t5v0__nand2_1
Xsignal_processor_y_inst__119_ signal_processor_y_inst__179_/A1 signal_processor_y_inst__255_/Q
+ signal_processor_y_inst__256_/D VDD VDD VSS VSS gf180mcu_fd_sc_mcu7t5v0__and2_1
XFILLER_37_450 VDD VDD VSS VSS gf180mcu_fd_sc_mcu7t5v0__fill_1
XFILLER_84_589 VDD VDD VSS VSS gf180mcu_fd_sc_mcu7t5v0__fillcap_4
XTAP_TAPCELL_ROW_127_1974 VDD VSS gf180mcu_fd_sc_mcu7t5v0__filltie
XFILLER_52_453 VDD VDD VSS VSS gf180mcu_fd_sc_mcu7t5v0__fill_2
XFILLER_53_954 VDD VDD VSS VSS gf180mcu_fd_sc_mcu7t5v0__fillcap_32
XFILLER_72_18 VDD VDD VSS VSS gf180mcu_fd_sc_mcu7t5v0__fill_2
XTAP_TAPCELL_ROW_33_1_578 VDD VSS gf180mcu_fd_sc_mcu7t5v0__filltie
Xwave_controller_y_inst__3420_ wave_controller_y_inst__3420_/A1 wave_controller_y_inst__3489_/A2
+ wave_controller_y_inst__3420_/B1 wave_controller_y_inst__3447_/S wave_controller_y_inst__3489_/C
+ wave_controller_y_inst__3421_/B VDD VDD VSS VSS gf180mcu_fd_sc_mcu7t5v0__aoi221_1
Xwave_controller_x_inst__3404_ wave_controller_x_inst__3404_/A1 wave_controller_x_inst__3404_/A2
+ wave_controller_x_inst__3404_/B wave_controller_x_inst__3616_/D VDD VDD VSS VSS
+ gf180mcu_fd_sc_mcu7t5v0__aoi21_1
XFILLER_24_177 VDD VDD VSS VSS gf180mcu_fd_sc_mcu7t5v0__fill_2
XFILLER_52_486 VDD VDD VSS VSS gf180mcu_fd_sc_mcu7t5v0__fillcap_4
XFILLER_80_773 VDD VDD VSS VSS gf180mcu_fd_sc_mcu7t5v0__fill_2
Xwave_controller_y_inst__3351_ wave_controller_y_inst__3352_/B wave_controller_y_inst__3318_/Z
+ wave_controller_y_inst__3352_/A2 wave_controller_y_inst__3396_/B VDD VDD VSS VSS
+ gf180mcu_fd_sc_mcu7t5v0__nand3_1
Xwave_controller_x_inst__3335_ wave_controller_x_inst__3336_/A1 wave_controller_x_inst__3336_/A2
+ wave_controller_x_inst__3335_/Z VDD VDD VSS VSS gf180mcu_fd_sc_mcu7t5v0__and2_1
XFILLER_127_1170 VDD VDD VSS VSS gf180mcu_fd_sc_mcu7t5v0__fillcap_4
XFILLER_166_801 VDD VDD VSS VSS gf180mcu_fd_sc_mcu7t5v0__fillcap_4
Xwave_controller_y_inst__2302_ wave_controller_y_inst__3212_/B wave_controller_y_inst__2298_/Z
+ wave_controller_y_inst__2302_/A3 wave_controller_y_inst__2302_/Z VDD VDD VSS VSS
+ gf180mcu_fd_sc_mcu7t5v0__xor3_1
Xwave_controller_y_inst__3282_ wave_controller_y_inst__3701_/Q wave_controller_y_inst__3378_/A2
+ wave_controller_y_inst__3282_/B wave_controller_y_inst__3377_/B VDD VDD VSS VSS
+ gf180mcu_fd_sc_mcu7t5v0__aoi21_1
Xwave_controller_x_inst__3266_ wave_controller_x_inst__3266_/A1 spi_regs_inst__1553_/Q
+ wave_controller_x_inst__3355_/A1 VDD VDD VSS VSS gf180mcu_fd_sc_mcu7t5v0__nand2_1
XFILLER_20_383 VDD VDD VSS VSS gf180mcu_fd_sc_mcu7t5v0__fill_2
Xwave_controller_y_inst__2233_ max_cap427/Z wave_controller_y_inst__2228_/Z wave_controller_y_inst__2233_/B
+ wave_controller_y_inst__2247_/A1 VDD VDD VSS VSS gf180mcu_fd_sc_mcu7t5v0__aoi21_1
Xwave_controller_x_inst__3197_ wave_controller_x_inst__3197_/A1 wave_controller_x_inst__3109_/Z
+ wave_controller_x_inst__3198_/A2 VDD VDD VSS VSS gf180mcu_fd_sc_mcu7t5v0__nor2_1
Xwave_controller_x_inst__2217_ wave_controller_x_inst__2226_/A1 spi_regs_inst__1320_/A1
+ wave_controller_x_inst__2259_/A1 VDD VDD VSS VSS gf180mcu_fd_sc_mcu7t5v0__nand2_1
XFILLER_119_772 VDD VDD VSS VSS gf180mcu_fd_sc_mcu7t5v0__fillcap_32
Xwave_controller_y_inst__2164_ wave_controller_y_inst__2757_/A1 wave_controller_y_inst__2164_/A2
+ wave_controller_y_inst__2170_/A2 wave_controller_y_inst__2757_/B VDD VDD VSS VSS
+ gf180mcu_fd_sc_mcu7t5v0__nor3_1
Xwave_controller_x_inst__2148_ wave_controller_x_inst__3732_/Q wave_controller_x_inst__2152_/A2
+ wave_controller_x_inst__2148_/Z VDD VDD VSS VSS gf180mcu_fd_sc_mcu7t5v0__xor2_1
XFILLER_118_293 VDD VDD VSS VSS gf180mcu_fd_sc_mcu7t5v0__fillcap_4
XFILLER_21_66 VDD VDD VSS VSS gf180mcu_fd_sc_mcu7t5v0__fillcap_4
XFILLER_4_527 VDD VDD VSS VSS gf180mcu_fd_sc_mcu7t5v0__fillcap_16
XFILLER_134_775 VDD VDD VSS VSS gf180mcu_fd_sc_mcu7t5v0__fillcap_8
Xwave_controller_y_inst__2095_ wave_controller_y_inst__2109_/B wave_controller_y_inst__2109_/A2
+ wave_controller_y_inst__2095_/B wave_controller_y_inst__2095_/C wave_controller_y_inst__2098_/A1
+ VDD VDD VSS VSS gf180mcu_fd_sc_mcu7t5v0__aoi211_1
Xwave_controller_x_inst__2079_ wave_controller_x_inst__2079_/A1 wave_controller_x_inst__2096_/A2
+ wave_controller_x_inst__2079_/B wave_controller_x_inst__2081_/A2 VDD VDD VSS VSS
+ gf180mcu_fd_sc_mcu7t5v0__aoi21_1
XFILLER_133_274 VDD VDD VSS VSS gf180mcu_fd_sc_mcu7t5v0__fillcap_4
XFILLER_134_797 VDD VDD VSS VSS gf180mcu_fd_sc_mcu7t5v0__fillcap_8
XFILLER_161_594 VDD VDD VSS VSS gf180mcu_fd_sc_mcu7t5v0__fill_2
XFILLER_102_683 VDD VDD VSS VSS gf180mcu_fd_sc_mcu7t5v0__fill_2
XFILLER_153_98 VDD VDD VSS VSS gf180mcu_fd_sc_mcu7t5v0__fillcap_4
XFILLER_75_545 VDD VDD VSS VSS gf180mcu_fd_sc_mcu7t5v0__fillcap_8
Xwave_controller_y_inst__2997_ wave_controller_y_inst__2938_/Z wave_controller_y_inst__2998_/A2
+ wave_controller_y_inst__3079_/A2 VDD VDD VSS VSS gf180mcu_fd_sc_mcu7t5v0__nand2_1
XFILLER_63_718 VDD VDD VSS VSS gf180mcu_fd_sc_mcu7t5v0__fill_2
Xwave_controller_y_inst__1948_ wave_controller_y_inst__3010_/B wave_controller_y_inst__3738_/Q
+ wave_controller_y_inst__3739_/D VDD VDD VSS VSS gf180mcu_fd_sc_mcu7t5v0__and2_1
XFILLER_62_217 VDD VDD VSS VSS gf180mcu_fd_sc_mcu7t5v0__fill_1
XFILLER_62_228 VDD VDD VSS VSS gf180mcu_fd_sc_mcu7t5v0__fill_2
XFILLER_90_537 VDD VDD VSS VSS gf180mcu_fd_sc_mcu7t5v0__fillcap_8
Xwave_controller_y_inst__1879_ max_cap432/I wave_controller_y_inst__3527_/B2 VDD VDD
+ VSS VSS gf180mcu_fd_sc_mcu7t5v0__clkinv_1
XFILLER_15_122 VDD VDD VSS VSS gf180mcu_fd_sc_mcu7t5v0__fill_1
XFILLER_71_740 VDD VDD VSS VSS gf180mcu_fd_sc_mcu7t5v0__fillcap_4
Xwave_controller_y_inst__3618_ wave_controller_y_inst__3618_/D wave_controller_y_inst__3618_/RN
+ clkload4/I _09_/A1 VDD VDD VSS VSS gf180mcu_fd_sc_mcu7t5v0__dffrnq_1
Xwave_controller_y_inst__3549_ wave_controller_y_inst__3719_/Q wave_controller_y_inst__3555_/A2
+ wave_controller_y_inst__3551_/A2 VDD VDD VSS VSS gf180mcu_fd_sc_mcu7t5v0__nor2_1
Xsignal_processor_x_inst__208_ spi_regs_inst__1167_/B2 signal_processor_x_inst__214_/A2
+ signal_processor_x_inst__209_/B VDD VDD VSS VSS gf180mcu_fd_sc_mcu7t5v0__nand2_1
Xsignal_processor_x_inst__139_ signal_processor_x_inst__237_/Q signal_processor_x_inst__141_/A2
+ signal_processor_x_inst__146_/A2 VDD VDD VSS VSS gf180mcu_fd_sc_mcu7t5v0__nand2_1
XFILLER_144_506 VDD VDD VSS VSS gf180mcu_fd_sc_mcu7t5v0__fill_2
XFILLER_156_377 VDD VDD VSS VSS gf180mcu_fd_sc_mcu7t5v0__fillcap_8
XFILLER_137_591 VDD VDD VSS VSS gf180mcu_fd_sc_mcu7t5v0__fill_1
XFILLER_7_398 VDD VDD VSS VSS gf180mcu_fd_sc_mcu7t5v0__fillcap_8
XFILLER_124_241 VDD VDD VSS VSS gf180mcu_fd_sc_mcu7t5v0__fillcap_4
XFILLER_139_1052 VDD VDD VSS VSS gf180mcu_fd_sc_mcu7t5v0__fillcap_64
Xspi_regs_inst__1023_ spi_regs_inst__1030_/A1 spi_regs_inst__1023_/A2 spi_regs_inst__1038_/B1
+ VDD VDD VSS VSS gf180mcu_fd_sc_mcu7t5v0__nor2_1
XFILLER_124_274 VDD VDD VSS VSS gf180mcu_fd_sc_mcu7t5v0__fill_2
XFILLER_140_734 VDD VDD VSS VSS gf180mcu_fd_sc_mcu7t5v0__fill_1
XFILLER_66_512 VDD VDD VSS VSS gf180mcu_fd_sc_mcu7t5v0__fillcap_8
XFILLER_78_361 VDD VDD VSS VSS gf180mcu_fd_sc_mcu7t5v0__fillcap_8
XFILLER_38_247 VDD VDD VSS VSS gf180mcu_fd_sc_mcu7t5v0__fill_2
XFILLER_81_504 VDD VDD VSS VSS gf180mcu_fd_sc_mcu7t5v0__fillcap_16
XTAP_TAPCELL_ROW_144_2252 VDD VSS gf180mcu_fd_sc_mcu7t5v0__filltie
XTAP_TAPCELL_ROW_109_1671 VDD VSS gf180mcu_fd_sc_mcu7t5v0__filltie
XTAP_TAPCELL_ROW_109_1682 VDD VSS gf180mcu_fd_sc_mcu7t5v0__filltie
XFILLER_81_559 VDD VDD VSS VSS gf180mcu_fd_sc_mcu7t5v0__fill_1
Xspi_regs_inst__0807_ spi_regs_inst__1653_/Q spi_regs_inst__1652_/Q spi_regs_inst__0852_/A1
+ VDD VDD VSS VSS gf180mcu_fd_sc_mcu7t5v0__nor2_1
Xspi_regs_inst__0738_ spi_regs_inst__1633_/Q spi_regs_inst__1374_/A1 VDD VDD VSS VSS
+ gf180mcu_fd_sc_mcu7t5v0__clkinv_1
XFILLER_21_114 VDD VDD VSS VSS gf180mcu_fd_sc_mcu7t5v0__fillcap_16
XFILLER_61_272 VDD VDD VSS VSS gf180mcu_fd_sc_mcu7t5v0__fill_2
XTAP_TAPCELL_ROW_122_1882 VDD VSS gf180mcu_fd_sc_mcu7t5v0__filltie
XTAP_TAPCELL_ROW_122_1893 VDD VSS gf180mcu_fd_sc_mcu7t5v0__filltie
Xwave_controller_x_inst__3120_ wave_controller_x_inst__3568_/A1 spi_regs_inst__1525_/Q
+ wave_controller_x_inst__3218_/A1 VDD VDD VSS VSS gf180mcu_fd_sc_mcu7t5v0__nand2_1
Xwave_controller_x_inst__3051_ wave_controller_x_inst__3091_/A1 wave_controller_x_inst__3051_/A2
+ wave_controller_x_inst__3052_/B2 VDD VDD VSS VSS gf180mcu_fd_sc_mcu7t5v0__nand2_1
XFILLER_135_517 VDD VDD VSS VSS gf180mcu_fd_sc_mcu7t5v0__fill_1
Xwave_controller_x_inst__2002_ wave_controller_x_inst__2000_/Z wave_controller_x_inst__2002_/A2
+ spi_regs_inst__1224_/B2 VDD VDD VSS VSS gf180mcu_fd_sc_mcu7t5v0__nor2_1
XFILLER_130_211 VDD VDD VSS VSS gf180mcu_fd_sc_mcu7t5v0__fill_2
XFILLER_130_233 VDD VDD VSS VSS gf180mcu_fd_sc_mcu7t5v0__fillcap_8
XFILLER_67_18 VDD VDD VSS VSS gf180mcu_fd_sc_mcu7t5v0__fillcap_8
Xwave_controller_y_inst__2920_ spi_regs_inst__1333_/B2 wave_controller_y_inst__2923_/S
+ wave_controller_y_inst__2921_/B VDD VDD VSS VSS gf180mcu_fd_sc_mcu7t5v0__nand2_1
Xwave_controller_x_inst__2904_ wave_controller_x_inst__2896_/B wave_controller_x_inst__2897_/Z
+ wave_controller_x_inst__2898_/Z wave_controller_x_inst_wire84/I VDD VDD VSS VSS
+ gf180mcu_fd_sc_mcu7t5v0__nor3_1
XFILLER_97_670 VDD VDD VSS VSS gf180mcu_fd_sc_mcu7t5v0__fillcap_4
Xwave_controller_y_inst__2851_ wave_controller_y_inst__2851_/A1 wave_controller_y_inst__2851_/A2
+ wave_controller_y_inst__2852_/B VDD VDD VSS VSS gf180mcu_fd_sc_mcu7t5v0__nand2_1
Xwave_controller_y_inst__1802_ wave_controller_y_inst__3613_/Q wave_controller_y_inst__3101_/A1
+ VDD VDD VSS VSS gf180mcu_fd_sc_mcu7t5v0__clkinv_1
Xwave_controller_x_inst__2835_ wave_controller_x_inst__3712_/Q wave_controller_x_inst__2835_/A2
+ wave_controller_x_inst__2835_/B wave_controller_x_inst__2835_/C wave_controller_x_inst__2839_/A2
+ VDD VDD VSS VSS gf180mcu_fd_sc_mcu7t5v0__oai211_1
XFILLER_123_68 VDD VDD VSS VSS gf180mcu_fd_sc_mcu7t5v0__fill_2
Xwave_controller_y_inst__2782_ wave_controller_y_inst__3163_/C wave_controller_y_inst__2819_/A2
+ wave_controller_y_inst__2820_/C VDD VDD VSS VSS gf180mcu_fd_sc_mcu7t5v0__nor2_1
Xwave_controller_x_inst__2766_ wave_controller_x_inst__2910_/B wave_controller_x_inst__3008_/A2
+ wave_controller_x_inst__2766_/ZN VDD VDD VSS VSS gf180mcu_fd_sc_mcu7t5v0__nand2_1
XFILLER_44_206 VDD VDD VSS VSS gf180mcu_fd_sc_mcu7t5v0__fillcap_32
XFILLER_72_559 VDD VDD VSS VSS gf180mcu_fd_sc_mcu7t5v0__fillcap_4
Xwave_controller_x_inst__2697_ wave_controller_x_inst__2697_/A1 wave_controller_x_inst__2697_/A2
+ spi_regs_inst__1346_/B2 VDD VDD VSS VSS gf180mcu_fd_sc_mcu7t5v0__xor2_1
XFILLER_53_784 VDD VDD VSS VSS gf180mcu_fd_sc_mcu7t5v0__fillcap_32
XTAP_TAPCELL_ROW_15_1_441 VDD VSS gf180mcu_fd_sc_mcu7t5v0__filltie
XTAP_TAPCELL_ROW_55_779 VDD VSS gf180mcu_fd_sc_mcu7t5v0__filltie
Xwave_controller_y_inst__3403_ wave_controller_y_inst__3403_/A1 wave_controller_y_inst__3346_/Z
+ wave_controller_y_inst__3403_/A3 wave_controller_y_inst__3403_/A4 wave_controller_y_inst__3404_/A2
+ VDD VDD VSS VSS gf180mcu_fd_sc_mcu7t5v0__nand4_1
XFILLER_157_119 VDD VDD VSS VSS gf180mcu_fd_sc_mcu7t5v0__fillcap_16
XFILLER_8_107 VDD VDD VSS VSS gf180mcu_fd_sc_mcu7t5v0__fillcap_64
Xwave_controller_y_inst__3334_ wave_controller_y_inst__3081_/B spi_regs_inst__1615_/Q
+ wave_controller_y_inst__3328_/Z wave_controller_y_inst__3336_/A2 VDD VDD VSS VSS
+ gf180mcu_fd_sc_mcu7t5v0__nand3_1
Xwave_controller_x_inst__3318_ wave_controller_x_inst__3350_/A1 wave_controller_x_inst__3315_/Z
+ wave_controller_x_inst__3350_/B wave_controller_x_inst__3318_/Z VDD VDD VSS VSS
+ gf180mcu_fd_sc_mcu7t5v0__or3_1
XFILLER_138_333 VDD VDD VSS VSS gf180mcu_fd_sc_mcu7t5v0__fillcap_4
XFILLER_138_344 VDD VDD VSS VSS gf180mcu_fd_sc_mcu7t5v0__fill_1
Xwave_controller_y_inst__3265_ wave_controller_y_inst__3265_/A1 spi_regs_inst__1612_/Q
+ wave_controller_y_inst__3315_/A1 VDD VDD VSS VSS gf180mcu_fd_sc_mcu7t5v0__nand2_1
Xwave_controller_x_inst__3249_ wave_controller_x_inst__3175_/Z wave_controller_x_inst__3249_/A2
+ wave_controller_x_inst__3249_/Z VDD VDD VSS VSS gf180mcu_fd_sc_mcu7t5v0__xor2_1
XFILLER_153_303 VDD VDD VSS VSS gf180mcu_fd_sc_mcu7t5v0__fillcap_4
Xwave_controller_y_inst__2216_ wave_controller_y_inst__3566_/A1 wave_controller_y_inst__2207_/Z
+ wave_controller_y_inst__2216_/B wave_controller_y_inst__2248_/C1 VDD VDD VSS VSS
+ gf180mcu_fd_sc_mcu7t5v0__aoi21_1
XFILLER_165_174 VDD VDD VSS VSS gf180mcu_fd_sc_mcu7t5v0__fillcap_16
XTAP_TAPCELL_ROW_78_1158 VDD VSS gf180mcu_fd_sc_mcu7t5v0__filltie
XTAP_TAPCELL_ROW_78_1169 VDD VSS gf180mcu_fd_sc_mcu7t5v0__filltie
Xwave_controller_y_inst__3196_ wave_controller_y_inst__3107_/Z wave_controller_y_inst__3196_/A2
+ wave_controller_y_inst__3196_/Z VDD VDD VSS VSS gf180mcu_fd_sc_mcu7t5v0__xor2_1
Xwave_controller_y_inst__2147_ wave_controller_y_inst__2147_/I wave_controller_y_inst__2152_/A2
+ VDD VDD VSS VSS gf180mcu_fd_sc_mcu7t5v0__clkinv_1
XTAP_TAPCELL_ROW_95_1450 VDD VSS gf180mcu_fd_sc_mcu7t5v0__filltie
XFILLER_84_1157 VDD VDD VSS VSS gf180mcu_fd_sc_mcu7t5v0__fillcap_16
Xwave_controller_y_inst__2078_ wave_controller_y_inst__2095_/C wave_controller_y_inst__2095_/B
+ wave_controller_y_inst__2109_/B wave_controller_y_inst__2096_/A2 VDD VDD VSS VSS
+ gf180mcu_fd_sc_mcu7t5v0__oai21_1
XFILLER_122_767 VDD VDD VSS VSS gf180mcu_fd_sc_mcu7t5v0__fill_1
XFILLER_95_607 VDD VDD VSS VSS gf180mcu_fd_sc_mcu7t5v0__fillcap_4
Xwave_controller_x_inst_fanout331 wave_controller_x_inst__3407_/B wave_controller_x_inst__3406_/A1
+ VDD VDD VSS VSS gf180mcu_fd_sc_mcu7t5v0__dlyb_1
XFILLER_48_523 VDD VDD VSS VSS gf180mcu_fd_sc_mcu7t5v0__fill_2
XFILLER_113_90 VDD VDD VSS VSS gf180mcu_fd_sc_mcu7t5v0__fill_1
XFILLER_28_280 VDD VDD VSS VSS gf180mcu_fd_sc_mcu7t5v0__fill_2
XFILLER_63_559 VDD VDD VSS VSS gf180mcu_fd_sc_mcu7t5v0__fill_1
XFILLER_91_868 VDD VDD VSS VSS gf180mcu_fd_sc_mcu7t5v0__fill_1
Xspi_regs_inst__1641_ spi_regs_inst__1641_/D fanout560/Z clkload7/I spi_regs_inst__1641_/Q
+ VDD VDD VSS VSS gf180mcu_fd_sc_mcu7t5v0__dffrnq_1
XFILLER_73_72 VDD VDD VSS VSS gf180mcu_fd_sc_mcu7t5v0__fill_2
Xspi_regs_inst__1572_ spi_regs_inst__1572_/D spi_regs_inst__1610_/RN clkload17/I spi_regs_inst__1572_/Q
+ VDD VDD VSS VSS gf180mcu_fd_sc_mcu7t5v0__dffrnq_1
XTAP_TAPCELL_ROW_104_1590 VDD VSS gf180mcu_fd_sc_mcu7t5v0__filltie
XFILLER_129_311 VDD VDD VSS VSS gf180mcu_fd_sc_mcu7t5v0__fillcap_8
XFILLER_117_528 VDD VDD VSS VSS gf180mcu_fd_sc_mcu7t5v0__fill_2
XFILLER_144_314 VDD VDD VSS VSS gf180mcu_fd_sc_mcu7t5v0__fill_1
XFILLER_144_325 VDD VDD VSS VSS gf180mcu_fd_sc_mcu7t5v0__fillcap_4
XFILLER_156_174 VDD VDD VSS VSS gf180mcu_fd_sc_mcu7t5v0__fill_1
XFILLER_89_1046 VDD VDD VSS VSS gf180mcu_fd_sc_mcu7t5v0__fillcap_4
XTAP_TAPCELL_ROW_24_1_509 VDD VSS gf180mcu_fd_sc_mcu7t5v0__filltie
XFILLER_160_807 VDD VDD VSS VSS gf180mcu_fd_sc_mcu7t5v0__fillcap_64
Xstate_machine_inst__36_ spi_regs_inst__1146_/A1 state_machine_inst__37_/A1 state_machine_inst__37_/B
+ VDD VDD VSS VSS gf180mcu_fd_sc_mcu7t5v0__nor2_1
XFILLER_140_531 VDD VDD VSS VSS gf180mcu_fd_sc_mcu7t5v0__fill_2
XFILLER_152_391 VDD VDD VSS VSS gf180mcu_fd_sc_mcu7t5v0__fill_1
XFILLER_98_434 VDD VDD VSS VSS gf180mcu_fd_sc_mcu7t5v0__fillcap_8
Xspi_regs_inst__1006_ spi_regs_inst__1006_/A1 spi_regs_inst__1342_/B1 spi_regs_inst__1039_/A1
+ VDD VDD VSS VSS gf180mcu_fd_sc_mcu7t5v0__nand2_1
XFILLER_112_255 VDD VDD VSS VSS gf180mcu_fd_sc_mcu7t5v0__fill_1
XFILLER_140_597 VDD VDD VSS VSS gf180mcu_fd_sc_mcu7t5v0__fillcap_4
XFILLER_39_512 VDD VDD VSS VSS gf180mcu_fd_sc_mcu7t5v0__fill_1
XFILLER_66_342 VDD VDD VSS VSS gf180mcu_fd_sc_mcu7t5v0__fillcap_16
Xwave_controller_x_inst__2620_ wave_controller_x_inst__2620_/A1 wave_controller_x_inst__2620_/A2
+ wave_controller_x_inst__2620_/A3 wave_controller_x_inst__2620_/B wave_controller_x_inst__2621_/A2
+ VDD VDD VSS VSS gf180mcu_fd_sc_mcu7t5v0__oai31_1
XFILLER_26_206 VDD VDD VSS VSS gf180mcu_fd_sc_mcu7t5v0__fill_1
XFILLER_54_537 VDD VDD VSS VSS gf180mcu_fd_sc_mcu7t5v0__fill_2
XFILLER_96_1017 VDD VDD VSS VSS gf180mcu_fd_sc_mcu7t5v0__fillcap_64
Xwave_controller_x_inst__2551_ wave_controller_x_inst__2534_/B wave_controller_x_inst__2555_/C
+ wave_controller_x_inst__2553_/A3 VDD VDD VSS VSS gf180mcu_fd_sc_mcu7t5v0__nand2_1
XFILLER_81_356 VDD VDD VSS VSS gf180mcu_fd_sc_mcu7t5v0__fill_2
XFILLER_82_857 VDD VDD VSS VSS gf180mcu_fd_sc_mcu7t5v0__fillcap_8
XTAP_TAPCELL_ROW_124_1922 VDD VSS gf180mcu_fd_sc_mcu7t5v0__filltie
Xwave_controller_x_inst__2482_ wave_controller_x_inst__2482_/A1 wave_controller_x_inst__2479_/I
+ wave_controller_x_inst__2482_/B wave_controller_x_inst__2509_/A2 VDD VDD VSS VSS
+ gf180mcu_fd_sc_mcu7t5v0__aoi21_1
XPHY_EDGE_ROW_34_1_Right_33 VDD VSS gf180mcu_fd_sc_mcu7t5v0__endcap
XFILLER_124_1151 VDD VDD VSS VSS gf180mcu_fd_sc_mcu7t5v0__fillcap_4
XFILLER_148_631 VDD VDD VSS VSS gf180mcu_fd_sc_mcu7t5v0__fill_2
XFILLER_148_642 VDD VDD VSS VSS gf180mcu_fd_sc_mcu7t5v0__fill_1
XTAP_TAPCELL_ROW_157_2465 VDD VSS gf180mcu_fd_sc_mcu7t5v0__filltie
Xwave_controller_x_inst__3103_ wave_controller_x_inst__3616_/Q wave_controller_x_inst__3615_/Q
+ wave_controller_x_inst__3406_/A3 VDD VDD VSS VSS gf180mcu_fd_sc_mcu7t5v0__nand2_1
XFILLER_124_1173 VDD VDD VSS VSS gf180mcu_fd_sc_mcu7t5v0__fill_1
XFILLER_135_303 VDD VDD VSS VSS gf180mcu_fd_sc_mcu7t5v0__fill_2
XFILLER_136_804 VDD VDD VSS VSS gf180mcu_fd_sc_mcu7t5v0__fill_1
Xwave_controller_y_inst__3050_ wave_controller_y_inst__2956_/I wave_controller_y_inst__2957_/Z
+ wave_controller_y_inst__3050_/B wave_controller_y_inst__3052_/B1 VDD VDD VSS VSS
+ gf180mcu_fd_sc_mcu7t5v0__aoi21_1
Xwave_controller_y_inst__2001_ wave_controller_y_inst__2001_/A1 wave_controller_y_inst__2001_/A2
+ wave_controller_y_inst__2001_/B wave_controller_y_inst__2002_/A2 VDD VDD VSS VSS
+ gf180mcu_fd_sc_mcu7t5v0__aoi21_1
Xwave_controller_x_inst__3034_ wave_controller_x_inst__3036_/B2 wave_controller_x_inst__3409_/A3
+ wave_controller_x_inst__3034_/A3 wave_controller_x_inst_wire60/Z wave_controller_x_inst__3479_/A1
+ wave_controller_x_inst__3698_/D VDD VDD VSS VSS gf180mcu_fd_sc_mcu7t5v0__oai32_1
XFILLER_118_57 VDD VDD VSS VSS gf180mcu_fd_sc_mcu7t5v0__fill_2
XTAP_TAPCELL_ROW_18_1_467 VDD VSS gf180mcu_fd_sc_mcu7t5v0__filltie
XFILLER_104_723 VDD VDD VSS VSS gf180mcu_fd_sc_mcu7t5v0__fillcap_8
XFILLER_150_317 VDD VDD VSS VSS gf180mcu_fd_sc_mcu7t5v0__fillcap_8
XFILLER_162_177 VDD VDD VSS VSS gf180mcu_fd_sc_mcu7t5v0__fillcap_32
Xwave_controller_x_inst_wire117 wave_controller_x_inst_wire117/I wave_controller_x_inst_wire117/Z
+ VDD VDD VSS VSS gf180mcu_fd_sc_mcu7t5v0__clkbuf_1
XFILLER_104_745 VDD VDD VSS VSS gf180mcu_fd_sc_mcu7t5v0__fill_2
XFILLER_116_594 VDD VDD VSS VSS gf180mcu_fd_sc_mcu7t5v0__fill_1
XFILLER_131_564 VDD VDD VSS VSS gf180mcu_fd_sc_mcu7t5v0__fill_1
XFILLER_131_575 VDD VDD VSS VSS gf180mcu_fd_sc_mcu7t5v0__fill_1
XTAP_TAPCELL_ROW_73_1077 VDD VSS gf180mcu_fd_sc_mcu7t5v0__filltie
XTAP_TAPCELL_ROW_73_1088 VDD VSS gf180mcu_fd_sc_mcu7t5v0__filltie
Xwave_controller_y_inst__2903_ wave_controller_y_inst__3407_/B wave_controller_y_inst__1902_/I
+ wave_controller_y_inst__2933_/A2 VDD VDD VSS VSS gf180mcu_fd_sc_mcu7t5v0__nor2_1
XFILLER_131_1122 VDD VDD VSS VSS gf180mcu_fd_sc_mcu7t5v0__fillcap_32
XFILLER_134_45 VDD VDD VSS VSS gf180mcu_fd_sc_mcu7t5v0__fill_1
XFILLER_94_16 VDD VDD VSS VSS gf180mcu_fd_sc_mcu7t5v0__fillcap_4
Xwave_controller_y_inst__2834_ wave_controller_y_inst__3266_/A1 wave_controller_y_inst__2834_/A2
+ wave_controller_y_inst__2834_/B wave_controller_y_inst__2834_/C wave_controller_y_inst__2835_/C
+ VDD VDD VSS VSS gf180mcu_fd_sc_mcu7t5v0__aoi211_1
Xwave_controller_x_inst__2818_ wave_controller_x_inst__2818_/A1 wave_controller_x_inst__2818_/A2
+ wave_controller_x_inst__2818_/B wave_controller_x_inst__2820_/B1 VDD VDD VSS VSS
+ gf180mcu_fd_sc_mcu7t5v0__oai21_1
XFILLER_45_504 VDD VDD VSS VSS gf180mcu_fd_sc_mcu7t5v0__fill_1
XFILLER_72_301 VDD VDD VSS VSS gf180mcu_fd_sc_mcu7t5v0__fill_2
Xwave_controller_y_inst__2765_ wave_controller_y_inst__3407_/B wave_controller_y_inst__2764_/Z
+ wave_controller_y_inst__3491_/B VDD VDD VSS VSS gf180mcu_fd_sc_mcu7t5v0__nor2_2
Xwave_controller_x_inst__2749_ wave_controller_x_inst__2749_/A1 wave_controller_x_inst_wire36/Z
+ wave_controller_x_inst__2749_/B wave_controller_x_inst__2750_/A2 VDD VDD VSS VSS
+ gf180mcu_fd_sc_mcu7t5v0__oai21_1
XFILLER_150_88 VDD VDD VSS VSS gf180mcu_fd_sc_mcu7t5v0__fillcap_4
Xwave_controller_y_inst__2696_ wave_controller_y_inst__2676_/Z wave_controller_y_inst__2696_/A2
+ wave_controller_y_inst__2697_/A2 VDD VDD VSS VSS gf180mcu_fd_sc_mcu7t5v0__nand2_1
XFILLER_53_570 VDD VDD VSS VSS gf180mcu_fd_sc_mcu7t5v0__fill_2
XFILLER_43_64 VDD VDD VSS VSS gf180mcu_fd_sc_mcu7t5v0__fillcap_4
XFILLER_43_86 VDD VDD VSS VSS gf180mcu_fd_sc_mcu7t5v0__fill_1
Xwave_controller_y_inst__3317_ wave_controller_y_inst__3715_/Q spi_regs_inst__1613_/Q
+ wave_controller_y_inst__3350_/B VDD VDD VSS VSS gf180mcu_fd_sc_mcu7t5v0__xor2_1
XFILLER_127_848 VDD VDD VSS VSS gf180mcu_fd_sc_mcu7t5v0__fill_2
XFILLER_153_111 VDD VDD VSS VSS gf180mcu_fd_sc_mcu7t5v0__fill_1
XFILLER_154_645 VDD VDD VSS VSS gf180mcu_fd_sc_mcu7t5v0__fill_2
Xwave_controller_y_inst__3248_ wave_controller_y_inst__3252_/A1 wave_controller_y_inst__3248_/A2
+ wave_controller_y_inst__3248_/B wave_controller_y_inst__3251_/A1 VDD VDD VSS VSS
+ gf180mcu_fd_sc_mcu7t5v0__oai21_1
XFILLER_126_347 VDD VDD VSS VSS gf180mcu_fd_sc_mcu7t5v0__fill_1
XFILLER_99_209 VDD VDD VSS VSS gf180mcu_fd_sc_mcu7t5v0__fill_1
Xwave_controller_y_inst__3179_ wave_controller_y_inst__3252_/A1 wave_controller_y_inst__3248_/A2
+ wave_controller_y_inst__3179_/B wave_controller_y_inst__3194_/A1 VDD VDD VSS VSS
+ gf180mcu_fd_sc_mcu7t5v0__oai21_1
XTAP_TAPCELL_ROW_93_1409 VDD VSS gf180mcu_fd_sc_mcu7t5v0__filltie
XFILLER_136_1011 VDD VDD VSS VSS gf180mcu_fd_sc_mcu7t5v0__fillcap_4
XFILLER_110_737 VDD VDD VSS VSS gf180mcu_fd_sc_mcu7t5v0__fill_1
XFILLER_122_597 VDD VDD VSS VSS gf180mcu_fd_sc_mcu7t5v0__fillcap_4
XFILLER_67_139 VDD VDD VSS VSS gf180mcu_fd_sc_mcu7t5v0__fill_1
XFILLER_48_331 VDD VDD VSS VSS gf180mcu_fd_sc_mcu7t5v0__fillcap_32
XFILLER_76_662 VDD VDD VSS VSS gf180mcu_fd_sc_mcu7t5v0__fill_2
Xwave_controller_x_inst_fanout161 wave_controller_x_inst__2766_/ZN wave_controller_x_inst__3542_/A1
+ VDD VDD VSS VSS gf180mcu_fd_sc_mcu7t5v0__dlyb_1
XTAP_TAPCELL_ROW_141_2200 VDD VSS gf180mcu_fd_sc_mcu7t5v0__filltie
XTAP_TAPCELL_ROW_141_2211 VDD VSS gf180mcu_fd_sc_mcu7t5v0__filltie
XTAP_TAPCELL_ROW_106_1630 VDD VSS gf180mcu_fd_sc_mcu7t5v0__filltie
XFILLER_63_378 VDD VDD VSS VSS gf180mcu_fd_sc_mcu7t5v0__fillcap_4
Xspi_regs_inst__1624_ spi_regs_inst__1624_/D fanout558/Z clkload8/I spi_regs_inst__1624_/Q
+ VDD VDD VSS VSS gf180mcu_fd_sc_mcu7t5v0__dffrnq_1
Xspi_regs_inst__1555_ spi_regs_inst__1555_/D fanout589/Z clkload22/I spi_regs_inst__1555_/Q
+ VDD VDD VSS VSS gf180mcu_fd_sc_mcu7t5v0__dffrnq_1
XFILLER_108_1157 VDD VDD VSS VSS gf180mcu_fd_sc_mcu7t5v0__fillcap_16
XTAP_TAPCELL_ROW_139_2173 VDD VSS gf180mcu_fd_sc_mcu7t5v0__filltie
Xspi_regs_inst__1486_ spi_regs_inst__1486_/D fanout615/Z clkbuf_leaf_36_clk/Z spi_regs_inst__1486_/Q
+ VDD VDD VSS VSS gf180mcu_fd_sc_mcu7t5v0__dffrnq_1
XFILLER_118_804 VDD VDD VSS VSS gf180mcu_fd_sc_mcu7t5v0__fill_1
XFILLER_118_815 VDD VDD VSS VSS gf180mcu_fd_sc_mcu7t5v0__fillcap_4
XFILLER_76_2 VDD VDD VSS VSS gf180mcu_fd_sc_mcu7t5v0__fillcap_8
XPHY_EDGE_ROW_140_Right_140 VDD VSS gf180mcu_fd_sc_mcu7t5v0__endcap
XFILLER_129_185 VDD VDD VSS VSS gf180mcu_fd_sc_mcu7t5v0__fill_1
XFILLER_8_482 VDD VDD VSS VSS gf180mcu_fd_sc_mcu7t5v0__fill_1
XTAP_TAPCELL_ROW_152_2384 VDD VSS gf180mcu_fd_sc_mcu7t5v0__filltie
XTAP_TAPCELL_ROW_14_1_440 VDD VSS gf180mcu_fd_sc_mcu7t5v0__filltie
XFILLER_59_629 VDD VDD VSS VSS gf180mcu_fd_sc_mcu7t5v0__fill_1
Xwave_controller_x_inst__1982_ wave_controller_x_inst__1986_/A1 wave_controller_x_inst__1986_/A3
+ wave_controller_x_inst__1983_/A2 VDD VDD VSS VSS gf180mcu_fd_sc_mcu7t5v0__nor2_1
Xstate_machine_inst__19_ spi_regs_inst__1079_/B2 state_machine_inst__26_/A2 VDD VDD
+ VSS VSS gf180mcu_fd_sc_mcu7t5v0__clkinv_1
XFILLER_100_214 VDD VDD VSS VSS gf180mcu_fd_sc_mcu7t5v0__fill_1
XFILLER_86_448 VDD VDD VSS VSS gf180mcu_fd_sc_mcu7t5v0__fill_1
Xwave_controller_x_inst__3721_ wave_controller_x_inst__3721_/D fanout598/Z clkbuf_leaf_22_clk/Z
+ wave_controller_x_inst__3721_/Q VDD VDD VSS VSS gf180mcu_fd_sc_mcu7t5v0__dffrnq_1
XFILLER_100_247 VDD VDD VSS VSS gf180mcu_fd_sc_mcu7t5v0__fillcap_4
XFILLER_67_662 VDD VDD VSS VSS gf180mcu_fd_sc_mcu7t5v0__fillcap_32
Xwave_controller_y_inst_max_cap417 wave_controller_y_inst__3717_/Q wave_controller_y_inst__1778_/I
+ VDD VDD VSS VSS gf180mcu_fd_sc_mcu7t5v0__buf_3
XFILLER_104_37 VDD VDD VSS VSS gf180mcu_fd_sc_mcu7t5v0__fill_2
XFILLER_95_982 VDD VDD VSS VSS gf180mcu_fd_sc_mcu7t5v0__fillcap_64
XTAP_TAPCELL_ROW_57_819 VDD VSS gf180mcu_fd_sc_mcu7t5v0__filltie
Xwave_controller_x_inst__3652_ wave_controller_x_inst__3652_/D wave_controller_x_inst__3701_/RN
+ clkload31/I max_cap460/I VDD VDD VSS VSS gf180mcu_fd_sc_mcu7t5v0__dffrnq_1
XFILLER_55_857 VDD VDD VSS VSS gf180mcu_fd_sc_mcu7t5v0__fillcap_8
XFILLER_82_654 VDD VDD VSS VSS gf180mcu_fd_sc_mcu7t5v0__fill_1
Xwave_controller_x_inst__3583_ wave_controller_x_inst__3583_/A1 wave_controller_x_inst__3588_/S
+ wave_controller_x_inst__3583_/B wave_controller_x_inst__3661_/D VDD VDD VSS VSS
+ gf180mcu_fd_sc_mcu7t5v0__oai21_1
Xwave_controller_x_inst__2603_ wave_controller_x_inst__2601_/Z wave_controller_x_inst__2631_/A2
+ wave_controller_x_inst__2604_/I VDD VDD VSS VSS gf180mcu_fd_sc_mcu7t5v0__xor2_1
XFILLER_70_827 VDD VDD VSS VSS gf180mcu_fd_sc_mcu7t5v0__fillcap_16
XTAP_TAPCELL_ROW_159_2505 VDD VSS gf180mcu_fd_sc_mcu7t5v0__filltie
Xwave_controller_y_inst__2550_ wave_controller_y_inst__2786_/A1 spi_regs_inst__1045_/B2
+ wave_controller_y_inst__2550_/Z VDD VDD VSS VSS gf180mcu_fd_sc_mcu7t5v0__xor2_1
Xwave_controller_x_inst__2534_ wave_controller_x_inst__2555_/A1 wave_controller_x_inst__2534_/A2
+ wave_controller_x_inst__2534_/B wave_controller_x_inst__2537_/A3 VDD VDD VSS VSS
+ gf180mcu_fd_sc_mcu7t5v0__aoi21_1
XFILLER_70_849 VDD VDD VSS VSS gf180mcu_fd_sc_mcu7t5v0__fill_2
Xwave_controller_y_inst__2481_ wave_controller_y_inst__2481_/I wave_controller_y_inst__2483_/B1
+ VDD VDD VSS VSS gf180mcu_fd_sc_mcu7t5v0__clkinv_1
Xwave_controller_x_inst__2465_ wave_controller_x_inst__2517_/A1 wave_controller_x_inst__2465_/A2
+ wave_controller_x_inst__2467_/A2 VDD VDD VSS VSS gf180mcu_fd_sc_mcu7t5v0__nor2_1
XFILLER_80_18 VDD VDD VSS VSS gf180mcu_fd_sc_mcu7t5v0__fill_1
Xwave_controller_x_inst__2396_ wave_controller_x_inst__2396_/A1 wave_controller_x_inst__2396_/A2
+ wave_controller_x_inst__2396_/B wave_controller_x_inst__2396_/C wave_controller_x_inst__2397_/B
+ VDD VDD VSS VSS gf180mcu_fd_sc_mcu7t5v0__aoi211_1
Xwave_controller_y_inst__3102_ wave_controller_y_inst__3102_/A1 wave_controller_y_inst__3101_/B
+ wave_controller_y_inst__3614_/D VDD VDD VSS VSS gf180mcu_fd_sc_mcu7t5v0__nor2_1
XFILLER_148_494 VDD VDD VSS VSS gf180mcu_fd_sc_mcu7t5v0__fill_2
XFILLER_108_336 VDD VDD VSS VSS gf180mcu_fd_sc_mcu7t5v0__fillcap_4
XFILLER_124_807 VDD VDD VSS VSS gf180mcu_fd_sc_mcu7t5v0__fillcap_4
XFILLER_135_133 VDD VDD VSS VSS gf180mcu_fd_sc_mcu7t5v0__fillcap_4
XTAP_TAPCELL_ROW_75_1117 VDD VSS gf180mcu_fd_sc_mcu7t5v0__filltie
Xwave_controller_y_inst__3033_ wave_controller_y_inst__3697_/Q wave_controller_y_inst__3033_/A2
+ wave_controller_y_inst__3698_/Q wave_controller_y_inst__3034_/A3 VDD VDD VSS VSS
+ gf180mcu_fd_sc_mcu7t5v0__aoi21_1
Xwave_controller_x_inst__3017_ wave_controller_x_inst__3440_/A1 wave_controller_x_inst__3017_/A2
+ wave_controller_x_inst__3026_/A3 VDD VDD VSS VSS gf180mcu_fd_sc_mcu7t5v0__nor2_1
XFILLER_151_604 VDD VDD VSS VSS gf180mcu_fd_sc_mcu7t5v0__fill_2
XFILLER_151_615 VDD VDD VSS VSS gf180mcu_fd_sc_mcu7t5v0__fill_2
XFILLER_150_136 VDD VDD VSS VSS gf180mcu_fd_sc_mcu7t5v0__fill_2
Xwave_controller_x_inst_wire87 wave_controller_x_inst_wire87/I wave_controller_x_inst_wire87/Z
+ VDD VDD VSS VSS gf180mcu_fd_sc_mcu7t5v0__clkbuf_1
XFILLER_145_55 VDD VDD VSS VSS gf180mcu_fd_sc_mcu7t5v0__fill_2
XFILLER_78_916 VDD VDD VSS VSS gf180mcu_fd_sc_mcu7t5v0__fillcap_16
XFILLER_78_938 VDD VDD VSS VSS gf180mcu_fd_sc_mcu7t5v0__fill_1
XFILLER_81_1116 VDD VDD VSS VSS gf180mcu_fd_sc_mcu7t5v0__fillcap_4
XFILLER_104_597 VDD VDD VSS VSS gf180mcu_fd_sc_mcu7t5v0__fillcap_4
XFILLER_131_361 VDD VDD VSS VSS gf180mcu_fd_sc_mcu7t5v0__fillcap_32
XFILLER_49_106 VDD VDD VSS VSS gf180mcu_fd_sc_mcu7t5v0__fillcap_16
XFILLER_77_415 VDD VDD VSS VSS gf180mcu_fd_sc_mcu7t5v0__fillcap_4
XFILLER_38_53 VDD VDD VSS VSS gf180mcu_fd_sc_mcu7t5v0__fillcap_16
XFILLER_93_908 VDD VDD VSS VSS gf180mcu_fd_sc_mcu7t5v0__fill_2
XFILLER_57_150 VDD VDD VSS VSS gf180mcu_fd_sc_mcu7t5v0__fillcap_4
XFILLER_58_662 VDD VDD VSS VSS gf180mcu_fd_sc_mcu7t5v0__fill_2
Xwave_controller_y_inst__2817_ wave_controller_y_inst__3709_/Q wave_controller_y_inst__2817_/A2
+ wave_controller_y_inst__2817_/B1 wave_controller_y_inst__1790_/I wave_controller_y_inst__2818_/B
+ VDD VDD VSS VSS gf180mcu_fd_sc_mcu7t5v0__aoi22_1
XFILLER_57_183 VDD VDD VSS VSS gf180mcu_fd_sc_mcu7t5v0__fill_1
XFILLER_73_632 VDD VDD VSS VSS gf180mcu_fd_sc_mcu7t5v0__fillcap_16
XFILLER_85_492 VDD VDD VSS VSS gf180mcu_fd_sc_mcu7t5v0__fillcap_4
XTAP_TAPCELL_ROW_0_1_2662 VDD VSS gf180mcu_fd_sc_mcu7t5v0__filltie
XTAP_TAPCELL_ROW_0_1_2673 VDD VSS gf180mcu_fd_sc_mcu7t5v0__filltie
Xwave_controller_y_inst__2748_ spi_regs_inst__1194_/B2 wave_controller_y_inst__2748_/A2
+ wave_controller_y_inst__2743_/Z wave_controller_y_inst__2748_/Z VDD VDD VSS VSS
+ gf180mcu_fd_sc_mcu7t5v0__xor3_1
Xwave_controller_y_inst__2679_ wave_controller_y_inst__2642_/Z wave_controller_y_inst__2679_/A2
+ wave_controller_y_inst__2710_/A3 wave_controller_y_inst__2681_/B VDD VDD VSS VSS
+ gf180mcu_fd_sc_mcu7t5v0__nand3_1
XFILLER_60_359 VDD VDD VSS VSS gf180mcu_fd_sc_mcu7t5v0__fillcap_8
XTAP_TAPCELL_ROW_31_1_565 VDD VSS gf180mcu_fd_sc_mcu7t5v0__filltie
XFILLER_158_247 VDD VDD VSS VSS gf180mcu_fd_sc_mcu7t5v0__fillcap_4
Xspi_regs_inst__1340_ spi_regs_inst__1340_/A1 spi_regs_inst__1340_/A2 spi_regs_inst__1340_/B1
+ spi_regs_inst__1614_/Q spi_regs_inst__1360_/A2 VDD VDD VSS VSS gf180mcu_fd_sc_mcu7t5v0__aoi22_1
XFILLER_142_1081 VDD VDD VSS VSS gf180mcu_fd_sc_mcu7t5v0__fillcap_4
Xspi_regs_inst__1271_ spi_regs_inst__1604_/Q spi_regs_inst_wire286/Z spi_regs_inst__1306_/A2
+ max_cap452/Z spi_regs_inst__1273_/A3 VDD VDD VSS VSS gf180mcu_fd_sc_mcu7t5v0__aoi22_1
Xclkload16 clkload16/I clkload16/ZN VDD VDD VSS VSS gf180mcu_fd_sc_mcu7t5v0__inv_3
XFILLER_127_667 VDD VDD VSS VSS gf180mcu_fd_sc_mcu7t5v0__fillcap_8
XFILLER_155_976 VDD VDD VSS VSS gf180mcu_fd_sc_mcu7t5v0__fillcap_4
Xclkload27 clkload27/I clkload27/ZN VDD VDD VSS VSS gf180mcu_fd_sc_mcu7t5v0__inv_2
XFILLER_126_177 VDD VDD VSS VSS gf180mcu_fd_sc_mcu7t5v0__fillcap_32
XTAP_TAPCELL_ROW_134_2081 VDD VSS gf180mcu_fd_sc_mcu7t5v0__filltie
XTAP_TAPCELL_ROW_134_2092 VDD VSS gf180mcu_fd_sc_mcu7t5v0__filltie
Xspi_regs_inst_wire28 spi_regs_inst_wire28/I spi_regs_inst_wire28/Z VDD VDD VSS VSS
+ gf180mcu_fd_sc_mcu7t5v0__buf_2
Xspi_regs_inst_wire17 spi_regs_inst_wire17/I spi_regs_inst_wire17/Z VDD VDD VSS VSS
+ gf180mcu_fd_sc_mcu7t5v0__clkbuf_1
XFILLER_108_892 VDD VDD VSS VSS gf180mcu_fd_sc_mcu7t5v0__fillcap_4
XFILLER_142_637 VDD VDD VSS VSS gf180mcu_fd_sc_mcu7t5v0__fill_2
XFILLER_5_496 VDD VDD VSS VSS gf180mcu_fd_sc_mcu7t5v0__fill_2
Xspi_regs_inst_wire39 spi_regs_inst_wire39/I spi_regs_inst_wire39/Z VDD VDD VSS VSS
+ gf180mcu_fd_sc_mcu7t5v0__buf_2
Xsignal_processor_y_inst__221_ signal_processor_y_inst__221_/D fanout558/Z clkload7/I
+ spi_regs_inst__1038_/B2 VDD VDD VSS VSS gf180mcu_fd_sc_mcu7t5v0__dffrnq_1
XFILLER_123_884 VDD VDD VSS VSS gf180mcu_fd_sc_mcu7t5v0__fill_1
XFILLER_68_415 VDD VDD VSS VSS gf180mcu_fd_sc_mcu7t5v0__fillcap_16
Xsignal_processor_y_inst__152_ fanout393/Z signal_processor_y_inst__203_/A1 signal_processor_y_inst__187_/B
+ VDD VDD VSS VSS gf180mcu_fd_sc_mcu7t5v0__nand2_1
XFILLER_110_556 VDD VDD VSS VSS gf180mcu_fd_sc_mcu7t5v0__fillcap_16
XFILLER_95_245 VDD VDD VSS VSS gf180mcu_fd_sc_mcu7t5v0__fillcap_4
XFILLER_96_779 VDD VDD VSS VSS gf180mcu_fd_sc_mcu7t5v0__fill_1
Xspi_regs_inst_fanout481 spi_regs_inst__1660_/Q spi_regs_inst__1441_/I1 VDD VDD VSS
+ VSS gf180mcu_fd_sc_mcu7t5v0__dlyb_1
Xspi_regs_inst_fanout470 spi_regs_inst__1663_/Q spi_regs_inst__1411_/I1 VDD VDD VSS
+ VSS gf180mcu_fd_sc_mcu7t5v0__dlyb_1
XFILLER_64_610 VDD VDD VSS VSS gf180mcu_fd_sc_mcu7t5v0__fill_2
XFILLER_77_982 VDD VDD VSS VSS gf180mcu_fd_sc_mcu7t5v0__fillcap_64
Xspi_regs_inst_fanout492 spi_regs_inst__1658_/Q spi_regs_inst__1430_/I1 VDD VDD VSS
+ VSS gf180mcu_fd_sc_mcu7t5v0__dlyb_1
Xspi_regs_inst__0986_ spi_regs_inst__1368_/A1 spi_regs_inst__1631_/Q spi_regs_inst__0909_/Z
+ spi_regs_inst__1021_/A2 VDD VDD VSS VSS gf180mcu_fd_sc_mcu7t5v0__nand3_1
XFILLER_63_142 VDD VDD VSS VSS gf180mcu_fd_sc_mcu7t5v0__fillcap_4
XFILLER_91_484 VDD VDD VSS VSS gf180mcu_fd_sc_mcu7t5v0__fillcap_4
XFILLER_149_203 VDD VDD VSS VSS gf180mcu_fd_sc_mcu7t5v0__fill_1
XFILLER_60_860 VDD VDD VSS VSS gf180mcu_fd_sc_mcu7t5v0__fillcap_8
Xspi_regs_inst__1607_ spi_regs_inst__1607_/D spi_regs_inst__1610_/RN clkload13/I spi_regs_inst__1607_/Q
+ VDD VDD VSS VSS gf180mcu_fd_sc_mcu7t5v0__dffrnq_1
XTAP_TAPCELL_ROW_62_899 VDD VSS gf180mcu_fd_sc_mcu7t5v0__filltie
Xwave_controller_x_inst__2250_ wave_controller_x_inst__2250_/A1 wave_controller_x_inst__2250_/A2
+ wave_controller_x_inst__2250_/B wave_controller_x_inst__2251_/A2 VDD VDD VSS VSS
+ gf180mcu_fd_sc_mcu7t5v0__aoi21_1
Xspi_regs_inst__1538_ spi_regs_inst__1538_/D fanout589/Z clkload24/I spi_regs_inst__1538_/Q
+ VDD VDD VSS VSS gf180mcu_fd_sc_mcu7t5v0__dffrnq_1
XTAP_TAPCELL_ROW_154_2413 VDD VSS gf180mcu_fd_sc_mcu7t5v0__filltie
XTAP_TAPCELL_ROW_154_2424 VDD VSS gf180mcu_fd_sc_mcu7t5v0__filltie
Xwave_controller_x_inst__2181_ wave_controller_x_inst__3231_/B wave_controller_x_inst__2181_/A2
+ wave_controller_x_inst__2178_/Z wave_controller_x_inst__2181_/Z VDD VDD VSS VSS
+ gf180mcu_fd_sc_mcu7t5v0__xor3_1
XTAP_TAPCELL_ROW_119_1843 VDD VSS gf180mcu_fd_sc_mcu7t5v0__filltie
Xspi_regs_inst__1469_ spi_regs_inst__1469_/D fanout591/Z clkload22/I fanout532/I VDD
+ VDD VSS VSS gf180mcu_fd_sc_mcu7t5v0__dffrnq_1
XFILLER_106_807 VDD VDD VSS VSS gf180mcu_fd_sc_mcu7t5v0__fillcap_4
XFILLER_117_133 VDD VDD VSS VSS gf180mcu_fd_sc_mcu7t5v0__fillcap_4
XFILLER_118_667 VDD VDD VSS VSS gf180mcu_fd_sc_mcu7t5v0__fillcap_8
XFILLER_121_1154 VDD VDD VSS VSS gf180mcu_fd_sc_mcu7t5v0__fillcap_16
XFILLER_145_475 VDD VDD VSS VSS gf180mcu_fd_sc_mcu7t5v0__fill_2
XFILLER_160_434 VDD VDD VSS VSS gf180mcu_fd_sc_mcu7t5v0__fillcap_8
XFILLER_99_562 VDD VDD VSS VSS gf180mcu_fd_sc_mcu7t5v0__fillcap_4
XTAP_TAPCELL_ROW_70_1025 VDD VSS gf180mcu_fd_sc_mcu7t5v0__filltie
XTAP_TAPCELL_ROW_70_1036 VDD VSS gf180mcu_fd_sc_mcu7t5v0__filltie
Xwave_controller_y_inst__1981_ wave_controller_y_inst__1981_/A1 spi_regs_inst__1354_/A1
+ wave_controller_y_inst__1981_/B wave_controller_y_inst__1981_/C wave_controller_y_inst__1986_/A3
+ VDD VDD VSS VSS gf180mcu_fd_sc_mcu7t5v0__aoi211_1
XFILLER_115_69 VDD VDD VSS VSS gf180mcu_fd_sc_mcu7t5v0__fill_1
Xwave_controller_y_inst__3720_ wave_controller_y_inst__3720_/D wave_controller_y_inst__3721_/RN
+ clkload5/I wave_controller_y_inst__3720_/Q VDD VDD VSS VSS gf180mcu_fd_sc_mcu7t5v0__dffrnq_1
Xwave_controller_x_inst__1965_ wave_controller_x_inst__3374_/B spi_regs_inst__1284_/B2
+ wave_controller_x_inst__1966_/B VDD VDD VSS VSS gf180mcu_fd_sc_mcu7t5v0__xor2_1
XFILLER_74_407 VDD VDD VSS VSS gf180mcu_fd_sc_mcu7t5v0__fill_1
XPHY_EDGE_ROW_105_Left_272 VDD VSS gf180mcu_fd_sc_mcu7t5v0__endcap
XPHY_EDGE_ROW_10_1_Left_177 VDD VSS gf180mcu_fd_sc_mcu7t5v0__endcap
XTAP_TAPCELL_ROW_165_2597 VDD VSS gf180mcu_fd_sc_mcu7t5v0__filltie
Xwave_controller_x_inst__3704_ wave_controller_x_inst__3704_/D wave_controller_x_inst__3704_/RN
+ clkload36/I wave_controller_x_inst__3704_/Q VDD VDD VSS VSS gf180mcu_fd_sc_mcu7t5v0__dffrnq_1
Xwave_controller_x_inst__1896_ wave_controller_x_inst__3697_/Q wave_controller_x_inst__3469_/A1
+ VDD VDD VSS VSS gf180mcu_fd_sc_mcu7t5v0__clkinv_1
XFILLER_55_621 VDD VDD VSS VSS gf180mcu_fd_sc_mcu7t5v0__fill_1
XFILLER_55_632 VDD VDD VSS VSS gf180mcu_fd_sc_mcu7t5v0__fill_2
XFILLER_67_492 VDD VDD VSS VSS gf180mcu_fd_sc_mcu7t5v0__fillcap_16
Xwave_controller_y_inst__3651_ wave_controller_y_inst__3651_/D wave_controller_y_inst__3673_/RN
+ clkbuf_leaf_35_clk/Z max_cap429/I VDD VDD VSS VSS gf180mcu_fd_sc_mcu7t5v0__dffrnq_1
Xwave_controller_x_inst__3635_ wave_controller_x_inst__3635_/D wave_controller_x_inst__3704_/RN
+ clkload35/I spi_regs_inst__1332_/A1 VDD VDD VSS VSS gf180mcu_fd_sc_mcu7t5v0__dffrnq_1
XFILLER_27_378 VDD VDD VSS VSS gf180mcu_fd_sc_mcu7t5v0__fill_1
Xwave_controller_y_inst__2602_ wave_controller_y_inst__3524_/B2 wave_controller_y_inst__2588_/Z
+ wave_controller_y_inst__2602_/B wave_controller_y_inst__2631_/A2 VDD VDD VSS VSS
+ gf180mcu_fd_sc_mcu7t5v0__oai21_1
Xwave_controller_y_inst__3582_ max_cap426/I wave_controller_y_inst__3588_/S wave_controller_y_inst__3583_/B
+ VDD VDD VSS VSS gf180mcu_fd_sc_mcu7t5v0__nand2_1
XFILLER_42_337 VDD VDD VSS VSS gf180mcu_fd_sc_mcu7t5v0__fillcap_8
Xwave_controller_y_inst__2533_ wave_controller_y_inst__2555_/C wave_controller_y_inst__2553_/A2
+ wave_controller_y_inst__2537_/A2 VDD VDD VSS VSS gf180mcu_fd_sc_mcu7t5v0__nand2_1
Xwave_controller_x_inst__3566_ spi_regs_inst__1257_/A1 wave_controller_x_inst__3569_/S
+ wave_controller_x_inst__3567_/B VDD VDD VSS VSS gf180mcu_fd_sc_mcu7t5v0__nand2_1
Xwave_controller_x_inst__3497_ wave_controller_x_inst__3497_/A1 wave_controller_x_inst__3530_/B1
+ wave_controller_x_inst__3497_/B1 wave_controller_x_inst__3497_/B2 wave_controller_x_inst__3628_/D
+ VDD VDD VSS VSS gf180mcu_fd_sc_mcu7t5v0__oai22_1
Xwave_controller_x_inst__2517_ wave_controller_x_inst__2517_/A1 wave_controller_x_inst__2517_/A2
+ wave_controller_x_inst__2517_/B wave_controller_x_inst__2517_/C wave_controller_x_inst__2556_/A1
+ VDD VDD VSS VSS gf180mcu_fd_sc_mcu7t5v0__oai211_1
Xsignal_processor_x_inst__241_ signal_processor_x_inst__241_/D signal_processor_x_inst__242_/RN
+ clkload23/I signal_processor_x_inst__241_/Q VDD VDD VSS VSS gf180mcu_fd_sc_mcu7t5v0__dffrnq_1
Xwave_controller_y_inst__2464_ wave_controller_y_inst__2464_/A1 wave_controller_y_inst__2464_/A2
+ wave_controller_y_inst__2463_/B wave_controller_y_inst__2465_/A2 VDD VDD VSS VSS
+ gf180mcu_fd_sc_mcu7t5v0__nor3_1
Xwave_controller_x_inst__2448_ wave_controller_x_inst__2432_/I wave_controller_x_inst__2445_/Z
+ wave_controller_x_inst__2449_/B1 VDD VDD VSS VSS gf180mcu_fd_sc_mcu7t5v0__nand2_1
Xsignal_processor_x_inst__172_ signal_processor_x_inst__235_/Q signal_processor_x_inst__172_/A2
+ signal_processor_x_inst__213_/A2 VDD VDD VSS VSS gf180mcu_fd_sc_mcu7t5v0__xnor2_1
XFILLER_126_1087 VDD VDD VSS VSS gf180mcu_fd_sc_mcu7t5v0__fillcap_64
XPHY_EDGE_ROW_114_Left_281 VDD VSS gf180mcu_fd_sc_mcu7t5v0__endcap
Xwave_controller_y_inst__2395_ wave_controller_y_inst__2391_/B wave_controller_y_inst__2389_/Z
+ wave_controller_y_inst__2396_/B VDD VDD VSS VSS gf180mcu_fd_sc_mcu7t5v0__nor2_1
Xwave_controller_x_inst__2379_ wave_controller_x_inst__2379_/A1 spi_regs_inst__1060_/A1
+ wave_controller_x_inst__2379_/Z VDD VDD VSS VSS gf180mcu_fd_sc_mcu7t5v0__xor2_1
XFILLER_109_612 VDD VDD VSS VSS gf180mcu_fd_sc_mcu7t5v0__fillcap_16
XFILLER_149_781 VDD VDD VSS VSS gf180mcu_fd_sc_mcu7t5v0__fillcap_32
Xchip_core_655 bidir_pu[1] VDD VDD VSS VSS gf180mcu_fd_sc_mcu7t5v0__tiel
Xchip_core_644 bidir_oe[2] VDD VDD VSS VSS gf180mcu_fd_sc_mcu7t5v0__tiel
Xchip_core_633 bidir_cs[8] VDD VDD VSS VSS gf180mcu_fd_sc_mcu7t5v0__tiel
XFILLER_108_122 VDD VDD VSS VSS gf180mcu_fd_sc_mcu7t5v0__fill_1
XFILLER_137_976 VDD VDD VSS VSS gf180mcu_fd_sc_mcu7t5v0__fillcap_4
XFILLER_40_43 VDD VDD VSS VSS gf180mcu_fd_sc_mcu7t5v0__fill_1
Xchip_core_688 bidir_sl[3] VDD VDD VSS VSS gf180mcu_fd_sc_mcu7t5v0__tieh
Xchip_core_677 bidir_cs[2] VDD VDD VSS VSS gf180mcu_fd_sc_mcu7t5v0__tieh
Xchip_core_666 bidir_sl[2] VDD VDD VSS VSS gf180mcu_fd_sc_mcu7t5v0__tiel
XFILLER_108_177 VDD VDD VSS VSS gf180mcu_fd_sc_mcu7t5v0__fillcap_16
Xwave_controller_y_inst__3016_ wave_controller_y_inst__3693_/Q wave_controller_y_inst__3692_/Q
+ wave_controller_y_inst__3016_/A3 wave_controller_y_inst__3021_/A2 VDD VDD VSS VSS
+ gf180mcu_fd_sc_mcu7t5v0__nand3_1
XFILLER_136_497 VDD VDD VSS VSS gf180mcu_fd_sc_mcu7t5v0__fillcap_4
XFILLER_105_862 VDD VDD VSS VSS gf180mcu_fd_sc_mcu7t5v0__fill_2
XFILLER_151_456 VDD VDD VSS VSS gf180mcu_fd_sc_mcu7t5v0__fill_2
XFILLER_156_98 VDD VDD VSS VSS gf180mcu_fd_sc_mcu7t5v0__fillcap_4
XFILLER_2_444 VDD VDD VSS VSS gf180mcu_fd_sc_mcu7t5v0__fillcap_8
XFILLER_6_2 VDD VDD VSS VSS gf180mcu_fd_sc_mcu7t5v0__fillcap_32
XFILLER_151_489 VDD VDD VSS VSS gf180mcu_fd_sc_mcu7t5v0__fill_1
XFILLER_2_488 VDD VDD VSS VSS gf180mcu_fd_sc_mcu7t5v0__fill_2
XFILLER_77_212 VDD VDD VSS VSS gf180mcu_fd_sc_mcu7t5v0__fillcap_8
Xwave_controller_y_inst_wire99 wave_controller_y_inst_wire99/I wave_controller_y_inst_wire99/Z
+ VDD VDD VSS VSS gf180mcu_fd_sc_mcu7t5v0__buf_2
XFILLER_77_245 VDD VDD VSS VSS gf180mcu_fd_sc_mcu7t5v0__fill_1
XPHY_EDGE_ROW_123_Left_290 VDD VSS gf180mcu_fd_sc_mcu7t5v0__endcap
XFILLER_59_982 VDD VDD VSS VSS gf180mcu_fd_sc_mcu7t5v0__fillcap_64
XFILLER_92_204 VDD VDD VSS VSS gf180mcu_fd_sc_mcu7t5v0__fillcap_4
Xspi_regs_inst__0840_ spi_regs_inst__1581_/Q spi_regs_inst__1380_/I1 spi_regs_inst__0840_/S
+ spi_regs_inst__1581_/D VDD VDD VSS VSS gf180mcu_fd_sc_mcu7t5v0__mux2_2
XFILLER_58_481 VDD VDD VSS VSS gf180mcu_fd_sc_mcu7t5v0__fill_1
XFILLER_58_492 VDD VDD VSS VSS gf180mcu_fd_sc_mcu7t5v0__fill_1
XFILLER_74_930 VDD VDD VSS VSS gf180mcu_fd_sc_mcu7t5v0__fill_2
XFILLER_92_237 VDD VDD VSS VSS gf180mcu_fd_sc_mcu7t5v0__fillcap_8
XFILLER_45_142 VDD VDD VSS VSS gf180mcu_fd_sc_mcu7t5v0__fill_2
Xspi_regs_inst__0771_ spi_regs_inst__0818_/A1 spi_regs_inst__0842_/A1 spi_regs_inst__0772_/A2
+ VDD VDD VSS VSS gf180mcu_fd_sc_mcu7t5v0__nand2_1
XFILLER_73_473 VDD VDD VSS VSS gf180mcu_fd_sc_mcu7t5v0__fill_1
XFILLER_121_90 VDD VDD VSS VSS gf180mcu_fd_sc_mcu7t5v0__fill_1
XFILLER_14_551 VDD VDD VSS VSS gf180mcu_fd_sc_mcu7t5v0__fillcap_4
XFILLER_81_72 VDD VDD VSS VSS gf180mcu_fd_sc_mcu7t5v0__fillcap_16
XFILLER_105_1116 VDD VDD VSS VSS gf180mcu_fd_sc_mcu7t5v0__fillcap_4
XFILLER_144_1165 VDD VDD VSS VSS gf180mcu_fd_sc_mcu7t5v0__fillcap_4
XTAP_TAPCELL_ROW_136_2121 VDD VSS gf180mcu_fd_sc_mcu7t5v0__filltie
XFILLER_128_910 VDD VDD VSS VSS gf180mcu_fd_sc_mcu7t5v0__fillcap_32
Xspi_regs_inst__1323_ spi_regs_inst__1323_/A1 spi_regs_inst__1323_/A2 spi_regs_inst__1323_/A3
+ spi_regs_inst__1323_/A4 spi_regs_inst__1327_/A3 VDD VDD VSS VSS gf180mcu_fd_sc_mcu7t5v0__nand4_1
Xspi_regs_inst__1254_ spi_regs_inst__1254_/A1 spi_regs_inst__1254_/A2 spi_regs_inst_wire227/I
+ spi_regs_inst__1254_/B2 spi_regs_inst__1258_/A1 VDD VDD VSS VSS gf180mcu_fd_sc_mcu7t5v0__aoi22_1
XFILLER_5_282 VDD VDD VSS VSS gf180mcu_fd_sc_mcu7t5v0__fillcap_64
Xspi_regs_inst_wire218 spi_regs_inst_wire218/I spi_regs_inst_wire218/Z VDD VDD VSS
+ VSS gf180mcu_fd_sc_mcu7t5v0__buf_2
Xspi_regs_inst_wire207 spi_regs_inst_wire207/I spi_regs_inst_wire207/Z VDD VDD VSS
+ VSS gf180mcu_fd_sc_mcu7t5v0__buf_2
Xspi_regs_inst__1185_ spi_regs_inst__1523_/Q spi_regs_inst__1357_/A2 spi_regs_inst__1185_/B1
+ spi_regs_inst__1185_/B2 spi_regs_inst__1187_/A3 VDD VDD VSS VSS gf180mcu_fd_sc_mcu7t5v0__aoi22_1
XFILLER_69_702 VDD VDD VSS VSS gf180mcu_fd_sc_mcu7t5v0__fillcap_16
XTAP_TAPCELL_ROW_114_1751 VDD VSS gf180mcu_fd_sc_mcu7t5v0__filltie
XTAP_TAPCELL_ROW_114_1762 VDD VSS gf180mcu_fd_sc_mcu7t5v0__filltie
XFILLER_39_2 VDD VDD VSS VSS gf180mcu_fd_sc_mcu7t5v0__fillcap_4
Xsignal_processor_y_inst__204_ spi_regs_inst__1038_/B2 signal_processor_y_inst__212_/A2
+ signal_processor_y_inst__205_/B VDD VDD VSS VSS gf180mcu_fd_sc_mcu7t5v0__nand2_1
XFILLER_96_554 VDD VDD VSS VSS gf180mcu_fd_sc_mcu7t5v0__fill_1
XPHY_EDGE_ROW_43_1_Right_42 VDD VSS gf180mcu_fd_sc_mcu7t5v0__endcap
Xsignal_processor_y_inst__135_ signal_processor_y_inst__202_/A2 signal_processor_y_inst__229_/Q
+ signal_processor_y_inst__203_/A1 signal_processor_y_inst__172_/A2 VDD VDD VSS VSS
+ gf180mcu_fd_sc_mcu7t5v0__nor3_1
XFILLER_110_353 VDD VDD VSS VSS gf180mcu_fd_sc_mcu7t5v0__fillcap_8
XFILLER_56_429 VDD VDD VSS VSS gf180mcu_fd_sc_mcu7t5v0__fill_2
XFILLER_49_492 VDD VDD VSS VSS gf180mcu_fd_sc_mcu7t5v0__fill_1
Xinput3 bidir_in[2] input3/Z VDD VDD VSS VSS gf180mcu_fd_sc_mcu7t5v0__buf_1
Xwave_controller_x_inst__3420_ wave_controller_x_inst__3420_/A1 wave_controller_x_inst_wire84/I
+ wave_controller_x_inst__3420_/B1 wave_controller_x_inst__3494_/A2 wave_controller_x_inst__3489_/C
+ wave_controller_x_inst__3421_/B VDD VDD VSS VSS gf180mcu_fd_sc_mcu7t5v0__aoi221_1
Xspi_regs_inst__0969_ spi_regs_inst__1629_/Q spi_regs_inst__1364_/A1 spi_regs_inst__1630_/Q
+ spi_regs_inst__1370_/A1 spi_regs_inst__1031_/A2 VDD VDD VSS VSS gf180mcu_fd_sc_mcu7t5v0__nand4_1
XFILLER_101_27 VDD VDD VSS VSS gf180mcu_fd_sc_mcu7t5v0__fill_1
XFILLER_80_955 VDD VDD VSS VSS gf180mcu_fd_sc_mcu7t5v0__fillcap_32
Xwave_controller_x_inst__3351_ wave_controller_x_inst__3352_/B wave_controller_x_inst__3318_/Z
+ wave_controller_x_inst__3352_/A2 wave_controller_x_inst__3396_/B VDD VDD VSS VSS
+ gf180mcu_fd_sc_mcu7t5v0__nand3_1
Xwave_controller_x_inst__3282_ wave_controller_x_inst__3701_/Q wave_controller_x_inst__3378_/A2
+ wave_controller_x_inst__3282_/B wave_controller_x_inst__3377_/B VDD VDD VSS VSS
+ gf180mcu_fd_sc_mcu7t5v0__aoi21_1
Xwave_controller_x_inst__2302_ fanout542/Z wave_controller_x_inst__2298_/Z wave_controller_x_inst__2302_/A3
+ wave_controller_x_inst__2302_/Z VDD VDD VSS VSS gf180mcu_fd_sc_mcu7t5v0__xor3_1
Xwave_controller_x_inst__2233_ max_cap458/Z wave_controller_x_inst__2228_/Z wave_controller_x_inst__2233_/B
+ wave_controller_x_inst__2247_/A1 VDD VDD VSS VSS gf180mcu_fd_sc_mcu7t5v0__aoi21_1
XFILLER_138_729 VDD VDD VSS VSS gf180mcu_fd_sc_mcu7t5v0__fillcap_4
Xwave_controller_y_inst__2180_ wave_controller_y_inst__3376_/B wave_controller_y_inst__2180_/A2
+ wave_controller_y_inst__2201_/A1 VDD VDD VSS VSS gf180mcu_fd_sc_mcu7t5v0__nand2_1
XFILLER_137_239 VDD VDD VSS VSS gf180mcu_fd_sc_mcu7t5v0__fillcap_4
XFILLER_146_751 VDD VDD VSS VSS gf180mcu_fd_sc_mcu7t5v0__fillcap_32
Xwave_controller_x_inst__2164_ wave_controller_x_inst__2757_/A1 wave_controller_x_inst__2164_/A2
+ wave_controller_x_inst__2170_/A2 wave_controller_x_inst__2757_/B VDD VDD VSS VSS
+ gf180mcu_fd_sc_mcu7t5v0__nor3_1
XFILLER_118_475 VDD VDD VSS VSS gf180mcu_fd_sc_mcu7t5v0__fill_1
XFILLER_119_976 VDD VDD VSS VSS gf180mcu_fd_sc_mcu7t5v0__fillcap_4
Xwave_controller_x_inst__2095_ wave_controller_x_inst__2109_/B wave_controller_x_inst__2109_/A2
+ wave_controller_x_inst__2095_/B wave_controller_x_inst__2095_/C wave_controller_x_inst__2098_/A1
+ VDD VDD VSS VSS gf180mcu_fd_sc_mcu7t5v0__aoi211_1
XFILLER_118_497 VDD VDD VSS VSS gf180mcu_fd_sc_mcu7t5v0__fill_2
XFILLER_121_607 VDD VDD VSS VSS gf180mcu_fd_sc_mcu7t5v0__fill_1
Xwave_controller_y_inst_fanout138 wave_controller_y_inst__2891_/ZN wave_controller_y_inst_wire139/I
+ VDD VDD VSS VSS gf180mcu_fd_sc_mcu7t5v0__dlyb_1
XFILLER_121_629 VDD VDD VSS VSS gf180mcu_fd_sc_mcu7t5v0__fill_1
XTAP_TAPCELL_ROW_167_2626 VDD VSS gf180mcu_fd_sc_mcu7t5v0__filltie
XTAP_TAPCELL_ROW_167_2637 VDD VSS gf180mcu_fd_sc_mcu7t5v0__filltie
XTAP_TAPCELL_ROW_167_2648 VDD VSS gf180mcu_fd_sc_mcu7t5v0__filltie
XTAP_TAPCELL_ROW_30_1_553 VDD VSS gf180mcu_fd_sc_mcu7t5v0__filltie
Xwave_controller_x_inst__2997_ wave_controller_x_inst__2938_/Z wave_controller_x_inst__2998_/A2
+ wave_controller_x_inst__3079_/A2 VDD VDD VSS VSS gf180mcu_fd_sc_mcu7t5v0__nand2_1
XFILLER_59_278 VDD VDD VSS VSS gf180mcu_fd_sc_mcu7t5v0__fill_2
Xwave_controller_y_inst__1964_ wave_controller_y_inst__3374_/B spi_regs_inst__1281_/A1
+ wave_controller_y_inst__1973_/A1 VDD VDD VSS VSS gf180mcu_fd_sc_mcu7t5v0__nand2_1
Xwave_controller_x_inst__1948_ fanout400/Z wave_controller_x_inst__3738_/Q wave_controller_x_inst__3739_/D
+ VDD VDD VSS VSS gf180mcu_fd_sc_mcu7t5v0__and2_1
XFILLER_142_45 VDD VDD VSS VSS gf180mcu_fd_sc_mcu7t5v0__fillcap_16
XFILLER_19_66 VDD VDD VSS VSS gf180mcu_fd_sc_mcu7t5v0__fillcap_4
Xwave_controller_y_inst__3703_ wave_controller_y_inst__3703_/D wave_controller_y_inst__3703_/RN
+ clkload20/I wave_controller_y_inst__3703_/Q VDD VDD VSS VSS gf180mcu_fd_sc_mcu7t5v0__dffrnq_1
Xwave_controller_y_inst__1895_ wave_controller_y_inst__3694_/Q wave_controller_y_inst__3440_/A1
+ VDD VDD VSS VSS gf180mcu_fd_sc_mcu7t5v0__clkinv_1
XFILLER_142_78 VDD VDD VSS VSS gf180mcu_fd_sc_mcu7t5v0__fillcap_8
XFILLER_27_142 VDD VDD VSS VSS gf180mcu_fd_sc_mcu7t5v0__fillcap_16
XFILLER_71_900 VDD VDD VSS VSS gf180mcu_fd_sc_mcu7t5v0__fill_2
XFILLER_74_259 VDD VDD VSS VSS gf180mcu_fd_sc_mcu7t5v0__fill_1
Xwave_controller_y_inst__3634_ wave_controller_y_inst__3634_/D wave_controller_y_inst__3708_/RN
+ clkload21/I spi_regs_inst__1312_/B2 VDD VDD VSS VSS gf180mcu_fd_sc_mcu7t5v0__dffrnq_1
Xwave_controller_x_inst__1879_ max_cap464/I wave_controller_x_inst__3527_/B2 VDD VDD
+ VSS VSS gf180mcu_fd_sc_mcu7t5v0__clkinv_1
XFILLER_15_315 VDD VDD VSS VSS gf180mcu_fd_sc_mcu7t5v0__fillcap_8
XFILLER_27_175 VDD VDD VSS VSS gf180mcu_fd_sc_mcu7t5v0__fillcap_4
XFILLER_55_473 VDD VDD VSS VSS gf180mcu_fd_sc_mcu7t5v0__fillcap_8
XFILLER_70_410 VDD VDD VSS VSS gf180mcu_fd_sc_mcu7t5v0__fillcap_4
Xwave_controller_x_inst__3618_ wave_controller_x_inst__3618_/D wave_controller_x_inst__3723_/RN
+ clkload27/I _09_/A2 VDD VDD VSS VSS gf180mcu_fd_sc_mcu7t5v0__dffrnq_1
XFILLER_15_348 VDD VDD VSS VSS gf180mcu_fd_sc_mcu7t5v0__fill_2
XFILLER_42_123 VDD VDD VSS VSS gf180mcu_fd_sc_mcu7t5v0__fillcap_8
XFILLER_70_454 VDD VDD VSS VSS gf180mcu_fd_sc_mcu7t5v0__fill_1
XTAP_TAPCELL_ROW_83_1249 VDD VSS gf180mcu_fd_sc_mcu7t5v0__filltie
Xwave_controller_y_inst__3565_ wave_controller_y_inst__3597_/I0 spi_regs_inst__1218_/A1
+ wave_controller_y_inst_wire48/Z wave_controller_y_inst__3652_/D VDD VDD VSS VSS
+ gf180mcu_fd_sc_mcu7t5v0__mux2_2
Xwave_controller_x_inst__3549_ wave_controller_x_inst__3719_/Q wave_controller_x_inst__3555_/A2
+ wave_controller_x_inst__3551_/A2 VDD VDD VSS VSS gf180mcu_fd_sc_mcu7t5v0__nor2_1
Xwave_controller_y_inst__2516_ wave_controller_y_inst__2516_/A1 spi_regs_inst__1183_/A1
+ wave_controller_y_inst__2516_/B1 wave_controller_y_inst__2489_/Z wave_controller_y_inst__2516_/C
+ wave_controller_y_inst_wire179/I VDD VDD VSS VSS gf180mcu_fd_sc_mcu7t5v0__aoi221_1
Xwave_controller_y_inst__3496_ wave_controller_y_inst__3701_/Q wave_controller_y_inst__3528_/A2
+ wave_controller_y_inst__3496_/B wave_controller_y_inst__3497_/B2 VDD VDD VSS VSS
+ gf180mcu_fd_sc_mcu7t5v0__oai21_1
Xsignal_processor_x_inst__224_ signal_processor_x_inst__224_/D fanout588/Z clkload25/I
+ spi_regs_inst__1189_/B2 VDD VDD VSS VSS gf180mcu_fd_sc_mcu7t5v0__dffrnq_1
XFILLER_11_510 VDD VDD VSS VSS gf180mcu_fd_sc_mcu7t5v0__fill_1
Xwave_controller_y_inst__2447_ wave_controller_y_inst__2445_/Z wave_controller_y_inst__2447_/A2
+ spi_regs_inst__1215_/A1 VDD VDD VSS VSS gf180mcu_fd_sc_mcu7t5v0__xor2_1
XFILLER_11_554 VDD VDD VSS VSS gf180mcu_fd_sc_mcu7t5v0__fill_1
Xsignal_processor_x_inst__155_ signal_processor_x_inst__202_/A2 signal_processor_x_inst__229_/Q
+ signal_processor_x_inst__129_/Z signal_processor_x_inst__158_/A2 VDD VDD VSS VSS
+ gf180mcu_fd_sc_mcu7t5v0__nand3_1
XFILLER_109_442 VDD VDD VSS VSS gf180mcu_fd_sc_mcu7t5v0__fillcap_4
XFILLER_156_548 VDD VDD VSS VSS gf180mcu_fd_sc_mcu7t5v0__fill_1
XFILLER_7_547 VDD VDD VSS VSS gf180mcu_fd_sc_mcu7t5v0__fillcap_8
Xwave_controller_y_inst__2378_ wave_controller_y_inst__2379_/A1 spi_regs_inst__1045_/A1
+ wave_controller_y_inst__2412_/C VDD VDD VSS VSS gf180mcu_fd_sc_mcu7t5v0__nor2_1
Xwire434 wire434/I _10_/A1 VDD VDD VSS VSS gf180mcu_fd_sc_mcu7t5v0__buf_3
Xwire456 wire456/I wire456/Z VDD VDD VSS VSS gf180mcu_fd_sc_mcu7t5v0__buf_3
XFILLER_143_209 VDD VDD VSS VSS gf180mcu_fd_sc_mcu7t5v0__fill_1
XFILLER_87_1122 VDD VDD VSS VSS gf180mcu_fd_sc_mcu7t5v0__fillcap_32
XTAP_TAPCELL_ROW_98_1492 VDD VSS gf180mcu_fd_sc_mcu7t5v0__filltie
XPHY_EDGE_ROW_54_Right_54 VDD VSS gf180mcu_fd_sc_mcu7t5v0__endcap
XTAP_TAPCELL_ROW_131_2040 VDD VSS gf180mcu_fd_sc_mcu7t5v0__filltie
XFILLER_151_253 VDD VDD VSS VSS gf180mcu_fd_sc_mcu7t5v0__fillcap_4
XFILLER_152_765 VDD VDD VSS VSS gf180mcu_fd_sc_mcu7t5v0__fill_2
XFILLER_2_241 VDD VDD VSS VSS gf180mcu_fd_sc_mcu7t5v0__fillcap_4
XTAP_TAPCELL_ROW_16_1_454 VDD VSS gf180mcu_fd_sc_mcu7t5v0__filltie
XFILLER_151_275 VDD VDD VSS VSS gf180mcu_fd_sc_mcu7t5v0__fillcap_4
XFILLER_97_329 VDD VDD VSS VSS gf180mcu_fd_sc_mcu7t5v0__fillcap_4
XFILLER_78_543 VDD VDD VSS VSS gf180mcu_fd_sc_mcu7t5v0__fillcap_4
XFILLER_116_90 VDD VDD VSS VSS gf180mcu_fd_sc_mcu7t5v0__fillcap_8
XFILLER_65_204 VDD VDD VSS VSS gf180mcu_fd_sc_mcu7t5v0__fillcap_4
XFILLER_76_61 VDD VDD VSS VSS gf180mcu_fd_sc_mcu7t5v0__fillcap_16
XFILLER_120_695 VDD VDD VSS VSS gf180mcu_fd_sc_mcu7t5v0__fillcap_4
XPHY_EDGE_ROW_63_Right_63 VDD VSS gf180mcu_fd_sc_mcu7t5v0__endcap
Xspi_regs_inst__0823_ spi_regs_inst__1391_/I1 spi_regs_inst__1566_/Q spi_regs_inst__0824_/S
+ spi_regs_inst__1566_/D VDD VDD VSS VSS gf180mcu_fd_sc_mcu7t5v0__mux2_2
XFILLER_46_473 VDD VDD VSS VSS gf180mcu_fd_sc_mcu7t5v0__fillcap_16
XFILLER_62_944 VDD VDD VSS VSS gf180mcu_fd_sc_mcu7t5v0__fill_1
XFILLER_74_771 VDD VDD VSS VSS gf180mcu_fd_sc_mcu7t5v0__fillcap_4
XTAP_TAPCELL_ROW_64_928 VDD VSS gf180mcu_fd_sc_mcu7t5v0__filltie
XTAP_TAPCELL_ROW_64_939 VDD VSS gf180mcu_fd_sc_mcu7t5v0__filltie
Xspi_regs_inst__0754_ spi_regs_inst__1627_/Q spi_regs_inst__0753_/I spi_regs_inst__1376_/A2
+ VDD VDD VSS VSS gf180mcu_fd_sc_mcu7t5v0__nand2_1
XFILLER_61_476 VDD VDD VSS VSS gf180mcu_fd_sc_mcu7t5v0__fill_2
XFILLER_61_498 VDD VDD VSS VSS gf180mcu_fd_sc_mcu7t5v0__fillcap_8
Xspi_regs_inst__1306_ spi_regs_inst__1306_/A1 spi_regs_inst__1306_/A2 spi_regs_inst__1306_/B1
+ spi_regs_inst__1306_/B2 spi_regs_inst__1307_/A4 VDD VDD VSS VSS gf180mcu_fd_sc_mcu7t5v0__aoi22_1
XFILLER_116_913 VDD VDD VSS VSS gf180mcu_fd_sc_mcu7t5v0__fillcap_32
XPHY_EDGE_ROW_72_Right_72 VDD VSS gf180mcu_fd_sc_mcu7t5v0__endcap
Xspi_regs_inst__1237_ spi_regs_inst__1074_/Z spi_regs_inst__1237_/A2 spi_regs_inst__1237_/A3
+ spi_regs_inst__1237_/A4 spi_regs_inst__1243_/A3 VDD VDD VSS VSS gf180mcu_fd_sc_mcu7t5v0__nand4_1
Xspi_regs_inst__1168_ spi_regs_inst__1168_/A1 spi_regs_inst__1215_/A2 spi_regs_inst__1227_/B1
+ spi_regs_inst__1617_/Q spi_regs_inst__1170_/A3 VDD VDD VSS VSS gf180mcu_fd_sc_mcu7t5v0__aoi22_1
XFILLER_103_629 VDD VDD VSS VSS gf180mcu_fd_sc_mcu7t5v0__fill_1
XFILLER_69_510 VDD VDD VSS VSS gf180mcu_fd_sc_mcu7t5v0__fillcap_4
XTAP_TAPCELL_ROW_149_2334 VDD VSS gf180mcu_fd_sc_mcu7t5v0__filltie
Xwave_controller_x_inst__2920_ spi_regs_inst__1349_/A1 wave_controller_x_inst__2918_/S
+ wave_controller_x_inst__2921_/B VDD VDD VSS VSS gf180mcu_fd_sc_mcu7t5v0__nand2_1
XFILLER_111_640 VDD VDD VSS VSS gf180mcu_fd_sc_mcu7t5v0__fill_2
XFILLER_130_437 VDD VDD VSS VSS gf180mcu_fd_sc_mcu7t5v0__fill_1
Xwave_controller_x_inst__2851_ wave_controller_x_inst__2851_/A1 wave_controller_x_inst__2851_/A2
+ wave_controller_x_inst__2852_/B VDD VDD VSS VSS gf180mcu_fd_sc_mcu7t5v0__nand2_1
Xspi_regs_inst__1099_ spi_regs_inst__1099_/A1 spi_regs_inst__1202_/A2 spi_regs_inst_wire221/Z
+ spi_regs_inst__1099_/B2 spi_regs_inst__1115_/A1 VDD VDD VSS VSS gf180mcu_fd_sc_mcu7t5v0__aoi22_1
XFILLER_111_651 VDD VDD VSS VSS gf180mcu_fd_sc_mcu7t5v0__fillcap_4
XFILLER_97_885 VDD VDD VSS VSS gf180mcu_fd_sc_mcu7t5v0__fill_1
Xwave_controller_x_inst__1802_ wave_controller_x_inst__3613_/Q wave_controller_x_inst__3101_/A1
+ VDD VDD VSS VSS gf180mcu_fd_sc_mcu7t5v0__clkinv_1
XFILLER_110_172 VDD VDD VSS VSS gf180mcu_fd_sc_mcu7t5v0__fill_2
XFILLER_110_183 VDD VDD VSS VSS gf180mcu_fd_sc_mcu7t5v0__fill_1
XFILLER_111_695 VDD VDD VSS VSS gf180mcu_fd_sc_mcu7t5v0__fill_1
XFILLER_96_384 VDD VDD VSS VSS gf180mcu_fd_sc_mcu7t5v0__fill_1
XPHY_EDGE_ROW_81_Right_81 VDD VSS gf180mcu_fd_sc_mcu7t5v0__endcap
XTAP_TAPCELL_ROW_162_2545 VDD VSS gf180mcu_fd_sc_mcu7t5v0__filltie
Xwave_controller_x_inst__2782_ wave_controller_x_inst__3163_/C wave_controller_x_inst__2819_/A2
+ wave_controller_x_inst__2820_/C VDD VDD VSS VSS gf180mcu_fd_sc_mcu7t5v0__nor2_1
Xsignal_processor_y_inst__118_ signal_processor_y_inst__179_/A1 signal_processor_y_inst__254_/Q
+ signal_processor_y_inst__255_/D VDD VDD VSS VSS gf180mcu_fd_sc_mcu7t5v0__and2_1
XFILLER_56_259 VDD VDD VSS VSS gf180mcu_fd_sc_mcu7t5v0__fill_1
XTAP_TAPCELL_ROW_162_2556 VDD VSS gf180mcu_fd_sc_mcu7t5v0__filltie
XTAP_TAPCELL_ROW_127_1975 VDD VSS gf180mcu_fd_sc_mcu7t5v0__filltie
XTAP_TAPCELL_ROW_33_1_579 VDD VSS gf180mcu_fd_sc_mcu7t5v0__filltie
Xwave_controller_x_inst__3403_ wave_controller_x_inst__3403_/A1 wave_controller_x_inst__3346_/Z
+ wave_controller_x_inst__3403_/A3 wave_controller_x_inst__3403_/A4 wave_controller_x_inst__3404_/A2
+ VDD VDD VSS VSS gf180mcu_fd_sc_mcu7t5v0__nand4_1
XFILLER_52_465 VDD VDD VSS VSS gf180mcu_fd_sc_mcu7t5v0__fill_2
XFILLER_53_988 VDD VDD VSS VSS gf180mcu_fd_sc_mcu7t5v0__fillcap_32
Xwave_controller_y_inst__3350_ wave_controller_y_inst__3350_/A1 wave_controller_y_inst__3315_/Z
+ wave_controller_y_inst__3350_/B wave_controller_y_inst__3352_/A2 VDD VDD VSS VSS
+ gf180mcu_fd_sc_mcu7t5v0__oai21_1
Xwave_controller_x_inst__3334_ wave_controller_x_inst__3081_/B spi_regs_inst__1536_/Q
+ wave_controller_x_inst__3328_/Z wave_controller_x_inst__3336_/A2 VDD VDD VSS VSS
+ gf180mcu_fd_sc_mcu7t5v0__nand3_1
XFILLER_12_329 VDD VDD VSS VSS gf180mcu_fd_sc_mcu7t5v0__fillcap_8
Xwave_controller_y_inst__3281_ wave_controller_y_inst__3702_/Q spi_regs_inst__1600_/Q
+ wave_controller_y_inst__3282_/B VDD VDD VSS VSS gf180mcu_fd_sc_mcu7t5v0__xor2_1
Xwave_controller_y_inst__2301_ spi_regs_inst__1478_/Q wave_controller_y_inst__2300_/Z
+ wave_controller_y_inst__2328_/A1 VDD VDD VSS VSS gf180mcu_fd_sc_mcu7t5v0__nor2_1
Xwave_controller_y_inst__2232_ wave_controller_y_inst__2248_/C1 wave_controller_y_inst__2229_/Z
+ wave_controller_y_inst__2232_/A3 spi_regs_inst__1288_/A1 VDD VDD VSS VSS gf180mcu_fd_sc_mcu7t5v0__xnor3_1
Xwave_controller_x_inst__3265_ wave_controller_x_inst__3265_/A1 spi_regs_inst__1554_/Q
+ wave_controller_x_inst__3315_/A1 VDD VDD VSS VSS gf180mcu_fd_sc_mcu7t5v0__nand2_1
XFILLER_123_1046 VDD VDD VSS VSS gf180mcu_fd_sc_mcu7t5v0__fillcap_4
XPHY_EDGE_ROW_90_Right_90 VDD VSS gf180mcu_fd_sc_mcu7t5v0__endcap
Xwave_controller_x_inst__3196_ wave_controller_x_inst__3107_/Z wave_controller_x_inst__3196_/A2
+ wave_controller_x_inst__3196_/Z VDD VDD VSS VSS gf180mcu_fd_sc_mcu7t5v0__xor2_1
Xwave_controller_x_inst__2216_ wave_controller_x_inst__2793_/I0 wave_controller_x_inst__2207_/Z
+ wave_controller_x_inst__2216_/B wave_controller_x_inst__2248_/C1 VDD VDD VSS VSS
+ gf180mcu_fd_sc_mcu7t5v0__aoi21_1
Xwave_controller_y_inst__2163_ wave_controller_y_inst__2757_/A1 spi_regs_inst__1065_/B2
+ wave_controller_y_inst__2163_/B wave_controller_y_inst__2168_/A2 VDD VDD VSS VSS
+ gf180mcu_fd_sc_mcu7t5v0__oai21_1
Xwave_controller_x_inst__2147_ wave_controller_x_inst__2147_/I wave_controller_x_inst__2152_/A2
+ VDD VDD VSS VSS gf180mcu_fd_sc_mcu7t5v0__clkinv_1
XFILLER_106_412 VDD VDD VSS VSS gf180mcu_fd_sc_mcu7t5v0__fillcap_8
XFILLER_146_592 VDD VDD VSS VSS gf180mcu_fd_sc_mcu7t5v0__fill_2
Xwave_controller_y_inst__2094_ wave_controller_y_inst__2051_/Z wave_controller_y_inst__2094_/A2
+ wave_controller_y_inst__2099_/A1 VDD VDD VSS VSS gf180mcu_fd_sc_mcu7t5v0__nand2_1
XFILLER_107_979 VDD VDD VSS VSS gf180mcu_fd_sc_mcu7t5v0__fill_1
XFILLER_97_16 VDD VDD VSS VSS gf180mcu_fd_sc_mcu7t5v0__fill_1
Xwave_controller_x_inst__2078_ wave_controller_x_inst__2095_/C wave_controller_x_inst__2095_/B
+ wave_controller_x_inst__2109_/B wave_controller_x_inst__2096_/A2 VDD VDD VSS VSS
+ gf180mcu_fd_sc_mcu7t5v0__oai21_1
XFILLER_121_426 VDD VDD VSS VSS gf180mcu_fd_sc_mcu7t5v0__fill_1
XFILLER_134_787 VDD VDD VSS VSS gf180mcu_fd_sc_mcu7t5v0__fill_2
XFILLER_161_562 VDD VDD VSS VSS gf180mcu_fd_sc_mcu7t5v0__fillcap_32
XFILLER_102_673 VDD VDD VSS VSS gf180mcu_fd_sc_mcu7t5v0__fill_1
XFILLER_88_874 VDD VDD VSS VSS gf180mcu_fd_sc_mcu7t5v0__fill_1
XFILLER_130_1017 VDD VDD VSS VSS gf180mcu_fd_sc_mcu7t5v0__fillcap_64
Xwave_controller_y_inst__2996_ wave_controller_y_inst__2938_/Z wave_controller_y_inst__2996_/A2
+ wave_controller_y_inst__3001_/B VDD VDD VSS VSS gf180mcu_fd_sc_mcu7t5v0__nand2_1
XFILLER_75_557 VDD VDD VSS VSS gf180mcu_fd_sc_mcu7t5v0__fill_2
Xwave_controller_y_inst__1947_ wave_controller_y_inst__3406_/A2 wave_controller_y_inst__1946_/Z
+ wave_controller_y_inst__3725_/D VDD VDD VSS VSS gf180mcu_fd_sc_mcu7t5v0__nor2_1
XFILLER_90_527 VDD VDD VSS VSS gf180mcu_fd_sc_mcu7t5v0__fill_2
Xwave_controller_y_inst__1878_ spi_regs_inst__1099_/B2 wave_controller_y_inst__3524_/B2
+ VDD VDD VSS VSS gf180mcu_fd_sc_mcu7t5v0__clkinv_1
XFILLER_90_549 VDD VDD VSS VSS gf180mcu_fd_sc_mcu7t5v0__fill_2
Xwave_controller_y_inst__3617_ wave_controller_y_inst__3617_/D fanout545/Z clkload1/I
+ spi_regs_inst__1290_/A1 VDD VDD VSS VSS gf180mcu_fd_sc_mcu7t5v0__dffrnq_1
XFILLER_43_454 VDD VDD VSS VSS gf180mcu_fd_sc_mcu7t5v0__fillcap_16
XFILLER_43_487 VDD VDD VSS VSS gf180mcu_fd_sc_mcu7t5v0__fill_2
XFILLER_70_240 VDD VDD VSS VSS gf180mcu_fd_sc_mcu7t5v0__fillcap_4
Xwave_controller_y_inst__3548_ wave_controller_y_inst__3557_/A1 wave_controller_y_inst__3548_/A2
+ wave_controller_y_inst__3548_/A3 wave_controller_y_inst__3554_/B1 wave_controller_y_inst__3548_/B2
+ wave_controller_y_inst__3645_/D VDD VDD VSS VSS gf180mcu_fd_sc_mcu7t5v0__oai32_1
XFILLER_30_126 VDD VDD VSS VSS gf180mcu_fd_sc_mcu7t5v0__fillcap_8
XFILLER_93_1170 VDD VDD VSS VSS gf180mcu_fd_sc_mcu7t5v0__fillcap_4
XFILLER_62_96 VDD VDD VSS VSS gf180mcu_fd_sc_mcu7t5v0__fill_1
Xwave_controller_y_inst__3479_ wave_controller_y_inst__3479_/A1 wave_controller_y_inst__3489_/A2
+ wave_controller_y_inst__3493_/A2 wave_controller_y_inst__3479_/B2 wave_controller_y_inst__3489_/C
+ wave_controller_y_inst__3480_/B VDD VDD VSS VSS gf180mcu_fd_sc_mcu7t5v0__aoi221_1
Xsignal_processor_x_inst__207_ signal_processor_x_inst__211_/A1 signal_processor_x_inst__163_/Z
+ signal_processor_x_inst__207_/B signal_processor_x_inst__222_/D VDD VDD VSS VSS
+ gf180mcu_fd_sc_mcu7t5v0__oai21_1
XFILLER_11_384 VDD VDD VSS VSS gf180mcu_fd_sc_mcu7t5v0__fill_1
XFILLER_129_537 VDD VDD VSS VSS gf180mcu_fd_sc_mcu7t5v0__fillcap_4
Xsignal_processor_x_inst__138_ signal_processor_x_inst__202_/A2 signal_processor_x_inst__229_/Q
+ signal_processor_x_inst__203_/A1 signal_processor_x_inst__138_/A4 signal_processor_x_inst__140_/A2
+ VDD VDD VSS VSS gf180mcu_fd_sc_mcu7t5v0__nor4_1
XFILLER_144_518 VDD VDD VSS VSS gf180mcu_fd_sc_mcu7t5v0__fillcap_4
XPHY_EDGE_ROW_35_1_Left_202 VDD VSS gf180mcu_fd_sc_mcu7t5v0__endcap
XFILLER_125_710 VDD VDD VSS VSS gf180mcu_fd_sc_mcu7t5v0__fillcap_4
XFILLER_124_220 VDD VDD VSS VSS gf180mcu_fd_sc_mcu7t5v0__fillcap_4
XFILLER_152_540 VDD VDD VSS VSS gf180mcu_fd_sc_mcu7t5v0__fillcap_16
Xspi_regs_inst__1022_ spi_regs_inst__1028_/A1 spi_regs_inst__1022_/A2 spi_regs_inst_wire218/I
+ VDD VDD VSS VSS gf180mcu_fd_sc_mcu7t5v0__nor2_1
XTAP_TAPCELL_ROW_111_1710 VDD VSS gf180mcu_fd_sc_mcu7t5v0__filltie
XFILLER_112_437 VDD VDD VSS VSS gf180mcu_fd_sc_mcu7t5v0__fill_2
XFILLER_121_982 VDD VDD VSS VSS gf180mcu_fd_sc_mcu7t5v0__fillcap_64
XFILLER_140_779 VDD VDD VSS VSS gf180mcu_fd_sc_mcu7t5v0__fillcap_4
XFILLER_120_481 VDD VDD VSS VSS gf180mcu_fd_sc_mcu7t5v0__fill_2
XFILLER_66_524 VDD VDD VSS VSS gf180mcu_fd_sc_mcu7t5v0__fill_1
XFILLER_66_535 VDD VDD VSS VSS gf180mcu_fd_sc_mcu7t5v0__fillcap_4
XFILLER_78_395 VDD VDD VSS VSS gf180mcu_fd_sc_mcu7t5v0__fill_2
XFILLER_94_877 VDD VDD VSS VSS gf180mcu_fd_sc_mcu7t5v0__fillcap_16
XTAP_TAPCELL_ROW_144_2253 VDD VSS gf180mcu_fd_sc_mcu7t5v0__filltie
XTAP_TAPCELL_ROW_109_1672 VDD VSS gf180mcu_fd_sc_mcu7t5v0__filltie
XFILLER_74_590 VDD VDD VSS VSS gf180mcu_fd_sc_mcu7t5v0__fillcap_4
XFILLER_98_1081 VDD VDD VSS VSS gf180mcu_fd_sc_mcu7t5v0__fillcap_4
XTAP_TAPCELL_ROW_109_1683 VDD VSS gf180mcu_fd_sc_mcu7t5v0__filltie
Xspi_regs_inst__0806_ spi_regs_inst__1412_/I1 spi_regs_inst__1556_/Q spi_regs_inst__0806_/S
+ spi_regs_inst__1556_/D VDD VDD VSS VSS gf180mcu_fd_sc_mcu7t5v0__mux2_2
Xspi_regs_inst__0737_ spi_regs_inst__1631_/Q spi_regs_inst__1370_/A1 VDD VDD VSS VSS
+ gf180mcu_fd_sc_mcu7t5v0__clkinv_1
XTAP_TAPCELL_ROW_122_1883 VDD VSS gf180mcu_fd_sc_mcu7t5v0__filltie
XTAP_TAPCELL_ROW_122_1894 VDD VSS gf180mcu_fd_sc_mcu7t5v0__filltie
XFILLER_147_334 VDD VDD VSS VSS gf180mcu_fd_sc_mcu7t5v0__fillcap_4
Xwave_controller_x_inst__3050_ wave_controller_x_inst__2956_/I wave_controller_x_inst__2957_/Z
+ wave_controller_x_inst__3050_/B wave_controller_x_inst__3052_/B1 VDD VDD VSS VSS
+ gf180mcu_fd_sc_mcu7t5v0__aoi21_1
Xanalog_block_inst_analog_readout_inst__0_ analog[0] state_machine_inst__24_/ZN analog[1]
+ VDD VDD VSS VSS gf180mcu_fd_sc_mcu7t5v0__and2_1
Xwave_controller_x_inst__2001_ wave_controller_x_inst__2001_/A1 wave_controller_x_inst__2001_/A2
+ wave_controller_x_inst__2001_/B wave_controller_x_inst__2002_/A2 VDD VDD VSS VSS
+ gf180mcu_fd_sc_mcu7t5v0__aoi21_1
XFILLER_116_721 VDD VDD VSS VSS gf180mcu_fd_sc_mcu7t5v0__fillcap_8
XFILLER_128_581 VDD VDD VSS VSS gf180mcu_fd_sc_mcu7t5v0__fill_2
XFILLER_162_348 VDD VDD VSS VSS gf180mcu_fd_sc_mcu7t5v0__fillcap_32
XFILLER_107_48 VDD VDD VSS VSS gf180mcu_fd_sc_mcu7t5v0__fillcap_4
XFILLER_115_264 VDD VDD VSS VSS gf180mcu_fd_sc_mcu7t5v0__fillcap_16
XFILLER_131_702 VDD VDD VSS VSS gf180mcu_fd_sc_mcu7t5v0__fillcap_8
XFILLER_143_562 VDD VDD VSS VSS gf180mcu_fd_sc_mcu7t5v0__fillcap_4
XFILLER_88_104 VDD VDD VSS VSS gf180mcu_fd_sc_mcu7t5v0__fill_1
XFILLER_131_768 VDD VDD VSS VSS gf180mcu_fd_sc_mcu7t5v0__fill_2
XFILLER_88_137 VDD VDD VSS VSS gf180mcu_fd_sc_mcu7t5v0__fillcap_16
Xwave_controller_x_inst__2903_ wave_controller_x_inst__3406_/A1 wave_controller_x_inst__1902_/I
+ wave_controller_x_inst__2933_/A2 VDD VDD VSS VSS gf180mcu_fd_sc_mcu7t5v0__nor2_1
Xwave_controller_y_inst__2850_ wave_controller_y_inst__3719_/Q wave_controller_y_inst__2850_/A2
+ wave_controller_y_inst__2850_/B1 wave_controller_y_inst__2845_/Z wave_controller_y_inst__2851_/A2
+ VDD VDD VSS VSS gf180mcu_fd_sc_mcu7t5v0__aoi22_1
XFILLER_69_384 VDD VDD VSS VSS gf180mcu_fd_sc_mcu7t5v0__fill_2
XFILLER_84_321 VDD VDD VSS VSS gf180mcu_fd_sc_mcu7t5v0__fill_2
Xwave_controller_y_inst__1801_ fanout499/Z wave_controller_y_inst__3098_/C VDD VDD
+ VSS VSS gf180mcu_fd_sc_mcu7t5v0__clkinv_1
Xwave_controller_x_inst__2834_ wave_controller_x_inst__3266_/A1 wave_controller_x_inst__2834_/A2
+ wave_controller_x_inst__2834_/B wave_controller_x_inst__2834_/C wave_controller_x_inst__2835_/C
+ VDD VDD VSS VSS gf180mcu_fd_sc_mcu7t5v0__aoi211_1
XFILLER_123_58 VDD VDD VSS VSS gf180mcu_fd_sc_mcu7t5v0__fill_2
XFILLER_85_855 VDD VDD VSS VSS gf180mcu_fd_sc_mcu7t5v0__fillcap_8
Xwave_controller_y_inst__2781_ wave_controller_y_inst__2616_/C wave_controller_y_inst__2831_/A2
+ wave_controller_y_inst__2781_/B wave_controller_y_inst__2819_/A2 VDD VDD VSS VSS
+ gf180mcu_fd_sc_mcu7t5v0__oai21_1
Xwave_controller_x_inst__2765_ wave_controller_x_inst__3406_/A1 wave_controller_x_inst__2764_/Z
+ wave_controller_x_inst__3471_/B VDD VDD VSS VSS gf180mcu_fd_sc_mcu7t5v0__nor2_2
XFILLER_72_527 VDD VDD VSS VSS gf180mcu_fd_sc_mcu7t5v0__fillcap_16
XFILLER_84_387 VDD VDD VSS VSS gf180mcu_fd_sc_mcu7t5v0__fillcap_16
XFILLER_16_34 VDD VDD VSS VSS gf180mcu_fd_sc_mcu7t5v0__fill_1
XFILLER_77_1154 VDD VDD VSS VSS gf180mcu_fd_sc_mcu7t5v0__fillcap_16
XPHY_EDGE_ROW_154_Right_154 VDD VSS gf180mcu_fd_sc_mcu7t5v0__endcap
Xwave_controller_x_inst__2696_ wave_controller_x_inst__2676_/Z wave_controller_x_inst__2696_/A2
+ wave_controller_x_inst__2697_/A2 VDD VDD VSS VSS gf180mcu_fd_sc_mcu7t5v0__nand2_1
XFILLER_25_454 VDD VDD VSS VSS gf180mcu_fd_sc_mcu7t5v0__fill_1
XTAP_TAPCELL_ROW_15_1_442 VDD VSS gf180mcu_fd_sc_mcu7t5v0__filltie
Xwave_controller_y_inst__3402_ wave_controller_y_inst__3402_/A1 wave_controller_y_inst__3402_/A2
+ wave_controller_y_inst__3402_/B wave_controller_y_inst__3402_/C wave_controller_y_inst__3403_/A4
+ VDD VDD VSS VSS gf180mcu_fd_sc_mcu7t5v0__oai211_1
XFILLER_12_104 VDD VDD VSS VSS gf180mcu_fd_sc_mcu7t5v0__fill_1
XFILLER_12_115 VDD VDD VSS VSS gf180mcu_fd_sc_mcu7t5v0__fillcap_4
XFILLER_164_1157 VDD VDD VSS VSS gf180mcu_fd_sc_mcu7t5v0__fillcap_16
XFILLER_80_593 VDD VDD VSS VSS gf180mcu_fd_sc_mcu7t5v0__fill_2
Xwave_controller_y_inst__3333_ wave_controller_y_inst__3320_/B wave_controller_y_inst__3333_/A2
+ wave_controller_y_inst__3333_/A3 wave_controller_y_inst__3333_/B wave_controller_y_inst__3337_/A1
+ VDD VDD VSS VSS gf180mcu_fd_sc_mcu7t5v0__oai31_1
XFILLER_12_137 VDD VDD VSS VSS gf180mcu_fd_sc_mcu7t5v0__fill_1
Xwave_controller_x_inst__3317_ wave_controller_x_inst__1783_/I spi_regs_inst__1555_/Q
+ wave_controller_x_inst__3350_/B VDD VDD VSS VSS gf180mcu_fd_sc_mcu7t5v0__xor2_1
XFILLER_139_846 VDD VDD VSS VSS gf180mcu_fd_sc_mcu7t5v0__fill_2
Xwave_controller_y_inst__3264_ wave_controller_y_inst__3265_/A1 spi_regs_inst__1612_/Q
+ wave_controller_y_inst__3350_/A1 VDD VDD VSS VSS gf180mcu_fd_sc_mcu7t5v0__nor2_1
Xwave_controller_x_inst__3248_ wave_controller_x_inst__3252_/A1 wave_controller_x_inst__3248_/A2
+ wave_controller_x_inst__3248_/B wave_controller_x_inst__3251_/A1 VDD VDD VSS VSS
+ gf180mcu_fd_sc_mcu7t5v0__oai21_1
XFILLER_165_142 VDD VDD VSS VSS gf180mcu_fd_sc_mcu7t5v0__fillcap_32
XFILLER_32_77 VDD VDD VSS VSS gf180mcu_fd_sc_mcu7t5v0__fillcap_16
Xwave_controller_y_inst__3195_ wave_controller_y_inst__3195_/A1 wave_controller_y_inst__3171_/Z
+ wave_controller_y_inst__3195_/Z VDD VDD VSS VSS gf180mcu_fd_sc_mcu7t5v0__xor2_1
Xwave_controller_y_inst__2215_ wave_controller_y_inst__2212_/Z wave_controller_y_inst_wire111/Z
+ spi_regs_inst__1226_/B2 VDD VDD VSS VSS gf180mcu_fd_sc_mcu7t5v0__xor2_1
XFILLER_119_581 VDD VDD VSS VSS gf180mcu_fd_sc_mcu7t5v0__fillcap_16
XFILLER_148_88 VDD VDD VSS VSS gf180mcu_fd_sc_mcu7t5v0__fillcap_4
XFILLER_148_99 VDD VDD VSS VSS gf180mcu_fd_sc_mcu7t5v0__fillcap_4
XTAP_TAPCELL_ROW_78_1159 VDD VSS gf180mcu_fd_sc_mcu7t5v0__filltie
Xwave_controller_y_inst__2146_ wave_controller_y_inst__2754_/A2 wave_controller_y_inst__2145_/Z
+ wave_controller_y_inst__2147_/I VDD VDD VSS VSS gf180mcu_fd_sc_mcu7t5v0__nand2_1
Xwave_controller_x_inst__3179_ wave_controller_x_inst__3252_/A1 wave_controller_x_inst__3248_/A2
+ wave_controller_x_inst__3179_/B wave_controller_x_inst__3194_/A1 VDD VDD VSS VSS
+ gf180mcu_fd_sc_mcu7t5v0__oai21_1
XFILLER_106_2 VDD VDD VSS VSS gf180mcu_fd_sc_mcu7t5v0__fillcap_8
XTAP_TAPCELL_ROW_95_1451 VDD VSS gf180mcu_fd_sc_mcu7t5v0__filltie
XTAP_TAPCELL_ROW_95_1440 VDD VSS gf180mcu_fd_sc_mcu7t5v0__filltie
XFILLER_134_584 VDD VDD VSS VSS gf180mcu_fd_sc_mcu7t5v0__fill_2
XFILLER_162_871 VDD VDD VSS VSS gf180mcu_fd_sc_mcu7t5v0__fillcap_4
Xwave_controller_y_inst__2077_ wave_controller_y_inst__2077_/A1 wave_controller_y_inst__2069_/Z
+ wave_controller_y_inst__2095_/B VDD VDD VSS VSS gf180mcu_fd_sc_mcu7t5v0__nor2_1
XFILLER_121_212 VDD VDD VSS VSS gf180mcu_fd_sc_mcu7t5v0__fillcap_8
XFILLER_161_381 VDD VDD VSS VSS gf180mcu_fd_sc_mcu7t5v0__fillcap_4
XFILLER_88_660 VDD VDD VSS VSS gf180mcu_fd_sc_mcu7t5v0__fillcap_4
XFILLER_94_107 VDD VDD VSS VSS gf180mcu_fd_sc_mcu7t5v0__fillcap_16
Xwave_controller_x_inst_fanout332 wave_controller_x_inst__3572_/A2 wave_controller_x_inst__3407_/B
+ VDD VDD VSS VSS gf180mcu_fd_sc_mcu7t5v0__dlyb_1
XFILLER_103_982 VDD VDD VSS VSS gf180mcu_fd_sc_mcu7t5v0__fillcap_64
XFILLER_88_693 VDD VDD VSS VSS gf180mcu_fd_sc_mcu7t5v0__fill_1
XFILLER_57_74 VDD VDD VSS VSS gf180mcu_fd_sc_mcu7t5v0__fill_1
XFILLER_57_85 VDD VDD VSS VSS gf180mcu_fd_sc_mcu7t5v0__fillcap_4
XFILLER_75_332 VDD VDD VSS VSS gf180mcu_fd_sc_mcu7t5v0__fillcap_8
XFILLER_76_855 VDD VDD VSS VSS gf180mcu_fd_sc_mcu7t5v0__fillcap_4
Xwave_controller_y_inst__2979_ wave_controller_y_inst__3305_/B2 wave_controller_y_inst__2979_/A2
+ wave_controller_y_inst__2979_/B wave_controller_y_inst__2981_/B VDD VDD VSS VSS
+ gf180mcu_fd_sc_mcu7t5v0__oai21_1
XFILLER_35_207 VDD VDD VSS VSS gf180mcu_fd_sc_mcu7t5v0__fill_2
XFILLER_113_80 VDD VDD VSS VSS gf180mcu_fd_sc_mcu7t5v0__fillcap_8
XPHY_EDGE_ROW_121_Right_121 VDD VSS gf180mcu_fd_sc_mcu7t5v0__endcap
Xspi_regs_inst__1640_ spi_regs_inst__1640_/D spi_regs_inst__1659_/RN clkload8/I spi_regs_inst__1640_/Q
+ VDD VDD VSS VSS gf180mcu_fd_sc_mcu7t5v0__dffrnq_1
Xspi_regs_inst__1571_ spi_regs_inst__1571_/D spi_regs_inst__1610_/RN clkload17/I spi_regs_inst__1571_/Q
+ VDD VDD VSS VSS gf180mcu_fd_sc_mcu7t5v0__dffrnq_1
XFILLER_92_8 VDD VDD VSS VSS gf180mcu_fd_sc_mcu7t5v0__fillcap_4
XFILLER_148_109 VDD VDD VSS VSS gf180mcu_fd_sc_mcu7t5v0__fill_1
XTAP_TAPCELL_ROW_104_1591 VDD VSS gf180mcu_fd_sc_mcu7t5v0__filltie
Xwave_controller_x_inst_max_cap382 wave_controller_x_inst__1945_/A1 wave_controller_x_inst__2117_/B
+ VDD VDD VSS VSS gf180mcu_fd_sc_mcu7t5v0__clkbuf_3
XFILLER_129_323 VDD VDD VSS VSS gf180mcu_fd_sc_mcu7t5v0__fill_2
XFILLER_157_632 VDD VDD VSS VSS gf180mcu_fd_sc_mcu7t5v0__fillcap_4
XPHY_EDGE_ROW_52_1_Right_51 VDD VSS gf180mcu_fd_sc_mcu7t5v0__endcap
XFILLER_129_356 VDD VDD VSS VSS gf180mcu_fd_sc_mcu7t5v0__fill_2
XFILLER_157_654 VDD VDD VSS VSS gf180mcu_fd_sc_mcu7t5v0__fill_1
XFILLER_125_551 VDD VDD VSS VSS gf180mcu_fd_sc_mcu7t5v0__fillcap_8
XFILLER_125_562 VDD VDD VSS VSS gf180mcu_fd_sc_mcu7t5v0__fillcap_8
XFILLER_98_413 VDD VDD VSS VSS gf180mcu_fd_sc_mcu7t5v0__fill_1
Xstate_machine_inst__35_ state_machine_inst__37_/A1 state_machine_inst__35_/A2 state_machine_inst__35_/B
+ _08_/I state_machine_inst__39_/D VDD VDD VSS VSS gf180mcu_fd_sc_mcu7t5v0__aoi211_1
Xspi_regs_inst__1005_ spi_regs_inst__1029_/A1 spi_regs_inst__1021_/A2 spi_regs_inst__1247_/B1
+ VDD VDD VSS VSS gf180mcu_fd_sc_mcu7t5v0__nor2_1
XFILLER_98_457 VDD VDD VSS VSS gf180mcu_fd_sc_mcu7t5v0__fill_2
XFILLER_100_407 VDD VDD VSS VSS gf180mcu_fd_sc_mcu7t5v0__fill_1
XFILLER_101_908 VDD VDD VSS VSS gf180mcu_fd_sc_mcu7t5v0__fill_2
XFILLER_140_554 VDD VDD VSS VSS gf180mcu_fd_sc_mcu7t5v0__fill_1
XFILLER_117_1170 VDD VDD VSS VSS gf180mcu_fd_sc_mcu7t5v0__fillcap_4
XFILLER_21_2 VDD VDD VSS VSS gf180mcu_fd_sc_mcu7t5v0__fillcap_64
XFILLER_79_671 VDD VDD VSS VSS gf180mcu_fd_sc_mcu7t5v0__fillcap_4
XFILLER_67_866 VDD VDD VSS VSS gf180mcu_fd_sc_mcu7t5v0__fillcap_4
XFILLER_54_527 VDD VDD VSS VSS gf180mcu_fd_sc_mcu7t5v0__fillcap_4
XFILLER_66_387 VDD VDD VSS VSS gf180mcu_fd_sc_mcu7t5v0__fillcap_16
XFILLER_93_151 VDD VDD VSS VSS gf180mcu_fd_sc_mcu7t5v0__fill_2
Xwave_controller_x_inst__2550_ wave_controller_x_inst__2786_/A1 max_cap465/Z wave_controller_x_inst__2550_/Z
+ VDD VDD VSS VSS gf180mcu_fd_sc_mcu7t5v0__xor2_1
XTAP_TAPCELL_ROW_124_1923 VDD VSS gf180mcu_fd_sc_mcu7t5v0__filltie
XFILLER_34_251 VDD VDD VSS VSS gf180mcu_fd_sc_mcu7t5v0__fill_2
Xwave_controller_x_inst__2481_ wave_controller_x_inst__2481_/I wave_controller_x_inst__2483_/B1
+ VDD VDD VSS VSS gf180mcu_fd_sc_mcu7t5v0__clkinv_1
XFILLER_62_593 VDD VDD VSS VSS gf180mcu_fd_sc_mcu7t5v0__fill_2
XFILLER_22_457 VDD VDD VSS VSS gf180mcu_fd_sc_mcu7t5v0__fill_1
XFILLER_22_479 VDD VDD VSS VSS gf180mcu_fd_sc_mcu7t5v0__fillcap_8
XTAP_TAPCELL_ROW_157_2466 VDD VSS gf180mcu_fd_sc_mcu7t5v0__filltie
Xwave_controller_x_inst__3102_ wave_controller_x_inst__3102_/A1 wave_controller_x_inst__3101_/B
+ wave_controller_x_inst__3614_/D VDD VDD VSS VSS gf180mcu_fd_sc_mcu7t5v0__nor2_1
XFILLER_136_849 VDD VDD VSS VSS gf180mcu_fd_sc_mcu7t5v0__fill_2
XFILLER_147_186 VDD VDD VSS VSS gf180mcu_fd_sc_mcu7t5v0__fillcap_16
XFILLER_162_101 VDD VDD VSS VSS gf180mcu_fd_sc_mcu7t5v0__fillcap_4
Xwave_controller_y_inst__2000_ wave_controller_y_inst__2001_/A1 wave_controller_y_inst__2001_/B
+ wave_controller_y_inst__2001_/A2 wave_controller_y_inst__2000_/Z VDD VDD VSS VSS
+ gf180mcu_fd_sc_mcu7t5v0__and3_1
Xwave_controller_x_inst__3033_ wave_controller_x_inst__3697_/Q wave_controller_x_inst__3033_/A2
+ wave_controller_x_inst__3698_/Q wave_controller_x_inst__3034_/A3 VDD VDD VSS VSS
+ gf180mcu_fd_sc_mcu7t5v0__aoi21_1
XFILLER_135_337 VDD VDD VSS VSS gf180mcu_fd_sc_mcu7t5v0__fillcap_8
XTAP_TAPCELL_ROW_18_1_468 VDD VSS gf180mcu_fd_sc_mcu7t5v0__filltie
XFILLER_144_871 VDD VDD VSS VSS gf180mcu_fd_sc_mcu7t5v0__fillcap_4
XFILLER_78_18 VDD VDD VSS VSS gf180mcu_fd_sc_mcu7t5v0__fill_2
Xwave_controller_x_inst_wire118 wave_controller_x_inst_wire118/I wave_controller_x_inst_wire118/Z
+ VDD VDD VSS VSS gf180mcu_fd_sc_mcu7t5v0__clkbuf_1
XFILLER_103_212 VDD VDD VSS VSS gf180mcu_fd_sc_mcu7t5v0__fillcap_4
XFILLER_76_107 VDD VDD VSS VSS gf180mcu_fd_sc_mcu7t5v0__fillcap_8
XTAP_TAPCELL_ROW_73_1078 VDD VSS gf180mcu_fd_sc_mcu7t5v0__filltie
XTAP_TAPCELL_ROW_73_1089 VDD VSS gf180mcu_fd_sc_mcu7t5v0__filltie
Xwave_controller_y_inst__2902_ wave_controller_y_inst__3489_/C wave_controller_y_inst__2902_/A2
+ wave_controller_y_inst__2902_/A3 wave_controller_y_inst__2902_/B1 wave_controller_y_inst__2902_/B2
+ wave_controller_y_inst__3723_/D VDD VDD VSS VSS gf180mcu_fd_sc_mcu7t5v0__oai32_1
XTAP_TAPCELL_ROW_90_1370 VDD VSS gf180mcu_fd_sc_mcu7t5v0__filltie
XFILLER_100_941 VDD VDD VSS VSS gf180mcu_fd_sc_mcu7t5v0__fillcap_4
XFILLER_58_877 VDD VDD VSS VSS gf180mcu_fd_sc_mcu7t5v0__fillcap_4
Xwave_controller_y_inst__2833_ wave_controller_y_inst__2915_/A1 wave_controller_y_inst__2833_/A2
+ wave_controller_y_inst__2835_/B VDD VDD VSS VSS gf180mcu_fd_sc_mcu7t5v0__nand2_1
Xwave_controller_x_inst__2817_ wave_controller_x_inst__3709_/Q wave_controller_x_inst__2817_/A2
+ wave_controller_x_inst__2817_/B1 wave_controller_x_inst__1790_/I wave_controller_x_inst__2818_/B
+ VDD VDD VSS VSS gf180mcu_fd_sc_mcu7t5v0__aoi22_1
Xwave_controller_y_inst__2764_ _09_/A1 _10_/A1 wave_controller_y_inst__3081_/C wave_controller_y_inst__2764_/Z
+ VDD VDD VSS VSS gf180mcu_fd_sc_mcu7t5v0__or3_1
XFILLER_73_858 VDD VDD VSS VSS gf180mcu_fd_sc_mcu7t5v0__fillcap_4
Xwave_controller_x_inst__2748_ spi_regs_inst__1188_/C1 wave_controller_x_inst__2748_/A2
+ wave_controller_x_inst__2743_/Z wave_controller_x_inst__2748_/Z VDD VDD VSS VSS
+ gf180mcu_fd_sc_mcu7t5v0__xor3_1
XFILLER_27_99 VDD VDD VSS VSS gf180mcu_fd_sc_mcu7t5v0__fillcap_8
Xwave_controller_y_inst__2695_ wave_controller_y_inst__2712_/C wave_controller_y_inst__2694_/Z
+ wave_controller_y_inst__2697_/A1 VDD VDD VSS VSS gf180mcu_fd_sc_mcu7t5v0__nor2_1
Xwave_controller_x_inst__2679_ wave_controller_x_inst__2642_/Z wave_controller_x_inst__2679_/A2
+ wave_controller_x_inst__2710_/A3 wave_controller_x_inst__2681_/B VDD VDD VSS VSS
+ gf180mcu_fd_sc_mcu7t5v0__nand3_1
XFILLER_129_1052 VDD VDD VSS VSS gf180mcu_fd_sc_mcu7t5v0__fillcap_64
XPHY_EDGE_ROW_4_1_Left_171 VDD VSS gf180mcu_fd_sc_mcu7t5v0__endcap
XFILLER_139_632 VDD VDD VSS VSS gf180mcu_fd_sc_mcu7t5v0__fillcap_4
XFILLER_90_1151 VDD VDD VSS VSS gf180mcu_fd_sc_mcu7t5v0__fillcap_4
Xwave_controller_y_inst__3316_ wave_controller_y_inst__3320_/A1 spi_regs_inst__1613_/Q
+ wave_controller_y_inst__3347_/B VDD VDD VSS VSS gf180mcu_fd_sc_mcu7t5v0__nand2_1
XFILLER_138_131 VDD VDD VSS VSS gf180mcu_fd_sc_mcu7t5v0__fill_2
Xwave_controller_y_inst__3247_ wave_controller_y_inst__3400_/A1 wave_controller_y_inst__3195_/Z
+ wave_controller_y_inst__3196_/Z wave_controller_y_inst__1816_/I wave_controller_y_inst__3254_/A2
+ VDD VDD VSS VSS gf180mcu_fd_sc_mcu7t5v0__aoi22_1
Xclkbuf_leaf_20_clk clkbuf_3_5__f_clk/Z clkbuf_leaf_20_clk/Z VDD VDD VSS VSS gf180mcu_fd_sc_mcu7t5v0__clkbuf_8
XFILLER_127_838 VDD VDD VSS VSS gf180mcu_fd_sc_mcu7t5v0__fill_2
XFILLER_153_134 VDD VDD VSS VSS gf180mcu_fd_sc_mcu7t5v0__fillcap_4
XFILLER_154_657 VDD VDD VSS VSS gf180mcu_fd_sc_mcu7t5v0__fillcap_8
Xwave_controller_y_inst__3178_ wave_controller_y_inst__3175_/Z wave_controller_y_inst__3248_/B
+ wave_controller_y_inst__3179_/B VDD VDD VSS VSS gf180mcu_fd_sc_mcu7t5v0__nor2_1
Xwave_controller_y_inst__2129_ wave_controller_y_inst__2058_/C wave_controller_y_inst__2137_/A2
+ wave_controller_y_inst__2129_/B wave_controller_y_inst__2144_/B wave_controller_y_inst__2130_/B
+ VDD VDD VSS VSS gf180mcu_fd_sc_mcu7t5v0__oai211_1
XFILLER_134_381 VDD VDD VSS VSS gf180mcu_fd_sc_mcu7t5v0__fillcap_4
XFILLER_4_177 VDD VDD VSS VSS gf180mcu_fd_sc_mcu7t5v0__fillcap_64
XFILLER_4_37 VDD VDD VSS VSS gf180mcu_fd_sc_mcu7t5v0__fillcap_64
XFILLER_122_543 VDD VDD VSS VSS gf180mcu_fd_sc_mcu7t5v0__fill_1
XFILLER_96_928 VDD VDD VSS VSS gf180mcu_fd_sc_mcu7t5v0__fillcap_16
XFILLER_64_803 VDD VDD VSS VSS gf180mcu_fd_sc_mcu7t5v0__fill_2
XTAP_TAPCELL_ROW_59_850 VDD VSS gf180mcu_fd_sc_mcu7t5v0__filltie
XFILLER_36_527 VDD VDD VSS VSS gf180mcu_fd_sc_mcu7t5v0__fillcap_4
XFILLER_48_387 VDD VDD VSS VSS gf180mcu_fd_sc_mcu7t5v0__fillcap_32
XTAP_TAPCELL_ROW_141_2201 VDD VSS gf180mcu_fd_sc_mcu7t5v0__filltie
XFILLER_63_324 VDD VDD VSS VSS gf180mcu_fd_sc_mcu7t5v0__fill_1
XTAP_TAPCELL_ROW_106_1620 VDD VSS gf180mcu_fd_sc_mcu7t5v0__filltie
XTAP_TAPCELL_ROW_106_1631 VDD VSS gf180mcu_fd_sc_mcu7t5v0__filltie
Xspi_regs_inst__1623_ spi_regs_inst__1623_/D spi_regs_inst__1659_/RN clkload8/I spi_regs_inst__1623_/Q
+ VDD VDD VSS VSS gf180mcu_fd_sc_mcu7t5v0__dffrnq_1
XFILLER_149_418 VDD VDD VSS VSS gf180mcu_fd_sc_mcu7t5v0__fill_2
Xspi_regs_inst__1554_ spi_regs_inst__1554_/D fanout592/Z clkbuf_leaf_26_clk/Z spi_regs_inst__1554_/Q
+ VDD VDD VSS VSS gf180mcu_fd_sc_mcu7t5v0__dffrnq_1
XFILLER_158_941 VDD VDD VSS VSS gf180mcu_fd_sc_mcu7t5v0__fillcap_4
XFILLER_31_265 VDD VDD VSS VSS gf180mcu_fd_sc_mcu7t5v0__fillcap_8
XTAP_TAPCELL_ROW_139_2163 VDD VSS gf180mcu_fd_sc_mcu7t5v0__filltie
Xspi_regs_inst__1485_ spi_regs_inst__1485_/D spi_regs_inst__1662_/RN clkbuf_leaf_7_clk/Z
+ fanout511/I VDD VDD VSS VSS gf180mcu_fd_sc_mcu7t5v0__dffrnq_1
XFILLER_129_142 VDD VDD VSS VSS gf180mcu_fd_sc_mcu7t5v0__fillcap_16
XTAP_TAPCELL_ROW_139_2174 VDD VSS gf180mcu_fd_sc_mcu7t5v0__filltie
Xclkbuf_leaf_11_clk clkbuf_3_4__f_clk/Z clkbuf_leaf_11_clk/Z VDD VDD VSS VSS gf180mcu_fd_sc_mcu7t5v0__clkbuf_8
XFILLER_117_304 VDD VDD VSS VSS gf180mcu_fd_sc_mcu7t5v0__fill_1
XFILLER_145_613 VDD VDD VSS VSS gf180mcu_fd_sc_mcu7t5v0__fill_1
XFILLER_133_808 VDD VDD VSS VSS gf180mcu_fd_sc_mcu7t5v0__fillcap_8
XFILLER_69_2 VDD VDD VSS VSS gf180mcu_fd_sc_mcu7t5v0__fillcap_16
XTAP_TAPCELL_ROW_152_2385 VDD VSS gf180mcu_fd_sc_mcu7t5v0__filltie
XFILLER_126_893 VDD VDD VSS VSS gf180mcu_fd_sc_mcu7t5v0__fillcap_8
XFILLER_132_329 VDD VDD VSS VSS gf180mcu_fd_sc_mcu7t5v0__fill_2
XFILLER_113_543 VDD VDD VSS VSS gf180mcu_fd_sc_mcu7t5v0__fill_2
XFILLER_87_928 VDD VDD VSS VSS gf180mcu_fd_sc_mcu7t5v0__fill_2
XFILLER_98_265 VDD VDD VSS VSS gf180mcu_fd_sc_mcu7t5v0__fill_1
XFILLER_99_788 VDD VDD VSS VSS gf180mcu_fd_sc_mcu7t5v0__fillcap_8
Xwave_controller_x_inst__1981_ wave_controller_x_inst__1981_/A1 spi_regs_inst__1343_/B2
+ wave_controller_x_inst__1981_/B wave_controller_x_inst__1981_/C wave_controller_x_inst__1986_/A3
+ VDD VDD VSS VSS gf180mcu_fd_sc_mcu7t5v0__aoi211_1
Xstate_machine_inst__18_ _08_/I state_machine_inst__30_/B VDD VDD VSS VSS gf180mcu_fd_sc_mcu7t5v0__clkinv_1
XFILLER_100_204 VDD VDD VSS VSS gf180mcu_fd_sc_mcu7t5v0__fillcap_8
XFILLER_58_107 VDD VDD VSS VSS gf180mcu_fd_sc_mcu7t5v0__fillcap_8
Xwave_controller_x_inst__3720_ wave_controller_x_inst__3720_/D fanout598/Z clkbuf_leaf_22_clk/Z
+ wave_controller_x_inst__3720_/Q VDD VDD VSS VSS gf180mcu_fd_sc_mcu7t5v0__dffrnq_1
XFILLER_140_395 VDD VDD VSS VSS gf180mcu_fd_sc_mcu7t5v0__fillcap_4
XFILLER_67_652 VDD VDD VSS VSS gf180mcu_fd_sc_mcu7t5v0__fillcap_4
Xwave_controller_x_inst__3651_ wave_controller_x_inst__3651_/D wave_controller_x_inst__3701_/RN
+ clkload31/I max_cap461/I VDD VDD VSS VSS gf180mcu_fd_sc_mcu7t5v0__dffrnq_1
XFILLER_66_151 VDD VDD VSS VSS gf180mcu_fd_sc_mcu7t5v0__fillcap_8
XFILLER_95_972 VDD VDD VSS VSS gf180mcu_fd_sc_mcu7t5v0__fillcap_8
Xwave_controller_x_inst__2602_ wave_controller_x_inst__3524_/B2 wave_controller_x_inst__2588_/Z
+ wave_controller_x_inst__2602_/B wave_controller_x_inst__2631_/A2 VDD VDD VSS VSS
+ gf180mcu_fd_sc_mcu7t5v0__oai21_1
XFILLER_54_335 VDD VDD VSS VSS gf180mcu_fd_sc_mcu7t5v0__fill_1
XFILLER_55_847 VDD VDD VSS VSS gf180mcu_fd_sc_mcu7t5v0__fill_1
XFILLER_55_869 VDD VDD VSS VSS gf180mcu_fd_sc_mcu7t5v0__fill_1
Xwave_controller_x_inst__3582_ max_cap453/I wave_controller_x_inst__3588_/S wave_controller_x_inst__3583_/B
+ VDD VDD VSS VSS gf180mcu_fd_sc_mcu7t5v0__nand2_1
XFILLER_42_519 VDD VDD VSS VSS gf180mcu_fd_sc_mcu7t5v0__fillcap_4
XFILLER_54_379 VDD VDD VSS VSS gf180mcu_fd_sc_mcu7t5v0__fillcap_4
Xwave_controller_x_inst__2533_ wave_controller_x_inst__2555_/C wave_controller_x_inst__2553_/A2
+ wave_controller_x_inst__2537_/A2 VDD VDD VSS VSS gf180mcu_fd_sc_mcu7t5v0__nand2_1
XFILLER_22_210 VDD VDD VSS VSS gf180mcu_fd_sc_mcu7t5v0__fillcap_4
XTAP_TAPCELL_ROW_159_2506 VDD VSS gf180mcu_fd_sc_mcu7t5v0__filltie
Xwave_controller_y_inst__2480_ wave_controller_y_inst__2482_/A1 wave_controller_y_inst__2479_/I
+ wave_controller_y_inst__2481_/I VDD VDD VSS VSS gf180mcu_fd_sc_mcu7t5v0__nor2_1
Xwave_controller_y_inst_wire358 wave_controller_y_inst__2035_/Z wave_controller_y_inst_wire358/Z
+ VDD VDD VSS VSS gf180mcu_fd_sc_mcu7t5v0__clkbuf_2
Xwave_controller_x_inst__2464_ wave_controller_x_inst__2464_/A1 wave_controller_x_inst__2464_/A2
+ wave_controller_x_inst__2463_/B wave_controller_x_inst__2465_/A2 VDD VDD VSS VSS
+ gf180mcu_fd_sc_mcu7t5v0__nor3_1
XFILLER_161_1116 VDD VDD VSS VSS gf180mcu_fd_sc_mcu7t5v0__fillcap_4
XFILLER_50_552 VDD VDD VSS VSS gf180mcu_fd_sc_mcu7t5v0__fill_2
XFILLER_74_1157 VDD VDD VSS VSS gf180mcu_fd_sc_mcu7t5v0__fillcap_16
Xwave_controller_x_inst__2395_ wave_controller_x_inst__2391_/B wave_controller_x_inst__2389_/Z
+ wave_controller_x_inst__2396_/B VDD VDD VSS VSS gf180mcu_fd_sc_mcu7t5v0__nor2_1
XFILLER_22_287 VDD VDD VSS VSS gf180mcu_fd_sc_mcu7t5v0__fill_2
Xwave_controller_y_inst__3101_ wave_controller_y_inst__3101_/A1 wave_controller_y_inst__3101_/A2
+ wave_controller_y_inst__3101_/B wave_controller_y_inst__3613_/D VDD VDD VSS VSS
+ gf180mcu_fd_sc_mcu7t5v0__aoi21_1
XFILLER_136_624 VDD VDD VSS VSS gf180mcu_fd_sc_mcu7t5v0__fillcap_4
XFILLER_148_473 VDD VDD VSS VSS gf180mcu_fd_sc_mcu7t5v0__fillcap_4
XFILLER_163_454 VDD VDD VSS VSS gf180mcu_fd_sc_mcu7t5v0__fill_1
XTAP_TAPCELL_ROW_75_1107 VDD VSS gf180mcu_fd_sc_mcu7t5v0__filltie
Xwave_controller_y_inst__3032_ wave_controller_y_inst__3469_/A1 wave_controller_y_inst__3479_/A1
+ wave_controller_y_inst__3032_/A3 wave_controller_y_inst__3034_/A2 VDD VDD VSS VSS
+ gf180mcu_fd_sc_mcu7t5v0__nor3_1
Xwave_controller_x_inst__3016_ wave_controller_x_inst__3693_/Q wave_controller_x_inst__3692_/Q
+ wave_controller_x_inst_wire60/I wave_controller_x_inst__3021_/A2 VDD VDD VSS VSS
+ gf180mcu_fd_sc_mcu7t5v0__nand3_1
XFILLER_150_104 VDD VDD VSS VSS gf180mcu_fd_sc_mcu7t5v0__fill_1
XFILLER_163_476 VDD VDD VSS VSS gf180mcu_fd_sc_mcu7t5v0__fill_2
XFILLER_163_487 VDD VDD VSS VSS gf180mcu_fd_sc_mcu7t5v0__fill_2
XTAP_TAPCELL_ROW_75_1118 VDD VSS gf180mcu_fd_sc_mcu7t5v0__filltie
XFILLER_150_115 VDD VDD VSS VSS gf180mcu_fd_sc_mcu7t5v0__fill_2
XFILLER_132_874 VDD VDD VSS VSS gf180mcu_fd_sc_mcu7t5v0__fill_1
XFILLER_1_136 VDD VDD VSS VSS gf180mcu_fd_sc_mcu7t5v0__fillcap_4
XFILLER_58_652 VDD VDD VSS VSS gf180mcu_fd_sc_mcu7t5v0__fillcap_4
Xwave_controller_y_inst__2816_ wave_controller_y_inst__2816_/I wave_controller_y_inst__2817_/B1
+ VDD VDD VSS VSS gf180mcu_fd_sc_mcu7t5v0__clkinv_1
XFILLER_161_66 VDD VDD VSS VSS gf180mcu_fd_sc_mcu7t5v0__fillcap_4
XFILLER_18_527 VDD VDD VSS VSS gf180mcu_fd_sc_mcu7t5v0__fill_1
XFILLER_79_1046 VDD VDD VSS VSS gf180mcu_fd_sc_mcu7t5v0__fillcap_4
XFILLER_73_688 VDD VDD VSS VSS gf180mcu_fd_sc_mcu7t5v0__fill_1
XPHY_EDGE_ROW_44_1_Left_211 VDD VSS gf180mcu_fd_sc_mcu7t5v0__endcap
XTAP_TAPCELL_ROW_0_1_2663 VDD VSS gf180mcu_fd_sc_mcu7t5v0__filltie
XTAP_TAPCELL_ROW_0_1_2674 VDD VSS gf180mcu_fd_sc_mcu7t5v0__filltie
Xwave_controller_y_inst__2747_ wave_controller_y_inst__2748_/A2 wave_controller_y_inst__2745_/Z
+ wave_controller_y_inst__2747_/Z VDD VDD VSS VSS gf180mcu_fd_sc_mcu7t5v0__and2_1
XFILLER_61_839 VDD VDD VSS VSS gf180mcu_fd_sc_mcu7t5v0__fill_1
XFILLER_73_699 VDD VDD VSS VSS gf180mcu_fd_sc_mcu7t5v0__fill_1
Xwave_controller_y_inst__2678_ wave_controller_y_inst__2674_/Z wave_controller_y_inst__2678_/A2
+ wave_controller_y_inst__2709_/A1 VDD VDD VSS VSS gf180mcu_fd_sc_mcu7t5v0__xnor2_1
XTAP_TAPCELL_ROW_31_1_566 VDD VSS gf180mcu_fd_sc_mcu7t5v0__filltie
XTAP_TAPCELL_ROW_101_1550 VDD VSS gf180mcu_fd_sc_mcu7t5v0__filltie
XFILLER_110_81 VDD VDD VSS VSS gf180mcu_fd_sc_mcu7t5v0__fillcap_16
XFILLER_70_30 VDD VDD VSS VSS gf180mcu_fd_sc_mcu7t5v0__fill_1
Xspi_regs_inst__1270_ spi_regs_inst__1270_/A1 spi_regs_inst_wire284/Z spi_regs_inst_wire277/Z
+ spi_regs_inst__1504_/Q spi_regs_inst_wire240/Z max_cap458/Z spi_regs_inst__1273_/A2
+ VDD VDD VSS VSS gf180mcu_fd_sc_mcu7t5v0__aoi222_1
Xclkload17 clkload17/I clkload17/ZN VDD VDD VSS VSS gf180mcu_fd_sc_mcu7t5v0__clkinv_2
XFILLER_126_123 VDD VDD VSS VSS gf180mcu_fd_sc_mcu7t5v0__fillcap_8
XFILLER_127_646 VDD VDD VSS VSS gf180mcu_fd_sc_mcu7t5v0__fill_2
XFILLER_86_1017 VDD VDD VSS VSS gf180mcu_fd_sc_mcu7t5v0__fillcap_64
Xclkload28 clkload28/I clkload28/ZN VDD VDD VSS VSS gf180mcu_fd_sc_mcu7t5v0__inv_2
XFILLER_127_679 VDD VDD VSS VSS gf180mcu_fd_sc_mcu7t5v0__fill_2
XFILLER_154_454 VDD VDD VSS VSS gf180mcu_fd_sc_mcu7t5v0__fill_1
XTAP_TAPCELL_ROW_134_2082 VDD VSS gf180mcu_fd_sc_mcu7t5v0__filltie
XTAP_TAPCELL_ROW_134_2093 VDD VSS gf180mcu_fd_sc_mcu7t5v0__filltie
Xspi_regs_inst_wire18 spi_regs_inst_wire18/I spi_regs_inst_wire18/Z VDD VDD VSS VSS
+ gf180mcu_fd_sc_mcu7t5v0__clkbuf_2
XFILLER_107_370 VDD VDD VSS VSS gf180mcu_fd_sc_mcu7t5v0__fill_1
XFILLER_79_72 VDD VDD VSS VSS gf180mcu_fd_sc_mcu7t5v0__fillcap_8
Xspi_regs_inst_wire29 spi_regs_inst_wire29/I spi_regs_inst_wire29/Z VDD VDD VSS VSS
+ gf180mcu_fd_sc_mcu7t5v0__buf_2
Xsignal_processor_y_inst__220_ signal_processor_y_inst__220_/D fanout557/Z clkload2/I
+ spi_regs_inst__1184_/A1 VDD VDD VSS VSS gf180mcu_fd_sc_mcu7t5v0__dffrnq_1
XFILLER_79_94 VDD VDD VSS VSS gf180mcu_fd_sc_mcu7t5v0__fill_1
XFILLER_110_524 VDD VDD VSS VSS gf180mcu_fd_sc_mcu7t5v0__fill_1
XFILLER_122_384 VDD VDD VSS VSS gf180mcu_fd_sc_mcu7t5v0__fill_1
Xsignal_processor_y_inst__151_ signal_processor_y_inst__252_/Q signal_processor_y_inst__203_/A2
+ signal_processor_y_inst__151_/B signal_processor_y_inst__229_/D VDD VDD VSS VSS
+ gf180mcu_fd_sc_mcu7t5v0__oai21_1
XFILLER_110_535 VDD VDD VSS VSS gf180mcu_fd_sc_mcu7t5v0__fillcap_4
Xspi_regs_inst_fanout482 spi_regs_inst_wire487/I spi_regs_inst__1379_/I1 VDD VDD VSS
+ VSS gf180mcu_fd_sc_mcu7t5v0__dlyb_1
Xspi_regs_inst_fanout471 spi_regs_inst__1663_/Q spi_regs_inst__1444_/I1 VDD VDD VSS
+ VSS gf180mcu_fd_sc_mcu7t5v0__dlyb_1
XFILLER_114_1151 VDD VDD VSS VSS gf180mcu_fd_sc_mcu7t5v0__fillcap_4
XFILLER_92_920 VDD VDD VSS VSS gf180mcu_fd_sc_mcu7t5v0__fillcap_4
Xspi_regs_inst_fanout493 spi_regs_inst__1429_/I1 spi_regs_inst__1405_/I1 VDD VDD VSS
+ VSS gf180mcu_fd_sc_mcu7t5v0__dlyb_1
Xclkbuf_leaf_0_clk clkbuf_leaf_3_clk/I clkbuf_leaf_0_clk/Z VDD VDD VSS VSS gf180mcu_fd_sc_mcu7t5v0__clkbuf_8
X_94_ _94_/I _94_/Z VDD VDD VSS VSS gf180mcu_fd_sc_mcu7t5v0__buf_1
XFILLER_48_173 VDD VDD VSS VSS gf180mcu_fd_sc_mcu7t5v0__fill_2
XFILLER_92_942 VDD VDD VSS VSS gf180mcu_fd_sc_mcu7t5v0__fill_2
Xspi_regs_inst__0985_ spi_regs_inst__1029_/A1 spi_regs_inst__1030_/A2 spi_regs_inst__1234_/A2
+ VDD VDD VSS VSS gf180mcu_fd_sc_mcu7t5v0__nor2_1
XTAP_TAPCELL_ROW_17_1_456 VDD VSS gf180mcu_fd_sc_mcu7t5v0__filltie
Xspi_regs_inst__1606_ spi_regs_inst__1606_/D spi_regs_inst__1647_/RN clkload18/I spi_regs_inst__1606_/Q
+ VDD VDD VSS VSS gf180mcu_fd_sc_mcu7t5v0__dffrnq_1
XFILLER_60_872 VDD VDD VSS VSS gf180mcu_fd_sc_mcu7t5v0__fill_2
Xspi_regs_inst__1537_ spi_regs_inst__1537_/D fanout588/Z clkload25/I spi_regs_inst__1537_/Q
+ VDD VDD VSS VSS gf180mcu_fd_sc_mcu7t5v0__dffrnq_1
XTAP_TAPCELL_ROW_154_2414 VDD VSS gf180mcu_fd_sc_mcu7t5v0__filltie
XTAP_TAPCELL_ROW_154_2425 VDD VSS gf180mcu_fd_sc_mcu7t5v0__filltie
Xwave_controller_x_inst__2180_ wave_controller_x_inst__3376_/B wave_controller_x_inst__2180_/A2
+ wave_controller_x_inst__2201_/A1 VDD VDD VSS VSS gf180mcu_fd_sc_mcu7t5v0__nand2_1
XFILLER_118_613 VDD VDD VSS VSS gf180mcu_fd_sc_mcu7t5v0__fill_2
XFILLER_121_1122 VDD VDD VSS VSS gf180mcu_fd_sc_mcu7t5v0__fillcap_32
XTAP_TAPCELL_ROW_119_1833 VDD VSS gf180mcu_fd_sc_mcu7t5v0__filltie
XTAP_TAPCELL_ROW_119_1844 VDD VSS gf180mcu_fd_sc_mcu7t5v0__filltie
Xspi_regs_inst__1468_ spi_regs_inst__1468_/D wire594/Z clkbuf_leaf_11_clk/Z fanout534/I
+ VDD VDD VSS VSS gf180mcu_fd_sc_mcu7t5v0__dffrnq_1
Xspi_regs_inst__1399_ spi_regs_inst__1473_/Q spi_regs_inst__1441_/I1 spi_regs_inst__1402_/S
+ spi_regs_inst__1473_/D VDD VDD VSS VSS gf180mcu_fd_sc_mcu7t5v0__mux2_2
XFILLER_118_679 VDD VDD VSS VSS gf180mcu_fd_sc_mcu7t5v0__fill_1
XFILLER_133_627 VDD VDD VSS VSS gf180mcu_fd_sc_mcu7t5v0__fill_2
XPHY_EDGE_ROW_15_1_Right_14 VDD VSS gf180mcu_fd_sc_mcu7t5v0__endcap
XFILLER_132_104 VDD VDD VSS VSS gf180mcu_fd_sc_mcu7t5v0__fill_1
XFILLER_160_446 VDD VDD VSS VSS gf180mcu_fd_sc_mcu7t5v0__fill_2
XFILLER_114_874 VDD VDD VSS VSS gf180mcu_fd_sc_mcu7t5v0__fill_1
XFILLER_101_524 VDD VDD VSS VSS gf180mcu_fd_sc_mcu7t5v0__fill_2
XFILLER_115_26 VDD VDD VSS VSS gf180mcu_fd_sc_mcu7t5v0__fill_1
XFILLER_87_714 VDD VDD VSS VSS gf180mcu_fd_sc_mcu7t5v0__fill_2
XTAP_TAPCELL_ROW_70_1026 VDD VSS gf180mcu_fd_sc_mcu7t5v0__filltie
XTAP_TAPCELL_ROW_70_1037 VDD VSS gf180mcu_fd_sc_mcu7t5v0__filltie
Xwave_controller_y_inst__1980_ wave_controller_y_inst__1980_/A1 wave_controller_y_inst__1986_/B
+ wave_controller_y_inst__1986_/A2 VDD VDD VSS VSS gf180mcu_fd_sc_mcu7t5v0__nand2_1
XFILLER_115_59 VDD VDD VSS VSS gf180mcu_fd_sc_mcu7t5v0__fillcap_8
XFILLER_140_170 VDD VDD VSS VSS gf180mcu_fd_sc_mcu7t5v0__fill_1
XFILLER_75_909 VDD VDD VSS VSS gf180mcu_fd_sc_mcu7t5v0__fill_1
Xwave_controller_x_inst__3703_ wave_controller_x_inst__3703_/D wave_controller_x_inst__3704_/RN
+ clkload36/I wave_controller_x_inst__3703_/Q VDD VDD VSS VSS gf180mcu_fd_sc_mcu7t5v0__dffrnq_1
Xwave_controller_x_inst__1964_ wave_controller_x_inst__3374_/B spi_regs_inst__1284_/B2
+ wave_controller_x_inst__1973_/A1 VDD VDD VSS VSS gf180mcu_fd_sc_mcu7t5v0__nand2_1
XTAP_TAPCELL_ROW_165_2598 VDD VSS gf180mcu_fd_sc_mcu7t5v0__filltie
Xwave_controller_x_inst__1895_ wave_controller_x_inst__3694_/Q wave_controller_x_inst__3440_/A1
+ VDD VDD VSS VSS gf180mcu_fd_sc_mcu7t5v0__clkinv_1
Xwave_controller_y_inst__3650_ wave_controller_y_inst__3650_/D wave_controller_y_inst__3673_/RN
+ clkbuf_leaf_35_clk/Z spi_regs_inst__1101_/A1 VDD VDD VSS VSS gf180mcu_fd_sc_mcu7t5v0__dffrnq_1
Xwave_controller_x_inst__3634_ wave_controller_x_inst__3634_/D wave_controller_x_inst__3704_/RN
+ clkload35/I spi_regs_inst__1311_/B2 VDD VDD VSS VSS gf180mcu_fd_sc_mcu7t5v0__dffrnq_1
XFILLER_82_452 VDD VDD VSS VSS gf180mcu_fd_sc_mcu7t5v0__fill_2
Xwave_controller_y_inst__2601_ max_cap432/Z wave_controller_y_inst__2599_/Z wave_controller_y_inst__2601_/Z
+ VDD VDD VSS VSS gf180mcu_fd_sc_mcu7t5v0__xor2_1
Xwave_controller_y_inst_wire111 wave_controller_y_inst_wire111/I wave_controller_y_inst_wire111/Z
+ VDD VDD VSS VSS gf180mcu_fd_sc_mcu7t5v0__clkbuf_1
Xwave_controller_y_inst__3581_ wave_controller_y_inst__3588_/S wave_controller_y_inst__3610_/A2
+ wave_controller_y_inst__3581_/B wave_controller_y_inst__3660_/D VDD VDD VSS VSS
+ gf180mcu_fd_sc_mcu7t5v0__oai21_1
Xwave_controller_x_inst__3565_ wave_controller_x_inst__3597_/I0 max_cap460/Z wave_controller_x_inst__3569_/S
+ wave_controller_x_inst__3652_/D VDD VDD VSS VSS gf180mcu_fd_sc_mcu7t5v0__mux2_2
XFILLER_131_69 VDD VDD VSS VSS gf180mcu_fd_sc_mcu7t5v0__fill_1
XFILLER_55_699 VDD VDD VSS VSS gf180mcu_fd_sc_mcu7t5v0__fill_1
Xwave_controller_y_inst__2532_ spi_regs_inst__1353_/A1 wave_controller_y_inst__3518_/B2
+ wave_controller_y_inst__2553_/A2 VDD VDD VSS VSS gf180mcu_fd_sc_mcu7t5v0__nand2_1
Xwave_controller_y_inst_wire122 wave_controller_y_inst_wire122/I wave_controller_y_inst_wire122/Z
+ VDD VDD VSS VSS gf180mcu_fd_sc_mcu7t5v0__clkbuf_1
Xwave_controller_y_inst_wire144 wave_controller_y_inst_wire144/I wave_controller_y_inst_wire144/Z
+ VDD VDD VSS VSS gf180mcu_fd_sc_mcu7t5v0__buf_4
Xwave_controller_x_inst__2516_ wave_controller_x_inst__2516_/A1 spi_regs_inst__1212_/B2
+ wave_controller_x_inst__2516_/B1 wave_controller_x_inst__2489_/Z wave_controller_x_inst__2516_/C
+ wave_controller_x_inst_wire182/I VDD VDD VSS VSS gf180mcu_fd_sc_mcu7t5v0__aoi221_1
Xsignal_processor_x_inst__240_ signal_processor_x_inst__240_/D fanout587/Z clkload23/I
+ signal_processor_x_inst__240_/Q VDD VDD VSS VSS gf180mcu_fd_sc_mcu7t5v0__dffrnq_1
XFILLER_126_1011 VDD VDD VSS VSS gf180mcu_fd_sc_mcu7t5v0__fillcap_4
XTAP_TAPCELL_ROW_85_1280 VDD VSS gf180mcu_fd_sc_mcu7t5v0__filltie
Xwave_controller_x_inst__3496_ wave_controller_x_inst__3701_/Q wave_controller_x_inst__3537_/A2
+ wave_controller_x_inst__3496_/B wave_controller_x_inst__3497_/B2 VDD VDD VSS VSS
+ gf180mcu_fd_sc_mcu7t5v0__oai21_1
XFILLER_24_34 VDD VDD VSS VSS gf180mcu_fd_sc_mcu7t5v0__fill_1
XFILLER_24_45 VDD VDD VSS VSS gf180mcu_fd_sc_mcu7t5v0__fillcap_4
XFILLER_50_360 VDD VDD VSS VSS gf180mcu_fd_sc_mcu7t5v0__fillcap_8
Xwave_controller_y_inst__2463_ wave_controller_y_inst__2464_/A1 wave_controller_y_inst__2464_/A2
+ wave_controller_y_inst__2463_/B wave_controller_y_inst__2516_/B1 VDD VDD VSS VSS
+ gf180mcu_fd_sc_mcu7t5v0__oai21_1
Xwave_controller_x_inst__2447_ wave_controller_x_inst__2445_/Z wave_controller_x_inst__2447_/A2
+ spi_regs_inst__1182_/A1 VDD VDD VSS VSS gf180mcu_fd_sc_mcu7t5v0__xor2_1
Xsignal_processor_x_inst__171_ signal_processor_x_inst__235_/Q signal_processor_x_inst__172_/A2
+ signal_processor_x_inst__171_/Z VDD VDD VSS VSS gf180mcu_fd_sc_mcu7t5v0__xor2_1
Xwave_controller_y_inst__2394_ wave_controller_y_inst__2394_/A1 wave_controller_y_inst__2373_/Z
+ wave_controller_y_inst__2396_/C wave_controller_y_inst__2389_/Z wave_controller_y_inst__2394_/Z
+ VDD VDD VSS VSS gf180mcu_fd_sc_mcu7t5v0__or4_1
Xwave_controller_x_inst__2378_ wave_controller_x_inst__2379_/A1 spi_regs_inst__1060_/A1
+ wave_controller_x_inst__2412_/C VDD VDD VSS VSS gf180mcu_fd_sc_mcu7t5v0__nor2_1
Xchip_core_645 bidir_pd[0] VDD VDD VSS VSS gf180mcu_fd_sc_mcu7t5v0__tiel
Xchip_core_634 bidir_cs[9] VDD VDD VSS VSS gf180mcu_fd_sc_mcu7t5v0__tiel
Xchip_core_678 bidir_ie[0] VDD VDD VSS VSS gf180mcu_fd_sc_mcu7t5v0__tieh
Xchip_core_667 bidir_sl[4] VDD VDD VSS VSS gf180mcu_fd_sc_mcu7t5v0__tiel
Xchip_core_656 bidir_pu[2] VDD VDD VSS VSS gf180mcu_fd_sc_mcu7t5v0__tiel
XFILLER_124_605 VDD VDD VSS VSS gf180mcu_fd_sc_mcu7t5v0__fillcap_8
XFILLER_156_22 VDD VDD VSS VSS gf180mcu_fd_sc_mcu7t5v0__fillcap_8
XFILLER_163_240 VDD VDD VSS VSS gf180mcu_fd_sc_mcu7t5v0__fill_2
Xwave_controller_y_inst__3015_ wave_controller_y_inst__3430_/A1 wave_controller_y_inst__3015_/A2
+ wave_controller_y_inst__3015_/B1 wave_controller_y_inst__3016_/A3 wave_controller_y_inst__3693_/D
+ VDD VDD VSS VSS gf180mcu_fd_sc_mcu7t5v0__aoi22_1
XFILLER_123_104 VDD VDD VSS VSS gf180mcu_fd_sc_mcu7t5v0__fill_2
XFILLER_151_413 VDD VDD VSS VSS gf180mcu_fd_sc_mcu7t5v0__fillcap_4
XFILLER_152_947 VDD VDD VSS VSS gf180mcu_fd_sc_mcu7t5v0__fillcap_64
XFILLER_163_295 VDD VDD VSS VSS gf180mcu_fd_sc_mcu7t5v0__fillcap_4
XFILLER_78_703 VDD VDD VSS VSS gf180mcu_fd_sc_mcu7t5v0__fill_1
XFILLER_104_362 VDD VDD VSS VSS gf180mcu_fd_sc_mcu7t5v0__fillcap_4
XFILLER_2_478 VDD VDD VSS VSS gf180mcu_fd_sc_mcu7t5v0__fillcap_4
Xwave_controller_y_inst_wire89 wave_controller_y_inst_wire89/I wave_controller_y_inst_wire89/Z
+ VDD VDD VSS VSS gf180mcu_fd_sc_mcu7t5v0__buf_2
XFILLER_120_866 VDD VDD VSS VSS gf180mcu_fd_sc_mcu7t5v0__fillcap_8
XFILLER_120_877 VDD VDD VSS VSS gf180mcu_fd_sc_mcu7t5v0__fillcap_4
XFILLER_86_780 VDD VDD VSS VSS gf180mcu_fd_sc_mcu7t5v0__fillcap_8
XFILLER_45_132 VDD VDD VSS VSS gf180mcu_fd_sc_mcu7t5v0__fill_2
XFILLER_65_63 VDD VDD VSS VSS gf180mcu_fd_sc_mcu7t5v0__fill_2
XFILLER_73_463 VDD VDD VSS VSS gf180mcu_fd_sc_mcu7t5v0__fillcap_8
XFILLER_85_290 VDD VDD VSS VSS gf180mcu_fd_sc_mcu7t5v0__fill_2
Xspi_regs_inst__0770_ spi_regs_inst__1650_/Q spi_regs_inst__0815_/A2 spi_regs_inst__1428_/A2
+ VDD VDD VSS VSS gf180mcu_fd_sc_mcu7t5v0__nand2_1
XFILLER_60_102 VDD VDD VSS VSS gf180mcu_fd_sc_mcu7t5v0__fill_2
XFILLER_121_80 VDD VDD VSS VSS gf180mcu_fd_sc_mcu7t5v0__fillcap_8
XFILLER_33_349 VDD VDD VSS VSS gf180mcu_fd_sc_mcu7t5v0__fill_1
XFILLER_61_658 VDD VDD VSS VSS gf180mcu_fd_sc_mcu7t5v0__fillcap_4
XFILLER_159_557 VDD VDD VSS VSS gf180mcu_fd_sc_mcu7t5v0__fill_2
XFILLER_92_1087 VDD VDD VSS VSS gf180mcu_fd_sc_mcu7t5v0__fillcap_64
XTAP_TAPCELL_ROW_136_2122 VDD VSS gf180mcu_fd_sc_mcu7t5v0__filltie
Xspi_regs_inst__1322_ spi_regs_inst_wire92/Z spi_regs_inst__1322_/A2 spi_regs_inst_wire242/Z
+ spi_regs_inst__1513_/Q spi_regs_inst__1323_/A4 VDD VDD VSS VSS gf180mcu_fd_sc_mcu7t5v0__aoi22_1
XFILLER_128_944 VDD VDD VSS VSS gf180mcu_fd_sc_mcu7t5v0__fill_1
Xspi_regs_inst__1253_ spi_regs_inst__1253_/A1 spi_regs_inst__1253_/A2 spi_regs_inst__1253_/A3
+ spi_regs_inst__1253_/A4 spi_regs_inst__1264_/A2 VDD VDD VSS VSS gf180mcu_fd_sc_mcu7t5v0__nand4_1
XFILLER_127_454 VDD VDD VSS VSS gf180mcu_fd_sc_mcu7t5v0__fillcap_16
Xspi_regs_inst__1184_ spi_regs_inst__1184_/A1 spi_regs_inst__1184_/A2 spi_regs_inst__1184_/B
+ spi_regs_inst__1187_/A2 VDD VDD VSS VSS gf180mcu_fd_sc_mcu7t5v0__aoi21_1
XFILLER_114_104 VDD VDD VSS VSS gf180mcu_fd_sc_mcu7t5v0__fill_1
XFILLER_142_413 VDD VDD VSS VSS gf180mcu_fd_sc_mcu7t5v0__fillcap_8
XFILLER_142_457 VDD VDD VSS VSS gf180mcu_fd_sc_mcu7t5v0__fill_1
XTAP_TAPCELL_ROW_114_1752 VDD VSS gf180mcu_fd_sc_mcu7t5v0__filltie
XTAP_TAPCELL_ROW_114_1763 VDD VSS gf180mcu_fd_sc_mcu7t5v0__filltie
XFILLER_123_660 VDD VDD VSS VSS gf180mcu_fd_sc_mcu7t5v0__fillcap_16
XFILLER_130_619 VDD VDD VSS VSS gf180mcu_fd_sc_mcu7t5v0__fill_1
XFILLER_142_479 VDD VDD VSS VSS gf180mcu_fd_sc_mcu7t5v0__fillcap_16
Xsignal_processor_y_inst__203_ signal_processor_y_inst__203_/A1 signal_processor_y_inst__203_/A2
+ signal_processor_y_inst__187_/B signal_processor_y_inst__203_/B2 signal_processor_y_inst__220_/D
+ VDD VDD VSS VSS gf180mcu_fd_sc_mcu7t5v0__oai22_1
XFILLER_57_909 VDD VDD VSS VSS gf180mcu_fd_sc_mcu7t5v0__fill_1
XFILLER_69_747 VDD VDD VSS VSS gf180mcu_fd_sc_mcu7t5v0__fill_1
Xsignal_processor_y_inst__134_ fanout393/Z signal_processor_y_inst__199_/A2 signal_processor_y_inst__215_/A1
+ VDD VDD VSS VSS gf180mcu_fd_sc_mcu7t5v0__nand2_1
XFILLER_111_888 VDD VDD VSS VSS gf180mcu_fd_sc_mcu7t5v0__fillcap_8
XFILLER_83_216 VDD VDD VSS VSS gf180mcu_fd_sc_mcu7t5v0__fill_2
XTAP_TAPCELL_ROW_147_2295 VDD VSS gf180mcu_fd_sc_mcu7t5v0__filltie
Xinput4 input_in _18_/A2 VDD VDD VSS VSS gf180mcu_fd_sc_mcu7t5v0__buf_1
XFILLER_64_430 VDD VDD VSS VSS gf180mcu_fd_sc_mcu7t5v0__fillcap_8
XFILLER_80_901 VDD VDD VSS VSS gf180mcu_fd_sc_mcu7t5v0__fillcap_4
Xspi_regs_inst__0968_ spi_regs_inst__1032_/A1 spi_regs_inst__1002_/A2 spi_regs_inst__1341_/A2
+ VDD VDD VSS VSS gf180mcu_fd_sc_mcu7t5v0__nor2_1
XFILLER_91_271 VDD VDD VSS VSS gf180mcu_fd_sc_mcu7t5v0__fillcap_8
XFILLER_101_17 VDD VDD VSS VSS gf180mcu_fd_sc_mcu7t5v0__fillcap_8
XFILLER_51_113 VDD VDD VSS VSS gf180mcu_fd_sc_mcu7t5v0__fillcap_4
Xwave_controller_x_inst__3350_ wave_controller_x_inst__3350_/A1 wave_controller_x_inst__3315_/Z
+ wave_controller_x_inst__3350_/B wave_controller_x_inst__3352_/A2 VDD VDD VSS VSS
+ gf180mcu_fd_sc_mcu7t5v0__oai21_1
Xspi_regs_inst__0899_ spi_regs_inst__0749_/Z spi_regs_inst__0899_/A2 spi_regs_inst__0899_/B
+ spi_regs_inst__1626_/D VDD VDD VSS VSS gf180mcu_fd_sc_mcu7t5v0__oai21_1
XFILLER_71_1116 VDD VDD VSS VSS gf180mcu_fd_sc_mcu7t5v0__fillcap_4
Xwave_controller_x_inst__3281_ wave_controller_x_inst__3702_/Q spi_regs_inst__1542_/Q
+ wave_controller_x_inst__3282_/B VDD VDD VSS VSS gf180mcu_fd_sc_mcu7t5v0__xor2_1
Xwave_controller_x_inst__2301_ fanout542/Z wave_controller_x_inst__2300_/Z wave_controller_x_inst__2328_/A1
+ VDD VDD VSS VSS gf180mcu_fd_sc_mcu7t5v0__nor2_1
XFILLER_60_691 VDD VDD VSS VSS gf180mcu_fd_sc_mcu7t5v0__fill_2
Xwave_controller_x_inst__2232_ wave_controller_x_inst__2248_/C1 wave_controller_x_inst__2229_/Z
+ wave_controller_x_inst__2232_/A3 spi_regs_inst__1276_/B2 VDD VDD VSS VSS gf180mcu_fd_sc_mcu7t5v0__xnor3_1
Xwave_controller_x_inst__2163_ wave_controller_x_inst__2757_/A1 spi_regs_inst__1033_/B2
+ wave_controller_x_inst__2163_/B wave_controller_x_inst__2168_/A2 VDD VDD VSS VSS
+ gf180mcu_fd_sc_mcu7t5v0__oai21_1
Xwave_controller_x_inst__2094_ wave_controller_x_inst__2051_/Z wave_controller_x_inst__2094_/A2
+ wave_controller_x_inst__2099_/A1 VDD VDD VSS VSS gf180mcu_fd_sc_mcu7t5v0__nand2_1
XFILLER_106_649 VDD VDD VSS VSS gf180mcu_fd_sc_mcu7t5v0__fill_1
XFILLER_134_947 VDD VDD VSS VSS gf180mcu_fd_sc_mcu7t5v0__fillcap_64
XFILLER_145_262 VDD VDD VSS VSS gf180mcu_fd_sc_mcu7t5v0__fill_1
XFILLER_161_766 VDD VDD VSS VSS gf180mcu_fd_sc_mcu7t5v0__fillcap_4
XFILLER_120_118 VDD VDD VSS VSS gf180mcu_fd_sc_mcu7t5v0__fillcap_4
XTAP_TAPCELL_ROW_167_2627 VDD VSS gf180mcu_fd_sc_mcu7t5v0__filltie
XTAP_TAPCELL_ROW_167_2638 VDD VSS gf180mcu_fd_sc_mcu7t5v0__filltie
XTAP_TAPCELL_ROW_167_2649 VDD VSS gf180mcu_fd_sc_mcu7t5v0__filltie
XTAP_TAPCELL_ROW_30_1_554 VDD VSS gf180mcu_fd_sc_mcu7t5v0__filltie
XFILLER_102_844 VDD VDD VSS VSS gf180mcu_fd_sc_mcu7t5v0__fill_1
Xwave_controller_x_inst__2996_ wave_controller_x_inst__2938_/Z wave_controller_x_inst__2996_/A2
+ wave_controller_x_inst__3001_/B VDD VDD VSS VSS gf180mcu_fd_sc_mcu7t5v0__nand2_1
XFILLER_101_343 VDD VDD VSS VSS gf180mcu_fd_sc_mcu7t5v0__fillcap_4
XFILLER_102_877 VDD VDD VSS VSS gf180mcu_fd_sc_mcu7t5v0__fill_2
XFILLER_47_419 VDD VDD VSS VSS gf180mcu_fd_sc_mcu7t5v0__fill_1
XFILLER_75_706 VDD VDD VSS VSS gf180mcu_fd_sc_mcu7t5v0__fillcap_8
Xwave_controller_y_inst__1963_ wave_controller_y_inst__1960_/I wave_controller_y_inst__1963_/A2
+ spi_regs_inst__1256_/B2 VDD VDD VSS VSS gf180mcu_fd_sc_mcu7t5v0__xor2_1
Xwave_controller_x_inst__1947_ wave_controller_x_inst__3406_/A2 wave_controller_x_inst__1946_/Z
+ wave_controller_x_inst__3725_/D VDD VDD VSS VSS gf180mcu_fd_sc_mcu7t5v0__nor2_1
XFILLER_68_780 VDD VDD VSS VSS gf180mcu_fd_sc_mcu7t5v0__fillcap_8
XTAP_TAPCELL_ROW_87_1320 VDD VSS gf180mcu_fd_sc_mcu7t5v0__filltie
Xwave_controller_y_inst__3702_ wave_controller_y_inst__3702_/D wave_controller_y_inst__3703_/RN
+ clkload20/I wave_controller_y_inst__3702_/Q VDD VDD VSS VSS gf180mcu_fd_sc_mcu7t5v0__dffrnq_1
Xwave_controller_y_inst__1894_ wave_controller_y_inst__3695_/Q wave_controller_y_inst__3449_/A1
+ VDD VDD VSS VSS gf180mcu_fd_sc_mcu7t5v0__clkinv_1
XFILLER_132_1081 VDD VDD VSS VSS gf180mcu_fd_sc_mcu7t5v0__fillcap_4
Xwave_controller_y_inst__3633_ wave_controller_y_inst__3633_/D wave_controller_y_inst__3703_/RN
+ clkload21/I spi_regs_inst__1275_/A1 VDD VDD VSS VSS gf180mcu_fd_sc_mcu7t5v0__dffrnq_1
Xwave_controller_x_inst__3617_ wave_controller_x_inst__3617_/D fanout589/Z clkload24/I
+ spi_regs_inst__1261_/A1 VDD VDD VSS VSS gf180mcu_fd_sc_mcu7t5v0__dffrnq_1
Xwave_controller_x_inst__1878_ spi_regs_inst__1085_/C2 wave_controller_x_inst__3524_/B2
+ VDD VDD VSS VSS gf180mcu_fd_sc_mcu7t5v0__clkinv_1
XFILLER_15_327 VDD VDD VSS VSS gf180mcu_fd_sc_mcu7t5v0__fill_2
XFILLER_83_772 VDD VDD VSS VSS gf180mcu_fd_sc_mcu7t5v0__fill_2
XTAP_TAPCELL_ROW_66_970 VDD VSS gf180mcu_fd_sc_mcu7t5v0__filltie
XFILLER_27_198 VDD VDD VSS VSS gf180mcu_fd_sc_mcu7t5v0__fillcap_8
XFILLER_35_66 VDD VDD VSS VSS gf180mcu_fd_sc_mcu7t5v0__fillcap_4
XTAP_TAPCELL_ROW_83_1239 VDD VSS gf180mcu_fd_sc_mcu7t5v0__filltie
Xwave_controller_y_inst__3564_ wave_controller_y_inst__3564_/A1 wave_controller_y_inst_wire323/I
+ wave_controller_y_inst__3597_/I0 VDD VDD VSS VSS gf180mcu_fd_sc_mcu7t5v0__nor2_1
Xwave_controller_x_inst__3548_ wave_controller_x_inst__3557_/A1 wave_controller_x_inst__3548_/A2
+ wave_controller_x_inst__3548_/A3 wave_controller_x_inst__3557_/B1 wave_controller_x_inst__3548_/B2
+ wave_controller_x_inst__3645_/D VDD VDD VSS VSS gf180mcu_fd_sc_mcu7t5v0__oai32_1
XFILLER_30_308 VDD VDD VSS VSS gf180mcu_fd_sc_mcu7t5v0__fillcap_4
XFILLER_70_477 VDD VDD VSS VSS gf180mcu_fd_sc_mcu7t5v0__fillcap_16
Xwave_controller_y_inst__2515_ wave_controller_y_inst__2488_/Z wave_controller_y_inst__2518_/A3
+ wave_controller_y_inst__2516_/C VDD VDD VSS VSS gf180mcu_fd_sc_mcu7t5v0__nand2_1
Xwave_controller_y_inst__3495_ spi_regs_inst__1063_/B2 wave_controller_y_inst__3529_/A2
+ wave_controller_y_inst__3497_/B1 VDD VDD VSS VSS gf180mcu_fd_sc_mcu7t5v0__nor2_1
Xwave_controller_x_inst__3479_ wave_controller_x_inst__3479_/A1 wave_controller_x_inst_wire84/Z
+ wave_controller_x_inst__3489_/B1 wave_controller_x_inst__3479_/B2 wave_controller_x_inst__3489_/C
+ wave_controller_x_inst__3480_/B VDD VDD VSS VSS gf180mcu_fd_sc_mcu7t5v0__aoi221_1
Xsignal_processor_x_inst__223_ signal_processor_x_inst__223_/D fanout583/Z clkbuf_leaf_14_clk/Z
+ spi_regs_inst__1167_/B2 VDD VDD VSS VSS gf180mcu_fd_sc_mcu7t5v0__dffrnq_1
Xwave_controller_y_inst__2446_ wave_controller_y_inst__2446_/A1 wave_controller_y_inst__2449_/B2
+ wave_controller_y_inst__2446_/B wave_controller_y_inst__2447_/A2 VDD VDD VSS VSS
+ gf180mcu_fd_sc_mcu7t5v0__oai21_1
Xsignal_processor_x_inst__154_ signal_processor_x_inst__187_/B signal_processor_x_inst__154_/A2
+ signal_processor_x_inst__230_/D VDD VDD VSS VSS gf180mcu_fd_sc_mcu7t5v0__nor2_1
XFILLER_128_207 VDD VDD VSS VSS gf180mcu_fd_sc_mcu7t5v0__fillcap_16
XFILLER_156_527 VDD VDD VSS VSS gf180mcu_fd_sc_mcu7t5v0__fillcap_4
XFILLER_137_741 VDD VDD VSS VSS gf180mcu_fd_sc_mcu7t5v0__fillcap_16
Xwave_controller_y_inst__2377_ wave_controller_y_inst__2394_/A1 wave_controller_y_inst__2391_/A2
+ spi_regs_inst__1311_/A1 VDD VDD VSS VSS gf180mcu_fd_sc_mcu7t5v0__xor2_1
XFILLER_167_65 VDD VDD VSS VSS gf180mcu_fd_sc_mcu7t5v0__fill_2
XTAP_TAPCELL_ROW_131_2041 VDD VSS gf180mcu_fd_sc_mcu7t5v0__filltie
XTAP_TAPCELL_ROW_98_1493 VDD VSS gf180mcu_fd_sc_mcu7t5v0__filltie
XFILLER_124_457 VDD VDD VSS VSS gf180mcu_fd_sc_mcu7t5v0__fillcap_4
XTAP_TAPCELL_ROW_16_1_455 VDD VSS gf180mcu_fd_sc_mcu7t5v0__filltie
XFILLER_97_308 VDD VDD VSS VSS gf180mcu_fd_sc_mcu7t5v0__fillcap_4
XFILLER_78_566 VDD VDD VSS VSS gf180mcu_fd_sc_mcu7t5v0__fillcap_8
Xfanout590 fanout608/Z fanout590/Z VDD VDD VSS VSS gf180mcu_fd_sc_mcu7t5v0__dlyb_1
XFILLER_111_1154 VDD VDD VSS VSS gf180mcu_fd_sc_mcu7t5v0__fillcap_16
Xspi_regs_inst__0822_ spi_regs_inst_wire480/Z spi_regs_inst__1565_/Q spi_regs_inst__0824_/S
+ spi_regs_inst__1565_/D VDD VDD VSS VSS gf180mcu_fd_sc_mcu7t5v0__mux2_2
XFILLER_74_794 VDD VDD VSS VSS gf180mcu_fd_sc_mcu7t5v0__fillcap_8
XFILLER_80_208 VDD VDD VSS VSS gf180mcu_fd_sc_mcu7t5v0__fill_1
XTAP_TAPCELL_ROW_64_929 VDD VSS gf180mcu_fd_sc_mcu7t5v0__filltie
Xspi_regs_inst__0753_ spi_regs_inst__0753_/I spi_regs_inst__0916_/A1 VDD VDD VSS VSS
+ gf180mcu_fd_sc_mcu7t5v0__clkinv_1
XFILLER_61_422 VDD VDD VSS VSS gf180mcu_fd_sc_mcu7t5v0__fill_1
XFILLER_92_61 VDD VDD VSS VSS gf180mcu_fd_sc_mcu7t5v0__fill_1
XFILLER_14_382 VDD VDD VSS VSS gf180mcu_fd_sc_mcu7t5v0__fill_2
Xspi_regs_inst__1305_ fanout502/Z spi_regs_inst_wire299/Z spi_regs_inst__1333_/A2
+ spi_regs_inst__1305_/B2 spi_regs_inst__1307_/A3 VDD VDD VSS VSS gf180mcu_fd_sc_mcu7t5v0__aoi22_1
XFILLER_127_240 VDD VDD VSS VSS gf180mcu_fd_sc_mcu7t5v0__fill_2
XFILLER_116_947 VDD VDD VSS VSS gf180mcu_fd_sc_mcu7t5v0__fillcap_64
XFILLER_128_796 VDD VDD VSS VSS gf180mcu_fd_sc_mcu7t5v0__fill_1
Xspi_regs_inst__1236_ spi_regs_inst__1524_/Q spi_regs_inst__1315_/B1 spi_regs_inst__1334_/B1
+ spi_regs_inst__1236_/B2 spi_regs_inst__1237_/A4 VDD VDD VSS VSS gf180mcu_fd_sc_mcu7t5v0__aoi22_1
XFILLER_143_755 VDD VDD VSS VSS gf180mcu_fd_sc_mcu7t5v0__fillcap_8
Xspi_regs_inst__1167_ spi_regs_inst__1601_/Q spi_regs_inst__1167_/A2 spi_regs_inst__1189_/B1
+ spi_regs_inst__1167_/B2 spi_regs_inst__1170_/A2 VDD VDD VSS VSS gf180mcu_fd_sc_mcu7t5v0__aoi22_1
XFILLER_102_107 VDD VDD VSS VSS gf180mcu_fd_sc_mcu7t5v0__fillcap_16
XFILLER_88_319 VDD VDD VSS VSS gf180mcu_fd_sc_mcu7t5v0__fill_1
XTAP_TAPCELL_ROW_149_2335 VDD VSS gf180mcu_fd_sc_mcu7t5v0__filltie
Xspi_regs_inst__1098_ spi_regs_inst__1098_/A1 spi_regs_inst__1184_/A2 spi_regs_inst__1182_/B1
+ fanout498/Z spi_regs_inst__1114_/A3 VDD VDD VSS VSS gf180mcu_fd_sc_mcu7t5v0__aoi22_1
XFILLER_96_330 VDD VDD VSS VSS gf180mcu_fd_sc_mcu7t5v0__fill_2
XPHY_EDGE_ROW_135_Right_135 VDD VSS gf180mcu_fd_sc_mcu7t5v0__endcap
Xwave_controller_x_inst__2850_ wave_controller_x_inst__3719_/Q wave_controller_x_inst__2850_/A2
+ wave_controller_x_inst__2850_/B1 wave_controller_x_inst__2845_/Z wave_controller_x_inst__2851_/A2
+ VDD VDD VSS VSS gf180mcu_fd_sc_mcu7t5v0__aoi22_1
XFILLER_57_728 VDD VDD VSS VSS gf180mcu_fd_sc_mcu7t5v0__fillcap_32
Xwave_controller_x_inst__2781_ wave_controller_x_inst__2616_/C wave_controller_x_inst__2793_/S
+ wave_controller_x_inst__2781_/B wave_controller_x_inst__2819_/A2 VDD VDD VSS VSS
+ gf180mcu_fd_sc_mcu7t5v0__oai21_1
Xwave_controller_x_inst__1801_ fanout498/Z wave_controller_x_inst__3098_/C VDD VDD
+ VSS VSS gf180mcu_fd_sc_mcu7t5v0__clkinv_1
XFILLER_116_1087 VDD VDD VSS VSS gf180mcu_fd_sc_mcu7t5v0__fillcap_64
XTAP_TAPCELL_ROW_162_2546 VDD VSS gf180mcu_fd_sc_mcu7t5v0__filltie
Xsignal_processor_y_inst__117_ fanout389/Z signal_processor_y_inst__253_/Q signal_processor_y_inst__254_/D
+ VDD VDD VSS VSS gf180mcu_fd_sc_mcu7t5v0__and2_1
XFILLER_65_761 VDD VDD VSS VSS gf180mcu_fd_sc_mcu7t5v0__fillcap_8
XTAP_TAPCELL_ROW_162_2557 VDD VSS gf180mcu_fd_sc_mcu7t5v0__filltie
XFILLER_24_102 VDD VDD VSS VSS gf180mcu_fd_sc_mcu7t5v0__fill_2
XFILLER_37_463 VDD VDD VSS VSS gf180mcu_fd_sc_mcu7t5v0__fill_2
XFILLER_71_208 VDD VDD VSS VSS gf180mcu_fd_sc_mcu7t5v0__fill_2
XTAP_TAPCELL_ROW_127_1965 VDD VSS gf180mcu_fd_sc_mcu7t5v0__filltie
XTAP_TAPCELL_ROW_127_1976 VDD VSS gf180mcu_fd_sc_mcu7t5v0__filltie
XFILLER_52_433 VDD VDD VSS VSS gf180mcu_fd_sc_mcu7t5v0__fillcap_16
XFILLER_80_731 VDD VDD VSS VSS gf180mcu_fd_sc_mcu7t5v0__fillcap_4
XFILLER_80_753 VDD VDD VSS VSS gf180mcu_fd_sc_mcu7t5v0__fillcap_4
Xwave_controller_x_inst__3402_ wave_controller_x_inst__3402_/A1 wave_controller_x_inst__3402_/A2
+ wave_controller_x_inst__3402_/B wave_controller_x_inst__3402_/C wave_controller_x_inst__3403_/A4
+ VDD VDD VSS VSS gf180mcu_fd_sc_mcu7t5v0__oai211_1
XFILLER_24_146 VDD VDD VSS VSS gf180mcu_fd_sc_mcu7t5v0__fillcap_4
Xwave_controller_x_inst__3333_ wave_controller_x_inst__3320_/B wave_controller_x_inst__3333_/A2
+ wave_controller_x_inst__3333_/A3 wave_controller_x_inst__3333_/B wave_controller_x_inst__3337_/A1
+ VDD VDD VSS VSS gf180mcu_fd_sc_mcu7t5v0__oai31_1
XFILLER_24_179 VDD VDD VSS VSS gf180mcu_fd_sc_mcu7t5v0__fill_1
Xwave_controller_y_inst__3280_ wave_controller_y_inst__3702_/Q spi_regs_inst__1600_/Q
+ wave_controller_y_inst__3283_/B VDD VDD VSS VSS gf180mcu_fd_sc_mcu7t5v0__xnor2_1
Xwave_controller_y_inst__2300_ wave_controller_y_inst__2298_/Z wave_controller_y_inst__2302_/A3
+ wave_controller_y_inst__2300_/Z VDD VDD VSS VSS gf180mcu_fd_sc_mcu7t5v0__xor2_1
XFILLER_138_527 VDD VDD VSS VSS gf180mcu_fd_sc_mcu7t5v0__fillcap_4
Xwave_controller_y_inst__2231_ wave_controller_y_inst__2231_/A1 wave_controller_y_inst__2231_/A2
+ wave_controller_y_inst__2232_/A3 VDD VDD VSS VSS gf180mcu_fd_sc_mcu7t5v0__nor2_1
Xwave_controller_x_inst__3264_ wave_controller_x_inst__3265_/A1 spi_regs_inst__1554_/Q
+ wave_controller_x_inst__3350_/A1 VDD VDD VSS VSS gf180mcu_fd_sc_mcu7t5v0__nor2_1
XFILLER_138_549 VDD VDD VSS VSS gf180mcu_fd_sc_mcu7t5v0__fillcap_16
XFILLER_20_352 VDD VDD VSS VSS gf180mcu_fd_sc_mcu7t5v0__fill_1
Xwave_controller_x_inst__3195_ wave_controller_x_inst__3195_/A1 wave_controller_x_inst__3171_/Z
+ wave_controller_x_inst__3195_/Z VDD VDD VSS VSS gf180mcu_fd_sc_mcu7t5v0__xor2_1
Xwave_controller_x_inst__2215_ wave_controller_x_inst__2212_/Z wave_controller_x_inst_wire118/Z
+ spi_regs_inst__1236_/B2 VDD VDD VSS VSS gf180mcu_fd_sc_mcu7t5v0__xor2_1
XFILLER_146_560 VDD VDD VSS VSS gf180mcu_fd_sc_mcu7t5v0__fillcap_32
XFILLER_165_368 VDD VDD VSS VSS gf180mcu_fd_sc_mcu7t5v0__fillcap_4
Xwave_controller_y_inst__2162_ spi_regs_inst__0967_/A1 wave_controller_y_inst__2162_/A2
+ wave_controller_y_inst__2162_/B wave_controller_y_inst__2170_/A2 VDD VDD VSS VSS
+ gf180mcu_fd_sc_mcu7t5v0__aoi21_1
Xwave_controller_x_inst__2146_ wave_controller_x_inst__2153_/A2 wave_controller_x_inst__2145_/Z
+ wave_controller_x_inst__2147_/I VDD VDD VSS VSS gf180mcu_fd_sc_mcu7t5v0__nand2_1
XFILLER_118_262 VDD VDD VSS VSS gf180mcu_fd_sc_mcu7t5v0__fill_2
Xwave_controller_y_inst__2093_ wave_controller_y_inst__2072_/B wave_controller_y_inst__2107_/B
+ wave_controller_y_inst__2093_/A3 wave_controller_y_inst__2093_/B1 wave_controller_y_inst__2093_/B2
+ wave_controller_y_inst__2094_/A2 VDD VDD VSS VSS gf180mcu_fd_sc_mcu7t5v0__oai32_1
XFILLER_106_457 VDD VDD VSS VSS gf180mcu_fd_sc_mcu7t5v0__fill_2
XFILLER_137_68 VDD VDD VSS VSS gf180mcu_fd_sc_mcu7t5v0__fill_2
Xwave_controller_x_inst__2077_ wave_controller_x_inst__2077_/A1 wave_controller_x_inst__2069_/Z
+ wave_controller_x_inst__2095_/B VDD VDD VSS VSS gf180mcu_fd_sc_mcu7t5v0__nor2_1
XFILLER_121_438 VDD VDD VSS VSS gf180mcu_fd_sc_mcu7t5v0__fillcap_16
XFILLER_133_298 VDD VDD VSS VSS gf180mcu_fd_sc_mcu7t5v0__fillcap_8
XFILLER_153_34 VDD VDD VSS VSS gf180mcu_fd_sc_mcu7t5v0__fillcap_16
XFILLER_161_596 VDD VDD VSS VSS gf180mcu_fd_sc_mcu7t5v0__fill_1
Xwave_controller_x_inst_fanout525 fanout524/I wave_controller_x_inst__3236_/B VDD
+ VDD VSS VSS gf180mcu_fd_sc_mcu7t5v0__dlyb_1
XFILLER_134_1165 VDD VDD VSS VSS gf180mcu_fd_sc_mcu7t5v0__fillcap_4
XFILLER_87_341 VDD VDD VSS VSS gf180mcu_fd_sc_mcu7t5v0__fill_1
XFILLER_87_352 VDD VDD VSS VSS gf180mcu_fd_sc_mcu7t5v0__fill_2
XPHY_EDGE_ROW_102_Right_102 VDD VSS gf180mcu_fd_sc_mcu7t5v0__endcap
Xwave_controller_y_inst__2995_ wave_controller_y_inst__2998_/A2 wave_controller_y_inst__2994_/B
+ wave_controller_y_inst__2996_/A2 VDD VDD VSS VSS gf180mcu_fd_sc_mcu7t5v0__nand2_1
XFILLER_102_685 VDD VDD VSS VSS gf180mcu_fd_sc_mcu7t5v0__fill_1
XFILLER_47_227 VDD VDD VSS VSS gf180mcu_fd_sc_mcu7t5v0__fill_1
XFILLER_87_374 VDD VDD VSS VSS gf180mcu_fd_sc_mcu7t5v0__fill_1
XFILLER_88_897 VDD VDD VSS VSS gf180mcu_fd_sc_mcu7t5v0__fill_2
Xwave_controller_y_inst__1946_ wave_controller_y_inst__1946_/A1 wave_controller_y_inst__1945_/Z
+ wave_controller_y_inst__1946_/Z VDD VDD VSS VSS gf180mcu_fd_sc_mcu7t5v0__xor2_1
Xwave_controller_x_inst__2979_ wave_controller_x_inst__3305_/B2 wave_controller_x_inst__2979_/A2
+ wave_controller_x_inst__2979_/B wave_controller_x_inst__2981_/B VDD VDD VSS VSS
+ gf180mcu_fd_sc_mcu7t5v0__oai21_1
XFILLER_90_506 VDD VDD VSS VSS gf180mcu_fd_sc_mcu7t5v0__fillcap_16
XFILLER_28_463 VDD VDD VSS VSS gf180mcu_fd_sc_mcu7t5v0__fill_1
Xwave_controller_y_inst__1877_ spi_regs_inst__1045_/B2 wave_controller_y_inst__3521_/B2
+ VDD VDD VSS VSS gf180mcu_fd_sc_mcu7t5v0__clkinv_1
XFILLER_43_422 VDD VDD VSS VSS gf180mcu_fd_sc_mcu7t5v0__fillcap_32
XFILLER_55_282 VDD VDD VSS VSS gf180mcu_fd_sc_mcu7t5v0__fillcap_8
Xwave_controller_y_inst__3616_ wave_controller_y_inst__3616_/D fanout545/Z clkload1/I
+ wave_controller_y_inst__3616_/Q VDD VDD VSS VSS gf180mcu_fd_sc_mcu7t5v0__dffrnq_1
Xwave_controller_y_inst__3547_ spi_regs_inst__1121_/A1 wave_controller_y_inst__3556_/A2
+ wave_controller_y_inst__3548_/A3 VDD VDD VSS VSS gf180mcu_fd_sc_mcu7t5v0__nor2_1
Xwave_controller_x_inst_max_cap531 spi_regs_inst__1470_/Q wave_controller_x_inst__3231_/B
+ VDD VDD VSS VSS gf180mcu_fd_sc_mcu7t5v0__buf_4
XFILLER_62_53 VDD VDD VSS VSS gf180mcu_fd_sc_mcu7t5v0__fill_1
Xsignal_processor_x_inst__206_ spi_regs_inst__1121_/B2 signal_processor_x_inst__214_/A2
+ signal_processor_x_inst__207_/B VDD VDD VSS VSS gf180mcu_fd_sc_mcu7t5v0__nand2_1
XFILLER_11_341 VDD VDD VSS VSS gf180mcu_fd_sc_mcu7t5v0__fillcap_4
XFILLER_30_138 VDD VDD VSS VSS gf180mcu_fd_sc_mcu7t5v0__fill_2
Xwave_controller_y_inst__3478_ wave_controller_y_inst__3478_/I wave_controller_y_inst__3479_/B2
+ VDD VDD VSS VSS gf180mcu_fd_sc_mcu7t5v0__clkinv_1
XFILLER_11_352 VDD VDD VSS VSS gf180mcu_fd_sc_mcu7t5v0__fillcap_16
XFILLER_157_836 VDD VDD VSS VSS gf180mcu_fd_sc_mcu7t5v0__fillcap_4
Xwave_controller_y_inst__2429_ wave_controller_y_inst__2443_/B wave_controller_y_inst__2429_/A2
+ wave_controller_y_inst__2430_/B VDD VDD VSS VSS gf180mcu_fd_sc_mcu7t5v0__nand2_1
Xsignal_processor_x_inst__137_ signal_processor_x_inst__236_/Q signal_processor_x_inst__235_/Q
+ signal_processor_x_inst__138_/A4 VDD VDD VSS VSS gf180mcu_fd_sc_mcu7t5v0__nand2_1
XFILLER_7_356 VDD VDD VSS VSS gf180mcu_fd_sc_mcu7t5v0__fillcap_4
XFILLER_125_755 VDD VDD VSS VSS gf180mcu_fd_sc_mcu7t5v0__fill_2
XFILLER_98_606 VDD VDD VSS VSS gf180mcu_fd_sc_mcu7t5v0__fillcap_16
Xspi_regs_inst__1021_ spi_regs_inst__1021_/A1 spi_regs_inst__1021_/A2 spi_regs_inst__1050_/C1
+ VDD VDD VSS VSS gf180mcu_fd_sc_mcu7t5v0__nor2_1
XFILLER_125_788 VDD VDD VSS VSS gf180mcu_fd_sc_mcu7t5v0__fillcap_8
XTAP_TAPCELL_ROW_111_1711 VDD VSS gf180mcu_fd_sc_mcu7t5v0__filltie
XFILLER_79_831 VDD VDD VSS VSS gf180mcu_fd_sc_mcu7t5v0__fill_1
XFILLER_79_842 VDD VDD VSS VSS gf180mcu_fd_sc_mcu7t5v0__fillcap_16
XFILLER_97_138 VDD VDD VSS VSS gf180mcu_fd_sc_mcu7t5v0__fill_2
XFILLER_87_72 VDD VDD VSS VSS gf180mcu_fd_sc_mcu7t5v0__fill_2
XFILLER_93_311 VDD VDD VSS VSS gf180mcu_fd_sc_mcu7t5v0__fill_1
XFILLER_94_823 VDD VDD VSS VSS gf180mcu_fd_sc_mcu7t5v0__fillcap_4
XFILLER_38_249 VDD VDD VSS VSS gf180mcu_fd_sc_mcu7t5v0__fill_1
XFILLER_94_856 VDD VDD VSS VSS gf180mcu_fd_sc_mcu7t5v0__fillcap_16
XTAP_TAPCELL_ROW_144_2254 VDD VSS gf180mcu_fd_sc_mcu7t5v0__filltie
XFILLER_81_528 VDD VDD VSS VSS gf180mcu_fd_sc_mcu7t5v0__fill_2
XFILLER_93_366 VDD VDD VSS VSS gf180mcu_fd_sc_mcu7t5v0__fill_2
XTAP_TAPCELL_ROW_109_1673 VDD VSS gf180mcu_fd_sc_mcu7t5v0__filltie
Xspi_regs_inst__0805_ spi_regs_inst__1411_/I1 spi_regs_inst__1555_/Q spi_regs_inst__0806_/S
+ spi_regs_inst__1555_/D VDD VDD VSS VSS gf180mcu_fd_sc_mcu7t5v0__mux2_2
XFILLER_19_496 VDD VDD VSS VSS gf180mcu_fd_sc_mcu7t5v0__fill_2
XFILLER_34_422 VDD VDD VSS VSS gf180mcu_fd_sc_mcu7t5v0__fillcap_4
XFILLER_34_477 VDD VDD VSS VSS gf180mcu_fd_sc_mcu7t5v0__fillcap_8
XFILLER_62_753 VDD VDD VSS VSS gf180mcu_fd_sc_mcu7t5v0__fill_2
XPHY_EDGE_ROW_24_1_Right_23 VDD VSS gf180mcu_fd_sc_mcu7t5v0__endcap
Xspi_regs_inst__0736_ spi_regs_inst__1630_/Q spi_regs_inst__1368_/A1 VDD VDD VSS VSS
+ gf180mcu_fd_sc_mcu7t5v0__clkinv_1
XTAP_TAPCELL_ROW_122_1884 VDD VSS gf180mcu_fd_sc_mcu7t5v0__filltie
Xspi_regs_inst_max_cap291 spi_regs_inst__1180_/B1 spi_regs_inst_wire290/I VDD VDD
+ VSS VSS gf180mcu_fd_sc_mcu7t5v0__buf_2
Xspi_regs_inst_max_cap280 spi_regs_inst__1194_/A2 spi_regs_inst__1336_/A2 VDD VDD
+ VSS VSS gf180mcu_fd_sc_mcu7t5v0__buf_2
XFILLER_148_803 VDD VDD VSS VSS gf180mcu_fd_sc_mcu7t5v0__fill_2
XTAP_TAPCELL_ROW_122_1895 VDD VSS gf180mcu_fd_sc_mcu7t5v0__filltie
XFILLER_135_508 VDD VDD VSS VSS gf180mcu_fd_sc_mcu7t5v0__fill_1
XFILLER_147_368 VDD VDD VSS VSS gf180mcu_fd_sc_mcu7t5v0__fillcap_8
XPHY_EDGE_ROW_141_Left_308 VDD VSS gf180mcu_fd_sc_mcu7t5v0__endcap
Xwave_controller_x_inst__2000_ wave_controller_x_inst__2001_/A1 wave_controller_x_inst__2001_/B
+ wave_controller_x_inst__2001_/A2 wave_controller_x_inst__2000_/Z VDD VDD VSS VSS
+ gf180mcu_fd_sc_mcu7t5v0__and3_1
XFILLER_116_733 VDD VDD VSS VSS gf180mcu_fd_sc_mcu7t5v0__fill_2
Xspi_regs_inst__1219_ spi_regs_inst__1219_/A1 spi_regs_inst__1219_/A2 spi_regs_inst__1219_/A3
+ spi_regs_inst__1219_/A4 spi_regs_inst__1220_/A4 VDD VDD VSS VSS gf180mcu_fd_sc_mcu7t5v0__nand4_1
XFILLER_104_917 VDD VDD VSS VSS gf180mcu_fd_sc_mcu7t5v0__fillcap_16
XFILLER_131_714 VDD VDD VSS VSS gf180mcu_fd_sc_mcu7t5v0__fill_2
XFILLER_157_1154 VDD VDD VSS VSS gf180mcu_fd_sc_mcu7t5v0__fillcap_16
XFILLER_89_628 VDD VDD VSS VSS gf180mcu_fd_sc_mcu7t5v0__fill_2
XFILLER_130_213 VDD VDD VSS VSS gf180mcu_fd_sc_mcu7t5v0__fill_1
XFILLER_88_127 VDD VDD VSS VSS gf180mcu_fd_sc_mcu7t5v0__fill_2
Xwave_controller_x_inst__2902_ wave_controller_x_inst__3489_/C wave_controller_x_inst__2902_/A2
+ wave_controller_x_inst__2902_/A3 wave_controller_x_inst__2902_/B1 wave_controller_x_inst__2902_/B2
+ wave_controller_x_inst__3723_/D VDD VDD VSS VSS gf180mcu_fd_sc_mcu7t5v0__oai32_1
XFILLER_69_330 VDD VDD VSS VSS gf180mcu_fd_sc_mcu7t5v0__fillcap_4
XFILLER_69_352 VDD VDD VSS VSS gf180mcu_fd_sc_mcu7t5v0__fillcap_32
Xwave_controller_x_inst__2833_ wave_controller_x_inst__3265_/A1 wave_controller_x_inst__2833_/A2
+ wave_controller_x_inst__2835_/B VDD VDD VSS VSS gf180mcu_fd_sc_mcu7t5v0__nand2_1
XFILLER_57_536 VDD VDD VSS VSS gf180mcu_fd_sc_mcu7t5v0__fillcap_16
XFILLER_85_834 VDD VDD VSS VSS gf180mcu_fd_sc_mcu7t5v0__fill_1
Xwave_controller_y_inst__1800_ wave_controller_y_inst__3100_/B wave_controller_y_inst__3098_/B
+ VDD VDD VSS VSS gf180mcu_fd_sc_mcu7t5v0__clkinv_1
XPHY_EDGE_ROW_150_Left_317 VDD VSS gf180mcu_fd_sc_mcu7t5v0__endcap
Xwave_controller_y_inst__2780_ max_cap432/Z wave_controller_y_inst__2831_/A2 wave_controller_y_inst__2781_/B
+ VDD VDD VSS VSS gf180mcu_fd_sc_mcu7t5v0__nand2_1
Xwave_controller_x_inst__2764_ _09_/A2 _10_/A2 wave_controller_x_inst__3081_/C wave_controller_x_inst__2764_/Z
+ VDD VDD VSS VSS gf180mcu_fd_sc_mcu7t5v0__or3_1
Xwave_controller_x_inst__2695_ wave_controller_x_inst__2712_/C wave_controller_x_inst__2694_/Z
+ wave_controller_x_inst__2697_/A1 VDD VDD VSS VSS gf180mcu_fd_sc_mcu7t5v0__nor2_1
XFILLER_37_282 VDD VDD VSS VSS gf180mcu_fd_sc_mcu7t5v0__fillcap_8
XFILLER_53_720 VDD VDD VSS VSS gf180mcu_fd_sc_mcu7t5v0__fill_2
XFILLER_77_1122 VDD VDD VSS VSS gf180mcu_fd_sc_mcu7t5v0__fillcap_32
XFILLER_25_444 VDD VDD VSS VSS gf180mcu_fd_sc_mcu7t5v0__fillcap_8
XTAP_TAPCELL_ROW_15_1_443 VDD VSS gf180mcu_fd_sc_mcu7t5v0__filltie
Xwave_controller_y_inst__3401_ wave_controller_y_inst__3401_/A1 wave_controller_y_inst__3401_/A2
+ wave_controller_y_inst__3401_/B wave_controller_y_inst__3401_/C wave_controller_y_inst__3403_/A3
+ VDD VDD VSS VSS gf180mcu_fd_sc_mcu7t5v0__aoi211_1
XFILLER_12_127 VDD VDD VSS VSS gf180mcu_fd_sc_mcu7t5v0__fillcap_8
XFILLER_25_488 VDD VDD VSS VSS gf180mcu_fd_sc_mcu7t5v0__fill_2
XFILLER_40_403 VDD VDD VSS VSS gf180mcu_fd_sc_mcu7t5v0__fill_2
XFILLER_52_263 VDD VDD VSS VSS gf180mcu_fd_sc_mcu7t5v0__fillcap_4
Xwave_controller_y_inst__3332_ wave_controller_y_inst__3716_/Q wave_controller_y_inst__3332_/A2
+ wave_controller_y_inst__3318_/Z wave_controller_y_inst__3332_/B2 wave_controller_y_inst__3332_/C
+ wave_controller_y_inst__3345_/A2 VDD VDD VSS VSS gf180mcu_fd_sc_mcu7t5v0__aoi221_1
XFILLER_12_149 VDD VDD VSS VSS gf180mcu_fd_sc_mcu7t5v0__fillcap_16
XFILLER_138_302 VDD VDD VSS VSS gf180mcu_fd_sc_mcu7t5v0__fillcap_8
Xwave_controller_x_inst__3316_ wave_controller_x_inst__3320_/A1 spi_regs_inst__1555_/Q
+ wave_controller_x_inst__3347_/B VDD VDD VSS VSS gf180mcu_fd_sc_mcu7t5v0__nand2_1
XFILLER_32_34 VDD VDD VSS VSS gf180mcu_fd_sc_mcu7t5v0__fill_1
Xwave_controller_y_inst__3263_ wave_controller_y_inst__3719_/Q spi_regs_inst__1617_/Q
+ wave_controller_y_inst__3337_/B VDD VDD VSS VSS gf180mcu_fd_sc_mcu7t5v0__xor2_1
Xwave_controller_x_inst__3247_ fanout532/Z wave_controller_x_inst__3195_/Z wave_controller_x_inst__3196_/Z
+ fanout534/I wave_controller_x_inst__3254_/A2 VDD VDD VSS VSS gf180mcu_fd_sc_mcu7t5v0__aoi22_1
XFILLER_148_34 VDD VDD VSS VSS gf180mcu_fd_sc_mcu7t5v0__fill_1
XFILLER_148_45 VDD VDD VSS VSS gf180mcu_fd_sc_mcu7t5v0__fillcap_8
Xwave_controller_y_inst__3194_ wave_controller_y_inst__3194_/A1 wave_controller_y_inst__3194_/A2
+ wave_controller_y_inst__3194_/B wave_controller_y_inst__3253_/A2 VDD VDD VSS VSS
+ gf180mcu_fd_sc_mcu7t5v0__aoi21_1
Xwave_controller_y_inst__2214_ wave_controller_y_inst__2212_/Z wave_controller_y_inst_wire111/Z
+ wave_controller_y_inst__2231_/A2 VDD VDD VSS VSS gf180mcu_fd_sc_mcu7t5v0__nor2_1
Xwave_controller_y_inst__2145_ wave_controller_y_inst__2124_/B wave_controller_y_inst__2145_/I1
+ wave_controller_y_inst__2145_/S wave_controller_y_inst__2145_/Z VDD VDD VSS VSS
+ gf180mcu_fd_sc_mcu7t5v0__mux2_2
Xwave_controller_x_inst__3178_ wave_controller_x_inst__3175_/Z wave_controller_x_inst__3248_/B
+ wave_controller_x_inst__3179_/B VDD VDD VSS VSS gf180mcu_fd_sc_mcu7t5v0__nor2_1
XFILLER_107_766 VDD VDD VSS VSS gf180mcu_fd_sc_mcu7t5v0__fillcap_4
XFILLER_153_338 VDD VDD VSS VSS gf180mcu_fd_sc_mcu7t5v0__fill_1
XFILLER_165_198 VDD VDD VSS VSS gf180mcu_fd_sc_mcu7t5v0__fillcap_4
Xwave_controller_x_inst__2129_ wave_controller_x_inst__2058_/C wave_controller_x_inst__2137_/A2
+ wave_controller_x_inst__2129_/B wave_controller_x_inst__2144_/B wave_controller_x_inst__2130_/B
+ VDD VDD VSS VSS gf180mcu_fd_sc_mcu7t5v0__oai211_1
XTAP_TAPCELL_ROW_95_1452 VDD VSS gf180mcu_fd_sc_mcu7t5v0__filltie
XTAP_TAPCELL_ROW_95_1441 VDD VSS gf180mcu_fd_sc_mcu7t5v0__filltie
XFILLER_134_552 VDD VDD VSS VSS gf180mcu_fd_sc_mcu7t5v0__fillcap_32
XFILLER_161_360 VDD VDD VSS VSS gf180mcu_fd_sc_mcu7t5v0__fillcap_4
Xwave_controller_y_inst__2076_ wave_controller_y_inst__2076_/A1 wave_controller_y_inst__2074_/Z
+ wave_controller_y_inst__2091_/A2 wave_controller_y_inst__2114_/C wave_controller_y_inst__2081_/B
+ VDD VDD VSS VSS gf180mcu_fd_sc_mcu7t5v0__oai31_1
XFILLER_0_554 VDD VDD VSS VSS gf180mcu_fd_sc_mcu7t5v0__fill_1
XFILLER_121_279 VDD VDD VSS VSS gf180mcu_fd_sc_mcu7t5v0__fill_1
XFILLER_130_791 VDD VDD VSS VSS gf180mcu_fd_sc_mcu7t5v0__fillcap_8
XFILLER_76_823 VDD VDD VSS VSS gf180mcu_fd_sc_mcu7t5v0__fillcap_4
XFILLER_88_683 VDD VDD VSS VSS gf180mcu_fd_sc_mcu7t5v0__fillcap_8
XFILLER_57_64 VDD VDD VSS VSS gf180mcu_fd_sc_mcu7t5v0__fillcap_4
Xwave_controller_y_inst__2978_ wave_controller_y_inst__3061_/A1 wave_controller_y_inst__2977_/Z
+ wave_controller_y_inst__2979_/B VDD VDD VSS VSS gf180mcu_fd_sc_mcu7t5v0__nand2_1
XFILLER_76_889 VDD VDD VSS VSS gf180mcu_fd_sc_mcu7t5v0__fillcap_16
XFILLER_91_815 VDD VDD VSS VSS gf180mcu_fd_sc_mcu7t5v0__fillcap_8
Xwave_controller_y_inst__1929_ wave_controller_y_inst__1929_/A1 wave_controller_y_inst__1929_/A2
+ wave_controller_y_inst__1930_/C VDD VDD VSS VSS gf180mcu_fd_sc_mcu7t5v0__nor2_1
XFILLER_28_282 VDD VDD VSS VSS gf180mcu_fd_sc_mcu7t5v0__fill_1
XFILLER_90_325 VDD VDD VSS VSS gf180mcu_fd_sc_mcu7t5v0__fillcap_4
Xspi_regs_inst__1570_ spi_regs_inst__1570_/D spi_regs_inst__1610_/RN clkload17/I spi_regs_inst__1570_/Q
+ VDD VDD VSS VSS gf180mcu_fd_sc_mcu7t5v0__dffrnq_1
XFILLER_71_572 VDD VDD VSS VSS gf180mcu_fd_sc_mcu7t5v0__fill_1
XTAP_TAPCELL_ROW_54_770 VDD VSS gf180mcu_fd_sc_mcu7t5v0__filltie
Xwave_controller_x_inst_max_cap372 wave_controller_x_inst__2077_/A1 wave_controller_x_inst__2039_/B
+ VDD VDD VSS VSS gf180mcu_fd_sc_mcu7t5v0__clkbuf_2
XFILLER_31_458 VDD VDD VSS VSS gf180mcu_fd_sc_mcu7t5v0__fillcap_8
XTAP_TAPCELL_ROW_104_1592 VDD VSS gf180mcu_fd_sc_mcu7t5v0__filltie
XFILLER_157_644 VDD VDD VSS VSS gf180mcu_fd_sc_mcu7t5v0__fillcap_4
XFILLER_145_806 VDD VDD VSS VSS gf180mcu_fd_sc_mcu7t5v0__fill_1
XFILLER_157_677 VDD VDD VSS VSS gf180mcu_fd_sc_mcu7t5v0__fill_1
XFILLER_145_828 VDD VDD VSS VSS gf180mcu_fd_sc_mcu7t5v0__fillcap_8
XFILLER_157_699 VDD VDD VSS VSS gf180mcu_fd_sc_mcu7t5v0__fill_1
XFILLER_7_142 VDD VDD VSS VSS gf180mcu_fd_sc_mcu7t5v0__fillcap_64
XFILLER_98_403 VDD VDD VSS VSS gf180mcu_fd_sc_mcu7t5v0__fillcap_8
Xstate_machine_inst__34_ state_machine_inst__34_/A1 state_machine_inst__28_/Z state_machine_inst__34_/B
+ state_machine_inst__35_/A2 VDD VDD VSS VSS gf180mcu_fd_sc_mcu7t5v0__oai21_1
Xspi_regs_inst__1004_ spi_regs_inst__1027_/A1 spi_regs_inst__1022_/A2 spi_regs_inst_wire241/I
+ VDD VDD VSS VSS gf180mcu_fd_sc_mcu7t5v0__nor2_1
XFILLER_140_511 VDD VDD VSS VSS gf180mcu_fd_sc_mcu7t5v0__fill_2
XFILLER_140_533 VDD VDD VSS VSS gf180mcu_fd_sc_mcu7t5v0__fill_1
XTAP_TAPCELL_ROW_32_1_568 VDD VSS gf180mcu_fd_sc_mcu7t5v0__filltie
XFILLER_113_769 VDD VDD VSS VSS gf180mcu_fd_sc_mcu7t5v0__fill_1
XFILLER_98_469 VDD VDD VSS VSS gf180mcu_fd_sc_mcu7t5v0__fillcap_16
XFILLER_67_834 VDD VDD VSS VSS gf180mcu_fd_sc_mcu7t5v0__fillcap_4
XFILLER_113_1046 VDD VDD VSS VSS gf180mcu_fd_sc_mcu7t5v0__fillcap_4
XFILLER_14_2 VDD VDD VSS VSS gf180mcu_fd_sc_mcu7t5v0__fillcap_16
XFILLER_82_804 VDD VDD VSS VSS gf180mcu_fd_sc_mcu7t5v0__fill_1
XFILLER_26_219 VDD VDD VSS VSS gf180mcu_fd_sc_mcu7t5v0__fillcap_4
XFILLER_66_366 VDD VDD VSS VSS gf180mcu_fd_sc_mcu7t5v0__fill_1
XFILLER_81_303 VDD VDD VSS VSS gf180mcu_fd_sc_mcu7t5v0__fillcap_8
XFILLER_19_282 VDD VDD VSS VSS gf180mcu_fd_sc_mcu7t5v0__fillcap_4
XFILLER_54_539 VDD VDD VSS VSS gf180mcu_fd_sc_mcu7t5v0__fill_1
XTAP_TAPCELL_ROW_124_1924 VDD VSS gf180mcu_fd_sc_mcu7t5v0__filltie
XFILLER_90_870 VDD VDD VSS VSS gf180mcu_fd_sc_mcu7t5v0__fillcap_4
Xwave_controller_x_inst__2480_ wave_controller_x_inst__2482_/A1 wave_controller_x_inst__2479_/I
+ wave_controller_x_inst__2481_/I VDD VDD VSS VSS gf180mcu_fd_sc_mcu7t5v0__nor2_1
XFILLER_22_403 VDD VDD VSS VSS gf180mcu_fd_sc_mcu7t5v0__fillcap_4
XFILLER_22_447 VDD VDD VSS VSS gf180mcu_fd_sc_mcu7t5v0__fillcap_8
XFILLER_34_296 VDD VDD VSS VSS gf180mcu_fd_sc_mcu7t5v0__fill_2
XFILLER_148_633 VDD VDD VSS VSS gf180mcu_fd_sc_mcu7t5v0__fill_1
XTAP_TAPCELL_ROW_157_2467 VDD VSS gf180mcu_fd_sc_mcu7t5v0__filltie
Xwave_controller_x_inst__3101_ wave_controller_x_inst__3101_/A1 wave_controller_x_inst__3101_/A2
+ wave_controller_x_inst__3101_/B wave_controller_x_inst__3613_/D VDD VDD VSS VSS
+ gf180mcu_fd_sc_mcu7t5v0__aoi21_1
XFILLER_120_1017 VDD VDD VSS VSS gf180mcu_fd_sc_mcu7t5v0__fillcap_64
Xwave_controller_x_inst__3032_ wave_controller_x_inst__3469_/A1 wave_controller_x_inst__3479_/A1
+ wave_controller_x_inst__3032_/A3 wave_controller_x_inst__3409_/A3 VDD VDD VSS VSS
+ gf180mcu_fd_sc_mcu7t5v0__nor3_1
XFILLER_135_305 VDD VDD VSS VSS gf180mcu_fd_sc_mcu7t5v0__fill_1
XFILLER_118_26 VDD VDD VSS VSS gf180mcu_fd_sc_mcu7t5v0__fill_1
XFILLER_118_37 VDD VDD VSS VSS gf180mcu_fd_sc_mcu7t5v0__fillcap_16
XFILLER_135_349 VDD VDD VSS VSS gf180mcu_fd_sc_mcu7t5v0__fill_1
XTAP_TAPCELL_ROW_18_1_469 VDD VSS gf180mcu_fd_sc_mcu7t5v0__filltie
XFILLER_116_552 VDD VDD VSS VSS gf180mcu_fd_sc_mcu7t5v0__fillcap_4
XFILLER_116_574 VDD VDD VSS VSS gf180mcu_fd_sc_mcu7t5v0__fillcap_16
XFILLER_131_500 VDD VDD VSS VSS gf180mcu_fd_sc_mcu7t5v0__fillcap_4
XFILLER_131_555 VDD VDD VSS VSS gf180mcu_fd_sc_mcu7t5v0__fillcap_4
XFILLER_83_1170 VDD VDD VSS VSS gf180mcu_fd_sc_mcu7t5v0__fillcap_4
XTAP_TAPCELL_ROW_73_1079 VDD VSS gf180mcu_fd_sc_mcu7t5v0__filltie
XTAP_TAPCELL_ROW_90_1360 VDD VSS gf180mcu_fd_sc_mcu7t5v0__filltie
Xwave_controller_y_inst__2901_ wave_controller_y_inst__3465_/B wave_controller_y_inst__3419_/B
+ wave_controller_y_inst__2908_/A1 wave_controller_y_inst__2902_/B1 VDD VDD VSS VSS
+ gf180mcu_fd_sc_mcu7t5v0__nand3_1
XFILLER_85_620 VDD VDD VSS VSS gf180mcu_fd_sc_mcu7t5v0__fillcap_8
XFILLER_58_867 VDD VDD VSS VSS gf180mcu_fd_sc_mcu7t5v0__fillcap_8
Xwave_controller_y_inst__2832_ wave_controller_y_inst__3266_/A1 wave_controller_y_inst__2834_/A2
+ wave_controller_y_inst__2833_/A2 wave_controller_y_inst__2915_/A1 wave_controller_y_inst__2834_/B
+ VDD VDD VSS VSS gf180mcu_fd_sc_mcu7t5v0__oai22_1
Xwave_controller_x_inst__2816_ wave_controller_x_inst__2816_/I wave_controller_x_inst__2817_/B1
+ VDD VDD VSS VSS gf180mcu_fd_sc_mcu7t5v0__clkinv_1
XFILLER_58_889 VDD VDD VSS VSS gf180mcu_fd_sc_mcu7t5v0__fillcap_4
Xwave_controller_y_inst__2763_ _09_/A1 _10_/A1 wave_controller_y_inst__3081_/C wave_controller_y_inst__3008_/A2
+ VDD VDD VSS VSS gf180mcu_fd_sc_mcu7t5v0__nor3_1
Xwave_controller_x_inst__2747_ wave_controller_x_inst__2748_/A2 wave_controller_x_inst__2745_/Z
+ wave_controller_x_inst__2747_/Z VDD VDD VSS VSS gf180mcu_fd_sc_mcu7t5v0__and2_1
XFILLER_27_56 VDD VDD VSS VSS gf180mcu_fd_sc_mcu7t5v0__fill_1
XFILLER_84_174 VDD VDD VSS VSS gf180mcu_fd_sc_mcu7t5v0__fill_1
Xwave_controller_y_inst__2694_ wave_controller_y_inst__2694_/A1 wave_controller_y_inst__2694_/A2
+ wave_controller_y_inst__2693_/B wave_controller_y_inst__2694_/Z VDD VDD VSS VSS
+ gf180mcu_fd_sc_mcu7t5v0__and3_1
Xwave_controller_x_inst__2678_ wave_controller_x_inst__2674_/Z wave_controller_x_inst__2678_/A2
+ wave_controller_x_inst__2709_/A1 VDD VDD VSS VSS gf180mcu_fd_sc_mcu7t5v0__xnor2_1
XFILLER_53_572 VDD VDD VSS VSS gf180mcu_fd_sc_mcu7t5v0__fill_1
XFILLER_158_419 VDD VDD VSS VSS gf180mcu_fd_sc_mcu7t5v0__fillcap_32
XFILLER_159_66 VDD VDD VSS VSS gf180mcu_fd_sc_mcu7t5v0__fillcap_4
XFILLER_167_920 VDD VDD VSS VSS gf180mcu_fd_sc_mcu7t5v0__fillcap_32
XFILLER_40_255 VDD VDD VSS VSS gf180mcu_fd_sc_mcu7t5v0__fillcap_4
Xwave_controller_y_inst__3315_ wave_controller_y_inst__3315_/A1 wave_controller_y_inst__3355_/A1
+ wave_controller_y_inst__3359_/A1 wave_controller_y_inst__3315_/Z VDD VDD VSS VSS
+ gf180mcu_fd_sc_mcu7t5v0__and3_1
XFILLER_139_655 VDD VDD VSS VSS gf180mcu_fd_sc_mcu7t5v0__fillcap_4
XFILLER_166_452 VDD VDD VSS VSS gf180mcu_fd_sc_mcu7t5v0__fill_2
Xwave_controller_y_inst__3246_ wave_controller_y_inst__1816_/I wave_controller_y_inst__3196_/Z
+ wave_controller_y_inst__3246_/B1 wave_controller_y_inst__3246_/B2 wave_controller_y_inst__3254_/A1
+ VDD VDD VSS VSS gf180mcu_fd_sc_mcu7t5v0__oai22_1
XFILLER_154_625 VDD VDD VSS VSS gf180mcu_fd_sc_mcu7t5v0__fillcap_16
XFILLER_4_101 VDD VDD VSS VSS gf180mcu_fd_sc_mcu7t5v0__fillcap_4
Xwave_controller_y_inst__3177_ wave_controller_y_inst__1778_/I spi_regs_inst__1578_/Q
+ wave_controller_y_inst__3248_/B VDD VDD VSS VSS gf180mcu_fd_sc_mcu7t5v0__xor2_1
XFILLER_135_850 VDD VDD VSS VSS gf180mcu_fd_sc_mcu7t5v0__fill_1
XFILLER_88_1081 VDD VDD VSS VSS gf180mcu_fd_sc_mcu7t5v0__fillcap_4
Xwave_controller_y_inst__2128_ wave_controller_y_inst__2058_/C wave_controller_y_inst__2128_/A2
+ wave_controller_y_inst__2137_/A2 wave_controller_y_inst__2129_/B VDD VDD VSS VSS
+ gf180mcu_fd_sc_mcu7t5v0__nand3_1
XFILLER_107_585 VDD VDD VSS VSS gf180mcu_fd_sc_mcu7t5v0__fillcap_4
Xwave_controller_y_inst__2059_ wave_controller_y_inst__2079_/B wave_controller_y_inst__2108_/B
+ wave_controller_y_inst__2138_/A2 VDD VDD VSS VSS gf180mcu_fd_sc_mcu7t5v0__nor2_1
XFILLER_122_555 VDD VDD VSS VSS gf180mcu_fd_sc_mcu7t5v0__fill_2
XFILLER_161_190 VDD VDD VSS VSS gf180mcu_fd_sc_mcu7t5v0__fillcap_8
XFILLER_68_30 VDD VDD VSS VSS gf180mcu_fd_sc_mcu7t5v0__fillcap_4
XFILLER_103_780 VDD VDD VSS VSS gf180mcu_fd_sc_mcu7t5v0__fillcap_4
XFILLER_95_439 VDD VDD VSS VSS gf180mcu_fd_sc_mcu7t5v0__fillcap_4
XFILLER_88_491 VDD VDD VSS VSS gf180mcu_fd_sc_mcu7t5v0__fill_2
Xwave_controller_x_inst_fanout163 wave_controller_x_inst__2766_/ZN wave_controller_x_inst__3530_/A1
+ VDD VDD VSS VSS gf180mcu_fd_sc_mcu7t5v0__dlyb_1
XFILLER_124_91 VDD VDD VSS VSS gf180mcu_fd_sc_mcu7t5v0__fill_2
XFILLER_36_506 VDD VDD VSS VSS gf180mcu_fd_sc_mcu7t5v0__fill_2
XFILLER_76_664 VDD VDD VSS VSS gf180mcu_fd_sc_mcu7t5v0__fill_1
XFILLER_76_675 VDD VDD VSS VSS gf180mcu_fd_sc_mcu7t5v0__fillcap_4
XTAP_TAPCELL_ROW_141_2202 VDD VSS gf180mcu_fd_sc_mcu7t5v0__filltie
XTAP_TAPCELL_ROW_59_851 VDD VSS gf180mcu_fd_sc_mcu7t5v0__filltie
XFILLER_63_314 VDD VDD VSS VSS gf180mcu_fd_sc_mcu7t5v0__fillcap_4
XTAP_TAPCELL_ROW_106_1621 VDD VSS gf180mcu_fd_sc_mcu7t5v0__filltie
XFILLER_63_347 VDD VDD VSS VSS gf180mcu_fd_sc_mcu7t5v0__fill_2
XFILLER_95_1052 VDD VDD VSS VSS gf180mcu_fd_sc_mcu7t5v0__fillcap_64
XTAP_TAPCELL_ROW_106_1632 VDD VSS gf180mcu_fd_sc_mcu7t5v0__filltie
Xwave_controller_y_inst_load_slew53 wave_controller_y_inst_fanout52/Z wave_controller_y_inst__2929_/S
+ VDD VDD VSS VSS gf180mcu_fd_sc_mcu7t5v0__buf_4
Xspi_regs_inst__1622_ spi_regs_inst__1622_/D fanout585/Z clkbuf_leaf_14_clk/Z spi_regs_inst__1622_/Q
+ VDD VDD VSS VSS gf180mcu_fd_sc_mcu7t5v0__dffrnq_1
XFILLER_16_263 VDD VDD VSS VSS gf180mcu_fd_sc_mcu7t5v0__fillcap_8
XFILLER_90_177 VDD VDD VSS VSS gf180mcu_fd_sc_mcu7t5v0__fillcap_4
Xspi_regs_inst__1553_ spi_regs_inst__1553_/D fanout592/Z clkbuf_leaf_26_clk/Z spi_regs_inst__1553_/Q
+ VDD VDD VSS VSS gf180mcu_fd_sc_mcu7t5v0__dffrnq_1
XFILLER_31_277 VDD VDD VSS VSS gf180mcu_fd_sc_mcu7t5v0__fill_2
XTAP_TAPCELL_ROW_139_2164 VDD VSS gf180mcu_fd_sc_mcu7t5v0__filltie
Xspi_regs_inst__1484_ spi_regs_inst__1484_/D spi_regs_inst__1662_/RN clkbuf_leaf_7_clk/Z
+ spi_regs_inst__1484_/Q VDD VDD VSS VSS gf180mcu_fd_sc_mcu7t5v0__dffrnq_1
XTAP_TAPCELL_ROW_139_2175 VDD VSS gf180mcu_fd_sc_mcu7t5v0__filltie
XFILLER_118_828 VDD VDD VSS VSS gf180mcu_fd_sc_mcu7t5v0__fill_2
XFILLER_8_462 VDD VDD VSS VSS gf180mcu_fd_sc_mcu7t5v0__fill_2
XFILLER_145_636 VDD VDD VSS VSS gf180mcu_fd_sc_mcu7t5v0__fill_2
XTAP_TAPCELL_ROW_152_2386 VDD VSS gf180mcu_fd_sc_mcu7t5v0__filltie
XFILLER_125_360 VDD VDD VSS VSS gf180mcu_fd_sc_mcu7t5v0__fillcap_8
XFILLER_141_842 VDD VDD VSS VSS gf180mcu_fd_sc_mcu7t5v0__fillcap_8
XFILLER_153_680 VDD VDD VSS VSS gf180mcu_fd_sc_mcu7t5v0__fillcap_4
XFILLER_67_1154 VDD VDD VSS VSS gf180mcu_fd_sc_mcu7t5v0__fillcap_16
XFILLER_154_1157 VDD VDD VSS VSS gf180mcu_fd_sc_mcu7t5v0__fillcap_8
XFILLER_99_767 VDD VDD VSS VSS gf180mcu_fd_sc_mcu7t5v0__fill_2
Xwave_controller_x_inst__1980_ wave_controller_x_inst__1980_/A1 wave_controller_x_inst__1986_/B
+ wave_controller_x_inst__1986_/A2 VDD VDD VSS VSS gf180mcu_fd_sc_mcu7t5v0__nand2_1
Xwave_controller_x_inst__3650_ wave_controller_x_inst__3650_/D wave_controller_x_inst__3701_/RN
+ clkload31/I wire462/I VDD VDD VSS VSS gf180mcu_fd_sc_mcu7t5v0__dffrnq_1
XFILLER_104_28 VDD VDD VSS VSS gf180mcu_fd_sc_mcu7t5v0__fillcap_4
XFILLER_94_450 VDD VDD VSS VSS gf180mcu_fd_sc_mcu7t5v0__fillcap_4
Xwave_controller_x_inst__2601_ max_cap464/Z wave_controller_x_inst__2599_/Z wave_controller_x_inst__2601_/Z
+ VDD VDD VSS VSS gf180mcu_fd_sc_mcu7t5v0__xor2_1
Xwave_controller_x_inst__3581_ wave_controller_x_inst__3581_/A1 wave_controller_x_inst__3610_/A2
+ wave_controller_x_inst__3581_/B wave_controller_x_inst__3660_/D VDD VDD VSS VSS
+ gf180mcu_fd_sc_mcu7t5v0__oai21_1
XFILLER_70_807 VDD VDD VSS VSS gf180mcu_fd_sc_mcu7t5v0__fillcap_8
XFILLER_82_667 VDD VDD VSS VSS gf180mcu_fd_sc_mcu7t5v0__fillcap_4
Xwave_controller_x_inst__2532_ max_cap457/I wave_controller_x_inst__3518_/B2 wave_controller_x_inst__2553_/A2
+ VDD VDD VSS VSS gf180mcu_fd_sc_mcu7t5v0__nand2_1
XFILLER_120_16 VDD VDD VSS VSS gf180mcu_fd_sc_mcu7t5v0__fillcap_16
XTAP_TAPCELL_ROW_159_2507 VDD VSS gf180mcu_fd_sc_mcu7t5v0__filltie
Xwave_controller_x_inst__2463_ wave_controller_x_inst__2464_/A1 wave_controller_x_inst__2464_/A2
+ wave_controller_x_inst__2463_/B wave_controller_x_inst__2516_/B1 VDD VDD VSS VSS
+ gf180mcu_fd_sc_mcu7t5v0__oai21_1
XFILLER_81_199 VDD VDD VSS VSS gf180mcu_fd_sc_mcu7t5v0__fillcap_8
XFILLER_22_244 VDD VDD VSS VSS gf180mcu_fd_sc_mcu7t5v0__fill_1
Xwave_controller_x_inst__2394_ wave_controller_x_inst__2394_/A1 wave_controller_x_inst__2373_/Z
+ wave_controller_x_inst__2396_/C wave_controller_x_inst__2389_/Z wave_controller_x_inst__2394_/Z
+ VDD VDD VSS VSS gf180mcu_fd_sc_mcu7t5v0__or4_1
XFILLER_148_441 VDD VDD VSS VSS gf180mcu_fd_sc_mcu7t5v0__fillcap_8
Xwave_controller_y_inst__3100_ wave_controller_y_inst__3101_/A2 wave_controller_y_inst__3100_/A2
+ wave_controller_y_inst__3100_/B fanout499/Z wave_controller_y_inst__3101_/B VDD
+ VDD VSS VSS gf180mcu_fd_sc_mcu7t5v0__oai211_1
XFILLER_163_422 VDD VDD VSS VSS gf180mcu_fd_sc_mcu7t5v0__fillcap_4
XTAP_TAPCELL_ROW_75_1108 VDD VSS gf180mcu_fd_sc_mcu7t5v0__filltie
Xwave_controller_y_inst__3031_ wave_controller_y_inst__3697_/Q wave_controller_y_inst_wire25/Z
+ wave_controller_y_inst__3032_/A3 wave_controller_y_inst__3031_/B wave_controller_y_inst__3697_/D
+ VDD VDD VSS VSS gf180mcu_fd_sc_mcu7t5v0__oai31_1
Xwave_controller_x_inst__3015_ wave_controller_x_inst__3430_/A1 wave_controller_x_inst__3015_/A2
+ wave_controller_x_inst__3015_/B1 wave_controller_x_inst_wire60/I wave_controller_x_inst__3693_/D
+ VDD VDD VSS VSS gf180mcu_fd_sc_mcu7t5v0__aoi22_1
XFILLER_123_319 VDD VDD VSS VSS gf180mcu_fd_sc_mcu7t5v0__fillcap_4
XFILLER_135_168 VDD VDD VSS VSS gf180mcu_fd_sc_mcu7t5v0__fill_2
XFILLER_151_606 VDD VDD VSS VSS gf180mcu_fd_sc_mcu7t5v0__fill_1
XFILLER_151_617 VDD VDD VSS VSS gf180mcu_fd_sc_mcu7t5v0__fill_1
XFILLER_159_1046 VDD VDD VSS VSS gf180mcu_fd_sc_mcu7t5v0__fillcap_4
XTAP_TAPCELL_ROW_75_1119 VDD VSS gf180mcu_fd_sc_mcu7t5v0__filltie
XTAP_TAPCELL_ROW_92_1400 VDD VSS gf180mcu_fd_sc_mcu7t5v0__filltie
XFILLER_104_522 VDD VDD VSS VSS gf180mcu_fd_sc_mcu7t5v0__fill_2
XFILLER_116_382 VDD VDD VSS VSS gf180mcu_fd_sc_mcu7t5v0__fill_2
XFILLER_150_138 VDD VDD VSS VSS gf180mcu_fd_sc_mcu7t5v0__fill_1
XFILLER_89_222 VDD VDD VSS VSS gf180mcu_fd_sc_mcu7t5v0__fillcap_4
Xwave_controller_x_inst_wire78 wave_controller_x_inst_wire78/I wave_controller_x_inst_wire78/Z
+ VDD VDD VSS VSS gf180mcu_fd_sc_mcu7t5v0__buf_2
XFILLER_104_555 VDD VDD VSS VSS gf180mcu_fd_sc_mcu7t5v0__fill_2
XFILLER_131_341 VDD VDD VSS VSS gf180mcu_fd_sc_mcu7t5v0__fillcap_8
XFILLER_145_57 VDD VDD VSS VSS gf180mcu_fd_sc_mcu7t5v0__fill_1
XFILLER_131_352 VDD VDD VSS VSS gf180mcu_fd_sc_mcu7t5v0__fill_1
XFILLER_58_664 VDD VDD VSS VSS gf180mcu_fd_sc_mcu7t5v0__fill_1
XFILLER_73_612 VDD VDD VSS VSS gf180mcu_fd_sc_mcu7t5v0__fillcap_4
Xwave_controller_y_inst__2815_ wave_controller_y_inst__2815_/A1 wave_controller_y_inst__2815_/A2
+ wave_controller_y_inst__2815_/B wave_controller_y_inst__2816_/I VDD VDD VSS VSS
+ gf180mcu_fd_sc_mcu7t5v0__oai21_1
XFILLER_45_325 VDD VDD VSS VSS gf180mcu_fd_sc_mcu7t5v0__fill_2
XFILLER_57_196 VDD VDD VSS VSS gf180mcu_fd_sc_mcu7t5v0__fillcap_8
XFILLER_166_1017 VDD VDD VSS VSS gf180mcu_fd_sc_mcu7t5v0__fillcap_64
XFILLER_61_807 VDD VDD VSS VSS gf180mcu_fd_sc_mcu7t5v0__fill_2
XTAP_TAPCELL_ROW_0_1_2664 VDD VSS gf180mcu_fd_sc_mcu7t5v0__filltie
Xwave_controller_y_inst__2746_ wave_controller_y_inst__2748_/A2 wave_controller_y_inst__2745_/Z
+ wave_controller_y_inst__2752_/C VDD VDD VSS VSS gf180mcu_fd_sc_mcu7t5v0__or2_1
XFILLER_60_317 VDD VDD VSS VSS gf180mcu_fd_sc_mcu7t5v0__fill_1
XFILLER_72_177 VDD VDD VSS VSS gf180mcu_fd_sc_mcu7t5v0__fillcap_16
Xwave_controller_y_inst__2677_ wave_controller_y_inst__2674_/Z wave_controller_y_inst__2678_/A2
+ wave_controller_y_inst__2677_/Z VDD VDD VSS VSS gf180mcu_fd_sc_mcu7t5v0__xor2_1
XFILLER_53_380 VDD VDD VSS VSS gf180mcu_fd_sc_mcu7t5v0__fill_2
XTAP_TAPCELL_ROW_31_1_567 VDD VSS gf180mcu_fd_sc_mcu7t5v0__filltie
XFILLER_13_244 VDD VDD VSS VSS gf180mcu_fd_sc_mcu7t5v0__fill_2
XFILLER_41_553 VDD VDD VSS VSS gf180mcu_fd_sc_mcu7t5v0__fill_2
XTAP_TAPCELL_ROW_101_1540 VDD VSS gf180mcu_fd_sc_mcu7t5v0__filltie
XTAP_TAPCELL_ROW_101_1551 VDD VSS gf180mcu_fd_sc_mcu7t5v0__filltie
XFILLER_107_1170 VDD VDD VSS VSS gf180mcu_fd_sc_mcu7t5v0__fillcap_4
XFILLER_139_430 VDD VDD VSS VSS gf180mcu_fd_sc_mcu7t5v0__fill_2
XFILLER_167_750 VDD VDD VSS VSS gf180mcu_fd_sc_mcu7t5v0__fillcap_32
XFILLER_127_603 VDD VDD VSS VSS gf180mcu_fd_sc_mcu7t5v0__fill_2
XFILLER_139_474 VDD VDD VSS VSS gf180mcu_fd_sc_mcu7t5v0__fillcap_4
XFILLER_155_912 VDD VDD VSS VSS gf180mcu_fd_sc_mcu7t5v0__fillcap_64
XFILLER_166_293 VDD VDD VSS VSS gf180mcu_fd_sc_mcu7t5v0__fill_2
Xwave_controller_y_inst__3229_ fanout507/Z wave_controller_y_inst__3233_/B1 wave_controller_y_inst__3234_/B1
+ VDD VDD VSS VSS gf180mcu_fd_sc_mcu7t5v0__nor2_1
Xclkload29 clkload29/I clkload29/ZN VDD VDD VSS VSS gf180mcu_fd_sc_mcu7t5v0__inv_4
Xclkload18 clkload18/I clkload18/ZN VDD VDD VSS VSS gf180mcu_fd_sc_mcu7t5v0__clkinv_2
XFILLER_126_168 VDD VDD VSS VSS gf180mcu_fd_sc_mcu7t5v0__fillcap_4
XTAP_TAPCELL_ROW_134_2083 VDD VSS gf180mcu_fd_sc_mcu7t5v0__filltie
XTAP_TAPCELL_ROW_134_2094 VDD VSS gf180mcu_fd_sc_mcu7t5v0__filltie
Xspi_regs_inst_wire19 spi_regs_inst_wire19/I spi_regs_inst_wire19/Z VDD VDD VSS VSS
+ gf180mcu_fd_sc_mcu7t5v0__buf_2
XFILLER_123_831 VDD VDD VSS VSS gf180mcu_fd_sc_mcu7t5v0__fill_1
XFILLER_142_639 VDD VDD VSS VSS gf180mcu_fd_sc_mcu7t5v0__fill_1
XFILLER_5_498 VDD VDD VSS VSS gf180mcu_fd_sc_mcu7t5v0__fill_1
XFILLER_122_330 VDD VDD VSS VSS gf180mcu_fd_sc_mcu7t5v0__fill_2
XFILLER_123_842 VDD VDD VSS VSS gf180mcu_fd_sc_mcu7t5v0__fillcap_4
XFILLER_69_907 VDD VDD VSS VSS gf180mcu_fd_sc_mcu7t5v0__fill_2
XPHY_EDGE_ROW_33_1_Right_32 VDD VSS gf180mcu_fd_sc_mcu7t5v0__endcap
XFILLER_110_503 VDD VDD VSS VSS gf180mcu_fd_sc_mcu7t5v0__fillcap_4
Xsignal_processor_y_inst__150_ fanout393/Z signal_processor_y_inst__229_/Q signal_processor_y_inst__203_/A2
+ VDD VDD VSS VSS gf180mcu_fd_sc_mcu7t5v0__nand2_1
XFILLER_95_225 VDD VDD VSS VSS gf180mcu_fd_sc_mcu7t5v0__fillcap_8
Xspi_regs_inst_fanout472 spi_regs_inst__1662_/Q spi_regs_inst__1410_/I1 VDD VDD VSS
+ VSS gf180mcu_fd_sc_mcu7t5v0__dlyb_1
XFILLER_48_152 VDD VDD VSS VSS gf180mcu_fd_sc_mcu7t5v0__fillcap_4
XFILLER_76_461 VDD VDD VSS VSS gf180mcu_fd_sc_mcu7t5v0__fill_2
XFILLER_95_72 VDD VDD VSS VSS gf180mcu_fd_sc_mcu7t5v0__fillcap_16
Xspi_regs_inst__0984_ spi_regs_inst__1021_/A1 spi_regs_inst__1019_/A1 spi_regs_inst_wire263/I
+ VDD VDD VSS VSS gf180mcu_fd_sc_mcu7t5v0__nor2_1
X_93_ _93_/I _93_/Z VDD VDD VSS VSS gf180mcu_fd_sc_mcu7t5v0__buf_1
XFILLER_48_185 VDD VDD VSS VSS gf180mcu_fd_sc_mcu7t5v0__fill_2
XFILLER_64_612 VDD VDD VSS VSS gf180mcu_fd_sc_mcu7t5v0__fill_1
XFILLER_64_634 VDD VDD VSS VSS gf180mcu_fd_sc_mcu7t5v0__fillcap_4
XFILLER_64_667 VDD VDD VSS VSS gf180mcu_fd_sc_mcu7t5v0__fill_2
XFILLER_91_464 VDD VDD VSS VSS gf180mcu_fd_sc_mcu7t5v0__fill_2
XTAP_TAPCELL_ROW_17_1_457 VDD VSS gf180mcu_fd_sc_mcu7t5v0__filltie
XFILLER_32_531 VDD VDD VSS VSS gf180mcu_fd_sc_mcu7t5v0__fill_2
Xspi_regs_inst__1605_ spi_regs_inst__1605_/D spi_regs_inst__1605_/RN clkbuf_leaf_39_clk/Z
+ spi_regs_inst__1605_/Q VDD VDD VSS VSS gf180mcu_fd_sc_mcu7t5v0__dffrnq_1
Xspi_regs_inst__1536_ spi_regs_inst__1536_/D fanout588/Z clkload25/I spi_regs_inst__1536_/Q
+ VDD VDD VSS VSS gf180mcu_fd_sc_mcu7t5v0__dffrnq_1
XTAP_TAPCELL_ROW_154_2415 VDD VSS gf180mcu_fd_sc_mcu7t5v0__filltie
XTAP_TAPCELL_ROW_154_2426 VDD VSS gf180mcu_fd_sc_mcu7t5v0__filltie
XTAP_TAPCELL_ROW_119_1834 VDD VSS gf180mcu_fd_sc_mcu7t5v0__filltie
Xspi_regs_inst__1467_ spi_regs_inst__1467_/D fanout592/Z clkbuf_leaf_26_clk/Z fanout535/I
+ VDD VDD VSS VSS gf180mcu_fd_sc_mcu7t5v0__dffrnq_1
XFILLER_118_636 VDD VDD VSS VSS gf180mcu_fd_sc_mcu7t5v0__fillcap_16
XFILLER_157_282 VDD VDD VSS VSS gf180mcu_fd_sc_mcu7t5v0__fillcap_16
XTAP_TAPCELL_ROW_119_1845 VDD VSS gf180mcu_fd_sc_mcu7t5v0__filltie
Xspi_regs_inst__1398_ fanout528/Z spi_regs_inst__1416_/I0 spi_regs_inst__1402_/S spi_regs_inst__1472_/D
+ VDD VDD VSS VSS gf180mcu_fd_sc_mcu7t5v0__mux2_2
XFILLER_114_864 VDD VDD VSS VSS gf180mcu_fd_sc_mcu7t5v0__fillcap_8
XFILLER_160_469 VDD VDD VSS VSS gf180mcu_fd_sc_mcu7t5v0__fillcap_4
XFILLER_99_542 VDD VDD VSS VSS gf180mcu_fd_sc_mcu7t5v0__fillcap_16
XFILLER_113_352 VDD VDD VSS VSS gf180mcu_fd_sc_mcu7t5v0__fill_2
XFILLER_119_1052 VDD VDD VSS VSS gf180mcu_fd_sc_mcu7t5v0__fillcap_64
XFILLER_86_214 VDD VDD VSS VSS gf180mcu_fd_sc_mcu7t5v0__fillcap_4
XFILLER_99_586 VDD VDD VSS VSS gf180mcu_fd_sc_mcu7t5v0__fill_2
XFILLER_99_597 VDD VDD VSS VSS gf180mcu_fd_sc_mcu7t5v0__fillcap_16
XTAP_TAPCELL_ROW_70_1027 VDD VSS gf180mcu_fd_sc_mcu7t5v0__filltie
XTAP_TAPCELL_ROW_70_1038 VDD VSS gf180mcu_fd_sc_mcu7t5v0__filltie
Xwave_controller_x_inst__1963_ wave_controller_x_inst__1960_/I wave_controller_x_inst__1963_/A2
+ spi_regs_inst_wire185/I VDD VDD VSS VSS gf180mcu_fd_sc_mcu7t5v0__xor2_1
XFILLER_80_1151 VDD VDD VSS VSS gf180mcu_fd_sc_mcu7t5v0__fillcap_4
XFILLER_86_247 VDD VDD VSS VSS gf180mcu_fd_sc_mcu7t5v0__fill_2
Xwave_controller_x_inst__3702_ wave_controller_x_inst__3702_/D fanout620/Z clkload31/I
+ wave_controller_x_inst__3702_/Q VDD VDD VSS VSS gf180mcu_fd_sc_mcu7t5v0__dffrnq_1
Xwave_controller_x_inst__1894_ wave_controller_x_inst__3695_/Q wave_controller_x_inst__3449_/A1
+ VDD VDD VSS VSS gf180mcu_fd_sc_mcu7t5v0__clkinv_1
XFILLER_55_634 VDD VDD VSS VSS gf180mcu_fd_sc_mcu7t5v0__fill_1
XFILLER_94_280 VDD VDD VSS VSS gf180mcu_fd_sc_mcu7t5v0__fill_1
XTAP_TAPCELL_ROW_165_2599 VDD VSS gf180mcu_fd_sc_mcu7t5v0__filltie
Xwave_controller_y_inst__2600_ max_cap432/Z wave_controller_y_inst__2599_/Z wave_controller_y_inst__2600_/Z
+ VDD VDD VSS VSS gf180mcu_fd_sc_mcu7t5v0__and2_1
Xwave_controller_x_inst__3633_ wave_controller_x_inst__3633_/D wave_controller_x_inst__3704_/RN
+ clkload35/I spi_regs_inst__1286_/B2 VDD VDD VSS VSS gf180mcu_fd_sc_mcu7t5v0__dffrnq_1
Xwave_controller_y_inst__3580_ spi_regs_inst__1199_/A1 wave_controller_y_inst__3588_/S
+ wave_controller_y_inst__3581_/B VDD VDD VSS VSS gf180mcu_fd_sc_mcu7t5v0__nand2_1
Xwave_controller_x_inst__3564_ wave_controller_x_inst__3564_/A1 wave_controller_x_inst_wire333/Z
+ wave_controller_x_inst__3597_/I0 VDD VDD VSS VSS gf180mcu_fd_sc_mcu7t5v0__nor2_1
XFILLER_42_317 VDD VDD VSS VSS gf180mcu_fd_sc_mcu7t5v0__fillcap_8
XFILLER_54_177 VDD VDD VSS VSS gf180mcu_fd_sc_mcu7t5v0__fill_2
Xwave_controller_y_inst__2531_ wave_controller_y_inst__2789_/A1 spi_regs_inst__1343_/A1
+ wave_controller_y_inst__2555_/A2 VDD VDD VSS VSS gf180mcu_fd_sc_mcu7t5v0__nor2_1
Xwave_controller_x_inst__2515_ wave_controller_x_inst__2488_/Z wave_controller_x_inst__2518_/A3
+ wave_controller_x_inst__2516_/C VDD VDD VSS VSS gf180mcu_fd_sc_mcu7t5v0__nand2_1
XFILLER_35_391 VDD VDD VSS VSS gf180mcu_fd_sc_mcu7t5v0__fillcap_8
XTAP_TAPCELL_ROW_85_1281 VDD VSS gf180mcu_fd_sc_mcu7t5v0__filltie
Xwave_controller_y_inst__2462_ wave_controller_y_inst__2462_/A1 wave_controller_y_inst__2462_/A2
+ wave_controller_y_inst__2462_/B wave_controller_y_inst__2517_/A1 VDD VDD VSS VSS
+ gf180mcu_fd_sc_mcu7t5v0__aoi21_1
Xwave_controller_y_inst_wire156 wave_controller_y_inst_wire156/I wave_controller_y_inst_wire156/Z
+ VDD VDD VSS VSS gf180mcu_fd_sc_mcu7t5v0__dlyb_1
Xwave_controller_x_inst__3495_ spi_regs_inst__1064_/B2 wave_controller_x_inst__3538_/A2
+ wave_controller_x_inst__3497_/B1 VDD VDD VSS VSS gf180mcu_fd_sc_mcu7t5v0__nor2_1
Xwave_controller_x_inst__2446_ wave_controller_x_inst__2446_/A1 wave_controller_x_inst__2449_/B2
+ wave_controller_x_inst__2446_/B wave_controller_x_inst__2447_/A2 VDD VDD VSS VSS
+ gf180mcu_fd_sc_mcu7t5v0__oai21_1
Xsignal_processor_x_inst__170_ signal_processor_x_inst__187_/A1 signal_processor_x_inst__169_/Z
+ signal_processor_x_inst__234_/D VDD VDD VSS VSS gf180mcu_fd_sc_mcu7t5v0__nor2_1
XFILLER_50_372 VDD VDD VSS VSS gf180mcu_fd_sc_mcu7t5v0__fill_1
XTAP_TAPCELL_ROW_61_890 VDD VSS gf180mcu_fd_sc_mcu7t5v0__filltie
Xwave_controller_y_inst__2393_ wave_controller_y_inst__2394_/A1 wave_controller_y_inst__2396_/C
+ wave_controller_y_inst__2389_/Z wave_controller_y_inst__2396_/A2 VDD VDD VSS VSS
+ gf180mcu_fd_sc_mcu7t5v0__nor3_1
Xwave_controller_x_inst__2377_ wave_controller_x_inst__2394_/A1 wave_controller_x_inst__2391_/A2
+ spi_regs_inst__1301_/B2 VDD VDD VSS VSS gf180mcu_fd_sc_mcu7t5v0__xor2_1
XFILLER_10_247 VDD VDD VSS VSS gf180mcu_fd_sc_mcu7t5v0__fillcap_64
XFILLER_137_912 VDD VDD VSS VSS gf180mcu_fd_sc_mcu7t5v0__fillcap_64
XFILLER_149_772 VDD VDD VSS VSS gf180mcu_fd_sc_mcu7t5v0__fillcap_4
Xwire628 wire628/I wire628/Z VDD VDD VSS VSS gf180mcu_fd_sc_mcu7t5v0__buf_4
Xchip_core_646 bidir_pd[1] VDD VDD VSS VSS gf180mcu_fd_sc_mcu7t5v0__tiel
Xchip_core_635 bidir_ie[3] VDD VDD VSS VSS gf180mcu_fd_sc_mcu7t5v0__tiel
XFILLER_164_731 VDD VDD VSS VSS gf180mcu_fd_sc_mcu7t5v0__fillcap_4
Xchip_core_679 bidir_ie[1] VDD VDD VSS VSS gf180mcu_fd_sc_mcu7t5v0__tieh
Xchip_core_668 bidir_sl[5] VDD VDD VSS VSS gf180mcu_fd_sc_mcu7t5v0__tiel
Xchip_core_657 bidir_pu[3] VDD VDD VSS VSS gf180mcu_fd_sc_mcu7t5v0__tiel
XFILLER_124_617 VDD VDD VSS VSS gf180mcu_fd_sc_mcu7t5v0__fill_2
XFILLER_156_34 VDD VDD VSS VSS gf180mcu_fd_sc_mcu7t5v0__fill_1
XFILLER_156_45 VDD VDD VSS VSS gf180mcu_fd_sc_mcu7t5v0__fill_2
XPHY_EDGE_ROW_149_Right_149 VDD VSS gf180mcu_fd_sc_mcu7t5v0__endcap
Xwave_controller_y_inst__3014_ wave_controller_y_inst__3039_/A1 wave_controller_y_inst__3017_/A2
+ wave_controller_y_inst__3015_/B1 VDD VDD VSS VSS gf180mcu_fd_sc_mcu7t5v0__nand2_1
XFILLER_123_127 VDD VDD VSS VSS gf180mcu_fd_sc_mcu7t5v0__fillcap_8
XFILLER_105_842 VDD VDD VSS VSS gf180mcu_fd_sc_mcu7t5v0__fillcap_16
XFILLER_2_457 VDD VDD VSS VSS gf180mcu_fd_sc_mcu7t5v0__fillcap_4
XFILLER_105_897 VDD VDD VSS VSS gf180mcu_fd_sc_mcu7t5v0__fillcap_4
XFILLER_78_737 VDD VDD VSS VSS gf180mcu_fd_sc_mcu7t5v0__fillcap_8
XFILLER_120_856 VDD VDD VSS VSS gf180mcu_fd_sc_mcu7t5v0__fillcap_4
XFILLER_131_193 VDD VDD VSS VSS gf180mcu_fd_sc_mcu7t5v0__fillcap_16
XFILLER_49_65 VDD VDD VSS VSS gf180mcu_fd_sc_mcu7t5v0__fillcap_4
XFILLER_65_409 VDD VDD VSS VSS gf180mcu_fd_sc_mcu7t5v0__fill_2
XFILLER_74_932 VDD VDD VSS VSS gf180mcu_fd_sc_mcu7t5v0__fill_1
XFILLER_45_144 VDD VDD VSS VSS gf180mcu_fd_sc_mcu7t5v0__fill_1
Xwave_controller_y_inst__2729_ wave_controller_y_inst__2729_/I wave_controller_y_inst__2734_/A1
+ VDD VDD VSS VSS gf180mcu_fd_sc_mcu7t5v0__clkinv_1
XFILLER_61_648 VDD VDD VSS VSS gf180mcu_fd_sc_mcu7t5v0__fillcap_4
XFILLER_92_1011 VDD VDD VSS VSS gf180mcu_fd_sc_mcu7t5v0__fillcap_4
XTAP_TAPCELL_ROW_13_1_430 VDD VSS gf180mcu_fd_sc_mcu7t5v0__filltie
XFILLER_41_361 VDD VDD VSS VSS gf180mcu_fd_sc_mcu7t5v0__fillcap_8
Xspi_regs_inst__1321_ spi_regs_inst__1321_/A1 spi_regs_inst_wire231/I spi_regs_inst_wire218/I
+ spi_regs_inst__1321_/B2 spi_regs_inst__1323_/A3 VDD VDD VSS VSS gf180mcu_fd_sc_mcu7t5v0__aoi22_1
XFILLER_127_400 VDD VDD VSS VSS gf180mcu_fd_sc_mcu7t5v0__fillcap_4
XTAP_TAPCELL_ROW_136_2123 VDD VSS gf180mcu_fd_sc_mcu7t5v0__filltie
XFILLER_127_422 VDD VDD VSS VSS gf180mcu_fd_sc_mcu7t5v0__fillcap_16
XFILLER_139_271 VDD VDD VSS VSS gf180mcu_fd_sc_mcu7t5v0__fillcap_8
XFILLER_139_282 VDD VDD VSS VSS gf180mcu_fd_sc_mcu7t5v0__fillcap_8
XFILLER_167_580 VDD VDD VSS VSS gf180mcu_fd_sc_mcu7t5v0__fillcap_32
Xspi_regs_inst__1252_ spi_regs_inst__1252_/A1 spi_regs_inst__1252_/A2 spi_regs_inst__1252_/B1
+ spi_regs_inst__1252_/B2 spi_regs_inst__1253_/A4 VDD VDD VSS VSS gf180mcu_fd_sc_mcu7t5v0__aoi22_1
XPHY_EDGE_ROW_116_Right_116 VDD VSS gf180mcu_fd_sc_mcu7t5v0__endcap
Xspi_regs_inst__1183_ spi_regs_inst__1183_/A1 spi_regs_inst__1343_/A2 spi_regs_inst__1191_/A1
+ VDD VDD VSS VSS gf180mcu_fd_sc_mcu7t5v0__nand2_1
XFILLER_107_190 VDD VDD VSS VSS gf180mcu_fd_sc_mcu7t5v0__fillcap_4
XFILLER_108_691 VDD VDD VSS VSS gf180mcu_fd_sc_mcu7t5v0__fill_1
XTAP_TAPCELL_ROW_114_1753 VDD VSS gf180mcu_fd_sc_mcu7t5v0__filltie
XTAP_TAPCELL_ROW_114_1764 VDD VSS gf180mcu_fd_sc_mcu7t5v0__filltie
XFILLER_64_1157 VDD VDD VSS VSS gf180mcu_fd_sc_mcu7t5v0__fillcap_16
XFILLER_68_203 VDD VDD VSS VSS gf180mcu_fd_sc_mcu7t5v0__fill_2
XFILLER_69_737 VDD VDD VSS VSS gf180mcu_fd_sc_mcu7t5v0__fillcap_8
Xsignal_processor_y_inst__202_ signal_processor_y_inst__202_/A1 signal_processor_y_inst__202_/A2
+ signal_processor_y_inst__203_/A1 signal_processor_y_inst__202_/B signal_processor_y_inst__219_/D
+ VDD VDD VSS VSS gf180mcu_fd_sc_mcu7t5v0__oai31_1
XFILLER_110_300 VDD VDD VSS VSS gf180mcu_fd_sc_mcu7t5v0__fill_1
XFILLER_111_856 VDD VDD VSS VSS gf180mcu_fd_sc_mcu7t5v0__fillcap_32
XFILLER_122_160 VDD VDD VSS VSS gf180mcu_fd_sc_mcu7t5v0__fillcap_8
XFILLER_122_193 VDD VDD VSS VSS gf180mcu_fd_sc_mcu7t5v0__fillcap_4
XFILLER_150_480 VDD VDD VSS VSS gf180mcu_fd_sc_mcu7t5v0__fillcap_16
XFILLER_151_1116 VDD VDD VSS VSS gf180mcu_fd_sc_mcu7t5v0__fillcap_4
XFILLER_68_247 VDD VDD VSS VSS gf180mcu_fd_sc_mcu7t5v0__fillcap_4
XFILLER_96_523 VDD VDD VSS VSS gf180mcu_fd_sc_mcu7t5v0__fill_2
Xsignal_processor_y_inst__133_ signal_processor_y_inst__195_/B signal_processor_y_inst__199_/A2
+ VDD VDD VSS VSS gf180mcu_fd_sc_mcu7t5v0__clkinv_1
XTAP_TAPCELL_ROW_147_2296 VDD VSS gf180mcu_fd_sc_mcu7t5v0__filltie
Xinput5 rst_n input5/Z VDD VDD VSS VSS gf180mcu_fd_sc_mcu7t5v0__buf_1
XFILLER_65_976 VDD VDD VSS VSS gf180mcu_fd_sc_mcu7t5v0__fillcap_4
Xspi_regs_inst__0967_ spi_regs_inst__0967_/A1 spi_regs_inst__1353_/A2 spi_regs_inst__1195_/A2
+ spi_regs_inst__1494_/Q spi_regs_inst__1049_/A1 VDD VDD VSS VSS gf180mcu_fd_sc_mcu7t5v0__aoi22_1
XFILLER_36_177 VDD VDD VSS VSS gf180mcu_fd_sc_mcu7t5v0__fillcap_16
Xspi_regs_inst__0898_ spi_regs_inst__1626_/Q spi_regs_inst__0748_/Z spi_regs_inst__0939_/S
+ spi_regs_inst__0899_/A2 VDD VDD VSS VSS gf180mcu_fd_sc_mcu7t5v0__oai21_1
Xwave_controller_x_inst__2300_ wave_controller_x_inst__2298_/Z wave_controller_x_inst__2302_/A3
+ wave_controller_x_inst__2300_/Z VDD VDD VSS VSS gf180mcu_fd_sc_mcu7t5v0__xor2_1
Xwave_controller_x_inst__3280_ wave_controller_x_inst__3702_/Q spi_regs_inst__1542_/Q
+ wave_controller_x_inst__3283_/B VDD VDD VSS VSS gf180mcu_fd_sc_mcu7t5v0__xnor2_1
XFILLER_32_383 VDD VDD VSS VSS gf180mcu_fd_sc_mcu7t5v0__fill_2
Xwave_controller_x_inst__2231_ wave_controller_x_inst__2231_/A1 wave_controller_x_inst__2231_/A2
+ wave_controller_x_inst__2232_/A3 VDD VDD VSS VSS gf180mcu_fd_sc_mcu7t5v0__nor2_1
XFILLER_119_912 VDD VDD VSS VSS gf180mcu_fd_sc_mcu7t5v0__fillcap_64
Xwave_controller_x_inst__2162_ spi_regs_inst__1064_/A1 wave_controller_x_inst__2162_/A2
+ wave_controller_x_inst__2162_/B wave_controller_x_inst__2170_/A2 VDD VDD VSS VSS
+ gf180mcu_fd_sc_mcu7t5v0__aoi21_1
Xspi_regs_inst__1519_ spi_regs_inst__1519_/D fanout588/Z clkload22/I spi_regs_inst__1519_/Q
+ VDD VDD VSS VSS gf180mcu_fd_sc_mcu7t5v0__dffrnq_1
XFILLER_106_606 VDD VDD VSS VSS gf180mcu_fd_sc_mcu7t5v0__fillcap_4
Xwave_controller_x_inst__2093_ wave_controller_x_inst__2072_/B wave_controller_x_inst__2107_/B
+ wave_controller_x_inst__2093_/A3 wave_controller_x_inst__2093_/B1 wave_controller_x_inst__2093_/B2
+ wave_controller_x_inst__2094_/A2 VDD VDD VSS VSS gf180mcu_fd_sc_mcu7t5v0__oai32_1
XFILLER_10_37 VDD VDD VSS VSS gf180mcu_fd_sc_mcu7t5v0__fillcap_64
XFILLER_69_1046 VDD VDD VSS VSS gf180mcu_fd_sc_mcu7t5v0__fillcap_4
XFILLER_126_37 VDD VDD VSS VSS gf180mcu_fd_sc_mcu7t5v0__fillcap_16
XFILLER_160_244 VDD VDD VSS VSS gf180mcu_fd_sc_mcu7t5v0__fill_1
XFILLER_160_277 VDD VDD VSS VSS gf180mcu_fd_sc_mcu7t5v0__fillcap_32
XTAP_TAPCELL_ROW_167_2628 VDD VSS gf180mcu_fd_sc_mcu7t5v0__filltie
XTAP_TAPCELL_ROW_167_2639 VDD VSS gf180mcu_fd_sc_mcu7t5v0__filltie
XTAP_TAPCELL_ROW_30_1_555 VDD VSS gf180mcu_fd_sc_mcu7t5v0__filltie
XFILLER_101_300 VDD VDD VSS VSS gf180mcu_fd_sc_mcu7t5v0__fillcap_8
XFILLER_99_394 VDD VDD VSS VSS gf180mcu_fd_sc_mcu7t5v0__fillcap_4
Xwave_controller_x_inst__2995_ wave_controller_x_inst__2998_/A2 wave_controller_x_inst__2994_/B
+ wave_controller_x_inst__2996_/A2 VDD VDD VSS VSS gf180mcu_fd_sc_mcu7t5v0__nand2_1
XFILLER_59_258 VDD VDD VSS VSS gf180mcu_fd_sc_mcu7t5v0__fillcap_16
XFILLER_87_556 VDD VDD VSS VSS gf180mcu_fd_sc_mcu7t5v0__fillcap_4
XFILLER_87_578 VDD VDD VSS VSS gf180mcu_fd_sc_mcu7t5v0__fillcap_4
Xwave_controller_y_inst__3701_ wave_controller_y_inst__3701_/D wave_controller_y_inst__3703_/RN
+ clkload20/I wave_controller_y_inst__3701_/Q VDD VDD VSS VSS gf180mcu_fd_sc_mcu7t5v0__dffrnq_1
Xwave_controller_y_inst__1962_ wave_controller_y_inst__1962_/A1 wave_controller_y_inst__1962_/A2
+ wave_controller_y_inst__1962_/B wave_controller_y_inst__1967_/A2 VDD VDD VSS VSS
+ gf180mcu_fd_sc_mcu7t5v0__aoi21_1
Xwave_controller_x_inst__1946_ wave_controller_x_inst__1946_/A1 wave_controller_x_inst__1945_/Z
+ wave_controller_x_inst__1946_/Z VDD VDD VSS VSS gf180mcu_fd_sc_mcu7t5v0__xor2_1
XFILLER_101_388 VDD VDD VSS VSS gf180mcu_fd_sc_mcu7t5v0__fill_2
XFILLER_56_943 VDD VDD VSS VSS gf180mcu_fd_sc_mcu7t5v0__fill_2
XFILLER_74_239 VDD VDD VSS VSS gf180mcu_fd_sc_mcu7t5v0__fillcap_4
XTAP_TAPCELL_ROW_87_1310 VDD VSS gf180mcu_fd_sc_mcu7t5v0__filltie
Xwave_controller_y_inst__1893_ wave_controller_y_inst__3692_/Q wave_controller_y_inst__3420_/A1
+ VDD VDD VSS VSS gf180mcu_fd_sc_mcu7t5v0__clkinv_1
XFILLER_27_133 VDD VDD VSS VSS gf180mcu_fd_sc_mcu7t5v0__fillcap_4
XFILLER_71_902 VDD VDD VSS VSS gf180mcu_fd_sc_mcu7t5v0__fill_1
Xwave_controller_y_inst__3632_ wave_controller_y_inst__3632_/D wave_controller_y_inst__3703_/RN
+ clkload20/I max_cap433/I VDD VDD VSS VSS gf180mcu_fd_sc_mcu7t5v0__dffrnq_1
Xwave_controller_x_inst__3616_ wave_controller_x_inst__3616_/D fanout596/Z clkbuf_leaf_19_clk/Z
+ wave_controller_x_inst__3616_/Q VDD VDD VSS VSS gf180mcu_fd_sc_mcu7t5v0__dffrnq_1
Xwave_controller_x_inst__1877_ max_cap465/I wave_controller_x_inst__3521_/B2 VDD VDD
+ VSS VSS gf180mcu_fd_sc_mcu7t5v0__clkinv_1
XFILLER_71_924 VDD VDD VSS VSS gf180mcu_fd_sc_mcu7t5v0__fillcap_4
XFILLER_76_1017 VDD VDD VSS VSS gf180mcu_fd_sc_mcu7t5v0__fillcap_64
XTAP_TAPCELL_ROW_66_960 VDD VSS gf180mcu_fd_sc_mcu7t5v0__filltie
XTAP_TAPCELL_ROW_66_971 VDD VSS gf180mcu_fd_sc_mcu7t5v0__filltie
Xwave_controller_y_inst__3563_ wave_controller_y_inst__3596_/I0 max_cap429/Z wave_controller_y_inst_wire48/Z
+ wave_controller_y_inst__3651_/D VDD VDD VSS VSS gf180mcu_fd_sc_mcu7t5v0__mux2_2
Xwave_controller_y_inst__2514_ wave_controller_y_inst__2488_/Z wave_controller_y_inst__2518_/A3
+ wave_controller_y_inst__2517_/B VDD VDD VSS VSS gf180mcu_fd_sc_mcu7t5v0__and2_1
Xwave_controller_x_inst__3547_ spi_regs_inst__1119_/A1 wave_controller_x_inst__3556_/A2
+ wave_controller_x_inst__3548_/A3 VDD VDD VSS VSS gf180mcu_fd_sc_mcu7t5v0__nor2_1
Xwave_controller_y_inst__3494_ wave_controller_y_inst__3494_/A1 wave_controller_y_inst__3494_/A2
+ wave_controller_y_inst__3520_/A2 VDD VDD VSS VSS gf180mcu_fd_sc_mcu7t5v0__nand2_1
Xwave_controller_x_inst__3478_ wave_controller_x_inst__3478_/I wave_controller_x_inst__3479_/B2
+ VDD VDD VSS VSS gf180mcu_fd_sc_mcu7t5v0__clkinv_1
Xsignal_processor_x_inst__222_ signal_processor_x_inst__222_/D fanout584/Z clkbuf_leaf_14_clk/Z
+ spi_regs_inst__1121_/B2 VDD VDD VSS VSS gf180mcu_fd_sc_mcu7t5v0__dffrnq_1
Xwave_controller_y_inst__2445_ wave_controller_y_inst__2774_/A1 wave_controller_y_inst__2443_/B
+ wave_controller_y_inst__2445_/A3 wave_controller_y_inst__2445_/Z VDD VDD VSS VSS
+ gf180mcu_fd_sc_mcu7t5v0__xor3_1
Xwave_controller_x_inst__2429_ wave_controller_x_inst__2443_/B wave_controller_x_inst__2429_/A2
+ wave_controller_x_inst__2430_/B VDD VDD VSS VSS gf180mcu_fd_sc_mcu7t5v0__nand2_1
Xsignal_processor_x_inst__153_ signal_processor_x_inst__252_/Q signal_processor_x_inst__230_/Q
+ signal_processor_x_inst__154_/A2 VDD VDD VSS VSS gf180mcu_fd_sc_mcu7t5v0__nor2_1
XFILLER_51_22 VDD VDD VSS VSS gf180mcu_fd_sc_mcu7t5v0__fillcap_16
Xwave_controller_y_inst__2376_ wave_controller_y_inst__2376_/A1 wave_controller_y_inst__2396_/A1
+ wave_controller_y_inst__2391_/A2 VDD VDD VSS VSS gf180mcu_fd_sc_mcu7t5v0__nor2_1
XFILLER_104_1151 VDD VDD VSS VSS gf180mcu_fd_sc_mcu7t5v0__fillcap_4
XFILLER_109_422 VDD VDD VSS VSS gf180mcu_fd_sc_mcu7t5v0__fill_2
XFILLER_167_22 VDD VDD VSS VSS gf180mcu_fd_sc_mcu7t5v0__fillcap_8
XFILLER_167_44 VDD VDD VSS VSS gf180mcu_fd_sc_mcu7t5v0__fill_1
XFILLER_51_66 VDD VDD VSS VSS gf180mcu_fd_sc_mcu7t5v0__fillcap_4
XFILLER_104_1173 VDD VDD VSS VSS gf180mcu_fd_sc_mcu7t5v0__fill_1
XFILLER_136_241 VDD VDD VSS VSS gf180mcu_fd_sc_mcu7t5v0__fillcap_4
XFILLER_164_561 VDD VDD VSS VSS gf180mcu_fd_sc_mcu7t5v0__fill_2
XFILLER_152_723 VDD VDD VSS VSS gf180mcu_fd_sc_mcu7t5v0__fillcap_8
XFILLER_164_594 VDD VDD VSS VSS gf180mcu_fd_sc_mcu7t5v0__fill_1
XTAP_TAPCELL_ROW_131_2031 VDD VSS gf180mcu_fd_sc_mcu7t5v0__filltie
XTAP_TAPCELL_ROW_131_2042 VDD VSS gf180mcu_fd_sc_mcu7t5v0__filltie
XTAP_TAPCELL_ROW_98_1494 VDD VSS gf180mcu_fd_sc_mcu7t5v0__filltie
XFILLER_152_745 VDD VDD VSS VSS gf180mcu_fd_sc_mcu7t5v0__fill_1
XFILLER_152_767 VDD VDD VSS VSS gf180mcu_fd_sc_mcu7t5v0__fill_1
XFILLER_124_469 VDD VDD VSS VSS gf180mcu_fd_sc_mcu7t5v0__fillcap_8
XFILLER_104_171 VDD VDD VSS VSS gf180mcu_fd_sc_mcu7t5v0__fillcap_4
XFILLER_105_694 VDD VDD VSS VSS gf180mcu_fd_sc_mcu7t5v0__fillcap_4
XFILLER_76_85 VDD VDD VSS VSS gf180mcu_fd_sc_mcu7t5v0__fillcap_4
XFILLER_78_589 VDD VDD VSS VSS gf180mcu_fd_sc_mcu7t5v0__fillcap_4
Xfanout591 fanout608/Z fanout591/Z VDD VDD VSS VSS gf180mcu_fd_sc_mcu7t5v0__dlyb_1
Xfanout580 fanout581/Z fanout580/Z VDD VDD VSS VSS gf180mcu_fd_sc_mcu7t5v0__dlyb_1
XFILLER_111_1122 VDD VDD VSS VSS gf180mcu_fd_sc_mcu7t5v0__fillcap_32
XFILLER_46_442 VDD VDD VSS VSS gf180mcu_fd_sc_mcu7t5v0__fillcap_4
XFILLER_93_548 VDD VDD VSS VSS gf180mcu_fd_sc_mcu7t5v0__fill_2
Xspi_regs_inst__0821_ spi_regs_inst__1416_/I0 spi_regs_inst__1564_/Q spi_regs_inst__0824_/S
+ spi_regs_inst__1564_/D VDD VDD VSS VSS gf180mcu_fd_sc_mcu7t5v0__mux2_2
XFILLER_18_144 VDD VDD VSS VSS gf180mcu_fd_sc_mcu7t5v0__fillcap_4
XFILLER_18_177 VDD VDD VSS VSS gf180mcu_fd_sc_mcu7t5v0__fill_2
Xspi_regs_inst__0752_ spi_regs_inst__0901_/A1 spi_regs_inst__0889_/B spi_regs_inst__0753_/I
+ VDD VDD VSS VSS gf180mcu_fd_sc_mcu7t5v0__nor2_1
XFILLER_46_497 VDD VDD VSS VSS gf180mcu_fd_sc_mcu7t5v0__fillcap_4
XFILLER_159_300 VDD VDD VSS VSS gf180mcu_fd_sc_mcu7t5v0__fill_1
XFILLER_33_158 VDD VDD VSS VSS gf180mcu_fd_sc_mcu7t5v0__fillcap_4
XFILLER_61_478 VDD VDD VSS VSS gf180mcu_fd_sc_mcu7t5v0__fill_1
XPHY_EDGE_ROW_54_Left_221 VDD VSS gf180mcu_fd_sc_mcu7t5v0__endcap
Xspi_regs_inst__1304_ spi_regs_inst__1555_/Q spi_regs_inst__1304_/A2 spi_regs_inst_wire207/Z
+ fanout523/Z spi_regs_inst__1304_/C1 spi_regs_inst__1589_/Q spi_regs_inst__1307_/A2
+ VDD VDD VSS VSS gf180mcu_fd_sc_mcu7t5v0__aoi222_1
XFILLER_162_509 VDD VDD VSS VSS gf180mcu_fd_sc_mcu7t5v0__fill_2
Xspi_regs_inst__1235_ spi_regs_inst_wire185/Z spi_regs_inst__1336_/B1 spi_regs_inst_wire231/Z
+ max_cap426/Z spi_regs_inst__1237_/A3 VDD VDD VSS VSS gf180mcu_fd_sc_mcu7t5v0__aoi22_1
XFILLER_155_594 VDD VDD VSS VSS gf180mcu_fd_sc_mcu7t5v0__fillcap_8
XFILLER_131_907 VDD VDD VSS VSS gf180mcu_fd_sc_mcu7t5v0__fill_2
XFILLER_143_767 VDD VDD VSS VSS gf180mcu_fd_sc_mcu7t5v0__fill_2
Xspi_regs_inst__1166_ max_cap461/Z spi_regs_inst_wire240/Z spi_regs_inst__1342_/B1
+ spi_regs_inst__1166_/B2 spi_regs_inst__1170_/A1 VDD VDD VSS VSS gf180mcu_fd_sc_mcu7t5v0__aoi22_1
XFILLER_130_417 VDD VDD VSS VSS gf180mcu_fd_sc_mcu7t5v0__fillcap_16
XFILLER_44_2 VDD VDD VSS VSS gf180mcu_fd_sc_mcu7t5v0__fillcap_32
Xspi_regs_inst__1097_ spi_regs_inst__1097_/A1 spi_regs_inst__1343_/A2 spi_regs_inst__1332_/B1
+ fanout530/Z spi_regs_inst__1114_/A2 VDD VDD VSS VSS gf180mcu_fd_sc_mcu7t5v0__aoi22_1
XFILLER_116_1011 VDD VDD VSS VSS gf180mcu_fd_sc_mcu7t5v0__fillcap_4
XPHY_EDGE_ROW_63_Left_230 VDD VSS gf180mcu_fd_sc_mcu7t5v0__endcap
XTAP_TAPCELL_ROW_149_2336 VDD VSS gf180mcu_fd_sc_mcu7t5v0__filltie
XFILLER_57_707 VDD VDD VSS VSS gf180mcu_fd_sc_mcu7t5v0__fill_1
Xwave_controller_x_inst__2780_ max_cap464/Z wave_controller_x_inst__2793_/S wave_controller_x_inst__2781_/B
+ VDD VDD VSS VSS gf180mcu_fd_sc_mcu7t5v0__nand2_1
Xwave_controller_x_inst__1800_ state_machine_inst__34_/A1 wave_controller_x_inst__3098_/B
+ VDD VDD VSS VSS gf180mcu_fd_sc_mcu7t5v0__clkinv_1
XFILLER_110_174 VDD VDD VSS VSS gf180mcu_fd_sc_mcu7t5v0__fill_1
Xsignal_processor_y_inst__116_ fanout389/Z wave_controller_y_inst__3616_/Q signal_processor_y_inst__253_/D
+ VDD VDD VSS VSS gf180mcu_fd_sc_mcu7t5v0__and2_1
XFILLER_84_548 VDD VDD VSS VSS gf180mcu_fd_sc_mcu7t5v0__fill_1
XTAP_TAPCELL_ROW_162_2547 VDD VSS gf180mcu_fd_sc_mcu7t5v0__filltie
XTAP_TAPCELL_ROW_162_2558 VDD VSS gf180mcu_fd_sc_mcu7t5v0__filltie
XFILLER_52_401 VDD VDD VSS VSS gf180mcu_fd_sc_mcu7t5v0__fillcap_16
XTAP_TAPCELL_ROW_127_1966 VDD VSS gf180mcu_fd_sc_mcu7t5v0__filltie
XTAP_TAPCELL_ROW_127_1977 VDD VSS gf180mcu_fd_sc_mcu7t5v0__filltie
Xwave_controller_x_inst__3401_ wave_controller_x_inst__3401_/A1 wave_controller_x_inst__3401_/A2
+ wave_controller_x_inst__3401_/B wave_controller_x_inst__3401_/C wave_controller_x_inst__3403_/A3
+ VDD VDD VSS VSS gf180mcu_fd_sc_mcu7t5v0__aoi211_1
XFILLER_52_467 VDD VDD VSS VSS gf180mcu_fd_sc_mcu7t5v0__fill_1
Xwave_controller_x_inst__3332_ wave_controller_x_inst__1781_/I wave_controller_x_inst__3332_/A2
+ wave_controller_x_inst__3318_/Z wave_controller_x_inst__3332_/B2 wave_controller_x_inst__3332_/C
+ wave_controller_x_inst__3345_/A2 VDD VDD VSS VSS gf180mcu_fd_sc_mcu7t5v0__aoi221_1
Xwave_controller_x_inst__3263_ wave_controller_x_inst__3719_/Q spi_regs_inst__1538_/Q
+ wave_controller_x_inst__3337_/B VDD VDD VSS VSS gf180mcu_fd_sc_mcu7t5v0__xor2_1
XFILLER_138_517 VDD VDD VSS VSS gf180mcu_fd_sc_mcu7t5v0__fillcap_8
Xwave_controller_y_inst__2230_ wave_controller_y_inst__2248_/C1 wave_controller_y_inst__2229_/Z
+ wave_controller_y_inst__2250_/A1 VDD VDD VSS VSS gf180mcu_fd_sc_mcu7t5v0__nand2_1
Xwave_controller_x_inst__2214_ wave_controller_x_inst__2212_/Z wave_controller_x_inst_wire118/Z
+ wave_controller_x_inst__2231_/A2 VDD VDD VSS VSS gf180mcu_fd_sc_mcu7t5v0__nor2_1
Xwave_controller_x_inst__3194_ wave_controller_x_inst__3194_/A1 wave_controller_x_inst__3194_/A2
+ wave_controller_x_inst__3194_/B wave_controller_x_inst__3253_/A2 VDD VDD VSS VSS
+ gf180mcu_fd_sc_mcu7t5v0__aoi21_1
XFILLER_118_241 VDD VDD VSS VSS gf180mcu_fd_sc_mcu7t5v0__fillcap_4
Xwave_controller_y_inst__2161_ spi_regs_inst__1065_/B2 wave_controller_y_inst__2163_/B
+ wave_controller_y_inst__2164_/A2 VDD VDD VSS VSS gf180mcu_fd_sc_mcu7t5v0__nor2_1
Xwave_controller_x_inst__2145_ wave_controller_x_inst__2124_/B wave_controller_x_inst__2145_/I1
+ wave_controller_x_inst__2145_/S wave_controller_x_inst__2145_/Z VDD VDD VSS VSS
+ gf180mcu_fd_sc_mcu7t5v0__mux2_2
XFILLER_134_723 VDD VDD VSS VSS gf180mcu_fd_sc_mcu7t5v0__fillcap_4
XFILLER_137_36 VDD VDD VSS VSS gf180mcu_fd_sc_mcu7t5v0__fillcap_32
XFILLER_4_519 VDD VDD VSS VSS gf180mcu_fd_sc_mcu7t5v0__fillcap_4
Xwave_controller_y_inst__2092_ wave_controller_y_inst__2092_/A1 wave_controller_y_inst__2092_/A2
+ wave_controller_y_inst__2092_/B wave_controller_y_inst__2108_/B wave_controller_y_inst__2093_/B2
+ VDD VDD VSS VSS gf180mcu_fd_sc_mcu7t5v0__aoi211_1
Xwave_controller_x_inst__2076_ wave_controller_x_inst__2076_/A1 wave_controller_x_inst__2074_/Z
+ wave_controller_x_inst__2091_/A2 wave_controller_x_inst__2098_/C wave_controller_x_inst__2081_/B
+ VDD VDD VSS VSS gf180mcu_fd_sc_mcu7t5v0__oai31_1
XFILLER_134_745 VDD VDD VSS VSS gf180mcu_fd_sc_mcu7t5v0__fill_2
XFILLER_146_594 VDD VDD VSS VSS gf180mcu_fd_sc_mcu7t5v0__fill_1
XFILLER_161_531 VDD VDD VSS VSS gf180mcu_fd_sc_mcu7t5v0__fillcap_8
XFILLER_97_29 VDD VDD VSS VSS gf180mcu_fd_sc_mcu7t5v0__fill_2
XFILLER_121_417 VDD VDD VSS VSS gf180mcu_fd_sc_mcu7t5v0__fill_2
XFILLER_133_244 VDD VDD VSS VSS gf180mcu_fd_sc_mcu7t5v0__fillcap_4
XFILLER_88_843 VDD VDD VSS VSS gf180mcu_fd_sc_mcu7t5v0__fillcap_16
XFILLER_102_664 VDD VDD VSS VSS gf180mcu_fd_sc_mcu7t5v0__fill_1
XFILLER_82_1087 VDD VDD VSS VSS gf180mcu_fd_sc_mcu7t5v0__fillcap_64
Xwave_controller_y_inst__2994_ wave_controller_y_inst__2994_/A1 wave_controller_y_inst__3077_/A2
+ wave_controller_y_inst__2994_/B wave_controller_y_inst__3079_/A1 VDD VDD VSS VSS
+ gf180mcu_fd_sc_mcu7t5v0__oai21_1
Xwave_controller_y_inst__1945_ wave_controller_y_inst__1945_/A1 spi_regs_inst__1561_/Q
+ wave_controller_y_inst__1945_/Z VDD VDD VSS VSS gf180mcu_fd_sc_mcu7t5v0__xor2_1
Xwave_controller_x_inst__2978_ wave_controller_x_inst__3061_/A1 wave_controller_x_inst__2977_/Z
+ wave_controller_x_inst__2979_/B VDD VDD VSS VSS gf180mcu_fd_sc_mcu7t5v0__nand2_1
XFILLER_75_559 VDD VDD VSS VSS gf180mcu_fd_sc_mcu7t5v0__fill_1
Xwave_controller_x_inst__1929_ wave_controller_x_inst__1929_/A1 wave_controller_x_inst__1929_/A2
+ wave_controller_x_inst__1930_/C VDD VDD VSS VSS gf180mcu_fd_sc_mcu7t5v0__nor2_1
XFILLER_62_209 VDD VDD VSS VSS gf180mcu_fd_sc_mcu7t5v0__fillcap_8
Xwave_controller_y_inst__3615_ wave_controller_y_inst__3615_/D fanout545/Z clkload1/I
+ wave_controller_y_inst__3615_/Q VDD VDD VSS VSS gf180mcu_fd_sc_mcu7t5v0__dffrnq_1
Xwave_controller_y_inst__1876_ spi_regs_inst__1343_/A1 wave_controller_y_inst__3518_/B2
+ VDD VDD VSS VSS gf180mcu_fd_sc_mcu7t5v0__clkinv_1
Xwave_controller_x_inst_hold691 wave_controller_x_inst__3734_/Q wave_controller_x_inst__3724_/D
+ VDD VDD VSS VSS gf180mcu_fd_sc_mcu7t5v0__dlyc_1
XFILLER_102_61 VDD VDD VSS VSS gf180mcu_fd_sc_mcu7t5v0__fill_2
XFILLER_15_158 VDD VDD VSS VSS gf180mcu_fd_sc_mcu7t5v0__fill_2
XFILLER_71_765 VDD VDD VSS VSS gf180mcu_fd_sc_mcu7t5v0__fillcap_4
Xwave_controller_y_inst__3546_ wave_controller_y_inst__3718_/Q wave_controller_y_inst__3555_/A2
+ wave_controller_y_inst__3548_/A2 VDD VDD VSS VSS gf180mcu_fd_sc_mcu7t5v0__nor2_1
XFILLER_43_489 VDD VDD VSS VSS gf180mcu_fd_sc_mcu7t5v0__fill_1
Xwave_controller_y_inst__3477_ wave_controller_y_inst__3479_/A1 wave_controller_y_inst__3493_/A1
+ wave_controller_y_inst__3477_/B wave_controller_y_inst__3478_/I VDD VDD VSS VSS
+ gf180mcu_fd_sc_mcu7t5v0__oai21_1
Xsignal_processor_x_inst__205_ signal_processor_x_inst__211_/A1 signal_processor_x_inst__158_/Z
+ signal_processor_x_inst__205_/B signal_processor_x_inst__221_/D VDD VDD VSS VSS
+ gf180mcu_fd_sc_mcu7t5v0__oai21_1
XFILLER_156_303 VDD VDD VSS VSS gf180mcu_fd_sc_mcu7t5v0__fill_2
XFILLER_23_191 VDD VDD VSS VSS gf180mcu_fd_sc_mcu7t5v0__fill_2
XPHY_EDGE_ROW_42_1_Right_41 VDD VSS gf180mcu_fd_sc_mcu7t5v0__endcap
Xwave_controller_y_inst__2428_ spi_regs_inst__1150_/A1 wave_controller_y_inst__2426_/Z
+ wave_controller_y_inst__2429_/A2 VDD VDD VSS VSS gf180mcu_fd_sc_mcu7t5v0__nand2_1
Xsignal_processor_x_inst__136_ signal_processor_x_inst__248_/Q signal_processor_x_inst__235_/Q
+ signal_processor_x_inst__161_/A2 signal_processor_x_inst__129_/Z signal_processor_x_inst__175_/A2
+ VDD VDD VSS VSS gf180mcu_fd_sc_mcu7t5v0__nand4_1
XFILLER_156_369 VDD VDD VSS VSS gf180mcu_fd_sc_mcu7t5v0__fill_2
Xwave_controller_y_inst__2359_ wave_controller_y_inst__2359_/I wave_controller_y_inst__2375_/A2
+ VDD VDD VSS VSS gf180mcu_fd_sc_mcu7t5v0__clkinv_1
XFILLER_152_531 VDD VDD VSS VSS gf180mcu_fd_sc_mcu7t5v0__fill_2
Xspi_regs_inst__1020_ spi_regs_inst__1021_/A1 spi_regs_inst__1027_/A2 spi_regs_inst__1141_/B1
+ VDD VDD VSS VSS gf180mcu_fd_sc_mcu7t5v0__nor2_1
XFILLER_112_417 VDD VDD VSS VSS gf180mcu_fd_sc_mcu7t5v0__fillcap_4
XFILLER_124_266 VDD VDD VSS VSS gf180mcu_fd_sc_mcu7t5v0__fillcap_8
XFILLER_98_629 VDD VDD VSS VSS gf180mcu_fd_sc_mcu7t5v0__fillcap_16
XTAP_TAPCELL_ROW_111_1701 VDD VSS gf180mcu_fd_sc_mcu7t5v0__filltie
XTAP_TAPCELL_ROW_111_1712 VDD VSS gf180mcu_fd_sc_mcu7t5v0__filltie
XFILLER_112_439 VDD VDD VSS VSS gf180mcu_fd_sc_mcu7t5v0__fill_1
XFILLER_152_586 VDD VDD VSS VSS gf180mcu_fd_sc_mcu7t5v0__fill_1
XFILLER_61_1116 VDD VDD VSS VSS gf180mcu_fd_sc_mcu7t5v0__fillcap_4
XFILLER_120_450 VDD VDD VSS VSS gf180mcu_fd_sc_mcu7t5v0__fillcap_4
XFILLER_78_397 VDD VDD VSS VSS gf180mcu_fd_sc_mcu7t5v0__fill_1
XFILLER_79_898 VDD VDD VSS VSS gf180mcu_fd_sc_mcu7t5v0__fillcap_8
XTAP_TAPCELL_ROW_144_2255 VDD VSS gf180mcu_fd_sc_mcu7t5v0__filltie
XFILLER_19_464 VDD VDD VSS VSS gf180mcu_fd_sc_mcu7t5v0__fill_1
XFILLER_19_475 VDD VDD VSS VSS gf180mcu_fd_sc_mcu7t5v0__fillcap_8
Xspi_regs_inst__0804_ spi_regs_inst__1410_/I1 spi_regs_inst__1554_/Q spi_regs_inst__0806_/S
+ spi_regs_inst__1554_/D VDD VDD VSS VSS gf180mcu_fd_sc_mcu7t5v0__mux2_2
XTAP_TAPCELL_ROW_109_1674 VDD VSS gf180mcu_fd_sc_mcu7t5v0__filltie
XFILLER_34_467 VDD VDD VSS VSS gf180mcu_fd_sc_mcu7t5v0__fill_2
Xspi_regs_inst__0735_ spi_regs_inst__1628_/Q spi_regs_inst__1364_/A1 VDD VDD VSS VSS
+ gf180mcu_fd_sc_mcu7t5v0__clkinv_1
Xspi_regs_inst_max_cap281 spi_regs_inst__1341_/A2 spi_regs_inst__1314_/A2 VDD VDD
+ VSS VSS gf180mcu_fd_sc_mcu7t5v0__buf_2
Xspi_regs_inst_max_cap270 spi_regs_inst__1251_/A2 spi_regs_inst__1207_/B1 VDD VDD
+ VSS VSS gf180mcu_fd_sc_mcu7t5v0__buf_2
XFILLER_14_191 VDD VDD VSS VSS gf180mcu_fd_sc_mcu7t5v0__fill_2
XTAP_TAPCELL_ROW_122_1885 VDD VSS gf180mcu_fd_sc_mcu7t5v0__filltie
XTAP_TAPCELL_ROW_122_1896 VDD VSS gf180mcu_fd_sc_mcu7t5v0__filltie
Xspi_regs_inst_max_cap292 spi_regs_inst__1136_/A2 spi_regs_inst__1246_/A2 VDD VDD
+ VSS VSS gf180mcu_fd_sc_mcu7t5v0__buf_2
XFILLER_159_174 VDD VDD VSS VSS gf180mcu_fd_sc_mcu7t5v0__fillcap_16
XFILLER_122_1081 VDD VDD VSS VSS gf180mcu_fd_sc_mcu7t5v0__fillcap_4
XFILLER_162_317 VDD VDD VSS VSS gf180mcu_fd_sc_mcu7t5v0__fillcap_4
XFILLER_143_542 VDD VDD VSS VSS gf180mcu_fd_sc_mcu7t5v0__fillcap_16
XFILLER_157_1122 VDD VDD VSS VSS gf180mcu_fd_sc_mcu7t5v0__fillcap_32
Xspi_regs_inst__1218_ spi_regs_inst__1218_/A1 spi_regs_inst__1353_/A2 spi_regs_inst_wire254/Z
+ spi_regs_inst__1581_/Q spi_regs_inst__1219_/A4 VDD VDD VSS VSS gf180mcu_fd_sc_mcu7t5v0__aoi22_1
Xspi_regs_inst__1149_ spi_regs_inst__1551_/Q spi_regs_inst__1356_/A2 spi_regs_inst__1322_/A2
+ spi_regs_inst_wire106/Z spi_regs_inst__1152_/A2 VDD VDD VSS VSS gf180mcu_fd_sc_mcu7t5v0__aoi22_1
Xwave_controller_x_inst__2901_ wave_controller_x_inst__3465_/B wave_controller_x_inst__3419_/B
+ wave_controller_x_inst__2908_/A1 wave_controller_x_inst__2902_/B1 VDD VDD VSS VSS
+ gf180mcu_fd_sc_mcu7t5v0__nand3_1
XFILLER_130_258 VDD VDD VSS VSS gf180mcu_fd_sc_mcu7t5v0__fillcap_16
XFILLER_97_662 VDD VDD VSS VSS gf180mcu_fd_sc_mcu7t5v0__fillcap_8
Xwave_controller_x_inst__2832_ wave_controller_x_inst__3266_/A1 wave_controller_x_inst__2834_/A2
+ wave_controller_x_inst__2833_/A2 wave_controller_x_inst__3265_/A1 wave_controller_x_inst__2834_/B
+ VDD VDD VSS VSS gf180mcu_fd_sc_mcu7t5v0__oai22_1
XFILLER_84_312 VDD VDD VSS VSS gf180mcu_fd_sc_mcu7t5v0__fill_2
Xwave_controller_x_inst__2763_ _09_/A2 _10_/A2 wave_controller_x_inst__3081_/C wave_controller_x_inst__3008_/A2
+ VDD VDD VSS VSS gf180mcu_fd_sc_mcu7t5v0__nor3_1
Xwave_controller_x_inst__2694_ wave_controller_x_inst__2694_/A1 wave_controller_x_inst__2694_/A2
+ wave_controller_x_inst__2693_/B wave_controller_x_inst__2694_/Z VDD VDD VSS VSS
+ gf180mcu_fd_sc_mcu7t5v0__and3_1
XFILLER_65_570 VDD VDD VSS VSS gf180mcu_fd_sc_mcu7t5v0__fill_2
XFILLER_52_220 VDD VDD VSS VSS gf180mcu_fd_sc_mcu7t5v0__fillcap_4
XTAP_TAPCELL_ROW_15_1_444 VDD VSS gf180mcu_fd_sc_mcu7t5v0__filltie
Xwave_controller_y_inst__3400_ wave_controller_y_inst__3400_/A1 wave_controller_y_inst__3348_/Z
+ wave_controller_y_inst__3400_/B wave_controller_y_inst__3400_/C wave_controller_y_inst__3401_/C
+ VDD VDD VSS VSS gf180mcu_fd_sc_mcu7t5v0__oai211_1
XFILLER_52_286 VDD VDD VSS VSS gf180mcu_fd_sc_mcu7t5v0__fillcap_16
Xwave_controller_y_inst__3331_ wave_controller_y_inst__3333_/B wave_controller_y_inst__3332_/C
+ VDD VDD VSS VSS gf180mcu_fd_sc_mcu7t5v0__clkinv_1
XFILLER_139_815 VDD VDD VSS VSS gf180mcu_fd_sc_mcu7t5v0__fill_2
XFILLER_40_448 VDD VDD VSS VSS gf180mcu_fd_sc_mcu7t5v0__fillcap_4
Xwave_controller_x_inst__3315_ wave_controller_x_inst__3315_/A1 wave_controller_x_inst__3355_/A1
+ wave_controller_x_inst__3359_/A1 wave_controller_x_inst__3315_/Z VDD VDD VSS VSS
+ gf180mcu_fd_sc_mcu7t5v0__and3_1
XFILLER_138_314 VDD VDD VSS VSS gf180mcu_fd_sc_mcu7t5v0__fill_1
XFILLER_139_848 VDD VDD VSS VSS gf180mcu_fd_sc_mcu7t5v0__fill_1
Xwave_controller_y_inst__3262_ wave_controller_y_inst__3262_/A1 spi_regs_inst__1617_/Q
+ wave_controller_y_inst__3341_/C VDD VDD VSS VSS gf180mcu_fd_sc_mcu7t5v0__xor2_1
Xwave_controller_x_inst__3246_ fanout534/I wave_controller_x_inst__3196_/Z wave_controller_x_inst__3246_/B1
+ wave_controller_x_inst__3246_/B2 wave_controller_x_inst__3254_/A1 VDD VDD VSS VSS
+ gf180mcu_fd_sc_mcu7t5v0__oai22_1
XFILLER_154_807 VDD VDD VSS VSS gf180mcu_fd_sc_mcu7t5v0__fillcap_64
XFILLER_166_667 VDD VDD VSS VSS gf180mcu_fd_sc_mcu7t5v0__fillcap_64
Xwave_controller_y_inst__3193_ wave_controller_y_inst__3194_/A1 wave_controller_y_inst__3194_/A2
+ wave_controller_y_inst__3194_/B wave_controller_y_inst__3193_/Z VDD VDD VSS VSS
+ gf180mcu_fd_sc_mcu7t5v0__and3_1
Xwave_controller_y_inst__2213_ wave_controller_y_inst__2186_/I wave_controller_y_inst__2213_/A2
+ wave_controller_y_inst__2213_/A3 wave_controller_y_inst__2213_/B wave_controller_y_inst_wire111/I
+ VDD VDD VSS VSS gf180mcu_fd_sc_mcu7t5v0__oai31_1
Xwave_controller_x_inst__3177_ wave_controller_x_inst__1778_/I spi_regs_inst__1515_/Q
+ wave_controller_x_inst__3248_/B VDD VDD VSS VSS gf180mcu_fd_sc_mcu7t5v0__xor2_1
XFILLER_119_550 VDD VDD VSS VSS gf180mcu_fd_sc_mcu7t5v0__fill_1
XFILLER_148_57 VDD VDD VSS VSS gf180mcu_fd_sc_mcu7t5v0__fill_1
XFILLER_153_328 VDD VDD VSS VSS gf180mcu_fd_sc_mcu7t5v0__fillcap_4
Xwave_controller_y_inst__2144_ wave_controller_y_inst__2058_/C wave_controller_y_inst__2144_/A2
+ wave_controller_y_inst__2144_/B wave_controller_y_inst__2145_/S VDD VDD VSS VSS
+ gf180mcu_fd_sc_mcu7t5v0__oai21_1
XFILLER_101_1154 VDD VDD VSS VSS gf180mcu_fd_sc_mcu7t5v0__fillcap_16
Xwave_controller_x_inst__2128_ wave_controller_x_inst__2058_/C wave_controller_x_inst__2128_/A2
+ wave_controller_x_inst__2137_/A2 wave_controller_x_inst__2129_/B VDD VDD VSS VSS
+ gf180mcu_fd_sc_mcu7t5v0__nand3_1
XTAP_TAPCELL_ROW_95_1442 VDD VSS gf180mcu_fd_sc_mcu7t5v0__filltie
XFILLER_106_244 VDD VDD VSS VSS gf180mcu_fd_sc_mcu7t5v0__fill_1
XFILLER_164_34 VDD VDD VSS VSS gf180mcu_fd_sc_mcu7t5v0__fill_1
Xwave_controller_y_inst__2075_ wave_controller_y_inst__2079_/B wave_controller_y_inst__2069_/Z
+ wave_controller_y_inst__2091_/A2 VDD VDD VSS VSS gf180mcu_fd_sc_mcu7t5v0__nor2_1
Xwave_controller_x_inst__2059_ wave_controller_x_inst__2114_/B wave_controller_x_inst__2125_/C
+ wave_controller_x_inst__2138_/A2 VDD VDD VSS VSS gf180mcu_fd_sc_mcu7t5v0__nor2_1
XFILLER_122_726 VDD VDD VSS VSS gf180mcu_fd_sc_mcu7t5v0__fill_1
XFILLER_122_737 VDD VDD VSS VSS gf180mcu_fd_sc_mcu7t5v0__fill_2
XFILLER_134_586 VDD VDD VSS VSS gf180mcu_fd_sc_mcu7t5v0__fill_1
XFILLER_134_597 VDD VDD VSS VSS gf180mcu_fd_sc_mcu7t5v0__fillcap_16
XFILLER_122_759 VDD VDD VSS VSS gf180mcu_fd_sc_mcu7t5v0__fillcap_8
Xwave_controller_y_inst__2977_ wave_controller_y_inst__3709_/Q wave_controller_y_inst__3212_/B
+ wave_controller_y_inst__2977_/Z VDD VDD VSS VSS gf180mcu_fd_sc_mcu7t5v0__xor2_1
Xwave_controller_x_inst_fanout378 wave_controller_x_inst__2079_/B wave_controller_x_inst__2114_/B
+ VDD VDD VSS VSS gf180mcu_fd_sc_mcu7t5v0__dlyb_1
XFILLER_35_209 VDD VDD VSS VSS gf180mcu_fd_sc_mcu7t5v0__fill_1
XFILLER_75_367 VDD VDD VSS VSS gf180mcu_fd_sc_mcu7t5v0__fill_2
Xwave_controller_y_inst__1928_ spi_regs_inst__1571_/Q wave_controller_y_inst__3305_/A1
+ wave_controller_y_inst__3305_/B2 spi_regs_inst__1570_/Q wave_controller_y_inst__1929_/A2
+ VDD VDD VSS VSS gf180mcu_fd_sc_mcu7t5v0__oai22_1
XFILLER_28_272 VDD VDD VSS VSS gf180mcu_fd_sc_mcu7t5v0__fillcap_8
Xwave_controller_y_inst__1859_ spi_regs_inst__1109_/B2 wave_controller_y_inst__2815_/A1
+ VDD VDD VSS VSS gf180mcu_fd_sc_mcu7t5v0__clkinv_1
XFILLER_31_415 VDD VDD VSS VSS gf180mcu_fd_sc_mcu7t5v0__fillcap_4
XFILLER_43_286 VDD VDD VSS VSS gf180mcu_fd_sc_mcu7t5v0__fill_1
XFILLER_71_562 VDD VDD VSS VSS gf180mcu_fd_sc_mcu7t5v0__fill_2
XPHY_EDGE_ROW_5_1_Right_4 VDD VSS gf180mcu_fd_sc_mcu7t5v0__endcap
XTAP_TAPCELL_ROW_54_760 VDD VSS gf180mcu_fd_sc_mcu7t5v0__filltie
XTAP_TAPCELL_ROW_54_771 VDD VSS gf180mcu_fd_sc_mcu7t5v0__filltie
XTAP_TAPCELL_ROW_104_1593 VDD VSS gf180mcu_fd_sc_mcu7t5v0__filltie
Xwave_controller_y_inst__3529_ spi_regs_inst__1216_/B2 wave_controller_y_inst__3529_/A2
+ wave_controller_y_inst__3530_/A3 VDD VDD VSS VSS gf180mcu_fd_sc_mcu7t5v0__nor2_1
Xwave_controller_x_inst_max_cap384 wave_controller_x_inst__3320_/A1 wave_controller_x_inst__3078_/A1
+ VDD VDD VSS VSS gf180mcu_fd_sc_mcu7t5v0__buf_4
Xwave_controller_x_inst_max_cap373 wave_controller_x_inst__2077_/A1 wave_controller_x_inst__2125_/B
+ VDD VDD VSS VSS gf180mcu_fd_sc_mcu7t5v0__clkbuf_2
XFILLER_11_150 VDD VDD VSS VSS gf180mcu_fd_sc_mcu7t5v0__fillcap_4
XFILLER_129_325 VDD VDD VSS VSS gf180mcu_fd_sc_mcu7t5v0__fill_1
XFILLER_106_1087 VDD VDD VSS VSS gf180mcu_fd_sc_mcu7t5v0__fillcap_64
XFILLER_129_358 VDD VDD VSS VSS gf180mcu_fd_sc_mcu7t5v0__fill_1
Xsignal_processor_x_inst__119_ signal_processor_x_inst__128_/A1 signal_processor_x_inst__255_/Q
+ signal_processor_x_inst__256_/D VDD VDD VSS VSS gf180mcu_fd_sc_mcu7t5v0__and2_1
XFILLER_144_317 VDD VDD VSS VSS gf180mcu_fd_sc_mcu7t5v0__fillcap_8
XFILLER_156_177 VDD VDD VSS VSS gf180mcu_fd_sc_mcu7t5v0__fillcap_4
XFILLER_98_61 VDD VDD VSS VSS gf180mcu_fd_sc_mcu7t5v0__fill_2
Xstate_machine_inst__33_ spi_regs_inst__1622_/Q state_machine_inst__28_/Z state_machine_inst__34_/B
+ VDD VDD VSS VSS gf180mcu_fd_sc_mcu7t5v0__nand2_1
Xspi_regs_inst__1003_ spi_regs_inst__1032_/A1 spi_regs_inst__1031_/A2 spi_regs_inst_wire242/I
+ VDD VDD VSS VSS gf180mcu_fd_sc_mcu7t5v0__nor2_1
XFILLER_112_203 VDD VDD VSS VSS gf180mcu_fd_sc_mcu7t5v0__fill_2
XFILLER_140_523 VDD VDD VSS VSS gf180mcu_fd_sc_mcu7t5v0__fill_2
XTAP_TAPCELL_ROW_32_1_569 VDD VSS gf180mcu_fd_sc_mcu7t5v0__filltie
XFILLER_112_247 VDD VDD VSS VSS gf180mcu_fd_sc_mcu7t5v0__fillcap_8
XFILLER_140_578 VDD VDD VSS VSS gf180mcu_fd_sc_mcu7t5v0__fillcap_16
XFILLER_39_548 VDD VDD VSS VSS gf180mcu_fd_sc_mcu7t5v0__fill_2
XFILLER_94_643 VDD VDD VSS VSS gf180mcu_fd_sc_mcu7t5v0__fillcap_4
XFILLER_19_250 VDD VDD VSS VSS gf180mcu_fd_sc_mcu7t5v0__fillcap_4
XFILLER_93_153 VDD VDD VSS VSS gf180mcu_fd_sc_mcu7t5v0__fill_1
XTAP_TAPCELL_ROW_124_1925 VDD VSS gf180mcu_fd_sc_mcu7t5v0__filltie
XFILLER_163_1170 VDD VDD VSS VSS gf180mcu_fd_sc_mcu7t5v0__fillcap_4
XTAP_TAPCELL_ROW_157_2468 VDD VSS gf180mcu_fd_sc_mcu7t5v0__filltie
Xwave_controller_x_inst__3100_ wave_controller_x_inst__3101_/A2 wave_controller_x_inst__3100_/A2
+ state_machine_inst__34_/A1 fanout498/Z wave_controller_x_inst__3101_/B VDD VDD VSS
+ VSS gf180mcu_fd_sc_mcu7t5v0__oai211_1
XFILLER_136_807 VDD VDD VSS VSS gf180mcu_fd_sc_mcu7t5v0__fill_2
XFILLER_147_122 VDD VDD VSS VSS gf180mcu_fd_sc_mcu7t5v0__fill_2
XFILLER_148_667 VDD VDD VSS VSS gf180mcu_fd_sc_mcu7t5v0__fillcap_8
XFILLER_30_492 VDD VDD VSS VSS gf180mcu_fd_sc_mcu7t5v0__fill_2
Xwave_controller_x_inst__3031_ wave_controller_x_inst__3697_/Q wave_controller_x_inst__3036_/B2
+ wave_controller_x_inst__3032_/A3 wave_controller_x_inst__3031_/B wave_controller_x_inst__3697_/D
+ VDD VDD VSS VSS gf180mcu_fd_sc_mcu7t5v0__oai31_1
XFILLER_128_391 VDD VDD VSS VSS gf180mcu_fd_sc_mcu7t5v0__fill_1
XFILLER_150_309 VDD VDD VSS VSS gf180mcu_fd_sc_mcu7t5v0__fillcap_4
XTAP_TAPCELL_ROW_77_1150 VDD VSS gf180mcu_fd_sc_mcu7t5v0__filltie
XFILLER_104_737 VDD VDD VSS VSS gf180mcu_fd_sc_mcu7t5v0__fillcap_8
XFILLER_143_372 VDD VDD VSS VSS gf180mcu_fd_sc_mcu7t5v0__fillcap_4
Xwave_controller_y_inst__2900_ wave_controller_y_inst__3557_/A1 wave_controller_y_inst__3424_/A2
+ wave_controller_y_inst__2909_/A3 wave_controller_y_inst__2908_/A1 VDD VDD VSS VSS
+ gf180mcu_fd_sc_mcu7t5v0__nor3_1
XFILLER_134_37 VDD VDD VSS VSS gf180mcu_fd_sc_mcu7t5v0__fillcap_8
XTAP_TAPCELL_ROW_90_1361 VDD VSS gf180mcu_fd_sc_mcu7t5v0__filltie
Xwave_controller_y_inst__2831_ wave_controller_y_inst__2831_/A1 wave_controller_y_inst__2831_/A2
+ wave_controller_y_inst__2831_/B wave_controller_y_inst__2833_/A2 VDD VDD VSS VSS
+ gf180mcu_fd_sc_mcu7t5v0__oai21_1
XFILLER_85_632 VDD VDD VSS VSS gf180mcu_fd_sc_mcu7t5v0__fillcap_4
XFILLER_97_492 VDD VDD VSS VSS gf180mcu_fd_sc_mcu7t5v0__fillcap_4
Xwave_controller_x_inst__2815_ wave_controller_x_inst__2815_/A1 wave_controller_x_inst__2793_/S
+ wave_controller_x_inst__2815_/B wave_controller_x_inst__2816_/I VDD VDD VSS VSS
+ gf180mcu_fd_sc_mcu7t5v0__oai21_1
XFILLER_17_209 VDD VDD VSS VSS gf180mcu_fd_sc_mcu7t5v0__fill_1
XPHY_EDGE_ROW_34_1_Left_201 VDD VSS gf180mcu_fd_sc_mcu7t5v0__endcap
Xwave_controller_y_inst__2762_ wave_controller_y_inst__2762_/I wave_controller_y_inst__3091_/A1
+ VDD VDD VSS VSS gf180mcu_fd_sc_mcu7t5v0__inv_1
Xwave_controller_x_inst__2746_ wave_controller_x_inst__2748_/A2 wave_controller_x_inst__2745_/Z
+ wave_controller_x_inst__2752_/C VDD VDD VSS VSS gf180mcu_fd_sc_mcu7t5v0__or2_1
XFILLER_72_326 VDD VDD VSS VSS gf180mcu_fd_sc_mcu7t5v0__fillcap_16
XFILLER_84_197 VDD VDD VSS VSS gf180mcu_fd_sc_mcu7t5v0__fillcap_4
Xwave_controller_y_inst__2693_ wave_controller_y_inst__2694_/A1 wave_controller_y_inst__2694_/A2
+ wave_controller_y_inst__2693_/B wave_controller_y_inst__2712_/C VDD VDD VSS VSS
+ gf180mcu_fd_sc_mcu7t5v0__aoi21_1
XFILLER_150_58 VDD VDD VSS VSS gf180mcu_fd_sc_mcu7t5v0__fill_2
Xwave_controller_x_inst__2677_ wave_controller_x_inst__2674_/Z wave_controller_x_inst__2678_/A2
+ wave_controller_x_inst__2677_/Z VDD VDD VSS VSS gf180mcu_fd_sc_mcu7t5v0__xor2_1
XFILLER_40_201 VDD VDD VSS VSS gf180mcu_fd_sc_mcu7t5v0__fill_1
XFILLER_53_562 VDD VDD VSS VSS gf180mcu_fd_sc_mcu7t5v0__fillcap_8
XFILLER_25_286 VDD VDD VSS VSS gf180mcu_fd_sc_mcu7t5v0__fill_2
XFILLER_40_234 VDD VDD VSS VSS gf180mcu_fd_sc_mcu7t5v0__fillcap_4
XFILLER_43_56 VDD VDD VSS VSS gf180mcu_fd_sc_mcu7t5v0__fillcap_8
XFILLER_139_612 VDD VDD VSS VSS gf180mcu_fd_sc_mcu7t5v0__fillcap_16
Xwave_controller_y_inst__3314_ wave_controller_y_inst__3358_/A2 wave_controller_y_inst__3358_/A3
+ wave_controller_y_inst__3314_/B wave_controller_y_inst__3359_/A1 VDD VDD VSS VSS
+ gf180mcu_fd_sc_mcu7t5v0__oai21_1
XFILLER_166_420 VDD VDD VSS VSS gf180mcu_fd_sc_mcu7t5v0__fillcap_32
XFILLER_167_954 VDD VDD VSS VSS gf180mcu_fd_sc_mcu7t5v0__fillcap_32
Xwave_controller_y_inst__3245_ wave_controller_y_inst__3245_/A1 wave_controller_y_inst__3245_/A2
+ wave_controller_y_inst__3243_/Z wave_controller_y_inst__3245_/B2 wave_controller_y_inst__3245_/C
+ wave_controller_y_inst__3246_/B2 VDD VDD VSS VSS gf180mcu_fd_sc_mcu7t5v0__aoi221_1
XFILLER_126_317 VDD VDD VSS VSS gf180mcu_fd_sc_mcu7t5v0__fillcap_16
XFILLER_127_818 VDD VDD VSS VSS gf180mcu_fd_sc_mcu7t5v0__fillcap_16
XFILLER_138_177 VDD VDD VSS VSS gf180mcu_fd_sc_mcu7t5v0__fill_2
XFILLER_21_492 VDD VDD VSS VSS gf180mcu_fd_sc_mcu7t5v0__fillcap_4
Xwave_controller_x_inst__3229_ fanout529/Z wave_controller_x_inst__3233_/B1 wave_controller_x_inst__3234_/B1
+ VDD VDD VSS VSS gf180mcu_fd_sc_mcu7t5v0__nor2_1
Xwave_controller_y_inst__3176_ wave_controller_y_inst__3081_/B spi_regs_inst__1578_/Q
+ wave_controller_y_inst__3249_/A2 VDD VDD VSS VSS gf180mcu_fd_sc_mcu7t5v0__nor2_1
Xwave_controller_y_inst__2127_ wave_controller_y_inst__2144_/A2 wave_controller_y_inst__2130_/A1
+ wave_controller_y_inst__2137_/A2 VDD VDD VSS VSS gf180mcu_fd_sc_mcu7t5v0__nor2_1
XPHY_EDGE_ROW_29_1_Left_196 VDD VSS gf180mcu_fd_sc_mcu7t5v0__endcap
Xwave_controller_y_inst__2058_ wave_controller_y_inst__2109_/B wave_controller_y_inst__2128_/A2
+ wave_controller_y_inst__2058_/B wave_controller_y_inst__2058_/C wave_controller_y_inst__2062_/A2
+ VDD VDD VSS VSS gf180mcu_fd_sc_mcu7t5v0__aoi211_1
Xspi_regs_inst_fanout610 spi_regs_inst__1648_/RN spi_regs_inst__1605_/RN VDD VDD VSS
+ VSS gf180mcu_fd_sc_mcu7t5v0__dlyb_1
XFILLER_89_982 VDD VDD VSS VSS gf180mcu_fd_sc_mcu7t5v0__fillcap_64
XFILLER_48_367 VDD VDD VSS VSS gf180mcu_fd_sc_mcu7t5v0__fill_1
XFILLER_75_142 VDD VDD VSS VSS gf180mcu_fd_sc_mcu7t5v0__fillcap_4
XFILLER_84_30 VDD VDD VSS VSS gf180mcu_fd_sc_mcu7t5v0__fillcap_4
XTAP_TAPCELL_ROW_141_2203 VDD VSS gf180mcu_fd_sc_mcu7t5v0__filltie
XTAP_TAPCELL_ROW_59_852 VDD VSS gf180mcu_fd_sc_mcu7t5v0__filltie
XTAP_TAPCELL_ROW_106_1622 VDD VSS gf180mcu_fd_sc_mcu7t5v0__filltie
XTAP_TAPCELL_ROW_106_1633 VDD VSS gf180mcu_fd_sc_mcu7t5v0__filltie
Xspi_regs_inst__1621_ spi_regs_inst__1621_/D fanout585/Z clkbuf_leaf_14_clk/Z fanout499/I
+ VDD VDD VSS VSS gf180mcu_fd_sc_mcu7t5v0__dffrnq_1
XFILLER_147_1154 VDD VDD VSS VSS gf180mcu_fd_sc_mcu7t5v0__fillcap_16
XFILLER_72_893 VDD VDD VSS VSS gf180mcu_fd_sc_mcu7t5v0__fillcap_4
Xspi_regs_inst__1552_ spi_regs_inst__1552_/D fanout592/Z clkload29/I spi_regs_inst__1552_/Q
+ VDD VDD VSS VSS gf180mcu_fd_sc_mcu7t5v0__dffrnq_1
XFILLER_31_212 VDD VDD VSS VSS gf180mcu_fd_sc_mcu7t5v0__fill_1
XFILLER_31_234 VDD VDD VSS VSS gf180mcu_fd_sc_mcu7t5v0__fillcap_16
Xspi_regs_inst__1483_ spi_regs_inst__1483_/D fanout564/Z clkbuf_leaf_7_clk/Z fanout513/I
+ VDD VDD VSS VSS gf180mcu_fd_sc_mcu7t5v0__dffrnq_1
XFILLER_118_807 VDD VDD VSS VSS gf180mcu_fd_sc_mcu7t5v0__fillcap_8
XTAP_TAPCELL_ROW_139_2165 VDD VSS gf180mcu_fd_sc_mcu7t5v0__filltie
XTAP_TAPCELL_ROW_139_2176 VDD VSS gf180mcu_fd_sc_mcu7t5v0__filltie
XFILLER_157_486 VDD VDD VSS VSS gf180mcu_fd_sc_mcu7t5v0__fillcap_4
XFILLER_145_659 VDD VDD VSS VSS gf180mcu_fd_sc_mcu7t5v0__fill_2
XFILLER_126_851 VDD VDD VSS VSS gf180mcu_fd_sc_mcu7t5v0__fillcap_16
XFILLER_67_1122 VDD VDD VSS VSS gf180mcu_fd_sc_mcu7t5v0__fillcap_32
XFILLER_99_702 VDD VDD VSS VSS gf180mcu_fd_sc_mcu7t5v0__fillcap_16
XTAP_TAPCELL_ROW_152_2387 VDD VSS gf180mcu_fd_sc_mcu7t5v0__filltie
XFILLER_99_746 VDD VDD VSS VSS gf180mcu_fd_sc_mcu7t5v0__fill_2
XFILLER_87_908 VDD VDD VSS VSS gf180mcu_fd_sc_mcu7t5v0__fill_2
XFILLER_101_718 VDD VDD VSS VSS gf180mcu_fd_sc_mcu7t5v0__fill_1
XFILLER_154_1169 VDD VDD VSS VSS gf180mcu_fd_sc_mcu7t5v0__fill_1
XFILLER_67_621 VDD VDD VSS VSS gf180mcu_fd_sc_mcu7t5v0__fillcap_8
XFILLER_67_632 VDD VDD VSS VSS gf180mcu_fd_sc_mcu7t5v0__fillcap_4
XFILLER_79_492 VDD VDD VSS VSS gf180mcu_fd_sc_mcu7t5v0__fillcap_4
XFILLER_55_827 VDD VDD VSS VSS gf180mcu_fd_sc_mcu7t5v0__fillcap_4
Xwave_controller_x_inst__2600_ max_cap464/Z wave_controller_x_inst__2599_/Z wave_controller_x_inst__2600_/Z
+ VDD VDD VSS VSS gf180mcu_fd_sc_mcu7t5v0__and2_1
XFILLER_67_698 VDD VDD VSS VSS gf180mcu_fd_sc_mcu7t5v0__fill_2
Xwave_controller_x_inst__3580_ wire454/I wave_controller_x_inst__3581_/A1 wave_controller_x_inst__3581_/B
+ VDD VDD VSS VSS gf180mcu_fd_sc_mcu7t5v0__nand2_1
XFILLER_70_819 VDD VDD VSS VSS gf180mcu_fd_sc_mcu7t5v0__fill_2
Xwave_controller_x_inst__2531_ wave_controller_x_inst__2789_/A1 spi_regs_inst__1332_/A1
+ wave_controller_x_inst__2555_/A2 VDD VDD VSS VSS gf180mcu_fd_sc_mcu7t5v0__nor2_1
XFILLER_63_882 VDD VDD VSS VSS gf180mcu_fd_sc_mcu7t5v0__fill_2
XTAP_TAPCELL_ROW_159_2508 VDD VSS gf180mcu_fd_sc_mcu7t5v0__filltie
Xwave_controller_x_inst__2462_ wave_controller_x_inst__2462_/A1 wave_controller_x_inst__2462_/A2
+ wave_controller_x_inst__2462_/B wave_controller_x_inst__2517_/A1 VDD VDD VSS VSS
+ gf180mcu_fd_sc_mcu7t5v0__aoi21_1
XFILLER_50_532 VDD VDD VSS VSS gf180mcu_fd_sc_mcu7t5v0__fillcap_16
Xwave_controller_x_inst__2393_ wave_controller_x_inst__2394_/A1 wave_controller_x_inst__2396_/C
+ wave_controller_x_inst__2389_/Z wave_controller_x_inst__2396_/A2 VDD VDD VSS VSS
+ gf180mcu_fd_sc_mcu7t5v0__nor3_1
XFILLER_167_206 VDD VDD VSS VSS gf180mcu_fd_sc_mcu7t5v0__fillcap_32
XFILLER_50_554 VDD VDD VSS VSS gf180mcu_fd_sc_mcu7t5v0__fill_1
XFILLER_108_317 VDD VDD VSS VSS gf180mcu_fd_sc_mcu7t5v0__fill_2
XFILLER_148_453 VDD VDD VSS VSS gf180mcu_fd_sc_mcu7t5v0__fill_2
XFILLER_149_976 VDD VDD VSS VSS gf180mcu_fd_sc_mcu7t5v0__fillcap_4
Xwave_controller_y_inst__3030_ wave_controller_y_inst__3697_/Q wave_controller_y_inst__3030_/A2
+ wave_controller_y_inst__3031_/B VDD VDD VSS VSS gf180mcu_fd_sc_mcu7t5v0__nand2_1
XFILLER_108_328 VDD VDD VSS VSS gf180mcu_fd_sc_mcu7t5v0__fillcap_8
XFILLER_135_125 VDD VDD VSS VSS gf180mcu_fd_sc_mcu7t5v0__fillcap_8
Xwave_controller_x_inst__3014_ wave_controller_x_inst__2910_/B wave_controller_x_inst__3017_/A2
+ wave_controller_x_inst__3015_/B1 VDD VDD VSS VSS gf180mcu_fd_sc_mcu7t5v0__nand2_1
XTAP_TAPCELL_ROW_75_1109 VDD VSS gf180mcu_fd_sc_mcu7t5v0__filltie
XTAP_TAPCELL_ROW_92_1401 VDD VSS gf180mcu_fd_sc_mcu7t5v0__filltie
XFILLER_116_350 VDD VDD VSS VSS gf180mcu_fd_sc_mcu7t5v0__fillcap_32
XFILLER_145_36 VDD VDD VSS VSS gf180mcu_fd_sc_mcu7t5v0__fill_2
XFILLER_150_117 VDD VDD VSS VSS gf180mcu_fd_sc_mcu7t5v0__fill_1
XFILLER_163_489 VDD VDD VSS VSS gf180mcu_fd_sc_mcu7t5v0__fill_1
XFILLER_89_212 VDD VDD VSS VSS gf180mcu_fd_sc_mcu7t5v0__fillcap_4
Xwave_controller_x_inst_wire68 wave_controller_x_inst_wire68/I wave_controller_x_inst_wire68/Z
+ VDD VDD VSS VSS gf180mcu_fd_sc_mcu7t5v0__buf_2
XFILLER_77_407 VDD VDD VSS VSS gf180mcu_fd_sc_mcu7t5v0__fillcap_8
XPHY_EDGE_ROW_51_1_Right_50 VDD VSS gf180mcu_fd_sc_mcu7t5v0__endcap
XFILLER_57_142 VDD VDD VSS VSS gf180mcu_fd_sc_mcu7t5v0__fillcap_8
XFILLER_85_462 VDD VDD VSS VSS gf180mcu_fd_sc_mcu7t5v0__fillcap_16
Xwave_controller_y_inst__2814_ spi_regs_inst__1099_/B2 wave_controller_y_inst__2815_/A2
+ wave_controller_y_inst__2815_/B VDD VDD VSS VSS gf180mcu_fd_sc_mcu7t5v0__nand2_1
XFILLER_45_304 VDD VDD VSS VSS gf180mcu_fd_sc_mcu7t5v0__fillcap_4
XFILLER_58_687 VDD VDD VSS VSS gf180mcu_fd_sc_mcu7t5v0__fillcap_4
XTAP_TAPCELL_ROW_56_800 VDD VSS gf180mcu_fd_sc_mcu7t5v0__filltie
XFILLER_26_540 VDD VDD VSS VSS gf180mcu_fd_sc_mcu7t5v0__fill_1
XTAP_TAPCELL_ROW_0_1_2665 VDD VSS gf180mcu_fd_sc_mcu7t5v0__filltie
Xwave_controller_y_inst__2745_ spi_regs_inst__1194_/B2 wave_controller_y_inst__2743_/Z
+ wave_controller_y_inst__2745_/Z VDD VDD VSS VSS gf180mcu_fd_sc_mcu7t5v0__xor2_1
Xwave_controller_x_inst__2729_ wave_controller_x_inst__2729_/I wave_controller_x_inst__2734_/A1
+ VDD VDD VSS VSS gf180mcu_fd_sc_mcu7t5v0__clkinv_1
Xwave_controller_y_inst__2676_ wave_controller_y_inst__2674_/Z wave_controller_y_inst__2678_/A2
+ wave_controller_y_inst__2676_/Z VDD VDD VSS VSS gf180mcu_fd_sc_mcu7t5v0__or2_1
XFILLER_13_212 VDD VDD VSS VSS gf180mcu_fd_sc_mcu7t5v0__fillcap_32
XFILLER_159_2 VDD VDD VSS VSS gf180mcu_fd_sc_mcu7t5v0__fillcap_64
XFILLER_53_370 VDD VDD VSS VSS gf180mcu_fd_sc_mcu7t5v0__fillcap_4
XFILLER_54_88 VDD VDD VSS VSS gf180mcu_fd_sc_mcu7t5v0__fillcap_16
XFILLER_70_10 VDD VDD VSS VSS gf180mcu_fd_sc_mcu7t5v0__fillcap_4
XTAP_TAPCELL_ROW_101_1541 VDD VSS gf180mcu_fd_sc_mcu7t5v0__filltie
XFILLER_158_239 VDD VDD VSS VSS gf180mcu_fd_sc_mcu7t5v0__fill_1
XFILLER_167_784 VDD VDD VSS VSS gf180mcu_fd_sc_mcu7t5v0__fillcap_32
XFILLER_103_1046 VDD VDD VSS VSS gf180mcu_fd_sc_mcu7t5v0__fillcap_4
XFILLER_127_648 VDD VDD VSS VSS gf180mcu_fd_sc_mcu7t5v0__fill_1
XFILLER_5_422 VDD VDD VSS VSS gf180mcu_fd_sc_mcu7t5v0__fillcap_8
Xwave_controller_y_inst__3228_ wave_controller_y_inst__3228_/A1 wave_controller_y_inst__3228_/A2
+ wave_controller_y_inst__3233_/B1 VDD VDD VSS VSS gf180mcu_fd_sc_mcu7t5v0__nand2_1
Xclkload19 clkload19/I clkload19/ZN VDD VDD VSS VSS gf180mcu_fd_sc_mcu7t5v0__inv_2
XFILLER_126_147 VDD VDD VSS VSS gf180mcu_fd_sc_mcu7t5v0__fill_2
XFILLER_154_467 VDD VDD VSS VSS gf180mcu_fd_sc_mcu7t5v0__fill_2
XTAP_TAPCELL_ROW_134_2084 VDD VSS gf180mcu_fd_sc_mcu7t5v0__filltie
Xwave_controller_y_inst__3159_ wave_controller_y_inst__3154_/Z wave_controller_y_inst__3205_/A2
+ wave_controller_y_inst__3159_/B wave_controller_y_inst__3206_/A1 VDD VDD VSS VSS
+ gf180mcu_fd_sc_mcu7t5v0__oai21_1
XFILLER_154_489 VDD VDD VSS VSS gf180mcu_fd_sc_mcu7t5v0__fill_2
XTAP_TAPCELL_ROW_134_2095 VDD VSS gf180mcu_fd_sc_mcu7t5v0__filltie
XFILLER_141_139 VDD VDD VSS VSS gf180mcu_fd_sc_mcu7t5v0__fill_1
XFILLER_123_898 VDD VDD VSS VSS gf180mcu_fd_sc_mcu7t5v0__fill_2
XFILLER_89_790 VDD VDD VSS VSS gf180mcu_fd_sc_mcu7t5v0__fillcap_4
Xspi_regs_inst_fanout473 spi_regs_inst__1662_/Q spi_regs_inst__1443_/I1 VDD VDD VSS
+ VSS gf180mcu_fd_sc_mcu7t5v0__dlyb_1
XFILLER_95_62 VDD VDD VSS VSS gf180mcu_fd_sc_mcu7t5v0__fillcap_8
Xspi_regs_inst_fanout495 spi_regs_inst__1657_/Q spi_regs_inst__1377_/I1 VDD VDD VSS
+ VSS gf180mcu_fd_sc_mcu7t5v0__dlyb_1
Xspi_regs_inst_fanout484 spi_regs_inst_wire487/Z spi_regs_inst__1407_/I1 VDD VDD VSS
+ VSS gf180mcu_fd_sc_mcu7t5v0__dlyb_1
Xspi_regs_inst__0983_ spi_regs_inst__0992_/A1 spi_regs_inst__1019_/A2 spi_regs_inst__1231_/B1
+ VDD VDD VSS VSS gf180mcu_fd_sc_mcu7t5v0__nor2_1
X_92_ _92_/I _92_/Z VDD VDD VSS VSS gf180mcu_fd_sc_mcu7t5v0__buf_1
XFILLER_110_1017 VDD VDD VSS VSS gf180mcu_fd_sc_mcu7t5v0__fillcap_64
XFILLER_92_944 VDD VDD VSS VSS gf180mcu_fd_sc_mcu7t5v0__fill_1
XFILLER_151_90 VDD VDD VSS VSS gf180mcu_fd_sc_mcu7t5v0__fill_2
XTAP_TAPCELL_ROW_17_1_458 VDD VSS gf180mcu_fd_sc_mcu7t5v0__filltie
Xspi_regs_inst__1604_ spi_regs_inst__1604_/D spi_regs_inst__1605_/RN clkbuf_leaf_39_clk/Z
+ spi_regs_inst__1604_/Q VDD VDD VSS VSS gf180mcu_fd_sc_mcu7t5v0__dffrnq_1
XFILLER_60_874 VDD VDD VSS VSS gf180mcu_fd_sc_mcu7t5v0__fill_1
Xspi_regs_inst__1535_ spi_regs_inst__1535_/D fanout591/Z clkbuf_leaf_11_clk/Z spi_regs_inst__1535_/Q
+ VDD VDD VSS VSS gf180mcu_fd_sc_mcu7t5v0__dffrnq_1
XFILLER_73_1170 VDD VDD VSS VSS gf180mcu_fd_sc_mcu7t5v0__fillcap_4
XTAP_TAPCELL_ROW_154_2416 VDD VSS gf180mcu_fd_sc_mcu7t5v0__filltie
Xspi_regs_inst__1466_ spi_regs_inst__1466_/D fanout592/Z clkload29/I fanout536/I VDD
+ VDD VSS VSS gf180mcu_fd_sc_mcu7t5v0__dffrnq_1
XFILLER_160_1151 VDD VDD VSS VSS gf180mcu_fd_sc_mcu7t5v0__fillcap_4
XFILLER_160_1173 VDD VDD VSS VSS gf180mcu_fd_sc_mcu7t5v0__fill_1
XFILLER_74_2 VDD VDD VSS VSS gf180mcu_fd_sc_mcu7t5v0__fillcap_8
XTAP_TAPCELL_ROW_119_1835 VDD VSS gf180mcu_fd_sc_mcu7t5v0__filltie
XFILLER_117_125 VDD VDD VSS VSS gf180mcu_fd_sc_mcu7t5v0__fillcap_8
XFILLER_118_626 VDD VDD VSS VSS gf180mcu_fd_sc_mcu7t5v0__fill_2
XTAP_TAPCELL_ROW_119_1846 VDD VSS gf180mcu_fd_sc_mcu7t5v0__filltie
Xspi_regs_inst__1397_ fanout530/Z spi_regs_inst__1430_/I1 spi_regs_inst__1402_/S spi_regs_inst__1471_/D
+ VDD VDD VSS VSS gf180mcu_fd_sc_mcu7t5v0__mux2_2
XFILLER_133_629 VDD VDD VSS VSS gf180mcu_fd_sc_mcu7t5v0__fill_1
XFILLER_145_489 VDD VDD VSS VSS gf180mcu_fd_sc_mcu7t5v0__fill_1
XFILLER_160_448 VDD VDD VSS VSS gf180mcu_fd_sc_mcu7t5v0__fill_1
XFILLER_87_716 VDD VDD VSS VSS gf180mcu_fd_sc_mcu7t5v0__fill_1
XPHY_EDGE_ROW_3_1_Left_170 VDD VSS gf180mcu_fd_sc_mcu7t5v0__endcap
XTAP_TAPCELL_ROW_70_1028 VDD VSS gf180mcu_fd_sc_mcu7t5v0__filltie
Xwave_controller_x_inst__1962_ wave_controller_x_inst__1962_/A1 wave_controller_x_inst__1962_/A2
+ wave_controller_x_inst__1962_/B wave_controller_x_inst__1967_/A2 VDD VDD VSS VSS
+ gf180mcu_fd_sc_mcu7t5v0__aoi21_1
XFILLER_68_941 VDD VDD VSS VSS gf180mcu_fd_sc_mcu7t5v0__fillcap_4
XTAP_TAPCELL_ROW_70_1039 VDD VSS gf180mcu_fd_sc_mcu7t5v0__filltie
Xwave_controller_x_inst__3701_ wave_controller_x_inst__3701_/D wave_controller_x_inst__3701_/RN
+ clkload31/I wave_controller_x_inst__3701_/Q VDD VDD VSS VSS gf180mcu_fd_sc_mcu7t5v0__dffrnq_1
XFILLER_95_760 VDD VDD VSS VSS gf180mcu_fd_sc_mcu7t5v0__fill_1
Xwave_controller_x_inst__1893_ wave_controller_x_inst__3692_/Q wave_controller_x_inst__3420_/A1
+ VDD VDD VSS VSS gf180mcu_fd_sc_mcu7t5v0__clkinv_1
Xwave_controller_x_inst__3632_ wave_controller_x_inst__3632_/D wave_controller_x_inst__3706_/RN
+ clkload36/I spi_regs_inst__1259_/B2 VDD VDD VSS VSS gf180mcu_fd_sc_mcu7t5v0__dffrnq_1
XFILLER_82_454 VDD VDD VSS VSS gf180mcu_fd_sc_mcu7t5v0__fill_1
Xwave_controller_x_inst__3563_ wave_controller_x_inst__3596_/I0 max_cap461/Z wave_controller_x_inst__3569_/S
+ wave_controller_x_inst__3651_/D VDD VDD VSS VSS gf180mcu_fd_sc_mcu7t5v0__mux2_2
Xwave_controller_y_inst__2530_ wave_controller_y_inst__2555_/C wave_controller_y_inst__2556_/C
+ VDD VDD VSS VSS gf180mcu_fd_sc_mcu7t5v0__clkinv_1
Xwave_controller_y_inst_wire124 wave_controller_y_inst_wire124/I wave_controller_y_inst_wire124/Z
+ VDD VDD VSS VSS gf180mcu_fd_sc_mcu7t5v0__clkbuf_1
Xwave_controller_x_inst__2514_ wave_controller_x_inst__2488_/Z wave_controller_x_inst__2518_/A3
+ wave_controller_x_inst__2517_/B VDD VDD VSS VSS gf180mcu_fd_sc_mcu7t5v0__and2_1
XFILLER_35_381 VDD VDD VSS VSS gf180mcu_fd_sc_mcu7t5v0__fillcap_4
XFILLER_78_1081 VDD VDD VSS VSS gf180mcu_fd_sc_mcu7t5v0__fillcap_4
XTAP_TAPCELL_ROW_85_1282 VDD VSS gf180mcu_fd_sc_mcu7t5v0__filltie
Xwave_controller_y_inst__2461_ wave_controller_y_inst__2462_/B wave_controller_y_inst__2463_/B
+ VDD VDD VSS VSS gf180mcu_fd_sc_mcu7t5v0__clkinv_1
Xwave_controller_x_inst__3494_ wave_controller_x_inst__3494_/A1 wave_controller_x_inst__3494_/A2
+ wave_controller_x_inst__3523_/A2 VDD VDD VSS VSS gf180mcu_fd_sc_mcu7t5v0__nand2_1
Xwave_controller_y_inst_wire179 wave_controller_y_inst_wire179/I wave_controller_y_inst_wire179/Z
+ VDD VDD VSS VSS gf180mcu_fd_sc_mcu7t5v0__clkbuf_1
Xwave_controller_x_inst__2445_ wave_controller_x_inst__2774_/A1 wave_controller_x_inst__2443_/B
+ wave_controller_x_inst__2445_/A3 wave_controller_x_inst__2445_/Z VDD VDD VSS VSS
+ gf180mcu_fd_sc_mcu7t5v0__xor3_1
XTAP_TAPCELL_ROW_61_880 VDD VSS gf180mcu_fd_sc_mcu7t5v0__filltie
Xwave_controller_y_inst__2392_ wave_controller_y_inst__2392_/A1 wave_controller_y_inst__2392_/A2
+ spi_regs_inst__1335_/A1 VDD VDD VSS VSS gf180mcu_fd_sc_mcu7t5v0__xor2_1
Xwave_controller_x_inst__2376_ wave_controller_x_inst__2376_/A1 wave_controller_x_inst__2396_/A1
+ wave_controller_x_inst__2391_/A2 VDD VDD VSS VSS gf180mcu_fd_sc_mcu7t5v0__nor2_1
XTAP_TAPCELL_ROW_61_891 VDD VSS gf180mcu_fd_sc_mcu7t5v0__filltie
Xchip_core_636 bidir_ie[4] VDD VDD VSS VSS gf180mcu_fd_sc_mcu7t5v0__tiel
XFILLER_108_103 VDD VDD VSS VSS gf180mcu_fd_sc_mcu7t5v0__fill_2
XFILLER_108_114 VDD VDD VSS VSS gf180mcu_fd_sc_mcu7t5v0__fillcap_8
XFILLER_109_648 VDD VDD VSS VSS gf180mcu_fd_sc_mcu7t5v0__fill_2
XFILLER_148_272 VDD VDD VSS VSS gf180mcu_fd_sc_mcu7t5v0__fill_1
Xchip_core_669 bidir_sl[6] VDD VDD VSS VSS gf180mcu_fd_sc_mcu7t5v0__tiel
Xchip_core_658 bidir_pu[4] VDD VDD VSS VSS gf180mcu_fd_sc_mcu7t5v0__tiel
Xchip_core_647 bidir_pd[2] VDD VDD VSS VSS gf180mcu_fd_sc_mcu7t5v0__tiel
XFILLER_163_220 VDD VDD VSS VSS gf180mcu_fd_sc_mcu7t5v0__fillcap_4
XFILLER_163_242 VDD VDD VSS VSS gf180mcu_fd_sc_mcu7t5v0__fill_1
Xwave_controller_y_inst__3013_ wave_controller_y_inst__3693_/Q wave_controller_y_inst__3692_/Q
+ wave_controller_y_inst__3017_/A2 VDD VDD VSS VSS gf180mcu_fd_sc_mcu7t5v0__nand2_1
XFILLER_163_275 VDD VDD VSS VSS gf180mcu_fd_sc_mcu7t5v0__fillcap_4
Xwave_controller_y_inst_wire25 wave_controller_y_inst_wire25/I wave_controller_y_inst_wire25/Z
+ VDD VDD VSS VSS gf180mcu_fd_sc_mcu7t5v0__buf_2
XFILLER_123_139 VDD VDD VSS VSS gf180mcu_fd_sc_mcu7t5v0__fill_1
XFILLER_151_448 VDD VDD VSS VSS gf180mcu_fd_sc_mcu7t5v0__fillcap_8
XFILLER_85_1052 VDD VDD VSS VSS gf180mcu_fd_sc_mcu7t5v0__fillcap_64
XFILLER_120_813 VDD VDD VSS VSS gf180mcu_fd_sc_mcu7t5v0__fill_1
XFILLER_77_237 VDD VDD VSS VSS gf180mcu_fd_sc_mcu7t5v0__fillcap_8
XFILLER_58_473 VDD VDD VSS VSS gf180mcu_fd_sc_mcu7t5v0__fillcap_8
XFILLER_100_592 VDD VDD VSS VSS gf180mcu_fd_sc_mcu7t5v0__fill_2
XFILLER_18_348 VDD VDD VSS VSS gf180mcu_fd_sc_mcu7t5v0__fill_1
XFILLER_45_134 VDD VDD VSS VSS gf180mcu_fd_sc_mcu7t5v0__fill_1
XFILLER_85_292 VDD VDD VSS VSS gf180mcu_fd_sc_mcu7t5v0__fill_1
XFILLER_60_104 VDD VDD VSS VSS gf180mcu_fd_sc_mcu7t5v0__fill_1
XFILLER_61_616 VDD VDD VSS VSS gf180mcu_fd_sc_mcu7t5v0__fill_2
XFILLER_61_627 VDD VDD VSS VSS gf180mcu_fd_sc_mcu7t5v0__fill_2
XFILLER_65_98 VDD VDD VSS VSS gf180mcu_fd_sc_mcu7t5v0__fill_1
Xwave_controller_y_inst__2728_ spi_regs_inst__1121_/A1 wave_controller_y_inst__2728_/A2
+ wave_controller_y_inst__2728_/B wave_controller_y_inst__2729_/I VDD VDD VSS VSS
+ gf180mcu_fd_sc_mcu7t5v0__aoi21_1
XFILLER_14_510 VDD VDD VSS VSS gf180mcu_fd_sc_mcu7t5v0__fill_2
XFILLER_14_521 VDD VDD VSS VSS gf180mcu_fd_sc_mcu7t5v0__fillcap_4
XFILLER_60_115 VDD VDD VSS VSS gf180mcu_fd_sc_mcu7t5v0__fill_2
XFILLER_14_543 VDD VDD VSS VSS gf180mcu_fd_sc_mcu7t5v0__fillcap_8
XFILLER_57_1154 VDD VDD VSS VSS gf180mcu_fd_sc_mcu7t5v0__fillcap_16
XTAP_TAPCELL_ROW_13_1_431 VDD VSS gf180mcu_fd_sc_mcu7t5v0__filltie
Xwave_controller_y_inst__2659_ wave_controller_y_inst__1819_/I wave_controller_y_inst__2660_/A3
+ wave_controller_y_inst__2675_/A2 VDD VDD VSS VSS gf180mcu_fd_sc_mcu7t5v0__nand2_1
XFILLER_144_1157 VDD VDD VSS VSS gf180mcu_fd_sc_mcu7t5v0__fillcap_8
XFILLER_159_559 VDD VDD VSS VSS gf180mcu_fd_sc_mcu7t5v0__fill_1
XFILLER_41_373 VDD VDD VSS VSS gf180mcu_fd_sc_mcu7t5v0__fill_2
Xspi_regs_inst__1320_ spi_regs_inst__1320_/A1 spi_regs_inst_wire240/Z spi_regs_inst_wire226/Z
+ spi_regs_inst__1320_/B2 spi_regs_inst__1323_/A2 VDD VDD VSS VSS gf180mcu_fd_sc_mcu7t5v0__aoi22_1
XTAP_TAPCELL_ROW_136_2113 VDD VSS gf180mcu_fd_sc_mcu7t5v0__filltie
XTAP_TAPCELL_ROW_136_2124 VDD VSS gf180mcu_fd_sc_mcu7t5v0__filltie
XFILLER_155_710 VDD VDD VSS VSS gf180mcu_fd_sc_mcu7t5v0__fill_1
Xspi_regs_inst__1251_ spi_regs_inst__1540_/Q spi_regs_inst__1251_/A2 spi_regs_inst__1251_/B1
+ spi_regs_inst__1251_/B2 spi_regs_inst__1253_/A3 VDD VDD VSS VSS gf180mcu_fd_sc_mcu7t5v0__aoi22_1
Xspi_regs_inst__1182_ spi_regs_inst__1182_/A1 spi_regs_inst_wire247/Z spi_regs_inst__1182_/B1
+ _08_/I spi_regs_inst__1210_/A2 VDD VDD VSS VSS gf180mcu_fd_sc_mcu7t5v0__aoi22_1
XFILLER_115_629 VDD VDD VSS VSS gf180mcu_fd_sc_mcu7t5v0__fill_1
XFILLER_127_478 VDD VDD VSS VSS gf180mcu_fd_sc_mcu7t5v0__fill_1
XFILLER_127_489 VDD VDD VSS VSS gf180mcu_fd_sc_mcu7t5v0__fill_1
XFILLER_154_297 VDD VDD VSS VSS gf180mcu_fd_sc_mcu7t5v0__fill_1
XTAP_TAPCELL_ROW_114_1754 VDD VSS gf180mcu_fd_sc_mcu7t5v0__filltie
XTAP_TAPCELL_ROW_114_1765 VDD VSS gf180mcu_fd_sc_mcu7t5v0__filltie
XFILLER_123_651 VDD VDD VSS VSS gf180mcu_fd_sc_mcu7t5v0__fill_2
XFILLER_151_982 VDD VDD VSS VSS gf180mcu_fd_sc_mcu7t5v0__fillcap_64
Xsignal_processor_y_inst__201_ fanout393/Z spi_regs_inst__1131_/A1 signal_processor_y_inst__203_/A1
+ signal_processor_y_inst__202_/B VDD VDD VSS VSS gf180mcu_fd_sc_mcu7t5v0__nand3_1
XFILLER_122_172 VDD VDD VSS VSS gf180mcu_fd_sc_mcu7t5v0__fill_2
XFILLER_96_535 VDD VDD VSS VSS gf180mcu_fd_sc_mcu7t5v0__fill_1
XFILLER_96_546 VDD VDD VSS VSS gf180mcu_fd_sc_mcu7t5v0__fillcap_8
Xsignal_processor_y_inst__132_ signal_processor_y_inst__239_/Q signal_processor_y_inst__203_/A1
+ signal_processor_y_inst__132_/A3 signal_processor_y_inst__195_/B VDD VDD VSS VSS
+ gf180mcu_fd_sc_mcu7t5v0__or3_1
XTAP_TAPCELL_ROW_147_2297 VDD VSS gf180mcu_fd_sc_mcu7t5v0__filltie
Xspi_regs_inst__0966_ spi_regs_inst__1024_/A1 spi_regs_inst__1009_/A1 spi_regs_inst__1244_/A2
+ VDD VDD VSS VSS gf180mcu_fd_sc_mcu7t5v0__nor2_1
XFILLER_149_1046 VDD VDD VSS VSS gf180mcu_fd_sc_mcu7t5v0__fillcap_4
XFILLER_36_167 VDD VDD VSS VSS gf180mcu_fd_sc_mcu7t5v0__fill_2
XFILLER_92_785 VDD VDD VSS VSS gf180mcu_fd_sc_mcu7t5v0__fillcap_16
Xspi_regs_inst__0897_ spi_regs_inst__1626_/Q spi_regs_inst__0897_/A2 spi_regs_inst__0899_/B
+ VDD VDD VSS VSS gf180mcu_fd_sc_mcu7t5v0__nand2_1
XFILLER_60_693 VDD VDD VSS VSS gf180mcu_fd_sc_mcu7t5v0__fill_1
Xwave_controller_x_inst__2230_ wave_controller_x_inst__2248_/C1 wave_controller_x_inst__2229_/Z
+ wave_controller_x_inst__2250_/A1 VDD VDD VSS VSS gf180mcu_fd_sc_mcu7t5v0__nand2_1
XTAP_TAPCELL_ROW_80_1190 VDD VSS gf180mcu_fd_sc_mcu7t5v0__filltie
Xwave_controller_x_inst__2161_ spi_regs_inst__1033_/B2 wave_controller_x_inst__2163_/B
+ wave_controller_x_inst__2164_/A2 VDD VDD VSS VSS gf180mcu_fd_sc_mcu7t5v0__nor2_1
Xspi_regs_inst__1518_ spi_regs_inst__1518_/D fanout588/Z clkbuf_leaf_13_clk/Z spi_regs_inst__1518_/Q
+ VDD VDD VSS VSS gf180mcu_fd_sc_mcu7t5v0__dffrnq_1
Xspi_regs_inst__1449_ spi_regs_inst__1517_/Q spi_regs_inst_wire487/Z spi_regs_inst__1451_/S
+ spi_regs_inst__1517_/D VDD VDD VSS VSS gf180mcu_fd_sc_mcu7t5v0__mux2_2
Xwave_controller_x_inst__2092_ wave_controller_x_inst__2125_/A1 wave_controller_x_inst__2125_/A2
+ wave_controller_x_inst__2092_/B wave_controller_x_inst__2092_/C wave_controller_x_inst__2093_/B2
+ VDD VDD VSS VSS gf180mcu_fd_sc_mcu7t5v0__aoi211_1
XFILLER_145_275 VDD VDD VSS VSS gf180mcu_fd_sc_mcu7t5v0__fillcap_4
XFILLER_161_702 VDD VDD VSS VSS gf180mcu_fd_sc_mcu7t5v0__fillcap_64
XPHY_EDGE_ROW_43_1_Left_210 VDD VSS gf180mcu_fd_sc_mcu7t5v0__endcap
XFILLER_133_448 VDD VDD VSS VSS gf180mcu_fd_sc_mcu7t5v0__fill_1
XFILLER_156_1017 VDD VDD VSS VSS gf180mcu_fd_sc_mcu7t5v0__fillcap_64
XFILLER_160_212 VDD VDD VSS VSS gf180mcu_fd_sc_mcu7t5v0__fill_2
XFILLER_102_802 VDD VDD VSS VSS gf180mcu_fd_sc_mcu7t5v0__fill_2
XTAP_TAPCELL_ROW_167_2629 VDD VSS gf180mcu_fd_sc_mcu7t5v0__filltie
XTAP_TAPCELL_ROW_30_1_556 VDD VSS gf180mcu_fd_sc_mcu7t5v0__filltie
XFILLER_141_492 VDD VDD VSS VSS gf180mcu_fd_sc_mcu7t5v0__fillcap_16
Xwave_controller_x_inst__2994_ wave_controller_x_inst__2994_/A1 wave_controller_x_inst__3077_/A2
+ wave_controller_x_inst__2994_/B wave_controller_x_inst__3079_/A1 VDD VDD VSS VSS
+ gf180mcu_fd_sc_mcu7t5v0__oai21_1
XFILLER_102_879 VDD VDD VSS VSS gf180mcu_fd_sc_mcu7t5v0__fill_1
Xwave_controller_y_inst__3700_ wave_controller_y_inst__3700_/D wave_controller_y_inst__3739_/RN
+ clkload16/I wave_controller_y_inst__3700_/Q VDD VDD VSS VSS gf180mcu_fd_sc_mcu7t5v0__dffsnq_1
Xwave_controller_y_inst__1961_ wave_controller_y_inst__1962_/A1 wave_controller_y_inst__1962_/A2
+ wave_controller_y_inst__1963_/A2 VDD VDD VSS VSS gf180mcu_fd_sc_mcu7t5v0__nand2_1
Xwave_controller_x_inst__1945_ wave_controller_x_inst__1945_/A1 spi_regs_inst__1498_/Q
+ wave_controller_x_inst__1945_/Z VDD VDD VSS VSS gf180mcu_fd_sc_mcu7t5v0__xor2_1
XFILLER_68_771 VDD VDD VSS VSS gf180mcu_fd_sc_mcu7t5v0__fill_1
XTAP_TAPCELL_ROW_87_1311 VDD VSS gf180mcu_fd_sc_mcu7t5v0__filltie
Xwave_controller_y_inst__1892_ wave_controller_y_inst__3693_/Q wave_controller_y_inst__3430_/A1
+ VDD VDD VSS VSS gf180mcu_fd_sc_mcu7t5v0__clkinv_1
Xwave_controller_x_inst__1876_ spi_regs_inst__1332_/A1 wave_controller_x_inst__3518_/B2
+ VDD VDD VSS VSS gf180mcu_fd_sc_mcu7t5v0__clkinv_1
Xwave_controller_y_inst__3631_ wave_controller_y_inst__3631_/D wave_controller_y_inst__3703_/RN
+ clkload20/I spi_regs_inst__1183_/A1 VDD VDD VSS VSS gf180mcu_fd_sc_mcu7t5v0__dffrnq_1
Xwave_controller_x_inst__3615_ wave_controller_x_inst__3615_/D fanout596/Z clkload25/I
+ wave_controller_x_inst__3615_/Q VDD VDD VSS VSS gf180mcu_fd_sc_mcu7t5v0__dffrnq_1
XFILLER_167_1124 VDD VDD VSS VSS gf180mcu_fd_sc_mcu7t5v0__fillcap_16
XFILLER_70_402 VDD VDD VSS VSS gf180mcu_fd_sc_mcu7t5v0__fillcap_8
XTAP_TAPCELL_ROW_66_961 VDD VSS gf180mcu_fd_sc_mcu7t5v0__filltie
XTAP_TAPCELL_ROW_66_972 VDD VSS gf180mcu_fd_sc_mcu7t5v0__filltie
Xwave_controller_y_inst__3562_ wave_controller_y_inst__3562_/A1 wave_controller_y_inst_wire323/I
+ wave_controller_y_inst__3596_/I0 VDD VDD VSS VSS gf180mcu_fd_sc_mcu7t5v0__nor2_1
XFILLER_15_329 VDD VDD VSS VSS gf180mcu_fd_sc_mcu7t5v0__fill_1
Xwave_controller_y_inst__2513_ wave_controller_y_inst__2521_/A1 spi_regs_inst__1312_/B2
+ wave_controller_y_inst__2534_/B VDD VDD VSS VSS gf180mcu_fd_sc_mcu7t5v0__nor2_1
Xwave_controller_x_inst__3546_ wave_controller_x_inst__3718_/Q wave_controller_x_inst__3555_/A2
+ wave_controller_x_inst__3548_/A2 VDD VDD VSS VSS gf180mcu_fd_sc_mcu7t5v0__nor2_1
XFILLER_70_457 VDD VDD VSS VSS gf180mcu_fd_sc_mcu7t5v0__fillcap_4
Xwave_controller_y_inst__3493_ wave_controller_y_inst__3493_/A1 wave_controller_y_inst__3493_/A2
+ wave_controller_y_inst__3493_/Z VDD VDD VSS VSS gf180mcu_fd_sc_mcu7t5v0__and2_1
Xwave_controller_x_inst__3477_ wave_controller_x_inst__3479_/A1 wave_controller_x_inst__3487_/A2
+ wave_controller_x_inst__3477_/B wave_controller_x_inst__3478_/I VDD VDD VSS VSS
+ gf180mcu_fd_sc_mcu7t5v0__oai21_1
Xsignal_processor_x_inst__221_ signal_processor_x_inst__221_/D signal_processor_x_inst__242_/RN
+ clkload23/I spi_regs_inst__1055_/B2 VDD VDD VSS VSS gf180mcu_fd_sc_mcu7t5v0__dffrnq_1
Xwave_controller_y_inst__2444_ wave_controller_y_inst__2443_/B wave_controller_y_inst__2450_/A2
+ wave_controller_y_inst__2442_/Z wave_controller_y_inst__2449_/A2 VDD VDD VSS VSS
+ gf180mcu_fd_sc_mcu7t5v0__nor3_1
Xwave_controller_x_inst__2428_ wire450/Z wave_controller_x_inst__2426_/Z wave_controller_x_inst__2429_/A2
+ VDD VDD VSS VSS gf180mcu_fd_sc_mcu7t5v0__nand2_1
Xsignal_processor_x_inst__152_ fanout397/Z signal_processor_x_inst__203_/A1 signal_processor_x_inst__187_/B
+ VDD VDD VSS VSS gf180mcu_fd_sc_mcu7t5v0__nand2_1
XFILLER_156_507 VDD VDD VSS VSS gf180mcu_fd_sc_mcu7t5v0__fillcap_16
Xwave_controller_y_inst__2375_ wave_controller_y_inst__2361_/B wave_controller_y_inst__2375_/A2
+ wave_controller_y_inst__2375_/B wave_controller_y_inst__2396_/A1 VDD VDD VSS VSS
+ gf180mcu_fd_sc_mcu7t5v0__oai21_1
Xclkbuf_3_3__f_clk clkbuf_0_clk/Z clkbuf_leaf_9_clk/I VDD VDD VSS VSS gf180mcu_fd_sc_mcu7t5v0__clkbuf_16
XFILLER_137_710 VDD VDD VSS VSS gf180mcu_fd_sc_mcu7t5v0__fillcap_4
Xwave_controller_x_inst__2359_ wave_controller_x_inst__2359_/I wave_controller_x_inst__2375_/A2
+ VDD VDD VSS VSS gf180mcu_fd_sc_mcu7t5v0__clkinv_1
XFILLER_109_434 VDD VDD VSS VSS gf180mcu_fd_sc_mcu7t5v0__fillcap_8
XFILLER_137_765 VDD VDD VSS VSS gf180mcu_fd_sc_mcu7t5v0__fillcap_4
XFILLER_167_67 VDD VDD VSS VSS gf180mcu_fd_sc_mcu7t5v0__fill_1
XTAP_TAPCELL_ROW_131_2032 VDD VSS gf180mcu_fd_sc_mcu7t5v0__filltie
XTAP_TAPCELL_ROW_98_1495 VDD VSS gf180mcu_fd_sc_mcu7t5v0__filltie
XFILLER_151_212 VDD VDD VSS VSS gf180mcu_fd_sc_mcu7t5v0__fill_2
XTAP_TAPCELL_ROW_131_2043 VDD VSS gf180mcu_fd_sc_mcu7t5v0__filltie
XFILLER_105_640 VDD VDD VSS VSS gf180mcu_fd_sc_mcu7t5v0__fill_2
XFILLER_133_982 VDD VDD VSS VSS gf180mcu_fd_sc_mcu7t5v0__fillcap_64
XFILLER_151_245 VDD VDD VSS VSS gf180mcu_fd_sc_mcu7t5v0__fillcap_8
XFILLER_4_2 VDD VDD VSS VSS gf180mcu_fd_sc_mcu7t5v0__fillcap_32
XFILLER_66_708 VDD VDD VSS VSS gf180mcu_fd_sc_mcu7t5v0__fill_2
XFILLER_120_676 VDD VDD VSS VSS gf180mcu_fd_sc_mcu7t5v0__fill_2
XFILLER_76_53 VDD VDD VSS VSS gf180mcu_fd_sc_mcu7t5v0__fill_2
Xfanout592 wire594/Z fanout592/Z VDD VDD VSS VSS gf180mcu_fd_sc_mcu7t5v0__dlyb_1
Xfanout581 wire628/Z fanout581/Z VDD VDD VSS VSS gf180mcu_fd_sc_mcu7t5v0__dlyb_1
Xfanout570 wire628/I fanout570/Z VDD VDD VSS VSS gf180mcu_fd_sc_mcu7t5v0__dlyb_1
XFILLER_18_134 VDD VDD VSS VSS gf180mcu_fd_sc_mcu7t5v0__fill_2
XFILLER_46_421 VDD VDD VSS VSS gf180mcu_fd_sc_mcu7t5v0__fill_2
Xspi_regs_inst__0820_ spi_regs_inst__1439_/I1 spi_regs_inst__1563_/Q spi_regs_inst__0826_/S
+ spi_regs_inst__1563_/D VDD VDD VSS VSS gf180mcu_fd_sc_mcu7t5v0__mux2_2
XFILLER_61_402 VDD VDD VSS VSS gf180mcu_fd_sc_mcu7t5v0__fillcap_4
XFILLER_74_763 VDD VDD VSS VSS gf180mcu_fd_sc_mcu7t5v0__fillcap_8
XPHY_EDGE_ROW_14_1_Right_13 VDD VSS gf180mcu_fd_sc_mcu7t5v0__endcap
Xspi_regs_inst__0751_ spi_regs_inst__0749_/Z spi_regs_inst__0939_/S spi_regs_inst__0889_/B
+ VDD VDD VSS VSS gf180mcu_fd_sc_mcu7t5v0__nand2_1
XFILLER_33_104 VDD VDD VSS VSS gf180mcu_fd_sc_mcu7t5v0__fill_2
XFILLER_62_947 VDD VDD VSS VSS gf180mcu_fd_sc_mcu7t5v0__fillcap_64
XFILLER_92_96 VDD VDD VSS VSS gf180mcu_fd_sc_mcu7t5v0__fillcap_8
XFILLER_109_1052 VDD VDD VSS VSS gf180mcu_fd_sc_mcu7t5v0__fillcap_64
XFILLER_119_209 VDD VDD VSS VSS gf180mcu_fd_sc_mcu7t5v0__fill_1
XFILLER_147_518 VDD VDD VSS VSS gf180mcu_fd_sc_mcu7t5v0__fillcap_4
XFILLER_14_384 VDD VDD VSS VSS gf180mcu_fd_sc_mcu7t5v0__fill_1
XFILLER_14_395 VDD VDD VSS VSS gf180mcu_fd_sc_mcu7t5v0__fill_1
XFILLER_159_356 VDD VDD VSS VSS gf180mcu_fd_sc_mcu7t5v0__fill_2
XFILLER_70_1151 VDD VDD VSS VSS gf180mcu_fd_sc_mcu7t5v0__fillcap_4
XFILLER_70_1173 VDD VDD VSS VSS gf180mcu_fd_sc_mcu7t5v0__fill_1
Xspi_regs_inst__1303_ spi_regs_inst__1303_/A1 spi_regs_inst_wire221/Z spi_regs_inst__1319_/A1
+ VDD VDD VSS VSS gf180mcu_fd_sc_mcu7t5v0__nand2_1
XFILLER_127_242 VDD VDD VSS VSS gf180mcu_fd_sc_mcu7t5v0__fill_1
Xspi_regs_inst__1234_ spi_regs_inst__1234_/A1 spi_regs_inst__1234_/A2 spi_regs_inst__1237_/A2
+ VDD VDD VSS VSS gf180mcu_fd_sc_mcu7t5v0__nand2_1
XFILLER_128_776 VDD VDD VSS VSS gf180mcu_fd_sc_mcu7t5v0__fillcap_16
XFILLER_143_702 VDD VDD VSS VSS gf180mcu_fd_sc_mcu7t5v0__fill_2
XFILLER_155_562 VDD VDD VSS VSS gf180mcu_fd_sc_mcu7t5v0__fillcap_32
XFILLER_142_234 VDD VDD VSS VSS gf180mcu_fd_sc_mcu7t5v0__fill_2
XFILLER_143_735 VDD VDD VSS VSS gf180mcu_fd_sc_mcu7t5v0__fillcap_4
Xspi_regs_inst__1165_ spi_regs_inst__1165_/A1 spi_regs_inst__1165_/A2 spi_regs_inst__1165_/A3
+ spi_regs_inst__1165_/A4 spi_regs_inst__1171_/A3 VDD VDD VSS VSS gf180mcu_fd_sc_mcu7t5v0__nand4_1
XFILLER_69_502 VDD VDD VSS VSS gf180mcu_fd_sc_mcu7t5v0__fillcap_8
Xspi_regs_inst__1096_ spi_regs_inst__1608_/Q spi_regs_inst_wire251/Z spi_regs_inst__1225_/A2
+ max_cap451/Z spi_regs_inst__1118_/A2 VDD VDD VSS VSS gf180mcu_fd_sc_mcu7t5v0__aoi22_1
XTAP_TAPCELL_ROW_149_2337 VDD VSS gf180mcu_fd_sc_mcu7t5v0__filltie
XFILLER_111_632 VDD VDD VSS VSS gf180mcu_fd_sc_mcu7t5v0__fillcap_8
XFILLER_123_492 VDD VDD VSS VSS gf180mcu_fd_sc_mcu7t5v0__fillcap_16
XFILLER_69_557 VDD VDD VSS VSS gf180mcu_fd_sc_mcu7t5v0__fill_2
XFILLER_96_332 VDD VDD VSS VSS gf180mcu_fd_sc_mcu7t5v0__fill_1
XFILLER_110_164 VDD VDD VSS VSS gf180mcu_fd_sc_mcu7t5v0__fillcap_8
XFILLER_84_527 VDD VDD VSS VSS gf180mcu_fd_sc_mcu7t5v0__fill_1
XFILLER_97_899 VDD VDD VSS VSS gf180mcu_fd_sc_mcu7t5v0__fill_2
Xsignal_processor_y_inst__115_ signal_processor_y_inst__252_/Q signal_processor_y_inst__179_/A1
+ signal_processor_y_inst__243_/D VDD VDD VSS VSS gf180mcu_fd_sc_mcu7t5v0__and2_1
XTAP_TAPCELL_ROW_162_2548 VDD VSS gf180mcu_fd_sc_mcu7t5v0__filltie
XFILLER_112_18 VDD VDD VSS VSS gf180mcu_fd_sc_mcu7t5v0__fill_2
XFILLER_92_560 VDD VDD VSS VSS gf180mcu_fd_sc_mcu7t5v0__fillcap_4
XTAP_TAPCELL_ROW_127_1967 VDD VSS gf180mcu_fd_sc_mcu7t5v0__filltie
XTAP_TAPCELL_ROW_127_1978 VDD VSS gf180mcu_fd_sc_mcu7t5v0__filltie
Xwave_controller_x_inst__3400_ fanout532/Z wave_controller_x_inst__3348_/Z wave_controller_x_inst__3400_/B
+ wave_controller_x_inst__3400_/C wave_controller_x_inst__3401_/C VDD VDD VSS VSS
+ gf180mcu_fd_sc_mcu7t5v0__oai211_1
Xspi_regs_inst__0949_ spi_regs_inst__1002_/A2 spi_regs_inst__1021_/A1 spi_regs_inst_wire297/I
+ VDD VDD VSS VSS gf180mcu_fd_sc_mcu7t5v0__nor2_1
XFILLER_24_104 VDD VDD VSS VSS gf180mcu_fd_sc_mcu7t5v0__fill_1
XTAP_TAPCELL_ROW_63_920 VDD VSS gf180mcu_fd_sc_mcu7t5v0__filltie
XFILLER_52_457 VDD VDD VSS VSS gf180mcu_fd_sc_mcu7t5v0__fillcap_8
XTAP_TAPCELL_ROW_82_1230 VDD VSS gf180mcu_fd_sc_mcu7t5v0__filltie
Xwave_controller_x_inst__3331_ wave_controller_x_inst__3333_/B wave_controller_x_inst__3332_/C
+ VDD VDD VSS VSS gf180mcu_fd_sc_mcu7t5v0__clkinv_1
Xwave_controller_x_inst__3262_ wave_controller_x_inst__3262_/A1 spi_regs_inst__1538_/Q
+ wave_controller_x_inst__3341_/C VDD VDD VSS VSS gf180mcu_fd_sc_mcu7t5v0__xor2_1
Xwave_controller_x_inst__2213_ wave_controller_x_inst__2186_/I wave_controller_x_inst__2213_/A2
+ wave_controller_x_inst__2213_/A3 wave_controller_x_inst__2213_/B wave_controller_x_inst_wire118/I
+ VDD VDD VSS VSS gf180mcu_fd_sc_mcu7t5v0__oai31_1
XFILLER_162_1087 VDD VDD VSS VSS gf180mcu_fd_sc_mcu7t5v0__fillcap_64
Xwave_controller_y_inst__2160_ spi_regs_inst__1101_/A1 spi_regs_inst__1090_/B2 wave_controller_y_inst__2162_/B
+ VDD VDD VSS VSS gf180mcu_fd_sc_mcu7t5v0__xor2_1
Xwave_controller_x_inst__3193_ wave_controller_x_inst__3194_/A1 wave_controller_x_inst__3194_/A2
+ wave_controller_x_inst__3194_/B wave_controller_x_inst__3193_/Z VDD VDD VSS VSS
+ gf180mcu_fd_sc_mcu7t5v0__and3_1
XFILLER_119_765 VDD VDD VSS VSS gf180mcu_fd_sc_mcu7t5v0__fillcap_4
XFILLER_165_348 VDD VDD VSS VSS gf180mcu_fd_sc_mcu7t5v0__fill_2
Xwave_controller_x_inst__2144_ wave_controller_x_inst__2058_/C wave_controller_x_inst__2144_/A2
+ wave_controller_x_inst__2144_/B wave_controller_x_inst__2145_/S VDD VDD VSS VSS
+ gf180mcu_fd_sc_mcu7t5v0__oai21_1
XFILLER_118_264 VDD VDD VSS VSS gf180mcu_fd_sc_mcu7t5v0__fill_1
Xwave_controller_y_inst__2091_ wave_controller_y_inst__2138_/A2 wave_controller_y_inst__2091_/A2
+ wave_controller_y_inst__2093_/B1 VDD VDD VSS VSS gf180mcu_fd_sc_mcu7t5v0__nor2_1
Xwave_controller_x_inst__2075_ wave_controller_x_inst__2079_/B wave_controller_x_inst__2069_/Z
+ wave_controller_x_inst__2091_/A2 VDD VDD VSS VSS gf180mcu_fd_sc_mcu7t5v0__nor2_1
XFILLER_107_949 VDD VDD VSS VSS gf180mcu_fd_sc_mcu7t5v0__fillcap_16
XFILLER_118_297 VDD VDD VSS VSS gf180mcu_fd_sc_mcu7t5v0__fill_1
XFILLER_133_212 VDD VDD VSS VSS gf180mcu_fd_sc_mcu7t5v0__fillcap_4
XFILLER_82_1011 VDD VDD VSS VSS gf180mcu_fd_sc_mcu7t5v0__fillcap_4
XFILLER_115_982 VDD VDD VSS VSS gf180mcu_fd_sc_mcu7t5v0__fillcap_64
XFILLER_133_278 VDD VDD VSS VSS gf180mcu_fd_sc_mcu7t5v0__fill_2
XFILLER_88_833 VDD VDD VSS VSS gf180mcu_fd_sc_mcu7t5v0__fillcap_4
XFILLER_153_58 VDD VDD VSS VSS gf180mcu_fd_sc_mcu7t5v0__fillcap_4
XFILLER_88_877 VDD VDD VSS VSS gf180mcu_fd_sc_mcu7t5v0__fillcap_16
Xwave_controller_y_inst__2993_ wave_controller_y_inst__1785_/I fanout513/Z wave_controller_y_inst__2989_/B
+ wave_controller_y_inst__2993_/B2 wave_controller_y_inst__3077_/A2 VDD VDD VSS VSS
+ gf180mcu_fd_sc_mcu7t5v0__oai22_1
Xwave_controller_x_inst_fanout538 fanout537/I wave_controller_x_inst__3244_/B2 VDD
+ VDD VSS VSS gf180mcu_fd_sc_mcu7t5v0__dlyb_1
Xwave_controller_x_inst__2977_ wave_controller_x_inst__3709_/Q fanout542/I wave_controller_x_inst__2977_/Z
+ VDD VDD VSS VSS gf180mcu_fd_sc_mcu7t5v0__xor2_1
XFILLER_101_142 VDD VDD VSS VSS gf180mcu_fd_sc_mcu7t5v0__fillcap_4
Xwave_controller_y_inst__1944_ wave_controller_y_inst__1944_/A1 wave_controller_y_inst__1944_/A2
+ wave_controller_y_inst__1944_/B wave_controller_y_inst__1946_/A1 VDD VDD VSS VSS
+ gf180mcu_fd_sc_mcu7t5v0__oai21_1
Xwave_controller_x_inst__1928_ spi_regs_inst__1508_/Q wave_controller_x_inst__3305_/A1
+ wave_controller_x_inst__3305_/B2 spi_regs_inst__1507_/Q wave_controller_x_inst__1929_/A2
+ VDD VDD VSS VSS gf180mcu_fd_sc_mcu7t5v0__oai22_1
XFILLER_56_730 VDD VDD VSS VSS gf180mcu_fd_sc_mcu7t5v0__fillcap_4
Xwave_controller_y_inst__3614_ wave_controller_y_inst__3614_/D fanout545/Z clkload1/I
+ wave_controller_y_inst__3614_/Q VDD VDD VSS VSS gf180mcu_fd_sc_mcu7t5v0__dffrnq_1
Xwave_controller_y_inst__1875_ spi_regs_inst__1312_/B2 wave_controller_y_inst__3515_/B2
+ VDD VDD VSS VSS gf180mcu_fd_sc_mcu7t5v0__clkinv_1
Xwave_controller_x_inst__1859_ spi_regs_inst__1090_/A1 wave_controller_x_inst__2815_/A1
+ VDD VDD VSS VSS gf180mcu_fd_sc_mcu7t5v0__clkinv_1
XFILLER_15_104 VDD VDD VSS VSS gf180mcu_fd_sc_mcu7t5v0__fillcap_4
XFILLER_71_722 VDD VDD VSS VSS gf180mcu_fd_sc_mcu7t5v0__fill_1
XFILLER_83_571 VDD VDD VSS VSS gf180mcu_fd_sc_mcu7t5v0__fill_2
Xwave_controller_y_inst__3545_ wave_controller_y_inst__3557_/A1 wave_controller_y_inst__3545_/A2
+ wave_controller_y_inst__3545_/A3 wave_controller_y_inst__3554_/B1 wave_controller_y_inst__3545_/B2
+ wave_controller_y_inst__3644_/D VDD VDD VSS VSS gf180mcu_fd_sc_mcu7t5v0__oai32_1
Xwave_controller_x_inst__3529_ spi_regs_inst__1186_/B2 wave_controller_x_inst__3556_/A2
+ wave_controller_x_inst__3530_/A3 VDD VDD VSS VSS gf180mcu_fd_sc_mcu7t5v0__nor2_1
XFILLER_30_107 VDD VDD VSS VSS gf180mcu_fd_sc_mcu7t5v0__fill_2
XFILLER_62_22 VDD VDD VSS VSS gf180mcu_fd_sc_mcu7t5v0__fill_2
XFILLER_62_33 VDD VDD VSS VSS gf180mcu_fd_sc_mcu7t5v0__fill_2
XFILLER_70_265 VDD VDD VSS VSS gf180mcu_fd_sc_mcu7t5v0__fill_1
Xwave_controller_y_inst__3476_ spi_regs_inst__1310_/A1 wave_controller_y_inst__3493_/A1
+ wave_controller_y_inst__3477_/B VDD VDD VSS VSS gf180mcu_fd_sc_mcu7t5v0__nand2_1
Xsignal_processor_x_inst__204_ spi_regs_inst__1055_/B2 signal_processor_x_inst__214_/A2
+ signal_processor_x_inst__205_/B VDD VDD VSS VSS gf180mcu_fd_sc_mcu7t5v0__nand2_1
XFILLER_141_1116 VDD VDD VSS VSS gf180mcu_fd_sc_mcu7t5v0__fillcap_4
XFILLER_54_1157 VDD VDD VSS VSS gf180mcu_fd_sc_mcu7t5v0__fillcap_16
XFILLER_62_88 VDD VDD VSS VSS gf180mcu_fd_sc_mcu7t5v0__fillcap_8
Xwave_controller_y_inst__2427_ spi_regs_inst__1150_/A1 wave_controller_y_inst__2426_/Z
+ wave_controller_y_inst__2443_/B VDD VDD VSS VSS gf180mcu_fd_sc_mcu7t5v0__or2_1
Xclkbuf_leaf_50_clk clkbuf_3_2__f_clk/Z clkload15/I VDD VDD VSS VSS gf180mcu_fd_sc_mcu7t5v0__clkbuf_8
XFILLER_7_314 VDD VDD VSS VSS gf180mcu_fd_sc_mcu7t5v0__fillcap_16
Xsignal_processor_x_inst__135_ signal_processor_x_inst__202_/A2 signal_processor_x_inst__229_/Q
+ signal_processor_x_inst__203_/A1 signal_processor_x_inst__172_/A2 VDD VDD VSS VSS
+ gf180mcu_fd_sc_mcu7t5v0__nor3_1
XFILLER_137_540 VDD VDD VSS VSS gf180mcu_fd_sc_mcu7t5v0__fill_2
Xwave_controller_y_inst__2358_ wave_controller_y_inst__2358_/A1 wave_controller_y_inst__2337_/Z
+ wave_controller_y_inst__2357_/B wave_controller_y_inst__2359_/I VDD VDD VSS VSS
+ gf180mcu_fd_sc_mcu7t5v0__or3_1
XFILLER_125_702 VDD VDD VSS VSS gf180mcu_fd_sc_mcu7t5v0__fillcap_8
XFILLER_137_562 VDD VDD VSS VSS gf180mcu_fd_sc_mcu7t5v0__fill_2
Xwave_controller_y_inst__2289_ wave_controller_y_inst__2284_/Z wave_controller_y_inst__2299_/A2
+ wave_controller_y_inst__2292_/A3 VDD VDD VSS VSS gf180mcu_fd_sc_mcu7t5v0__xnor2_1
XFILLER_152_521 VDD VDD VSS VSS gf180mcu_fd_sc_mcu7t5v0__fillcap_4
XFILLER_164_381 VDD VDD VSS VSS gf180mcu_fd_sc_mcu7t5v0__fillcap_4
XFILLER_113_908 VDD VDD VSS VSS gf180mcu_fd_sc_mcu7t5v0__fill_2
XFILLER_124_256 VDD VDD VSS VSS gf180mcu_fd_sc_mcu7t5v0__fillcap_4
XTAP_TAPCELL_ROW_111_1702 VDD VSS gf180mcu_fd_sc_mcu7t5v0__filltie
XTAP_TAPCELL_ROW_111_1713 VDD VSS gf180mcu_fd_sc_mcu7t5v0__filltie
XFILLER_127_92 VDD VDD VSS VSS gf180mcu_fd_sc_mcu7t5v0__fill_2
XFILLER_79_866 VDD VDD VSS VSS gf180mcu_fd_sc_mcu7t5v0__fillcap_32
XFILLER_87_63 VDD VDD VSS VSS gf180mcu_fd_sc_mcu7t5v0__fillcap_4
XFILLER_78_387 VDD VDD VSS VSS gf180mcu_fd_sc_mcu7t5v0__fillcap_8
XTAP_TAPCELL_ROW_144_2245 VDD VSS gf180mcu_fd_sc_mcu7t5v0__filltie
XTAP_TAPCELL_ROW_144_2256 VDD VSS gf180mcu_fd_sc_mcu7t5v0__filltie
XFILLER_93_368 VDD VDD VSS VSS gf180mcu_fd_sc_mcu7t5v0__fill_1
Xspi_regs_inst__0803_ spi_regs_inst__1391_/I1 spi_regs_inst__1553_/Q spi_regs_inst__0803_/S
+ spi_regs_inst__1553_/D VDD VDD VSS VSS gf180mcu_fd_sc_mcu7t5v0__mux2_2
XFILLER_34_402 VDD VDD VSS VSS gf180mcu_fd_sc_mcu7t5v0__fill_2
XFILLER_59_1046 VDD VDD VSS VSS gf180mcu_fd_sc_mcu7t5v0__fillcap_4
XFILLER_74_582 VDD VDD VSS VSS gf180mcu_fd_sc_mcu7t5v0__fillcap_8
XTAP_TAPCELL_ROW_109_1675 VDD VSS gf180mcu_fd_sc_mcu7t5v0__filltie
XFILLER_34_435 VDD VDD VSS VSS gf180mcu_fd_sc_mcu7t5v0__fillcap_16
XFILLER_34_457 VDD VDD VSS VSS gf180mcu_fd_sc_mcu7t5v0__fillcap_4
Xspi_regs_inst__0734_ spi_regs_inst__1629_/Q spi_regs_inst__1366_/A1 VDD VDD VSS VSS
+ gf180mcu_fd_sc_mcu7t5v0__clkinv_1
XFILLER_62_799 VDD VDD VSS VSS gf180mcu_fd_sc_mcu7t5v0__fillcap_4
Xspi_regs_inst_max_cap282 spi_regs_inst__1244_/A2 spi_regs_inst__1195_/A2 VDD VDD
+ VSS VSS gf180mcu_fd_sc_mcu7t5v0__buf_2
Xspi_regs_inst_max_cap271 spi_regs_inst__1249_/A2 spi_regs_inst__1215_/A2 VDD VDD
+ VSS VSS gf180mcu_fd_sc_mcu7t5v0__buf_2
Xspi_regs_inst_max_cap260 spi_regs_inst__1198_/A2 spi_regs_inst__1304_/C1 VDD VDD
+ VSS VSS gf180mcu_fd_sc_mcu7t5v0__buf_2
XFILLER_159_142 VDD VDD VSS VSS gf180mcu_fd_sc_mcu7t5v0__fillcap_32
XTAP_TAPCELL_ROW_122_1886 VDD VSS gf180mcu_fd_sc_mcu7t5v0__filltie
XTAP_TAPCELL_ROW_122_1897 VDD VSS gf180mcu_fd_sc_mcu7t5v0__filltie
Xspi_regs_inst_max_cap293 spi_regs_inst__1292_/A2 spi_regs_inst__1356_/A2 VDD VDD
+ VSS VSS gf180mcu_fd_sc_mcu7t5v0__buf_2
Xclkbuf_leaf_41_clk clkbuf_leaf_9_clk/I clkbuf_leaf_41_clk/Z VDD VDD VSS VSS gf180mcu_fd_sc_mcu7t5v0__clkbuf_8
XFILLER_147_326 VDD VDD VSS VSS gf180mcu_fd_sc_mcu7t5v0__fillcap_8
XFILLER_147_348 VDD VDD VSS VSS gf180mcu_fd_sc_mcu7t5v0__fill_2
XFILLER_116_713 VDD VDD VSS VSS gf180mcu_fd_sc_mcu7t5v0__fill_2
XFILLER_156_871 VDD VDD VSS VSS gf180mcu_fd_sc_mcu7t5v0__fillcap_4
Xspi_regs_inst__1217_ spi_regs_inst__1217_/A1 spi_regs_inst__1252_/A2 spi_regs_inst__1290_/A2
+ _10_/A1 spi_regs_inst__1219_/A3 VDD VDD VSS VSS gf180mcu_fd_sc_mcu7t5v0__aoi22_1
XFILLER_103_407 VDD VDD VSS VSS gf180mcu_fd_sc_mcu7t5v0__fillcap_4
XFILLER_66_1017 VDD VDD VSS VSS gf180mcu_fd_sc_mcu7t5v0__fillcap_64
Xspi_regs_inst__1148_ spi_regs_inst__1501_/Q spi_regs_inst__1195_/B1 spi_regs_inst__1148_/B1
+ spi_regs_inst__1148_/B2 spi_regs_inst__1152_/A1 VDD VDD VSS VSS gf180mcu_fd_sc_mcu7t5v0__aoi22_1
XFILLER_143_598 VDD VDD VSS VSS gf180mcu_fd_sc_mcu7t5v0__fill_1
XFILLER_88_107 VDD VDD VSS VSS gf180mcu_fd_sc_mcu7t5v0__fillcap_8
Xwave_controller_x_inst__2900_ wave_controller_x_inst__3557_/A1 wave_controller_x_inst__2896_/B
+ wave_controller_x_inst__2909_/A3 wave_controller_x_inst__2908_/A1 VDD VDD VSS VSS
+ gf180mcu_fd_sc_mcu7t5v0__nor3_1
Xwave_controller_x_inst__2831_ wave_controller_x_inst__2831_/A1 wave_controller_x_inst__2831_/A2
+ wave_controller_x_inst__2831_/B wave_controller_x_inst__2833_/A2 VDD VDD VSS VSS
+ gf180mcu_fd_sc_mcu7t5v0__oai21_1
Xspi_regs_inst__1079_ fanout519/Z spi_regs_inst__1314_/A2 spi_regs_inst__1146_/A2
+ spi_regs_inst__1079_/B2 spi_regs_inst__1122_/A1 VDD VDD VSS VSS gf180mcu_fd_sc_mcu7t5v0__aoi22_1
XFILLER_111_473 VDD VDD VSS VSS gf180mcu_fd_sc_mcu7t5v0__fill_1
XFILLER_97_674 VDD VDD VSS VSS gf180mcu_fd_sc_mcu7t5v0__fill_2
XFILLER_96_195 VDD VDD VSS VSS gf180mcu_fd_sc_mcu7t5v0__fillcap_4
Xwave_controller_x_inst__2762_ wave_controller_x_inst__2762_/I wave_controller_x_inst__3091_/A1
+ VDD VDD VSS VSS gf180mcu_fd_sc_mcu7t5v0__inv_1
XFILLER_84_357 VDD VDD VSS VSS gf180mcu_fd_sc_mcu7t5v0__fillcap_4
Xwave_controller_x_inst__2693_ wave_controller_x_inst__2694_/A1 wave_controller_x_inst__2694_/A2
+ wave_controller_x_inst__2693_/B wave_controller_x_inst__2712_/C VDD VDD VSS VSS
+ gf180mcu_fd_sc_mcu7t5v0__aoi21_1
XFILLER_93_880 VDD VDD VSS VSS gf180mcu_fd_sc_mcu7t5v0__fillcap_16
XFILLER_16_37 VDD VDD VSS VSS gf180mcu_fd_sc_mcu7t5v0__fillcap_64
XTAP_TAPCELL_ROW_15_1_445 VDD VSS gf180mcu_fd_sc_mcu7t5v0__filltie
Xwave_controller_y_inst_load_slew572 wave_controller_y_inst__3696_/RN wave_controller_y_inst__3699_/RN
+ VDD VDD VSS VSS gf180mcu_fd_sc_mcu7t5v0__buf_4
XFILLER_12_107 VDD VDD VSS VSS gf180mcu_fd_sc_mcu7t5v0__fillcap_8
XFILLER_25_468 VDD VDD VSS VSS gf180mcu_fd_sc_mcu7t5v0__fillcap_16
Xwave_controller_y_inst__3330_ wave_controller_y_inst__3326_/Z wave_controller_y_inst__3398_/A2
+ wave_controller_y_inst__3333_/B VDD VDD VSS VSS gf180mcu_fd_sc_mcu7t5v0__nor2_1
Xwave_controller_x_inst__3314_ wave_controller_x_inst__3358_/A2 wave_controller_x_inst__3358_/A3
+ wave_controller_x_inst__3314_/B wave_controller_x_inst__3359_/A1 VDD VDD VSS VSS
+ gf180mcu_fd_sc_mcu7t5v0__oai21_1
Xclkbuf_leaf_32_clk clkload0/I clkload35/I VDD VDD VSS VSS gf180mcu_fd_sc_mcu7t5v0__clkbuf_8
XFILLER_139_838 VDD VDD VSS VSS gf180mcu_fd_sc_mcu7t5v0__fill_2
Xwave_controller_y_inst__3261_ wave_controller_y_inst__3189_/C spi_regs_inst__1617_/Q
+ wave_controller_y_inst__3338_/B VDD VDD VSS VSS gf180mcu_fd_sc_mcu7t5v0__nand2_1
Xwave_controller_x_inst__3245_ wave_controller_x_inst__3245_/A1 wave_controller_x_inst__3245_/A2
+ wave_controller_x_inst__3243_/Z wave_controller_x_inst__3245_/B2 wave_controller_x_inst__3245_/C
+ wave_controller_x_inst__3246_/B2 VDD VDD VSS VSS gf180mcu_fd_sc_mcu7t5v0__aoi221_1
XFILLER_138_337 VDD VDD VSS VSS gf180mcu_fd_sc_mcu7t5v0__fill_2
Xwave_controller_y_inst__3192_ wave_controller_y_inst__3255_/A1 wave_controller_y_inst__3255_/A2
+ wave_controller_y_inst__3192_/B wave_controller_y_inst__3256_/A1 VDD VDD VSS VSS
+ gf180mcu_fd_sc_mcu7t5v0__oai21_1
Xwave_controller_y_inst__2212_ wave_controller_y_inst__2209_/I wave_controller_y_inst__2248_/A2
+ wave_controller_y_inst__2212_/Z VDD VDD VSS VSS gf180mcu_fd_sc_mcu7t5v0__xor2_1
Xwave_controller_x_inst__3176_ wave_controller_x_inst__3081_/B spi_regs_inst__1515_/Q
+ wave_controller_x_inst__3249_/A2 VDD VDD VSS VSS gf180mcu_fd_sc_mcu7t5v0__nor2_1
XFILLER_101_1122 VDD VDD VSS VSS gf180mcu_fd_sc_mcu7t5v0__fillcap_32
XFILLER_107_702 VDD VDD VSS VSS gf180mcu_fd_sc_mcu7t5v0__fillcap_4
XFILLER_119_562 VDD VDD VSS VSS gf180mcu_fd_sc_mcu7t5v0__fill_1
XFILLER_153_307 VDD VDD VSS VSS gf180mcu_fd_sc_mcu7t5v0__fill_2
Xwave_controller_y_inst__2143_ wave_controller_y_inst__3731_/Q wave_controller_y_inst__2149_/A1
+ wave_controller_y_inst__2143_/A3 wave_controller_y_inst__3731_/D VDD VDD VSS VSS
+ gf180mcu_fd_sc_mcu7t5v0__xor3_1
Xwave_controller_x_inst__2127_ wave_controller_x_inst__2144_/A2 wave_controller_x_inst__2130_/A1
+ wave_controller_x_inst__2137_/A2 VDD VDD VSS VSS gf180mcu_fd_sc_mcu7t5v0__nor2_1
XFILLER_146_381 VDD VDD VSS VSS gf180mcu_fd_sc_mcu7t5v0__fillcap_4
XFILLER_4_317 VDD VDD VSS VSS gf180mcu_fd_sc_mcu7t5v0__fillcap_64
Xwave_controller_y_inst__2074_ wave_controller_y_inst__2079_/B wave_controller_y_inst__2109_/B
+ wave_controller_y_inst__2074_/A3 wave_controller_y_inst__2074_/A4 wave_controller_y_inst__2074_/Z
+ VDD VDD VSS VSS gf180mcu_fd_sc_mcu7t5v0__and4_1
XTAP_TAPCELL_ROW_95_1443 VDD VSS gf180mcu_fd_sc_mcu7t5v0__filltie
Xwave_controller_x_inst__2058_ wave_controller_x_inst__2109_/B wave_controller_x_inst__2128_/A2
+ wave_controller_x_inst__2058_/B wave_controller_x_inst__2058_/C wave_controller_x_inst__2062_/A2
+ VDD VDD VSS VSS gf180mcu_fd_sc_mcu7t5v0__aoi211_1
XFILLER_0_512 VDD VDD VSS VSS gf180mcu_fd_sc_mcu7t5v0__fillcap_32
Xwave_controller_x_inst_fanout324 wave_controller_x_inst__2905_/ZN wave_controller_x_inst__3494_/A1
+ VDD VDD VSS VSS gf180mcu_fd_sc_mcu7t5v0__dlyb_1
XFILLER_102_451 VDD VDD VSS VSS gf180mcu_fd_sc_mcu7t5v0__fillcap_4
XFILLER_48_527 VDD VDD VSS VSS gf180mcu_fd_sc_mcu7t5v0__fillcap_4
Xwave_controller_y_inst__2976_ wave_controller_y_inst__3058_/A3 wave_controller_y_inst__2976_/A2
+ wave_controller_y_inst__2976_/B wave_controller_y_inst__3061_/A1 VDD VDD VSS VSS
+ gf180mcu_fd_sc_mcu7t5v0__oai21_1
Xwave_controller_x_inst_fanout379 wave_controller_x_inst__1911_/ZN wave_controller_x_inst__3465_/B
+ VDD VDD VSS VSS gf180mcu_fd_sc_mcu7t5v0__dlyb_1
XPHY_EDGE_ROW_82_Left_249 VDD VSS gf180mcu_fd_sc_mcu7t5v0__endcap
Xwave_controller_y_inst__1927_ wave_controller_y_inst__3305_/B2 spi_regs_inst__1570_/Q
+ spi_regs_inst__1569_/Q wave_controller_y_inst__3572_/A1 wave_controller_y_inst__1927_/C
+ wave_controller_y_inst__1929_/A1 VDD VDD VSS VSS gf180mcu_fd_sc_mcu7t5v0__aoi221_1
XFILLER_113_50 VDD VDD VSS VSS gf180mcu_fd_sc_mcu7t5v0__fillcap_8
XFILLER_16_413 VDD VDD VSS VSS gf180mcu_fd_sc_mcu7t5v0__fill_1
XFILLER_56_593 VDD VDD VSS VSS gf180mcu_fd_sc_mcu7t5v0__fill_2
Xwave_controller_y_inst__1858_ spi_regs_inst__1034_/A1 wave_controller_y_inst__2786_/A1
+ VDD VDD VSS VSS gf180mcu_fd_sc_mcu7t5v0__clkinv_1
XFILLER_16_435 VDD VDD VSS VSS gf180mcu_fd_sc_mcu7t5v0__fill_2
XFILLER_16_457 VDD VDD VSS VSS gf180mcu_fd_sc_mcu7t5v0__fillcap_16
XTAP_TAPCELL_ROW_54_761 VDD VSS gf180mcu_fd_sc_mcu7t5v0__filltie
XTAP_TAPCELL_ROW_54_772 VDD VSS gf180mcu_fd_sc_mcu7t5v0__filltie
Xwave_controller_y_inst__3528_ wave_controller_y_inst__3712_/Q wave_controller_y_inst__3528_/A2
+ wave_controller_y_inst__3530_/A2 VDD VDD VSS VSS gf180mcu_fd_sc_mcu7t5v0__nor2_1
Xwave_controller_y_inst__1789_ wave_controller_y_inst__3711_/Q wave_controller_y_inst__3163_/C
+ VDD VDD VSS VSS gf180mcu_fd_sc_mcu7t5v0__clkinv_1
XFILLER_106_1011 VDD VDD VSS VSS gf180mcu_fd_sc_mcu7t5v0__fillcap_4
XTAP_TAPCELL_ROW_104_1594 VDD VSS gf180mcu_fd_sc_mcu7t5v0__filltie
Xwave_controller_x_inst_max_cap374 wave_controller_x_inst__2037_/Z wave_controller_x_inst__2073_/A2
+ VDD VDD VSS VSS gf180mcu_fd_sc_mcu7t5v0__clkbuf_2
Xclkbuf_leaf_23_clk clkbuf_3_5__f_clk/Z clkload27/I VDD VDD VSS VSS gf180mcu_fd_sc_mcu7t5v0__clkbuf_8
XFILLER_157_613 VDD VDD VSS VSS gf180mcu_fd_sc_mcu7t5v0__fill_1
Xwave_controller_y_inst__3459_ wave_controller_y_inst__3490_/A1 wave_controller_y_inst__3459_/A2
+ wave_controller_y_inst__3459_/Z VDD VDD VSS VSS gf180mcu_fd_sc_mcu7t5v0__or2_1
XFILLER_156_123 VDD VDD VSS VSS gf180mcu_fd_sc_mcu7t5v0__fillcap_4
Xsignal_processor_x_inst__118_ signal_processor_x_inst__128_/A1 signal_processor_x_inst__254_/Q
+ signal_processor_x_inst__255_/D VDD VDD VSS VSS gf180mcu_fd_sc_mcu7t5v0__and2_1
XPHY_EDGE_ROW_91_Left_258 VDD VSS gf180mcu_fd_sc_mcu7t5v0__endcap
XFILLER_144_329 VDD VDD VSS VSS gf180mcu_fd_sc_mcu7t5v0__fill_2
XFILLER_153_830 VDD VDD VSS VSS gf180mcu_fd_sc_mcu7t5v0__fillcap_8
XFILLER_125_543 VDD VDD VSS VSS gf180mcu_fd_sc_mcu7t5v0__fillcap_4
XFILLER_99_906 VDD VDD VSS VSS gf180mcu_fd_sc_mcu7t5v0__fillcap_4
Xstate_machine_inst__32_ spi_regs_inst__1079_/B2 state_machine_inst__37_/A1 state_machine_inst__35_/B
+ VDD VDD VSS VSS gf180mcu_fd_sc_mcu7t5v0__nor2_1
Xspi_regs_inst__1002_ spi_regs_inst__1029_/A1 spi_regs_inst__1002_/A2 spi_regs_inst__1336_/B1
+ VDD VDD VSS VSS gf180mcu_fd_sc_mcu7t5v0__nor2_1
XFILLER_140_513 VDD VDD VSS VSS gf180mcu_fd_sc_mcu7t5v0__fill_1
XFILLER_152_384 VDD VDD VSS VSS gf180mcu_fd_sc_mcu7t5v0__fill_1
XFILLER_3_372 VDD VDD VSS VSS gf180mcu_fd_sc_mcu7t5v0__fill_2
XFILLER_3_394 VDD VDD VSS VSS gf180mcu_fd_sc_mcu7t5v0__fill_1
XFILLER_79_652 VDD VDD VSS VSS gf180mcu_fd_sc_mcu7t5v0__fill_2
XFILLER_67_825 VDD VDD VSS VSS gf180mcu_fd_sc_mcu7t5v0__fill_1
XFILLER_79_663 VDD VDD VSS VSS gf180mcu_fd_sc_mcu7t5v0__fillcap_8
XFILLER_121_782 VDD VDD VSS VSS gf180mcu_fd_sc_mcu7t5v0__fillcap_16
XFILLER_67_858 VDD VDD VSS VSS gf180mcu_fd_sc_mcu7t5v0__fillcap_8
XFILLER_78_173 VDD VDD VSS VSS gf180mcu_fd_sc_mcu7t5v0__fill_2
XFILLER_54_519 VDD VDD VSS VSS gf180mcu_fd_sc_mcu7t5v0__fillcap_4
XFILLER_66_379 VDD VDD VSS VSS gf180mcu_fd_sc_mcu7t5v0__fillcap_4
XFILLER_75_891 VDD VDD VSS VSS gf180mcu_fd_sc_mcu7t5v0__fillcap_16
XTAP_TAPCELL_ROW_124_1915 VDD VSS gf180mcu_fd_sc_mcu7t5v0__filltie
XTAP_TAPCELL_ROW_124_1926 VDD VSS gf180mcu_fd_sc_mcu7t5v0__filltie
XFILLER_34_243 VDD VDD VSS VSS gf180mcu_fd_sc_mcu7t5v0__fill_2
XFILLER_62_552 VDD VDD VSS VSS gf180mcu_fd_sc_mcu7t5v0__fillcap_8
XFILLER_81_349 VDD VDD VSS VSS gf180mcu_fd_sc_mcu7t5v0__fill_1
XFILLER_34_276 VDD VDD VSS VSS gf180mcu_fd_sc_mcu7t5v0__fillcap_4
XTAP_TAPCELL_ROW_157_2469 VDD VSS gf180mcu_fd_sc_mcu7t5v0__filltie
Xclkbuf_leaf_14_clk clkbuf_leaf_8_clk/I clkbuf_leaf_14_clk/Z VDD VDD VSS VSS gf180mcu_fd_sc_mcu7t5v0__clkbuf_8
XFILLER_72_1087 VDD VDD VSS VSS gf180mcu_fd_sc_mcu7t5v0__fillcap_64
Xwave_controller_x_inst__3030_ wave_controller_x_inst__3697_/Q wave_controller_x_inst__3030_/A2
+ wave_controller_x_inst__3031_/B VDD VDD VSS VSS gf180mcu_fd_sc_mcu7t5v0__nand2_1
XFILLER_147_156 VDD VDD VSS VSS gf180mcu_fd_sc_mcu7t5v0__fillcap_16
XTAP_TAPCELL_ROW_77_1140 VDD VSS gf180mcu_fd_sc_mcu7t5v0__filltie
XTAP_TAPCELL_ROW_77_1151 VDD VSS gf180mcu_fd_sc_mcu7t5v0__filltie
XFILLER_89_416 VDD VDD VSS VSS gf180mcu_fd_sc_mcu7t5v0__fillcap_4
XFILLER_112_771 VDD VDD VSS VSS gf180mcu_fd_sc_mcu7t5v0__fillcap_8
XTAP_TAPCELL_ROW_90_1362 VDD VSS gf180mcu_fd_sc_mcu7t5v0__filltie
Xwave_controller_y_inst__2830_ spi_regs_inst__1285_/B2 wave_controller_y_inst__2831_/A2
+ wave_controller_y_inst__2831_/B VDD VDD VSS VSS gf180mcu_fd_sc_mcu7t5v0__nand2_1
Xwave_controller_x_inst__2814_ spi_regs_inst__1085_/C2 wave_controller_x_inst__2793_/S
+ wave_controller_x_inst__2815_/B VDD VDD VSS VSS gf180mcu_fd_sc_mcu7t5v0__nand2_1
XFILLER_27_36 VDD VDD VSS VSS gf180mcu_fd_sc_mcu7t5v0__fillcap_16
XFILLER_57_368 VDD VDD VSS VSS gf180mcu_fd_sc_mcu7t5v0__fillcap_16
XFILLER_84_154 VDD VDD VSS VSS gf180mcu_fd_sc_mcu7t5v0__fillcap_16
Xwave_controller_y_inst__2761_ wave_controller_y_inst__3039_/A1 wave_controller_y_inst__3092_/A1
+ wave_controller_y_inst_wire147/I VDD VDD VSS VSS gf180mcu_fd_sc_mcu7t5v0__nand2_1
Xwave_controller_x_inst__2745_ spi_regs_inst__1188_/C1 wave_controller_x_inst__2743_/Z
+ wave_controller_x_inst__2745_/Z VDD VDD VSS VSS gf180mcu_fd_sc_mcu7t5v0__xor2_1
XFILLER_85_688 VDD VDD VSS VSS gf180mcu_fd_sc_mcu7t5v0__fillcap_4
Xwave_controller_y_inst__2692_ fanout513/Z max_cap431/Z wave_controller_y_inst__2689_/Z
+ wave_controller_y_inst__2693_/B VDD VDD VSS VSS gf180mcu_fd_sc_mcu7t5v0__xor3_1
Xwave_controller_x_inst__2676_ wave_controller_x_inst__2674_/Z wave_controller_x_inst__2678_/A2
+ wave_controller_x_inst__2676_/Z VDD VDD VSS VSS gf180mcu_fd_sc_mcu7t5v0__or2_1
XFILLER_13_416 VDD VDD VSS VSS gf180mcu_fd_sc_mcu7t5v0__fillcap_4
XFILLER_81_872 VDD VDD VSS VSS gf180mcu_fd_sc_mcu7t5v0__fillcap_4
XFILLER_13_438 VDD VDD VSS VSS gf180mcu_fd_sc_mcu7t5v0__fill_1
XFILLER_138_101 VDD VDD VSS VSS gf180mcu_fd_sc_mcu7t5v0__fillcap_4
XFILLER_43_68 VDD VDD VSS VSS gf180mcu_fd_sc_mcu7t5v0__fill_2
XFILLER_90_1165 VDD VDD VSS VSS gf180mcu_fd_sc_mcu7t5v0__fill_2
Xwave_controller_y_inst__3313_ wave_controller_y_inst__3313_/I wave_controller_y_inst__3358_/A3
+ VDD VDD VSS VSS gf180mcu_fd_sc_mcu7t5v0__clkinv_1
XFILLER_138_123 VDD VDD VSS VSS gf180mcu_fd_sc_mcu7t5v0__fillcap_8
Xwave_controller_y_inst__3244_ wave_controller_y_inst__1818_/I wave_controller_y_inst__3244_/A2
+ wave_controller_y_inst__3204_/Z wave_controller_y_inst__1819_/I wave_controller_y_inst__3245_/B2
+ VDD VDD VSS VSS gf180mcu_fd_sc_mcu7t5v0__aoi22_1
Xwave_controller_x_inst__3228_ wave_controller_x_inst__3228_/A1 wave_controller_x_inst__3228_/A2
+ wave_controller_x_inst__3233_/B1 VDD VDD VSS VSS gf180mcu_fd_sc_mcu7t5v0__nand2_1
XFILLER_154_605 VDD VDD VSS VSS gf180mcu_fd_sc_mcu7t5v0__fill_2
XFILLER_154_616 VDD VDD VSS VSS gf180mcu_fd_sc_mcu7t5v0__fill_1
XFILLER_166_454 VDD VDD VSS VSS gf180mcu_fd_sc_mcu7t5v0__fill_1
XFILLER_167_988 VDD VDD VSS VSS gf180mcu_fd_sc_mcu7t5v0__fill_1
Xwave_controller_y_inst__3175_ wave_controller_y_inst__3718_/Q spi_regs_inst__1579_/Q
+ wave_controller_y_inst__3175_/Z VDD VDD VSS VSS gf180mcu_fd_sc_mcu7t5v0__xor2_1
Xwave_controller_x_inst__3159_ wave_controller_x_inst__3154_/Z wave_controller_x_inst__3205_/A2
+ wave_controller_x_inst__3159_/B wave_controller_x_inst__3206_/A1 VDD VDD VSS VSS
+ gf180mcu_fd_sc_mcu7t5v0__oai21_1
Xwave_controller_y_inst__2126_ wave_controller_y_inst__2058_/C wave_controller_y_inst__2051_/Z
+ wave_controller_y_inst__2138_/B1 wave_controller_y_inst__2130_/A2 VDD VDD VSS VSS
+ gf180mcu_fd_sc_mcu7t5v0__nand3_1
XFILLER_108_50 VDD VDD VSS VSS gf180mcu_fd_sc_mcu7t5v0__fill_1
XFILLER_122_524 VDD VDD VSS VSS gf180mcu_fd_sc_mcu7t5v0__fill_1
XFILLER_134_373 VDD VDD VSS VSS gf180mcu_fd_sc_mcu7t5v0__fillcap_8
XPHY_EDGE_ROW_23_1_Right_22 VDD VSS gf180mcu_fd_sc_mcu7t5v0__endcap
Xwave_controller_y_inst__2057_ wave_controller_y_inst__2079_/A1 wave_controller_y_inst__2093_/A3
+ wave_controller_y_inst__2058_/B VDD VDD VSS VSS gf180mcu_fd_sc_mcu7t5v0__nor2_1
Xspi_regs_inst_fanout611 fanout620/Z spi_regs_inst__1648_/RN VDD VDD VSS VSS gf180mcu_fd_sc_mcu7t5v0__dlyb_1
XFILLER_0_342 VDD VDD VSS VSS gf180mcu_fd_sc_mcu7t5v0__fillcap_32
XFILLER_150_877 VDD VDD VSS VSS gf180mcu_fd_sc_mcu7t5v0__fillcap_64
XFILLER_89_972 VDD VDD VSS VSS gf180mcu_fd_sc_mcu7t5v0__fillcap_8
Xspi_regs_inst_wire190 spi_regs_inst_wire190/I spi_regs_inst_wire190/Z VDD VDD VSS
+ VSS gf180mcu_fd_sc_mcu7t5v0__clkbuf_1
XFILLER_88_471 VDD VDD VSS VSS gf180mcu_fd_sc_mcu7t5v0__fillcap_16
Xwave_controller_x_inst_fanout165 wave_controller_x_inst_wire166/Z wave_controller_x_inst__2762_/I
+ VDD VDD VSS VSS gf180mcu_fd_sc_mcu7t5v0__dlyb_1
XFILLER_36_508 VDD VDD VSS VSS gf180mcu_fd_sc_mcu7t5v0__fill_1
XTAP_TAPCELL_ROW_59_853 VDD VSS gf180mcu_fd_sc_mcu7t5v0__filltie
Xwave_controller_y_inst__2959_ wave_controller_y_inst__3703_/Q fanout507/Z wave_controller_y_inst__2960_/I
+ VDD VDD VSS VSS gf180mcu_fd_sc_mcu7t5v0__nand2_1
XFILLER_57_891 VDD VDD VSS VSS gf180mcu_fd_sc_mcu7t5v0__fillcap_16
XFILLER_90_102 VDD VDD VSS VSS gf180mcu_fd_sc_mcu7t5v0__fill_2
XTAP_TAPCELL_ROW_141_2204 VDD VSS gf180mcu_fd_sc_mcu7t5v0__filltie
XFILLER_112_1081 VDD VDD VSS VSS gf180mcu_fd_sc_mcu7t5v0__fillcap_4
XFILLER_16_210 VDD VDD VSS VSS gf180mcu_fd_sc_mcu7t5v0__fillcap_4
XFILLER_63_349 VDD VDD VSS VSS gf180mcu_fd_sc_mcu7t5v0__fill_1
XTAP_TAPCELL_ROW_106_1623 VDD VSS gf180mcu_fd_sc_mcu7t5v0__filltie
XTAP_TAPCELL_ROW_106_1634 VDD VSS gf180mcu_fd_sc_mcu7t5v0__filltie
Xspi_regs_inst__1620_ spi_regs_inst__1620_/D fanout584/Z clkbuf_leaf_13_clk/Z spi_regs_inst__1620_/Q
+ VDD VDD VSS VSS gf180mcu_fd_sc_mcu7t5v0__dffrnq_1
XFILLER_147_1122 VDD VDD VSS VSS gf180mcu_fd_sc_mcu7t5v0__fillcap_32
XFILLER_72_861 VDD VDD VSS VSS gf180mcu_fd_sc_mcu7t5v0__fill_1
Xwave_controller_y_inst_load_slew55 wave_controller_y_inst__3606_/A1 wave_controller_y_inst__3597_/S
+ VDD VDD VSS VSS gf180mcu_fd_sc_mcu7t5v0__buf_4
Xspi_regs_inst__1551_ spi_regs_inst__1551_/D spi_regs_inst__1551_/RN clkload30/I spi_regs_inst__1551_/Q
+ VDD VDD VSS VSS gf180mcu_fd_sc_mcu7t5v0__dffrnq_1
XFILLER_31_202 VDD VDD VSS VSS gf180mcu_fd_sc_mcu7t5v0__fillcap_8
XFILLER_71_371 VDD VDD VSS VSS gf180mcu_fd_sc_mcu7t5v0__fillcap_4
Xspi_regs_inst__1482_ spi_regs_inst__1482_/D fanout564/Z clkbuf_leaf_7_clk/Z spi_regs_inst__1482_/Q
+ VDD VDD VSS VSS gf180mcu_fd_sc_mcu7t5v0__dffrnq_1
XFILLER_31_279 VDD VDD VSS VSS gf180mcu_fd_sc_mcu7t5v0__fill_1
XTAP_TAPCELL_ROW_139_2166 VDD VSS gf180mcu_fd_sc_mcu7t5v0__filltie
XTAP_TAPCELL_ROW_139_2177 VDD VSS gf180mcu_fd_sc_mcu7t5v0__filltie
XFILLER_118_819 VDD VDD VSS VSS gf180mcu_fd_sc_mcu7t5v0__fill_1
XFILLER_117_318 VDD VDD VSS VSS gf180mcu_fd_sc_mcu7t5v0__fillcap_32
XFILLER_144_115 VDD VDD VSS VSS gf180mcu_fd_sc_mcu7t5v0__fillcap_4
XTAP_TAPCELL_ROW_152_2377 VDD VSS gf180mcu_fd_sc_mcu7t5v0__filltie
XTAP_TAPCELL_ROW_152_2388 VDD VSS gf180mcu_fd_sc_mcu7t5v0__filltie
XTAP_TAPCELL_ROW_14_1_433 VDD VSS gf180mcu_fd_sc_mcu7t5v0__filltie
XFILLER_99_769 VDD VDD VSS VSS gf180mcu_fd_sc_mcu7t5v0__fill_1
XFILLER_141_888 VDD VDD VSS VSS gf180mcu_fd_sc_mcu7t5v0__fillcap_16
XTAP_TAPCELL_ROW_72_1070 VDD VSS gf180mcu_fd_sc_mcu7t5v0__filltie
Xclkbuf_leaf_3_clk clkbuf_leaf_3_clk/I _21_/CLK VDD VDD VSS VSS gf180mcu_fd_sc_mcu7t5v0__clkbuf_8
XFILLER_100_229 VDD VDD VSS VSS gf180mcu_fd_sc_mcu7t5v0__fill_1
XFILLER_140_387 VDD VDD VSS VSS gf180mcu_fd_sc_mcu7t5v0__fillcap_8
Xwave_controller_x_inst__2530_ wave_controller_x_inst__2555_/C wave_controller_x_inst__2556_/C
+ VDD VDD VSS VSS gf180mcu_fd_sc_mcu7t5v0__clkinv_1
XFILLER_50_500 VDD VDD VSS VSS gf180mcu_fd_sc_mcu7t5v0__fill_2
XFILLER_62_360 VDD VDD VSS VSS gf180mcu_fd_sc_mcu7t5v0__fillcap_4
Xwave_controller_x_inst__2461_ wave_controller_x_inst__2462_/B wave_controller_x_inst__2463_/B
+ VDD VDD VSS VSS gf180mcu_fd_sc_mcu7t5v0__clkinv_1
XPHY_EDGE_ROW_138_Left_305 VDD VSS gf180mcu_fd_sc_mcu7t5v0__endcap
Xwave_controller_x_inst__2392_ wave_controller_x_inst__2392_/A1 wave_controller_x_inst__2392_/A2
+ spi_regs_inst__1342_/B2 VDD VDD VSS VSS gf180mcu_fd_sc_mcu7t5v0__xor2_1
XFILLER_109_808 VDD VDD VSS VSS gf180mcu_fd_sc_mcu7t5v0__fillcap_4
XFILLER_136_605 VDD VDD VSS VSS gf180mcu_fd_sc_mcu7t5v0__fill_1
XFILLER_164_947 VDD VDD VSS VSS gf180mcu_fd_sc_mcu7t5v0__fillcap_64
Xwave_controller_x_inst__3013_ wave_controller_x_inst__3693_/Q wave_controller_x_inst__3692_/Q
+ wave_controller_x_inst__3017_/A2 VDD VDD VSS VSS gf180mcu_fd_sc_mcu7t5v0__nand2_1
XFILLER_135_137 VDD VDD VSS VSS gf180mcu_fd_sc_mcu7t5v0__fill_2
XFILLER_163_446 VDD VDD VSS VSS gf180mcu_fd_sc_mcu7t5v0__fillcap_8
XFILLER_163_468 VDD VDD VSS VSS gf180mcu_fd_sc_mcu7t5v0__fillcap_8
Xwave_controller_x_inst_wire36 wave_controller_x_inst_wire36/I wave_controller_x_inst_wire36/Z
+ VDD VDD VSS VSS gf180mcu_fd_sc_mcu7t5v0__clkbuf_1
XTAP_TAPCELL_ROW_92_1402 VDD VSS gf180mcu_fd_sc_mcu7t5v0__filltie
XFILLER_104_524 VDD VDD VSS VSS gf180mcu_fd_sc_mcu7t5v0__fill_1
XFILLER_104_535 VDD VDD VSS VSS gf180mcu_fd_sc_mcu7t5v0__fill_2
XFILLER_116_384 VDD VDD VSS VSS gf180mcu_fd_sc_mcu7t5v0__fill_1
XFILLER_131_332 VDD VDD VSS VSS gf180mcu_fd_sc_mcu7t5v0__fill_2
XFILLER_143_170 VDD VDD VSS VSS gf180mcu_fd_sc_mcu7t5v0__fill_1
XFILLER_143_192 VDD VDD VSS VSS gf180mcu_fd_sc_mcu7t5v0__fillcap_4
XPHY_EDGE_ROW_147_Left_314 VDD VSS gf180mcu_fd_sc_mcu7t5v0__endcap
XFILLER_132_877 VDD VDD VSS VSS gf180mcu_fd_sc_mcu7t5v0__fillcap_4
XFILLER_77_419 VDD VDD VSS VSS gf180mcu_fd_sc_mcu7t5v0__fill_1
XFILLER_86_942 VDD VDD VSS VSS gf180mcu_fd_sc_mcu7t5v0__fill_2
XFILLER_85_441 VDD VDD VSS VSS gf180mcu_fd_sc_mcu7t5v0__fill_1
Xwave_controller_y_inst__2813_ wave_controller_y_inst__3709_/Q wave_controller_y_inst__2817_/A2
+ wave_controller_y_inst__2813_/B1 wave_controller_y_inst__1792_/I wave_controller_y_inst__2818_/A2
+ VDD VDD VSS VSS gf180mcu_fd_sc_mcu7t5v0__oai22_1
XFILLER_57_154 VDD VDD VSS VSS gf180mcu_fd_sc_mcu7t5v0__fill_2
XPHY_EDGE_ROW_79_Right_79 VDD VSS gf180mcu_fd_sc_mcu7t5v0__endcap
XTAP_TAPCELL_ROW_56_801 VDD VSS gf180mcu_fd_sc_mcu7t5v0__filltie
Xwave_controller_y_inst__2744_ spi_regs_inst__1194_/B2 wave_controller_y_inst__2743_/Z
+ wave_controller_y_inst__2753_/A2 VDD VDD VSS VSS gf180mcu_fd_sc_mcu7t5v0__nor2_1
XTAP_TAPCELL_ROW_0_1_2666 VDD VSS gf180mcu_fd_sc_mcu7t5v0__filltie
Xwave_controller_x_inst__2728_ spi_regs_inst__1119_/A1 wave_controller_x_inst__2728_/A2
+ wave_controller_x_inst__2728_/B wave_controller_x_inst__2729_/I VDD VDD VSS VSS
+ gf180mcu_fd_sc_mcu7t5v0__aoi21_1
XFILLER_41_500 VDD VDD VSS VSS gf180mcu_fd_sc_mcu7t5v0__fill_1
XFILLER_54_34 VDD VDD VSS VSS gf180mcu_fd_sc_mcu7t5v0__fill_1
XFILLER_60_308 VDD VDD VSS VSS gf180mcu_fd_sc_mcu7t5v0__fill_2
XPHY_EDGE_ROW_156_Left_323 VDD VSS gf180mcu_fd_sc_mcu7t5v0__endcap
Xwave_controller_y_inst__2675_ spi_regs_inst__1285_/B2 wave_controller_y_inst__2675_/A2
+ wave_controller_y_inst__2675_/B wave_controller_y_inst__2678_/A2 VDD VDD VSS VSS
+ gf180mcu_fd_sc_mcu7t5v0__aoi21_1
Xwave_controller_x_inst__2659_ wave_controller_x_inst__3244_/B2 wave_controller_x_inst__2660_/A3
+ wave_controller_x_inst__2675_/A2 VDD VDD VSS VSS gf180mcu_fd_sc_mcu7t5v0__nand2_1
XFILLER_41_533 VDD VDD VSS VSS gf180mcu_fd_sc_mcu7t5v0__fillcap_16
XFILLER_53_382 VDD VDD VSS VSS gf180mcu_fd_sc_mcu7t5v0__fill_1
XFILLER_53_393 VDD VDD VSS VSS gf180mcu_fd_sc_mcu7t5v0__fill_1
XFILLER_81_691 VDD VDD VSS VSS gf180mcu_fd_sc_mcu7t5v0__fillcap_8
XFILLER_9_206 VDD VDD VSS VSS gf180mcu_fd_sc_mcu7t5v0__fillcap_4
XTAP_TAPCELL_ROW_101_1542 VDD VSS gf180mcu_fd_sc_mcu7t5v0__filltie
XFILLER_139_432 VDD VDD VSS VSS gf180mcu_fd_sc_mcu7t5v0__fill_1
XFILLER_127_605 VDD VDD VSS VSS gf180mcu_fd_sc_mcu7t5v0__fill_1
XFILLER_166_295 VDD VDD VSS VSS gf180mcu_fd_sc_mcu7t5v0__fill_1
XFILLER_5_401 VDD VDD VSS VSS gf180mcu_fd_sc_mcu7t5v0__fillcap_8
XPHY_EDGE_ROW_88_Right_88 VDD VSS gf180mcu_fd_sc_mcu7t5v0__endcap
Xwave_controller_y_inst__3227_ wave_controller_y_inst__3227_/A1 wave_controller_y_inst__3232_/B1
+ wave_controller_y_inst__3137_/B wave_controller_y_inst__3228_/A2 VDD VDD VSS VSS
+ gf180mcu_fd_sc_mcu7t5v0__nand3_1
XFILLER_5_434 VDD VDD VSS VSS gf180mcu_fd_sc_mcu7t5v0__fill_2
XTAP_TAPCELL_ROW_134_2085 VDD VSS gf180mcu_fd_sc_mcu7t5v0__filltie
Xwave_controller_y_inst__3158_ wave_controller_y_inst__3158_/I wave_controller_y_inst__3159_/B
+ VDD VDD VSS VSS gf180mcu_fd_sc_mcu7t5v0__clkinv_1
XFILLER_108_874 VDD VDD VSS VSS gf180mcu_fd_sc_mcu7t5v0__fill_1
XFILLER_108_896 VDD VDD VSS VSS gf180mcu_fd_sc_mcu7t5v0__fill_2
XFILLER_141_107 VDD VDD VSS VSS gf180mcu_fd_sc_mcu7t5v0__fill_2
XPHY_EDGE_ROW_165_Left_332 VDD VSS gf180mcu_fd_sc_mcu7t5v0__endcap
XTAP_TAPCELL_ROW_134_2096 VDD VSS gf180mcu_fd_sc_mcu7t5v0__filltie
Xwave_controller_y_inst__2109_ wave_controller_y_inst_wire356/Z wave_controller_y_inst__2109_/A2
+ wave_controller_y_inst__2109_/B wave_controller_y_inst__2144_/A2 VDD VDD VSS VSS
+ gf180mcu_fd_sc_mcu7t5v0__aoi21_1
XFILLER_107_395 VDD VDD VSS VSS gf180mcu_fd_sc_mcu7t5v0__fillcap_16
XFILLER_122_332 VDD VDD VSS VSS gf180mcu_fd_sc_mcu7t5v0__fill_1
XFILLER_134_181 VDD VDD VSS VSS gf180mcu_fd_sc_mcu7t5v0__fill_1
XFILLER_69_909 VDD VDD VSS VSS gf180mcu_fd_sc_mcu7t5v0__fill_1
Xwave_controller_y_inst__3089_ wave_controller_y_inst__3719_/Q wave_controller_y_inst__3089_/A2
+ wave_controller_y_inst__3089_/B wave_controller_y_inst__3090_/A3 VDD VDD VSS VSS
+ gf180mcu_fd_sc_mcu7t5v0__aoi21_1
XFILLER_122_343 VDD VDD VSS VSS gf180mcu_fd_sc_mcu7t5v0__fill_1
XFILLER_96_728 VDD VDD VSS VSS gf180mcu_fd_sc_mcu7t5v0__fillcap_4
XFILLER_0_172 VDD VDD VSS VSS gf180mcu_fd_sc_mcu7t5v0__fillcap_32
XFILLER_110_527 VDD VDD VSS VSS gf180mcu_fd_sc_mcu7t5v0__fillcap_8
XFILLER_77_920 VDD VDD VSS VSS gf180mcu_fd_sc_mcu7t5v0__fillcap_16
XFILLER_76_452 VDD VDD VSS VSS gf180mcu_fd_sc_mcu7t5v0__fill_2
XFILLER_95_249 VDD VDD VSS VSS gf180mcu_fd_sc_mcu7t5v0__fill_1
XPHY_EDGE_ROW_97_Right_97 VDD VSS gf180mcu_fd_sc_mcu7t5v0__endcap
Xspi_regs_inst_fanout474 spi_regs_inst__1391_/I1 spi_regs_inst__1451_/I1 VDD VDD VSS
+ VSS gf180mcu_fd_sc_mcu7t5v0__dlyb_1
Xspi_regs_inst__0982_ spi_regs_inst__0992_/A1 spi_regs_inst__1021_/A1 spi_regs_inst__1176_/A2
+ VDD VDD VSS VSS gf180mcu_fd_sc_mcu7t5v0__nor2_2
X_91_ _91_/I _91_/Z VDD VDD VSS VSS gf180mcu_fd_sc_mcu7t5v0__buf_1
XFILLER_114_1165 VDD VDD VSS VSS gf180mcu_fd_sc_mcu7t5v0__fillcap_4
XFILLER_76_463 VDD VDD VSS VSS gf180mcu_fd_sc_mcu7t5v0__fill_1
XFILLER_92_912 VDD VDD VSS VSS gf180mcu_fd_sc_mcu7t5v0__fillcap_8
XFILLER_95_96 VDD VDD VSS VSS gf180mcu_fd_sc_mcu7t5v0__fillcap_4
XFILLER_97_1116 VDD VDD VSS VSS gf180mcu_fd_sc_mcu7t5v0__fillcap_4
XFILLER_36_349 VDD VDD VSS VSS gf180mcu_fd_sc_mcu7t5v0__fillcap_4
XFILLER_63_146 VDD VDD VSS VSS gf180mcu_fd_sc_mcu7t5v0__fill_1
XFILLER_64_669 VDD VDD VSS VSS gf180mcu_fd_sc_mcu7t5v0__fill_1
XFILLER_17_541 VDD VDD VSS VSS gf180mcu_fd_sc_mcu7t5v0__fillcap_8
XFILLER_91_488 VDD VDD VSS VSS gf180mcu_fd_sc_mcu7t5v0__fill_2
XTAP_TAPCELL_ROW_17_1_459 VDD VSS gf180mcu_fd_sc_mcu7t5v0__filltie
Xspi_regs_inst__1603_ spi_regs_inst__1603_/D spi_regs_inst__1647_/RN clkbuf_leaf_39_clk/Z
+ spi_regs_inst__1603_/Q VDD VDD VSS VSS gf180mcu_fd_sc_mcu7t5v0__dffrnq_1
XFILLER_32_511 VDD VDD VSS VSS gf180mcu_fd_sc_mcu7t5v0__fill_1
XFILLER_32_522 VDD VDD VSS VSS gf180mcu_fd_sc_mcu7t5v0__fill_2
XFILLER_44_382 VDD VDD VSS VSS gf180mcu_fd_sc_mcu7t5v0__fill_2
Xspi_regs_inst__1534_ spi_regs_inst__1534_/D fanout591/Z clkbuf_leaf_13_clk/Z spi_regs_inst__1534_/Q
+ VDD VDD VSS VSS gf180mcu_fd_sc_mcu7t5v0__dffrnq_1
XFILLER_60_897 VDD VDD VSS VSS gf180mcu_fd_sc_mcu7t5v0__fillcap_8
XTAP_TAPCELL_ROW_154_2417 VDD VSS gf180mcu_fd_sc_mcu7t5v0__filltie
Xspi_regs_inst__1465_ spi_regs_inst__1465_/D spi_regs_inst__1551_/RN clkload30/I fanout537/I
+ VDD VDD VSS VSS gf180mcu_fd_sc_mcu7t5v0__dffrnq_1
XFILLER_146_947 VDD VDD VSS VSS gf180mcu_fd_sc_mcu7t5v0__fillcap_64
XFILLER_157_262 VDD VDD VSS VSS gf180mcu_fd_sc_mcu7t5v0__fill_2
XTAP_TAPCELL_ROW_119_1836 VDD VSS gf180mcu_fd_sc_mcu7t5v0__filltie
XTAP_TAPCELL_ROW_119_1847 VDD VSS gf180mcu_fd_sc_mcu7t5v0__filltie
Xspi_regs_inst__1396_ spi_regs_inst__1470_/Q spi_regs_inst__1429_/I1 spi_regs_inst__1402_/S
+ spi_regs_inst__1470_/D VDD VDD VSS VSS gf180mcu_fd_sc_mcu7t5v0__mux2_2
XFILLER_117_137 VDD VDD VSS VSS gf180mcu_fd_sc_mcu7t5v0__fill_2
XFILLER_145_457 VDD VDD VSS VSS gf180mcu_fd_sc_mcu7t5v0__fillcap_8
XFILLER_161_906 VDD VDD VSS VSS gf180mcu_fd_sc_mcu7t5v0__fillcap_4
XFILLER_67_2 VDD VDD VSS VSS gf180mcu_fd_sc_mcu7t5v0__fillcap_16
XFILLER_132_107 VDD VDD VSS VSS gf180mcu_fd_sc_mcu7t5v0__fillcap_4
XFILLER_133_619 VDD VDD VSS VSS gf180mcu_fd_sc_mcu7t5v0__fillcap_8
XFILLER_99_511 VDD VDD VSS VSS gf180mcu_fd_sc_mcu7t5v0__fillcap_16
XFILLER_114_844 VDD VDD VSS VSS gf180mcu_fd_sc_mcu7t5v0__fillcap_4
XFILLER_158_1081 VDD VDD VSS VSS gf180mcu_fd_sc_mcu7t5v0__fillcap_4
XFILLER_5_72 VDD VDD VSS VSS gf180mcu_fd_sc_mcu7t5v0__fillcap_64
XFILLER_113_354 VDD VDD VSS VSS gf180mcu_fd_sc_mcu7t5v0__fill_1
XFILLER_114_877 VDD VDD VSS VSS gf180mcu_fd_sc_mcu7t5v0__fill_1
XFILLER_115_18 VDD VDD VSS VSS gf180mcu_fd_sc_mcu7t5v0__fillcap_8
XTAP_TAPCELL_ROW_70_1029 VDD VSS gf180mcu_fd_sc_mcu7t5v0__filltie
Xwave_controller_x_inst__1961_ wave_controller_x_inst__1962_/A1 wave_controller_x_inst__1962_/A2
+ wave_controller_x_inst__1963_/A2 VDD VDD VSS VSS gf180mcu_fd_sc_mcu7t5v0__nand2_1
XFILLER_113_398 VDD VDD VSS VSS gf180mcu_fd_sc_mcu7t5v0__fillcap_4
XPHY_EDGE_ROW_163_Right_163 VDD VSS gf180mcu_fd_sc_mcu7t5v0__endcap
Xwave_controller_x_inst__3700_ wave_controller_x_inst__3700_/D wave_controller_x_inst__3736_/RN
+ clkbuf_leaf_22_clk/Z wave_controller_x_inst__3700_/Q VDD VDD VSS VSS gf180mcu_fd_sc_mcu7t5v0__dffsnq_1
XFILLER_86_249 VDD VDD VSS VSS gf180mcu_fd_sc_mcu7t5v0__fill_1
Xwave_controller_x_inst__3631_ wave_controller_x_inst__3631_/D wave_controller_x_inst__3706_/RN
+ clkload36/I spi_regs_inst__1212_/B2 VDD VDD VSS VSS gf180mcu_fd_sc_mcu7t5v0__dffrnq_1
Xwave_controller_x_inst__1892_ wave_controller_x_inst__3693_/Q wave_controller_x_inst__3430_/A1
+ VDD VDD VSS VSS gf180mcu_fd_sc_mcu7t5v0__clkinv_1
XFILLER_27_316 VDD VDD VSS VSS gf180mcu_fd_sc_mcu7t5v0__fillcap_4
XFILLER_95_772 VDD VDD VSS VSS gf180mcu_fd_sc_mcu7t5v0__fillcap_16
XFILLER_55_669 VDD VDD VSS VSS gf180mcu_fd_sc_mcu7t5v0__fillcap_4
Xwave_controller_x_inst__3562_ wave_controller_x_inst__3562_/A1 wave_controller_x_inst_wire333/Z
+ wave_controller_x_inst__3596_/I0 VDD VDD VSS VSS gf180mcu_fd_sc_mcu7t5v0__nor2_1
XFILLER_42_308 VDD VDD VSS VSS gf180mcu_fd_sc_mcu7t5v0__fillcap_4
Xwave_controller_x_inst__3493_ wave_controller_x_inst__3494_/A1 wave_controller_x_inst__3494_/A2
+ wave_controller_x_inst__3493_/Z VDD VDD VSS VSS gf180mcu_fd_sc_mcu7t5v0__and2_1
Xwave_controller_x_inst__2513_ wave_controller_x_inst__2521_/A1 spi_regs_inst__1311_/B2
+ wave_controller_x_inst__2534_/B VDD VDD VSS VSS gf180mcu_fd_sc_mcu7t5v0__nor2_1
XFILLER_165_1052 VDD VDD VSS VSS gf180mcu_fd_sc_mcu7t5v0__fillcap_64
XFILLER_23_511 VDD VDD VSS VSS gf180mcu_fd_sc_mcu7t5v0__fill_2
XFILLER_70_639 VDD VDD VSS VSS gf180mcu_fd_sc_mcu7t5v0__fill_2
XTAP_TAPCELL_ROW_85_1272 VDD VSS gf180mcu_fd_sc_mcu7t5v0__filltie
XTAP_TAPCELL_ROW_85_1283 VDD VSS gf180mcu_fd_sc_mcu7t5v0__filltie
Xwave_controller_y_inst__2460_ max_cap429/I spi_regs_inst__1139_/A1 wave_controller_y_inst__2462_/B
+ VDD VDD VSS VSS gf180mcu_fd_sc_mcu7t5v0__xor2_1
Xwave_controller_y_inst_wire147 wave_controller_y_inst_wire147/I wave_controller_y_inst_wire147/Z
+ VDD VDD VSS VSS gf180mcu_fd_sc_mcu7t5v0__clkbuf_3
Xwave_controller_x_inst__2444_ wave_controller_x_inst__2443_/B wave_controller_x_inst__2450_/A2
+ wave_controller_x_inst__2442_/Z wave_controller_x_inst__2449_/A2 VDD VDD VSS VSS
+ gf180mcu_fd_sc_mcu7t5v0__nor3_1
XFILLER_24_37 VDD VDD VSS VSS gf180mcu_fd_sc_mcu7t5v0__fillcap_8
XTAP_TAPCELL_ROW_61_881 VDD VSS gf180mcu_fd_sc_mcu7t5v0__filltie
Xwave_controller_y_inst__2391_ wave_controller_y_inst__2394_/A1 wave_controller_y_inst__2391_/A2
+ wave_controller_y_inst__2391_/B wave_controller_y_inst__2392_/A2 VDD VDD VSS VSS
+ gf180mcu_fd_sc_mcu7t5v0__oai21_1
Xwave_controller_x_inst__2375_ wave_controller_x_inst__2361_/B wave_controller_x_inst__2375_/A2
+ wave_controller_x_inst__2375_/B wave_controller_x_inst__2396_/A1 VDD VDD VSS VSS
+ gf180mcu_fd_sc_mcu7t5v0__oai21_1
Xchip_core_637 bidir_ie[5] VDD VDD VSS VSS gf180mcu_fd_sc_mcu7t5v0__tiel
Xchip_core_659 bidir_pu[5] VDD VDD VSS VSS gf180mcu_fd_sc_mcu7t5v0__tiel
Xchip_core_648 bidir_pd[3] VDD VDD VSS VSS gf180mcu_fd_sc_mcu7t5v0__tiel
XFILLER_136_457 VDD VDD VSS VSS gf180mcu_fd_sc_mcu7t5v0__fillcap_32
Xwave_controller_y_inst__3012_ wave_controller_y_inst__3012_/A1 wave_controller_y_inst__3015_/A2
+ wave_controller_y_inst__3692_/D VDD VDD VSS VSS gf180mcu_fd_sc_mcu7t5v0__and2_1
XFILLER_105_811 VDD VDD VSS VSS gf180mcu_fd_sc_mcu7t5v0__fill_1
XFILLER_156_47 VDD VDD VSS VSS gf180mcu_fd_sc_mcu7t5v0__fill_1
Xwave_controller_y_inst_wire48 wave_controller_y_inst_wire48/I wave_controller_y_inst_wire48/Z
+ VDD VDD VSS VSS gf180mcu_fd_sc_mcu7t5v0__buf_4
XFILLER_137_1154 VDD VDD VSS VSS gf180mcu_fd_sc_mcu7t5v0__fillcap_16
XFILLER_104_387 VDD VDD VSS VSS gf180mcu_fd_sc_mcu7t5v0__fillcap_4
XFILLER_58_430 VDD VDD VSS VSS gf180mcu_fd_sc_mcu7t5v0__fillcap_16
XFILLER_59_975 VDD VDD VSS VSS gf180mcu_fd_sc_mcu7t5v0__fillcap_4
XFILLER_74_901 VDD VDD VSS VSS gf180mcu_fd_sc_mcu7t5v0__fill_1
XPHY_EDGE_ROW_130_Right_130 VDD VSS gf180mcu_fd_sc_mcu7t5v0__endcap
XFILLER_92_208 VDD VDD VSS VSS gf180mcu_fd_sc_mcu7t5v0__fill_2
XFILLER_85_282 VDD VDD VSS VSS gf180mcu_fd_sc_mcu7t5v0__fillcap_8
Xwave_controller_y_inst__2727_ wave_controller_y_inst__2737_/A2 wave_controller_y_inst__2727_/A2
+ spi_regs_inst__1105_/B2 VDD VDD VSS VSS gf180mcu_fd_sc_mcu7t5v0__xnor2_1
XFILLER_57_1122 VDD VDD VSS VSS gf180mcu_fd_sc_mcu7t5v0__fillcap_32
XFILLER_73_499 VDD VDD VSS VSS gf180mcu_fd_sc_mcu7t5v0__fillcap_8
Xwave_controller_y_inst__2658_ wave_controller_y_inst__1819_/I wave_controller_y_inst__2660_/A3
+ wave_controller_y_inst__2675_/B VDD VDD VSS VSS gf180mcu_fd_sc_mcu7t5v0__nor2_1
XTAP_TAPCELL_ROW_13_1_432 VDD VSS gf180mcu_fd_sc_mcu7t5v0__filltie
XFILLER_144_1169 VDD VDD VSS VSS gf180mcu_fd_sc_mcu7t5v0__fill_1
Xwave_controller_y_inst__2589_ wave_controller_y_inst__1823_/I wave_controller_y_inst__3524_/B2
+ wave_controller_y_inst__2589_/A3 wave_controller_y_inst__2590_/B VDD VDD VSS VSS
+ gf180mcu_fd_sc_mcu7t5v0__xor3_1
XTAP_TAPCELL_ROW_136_2114 VDD VSS gf180mcu_fd_sc_mcu7t5v0__filltie
XTAP_TAPCELL_ROW_136_2125 VDD VSS gf180mcu_fd_sc_mcu7t5v0__filltie
XFILLER_128_947 VDD VDD VSS VSS gf180mcu_fd_sc_mcu7t5v0__fillcap_64
Xspi_regs_inst__1250_ spi_regs_inst__1553_/Q spi_regs_inst__1356_/A2 spi_regs_inst__1250_/B1
+ spi_regs_inst__1250_/B2 spi_regs_inst__1253_/A2 VDD VDD VSS VSS gf180mcu_fd_sc_mcu7t5v0__aoi22_1
XFILLER_143_906 VDD VDD VSS VSS gf180mcu_fd_sc_mcu7t5v0__fillcap_4
Xspi_regs_inst__1181_ spi_regs_inst__1552_/Q spi_regs_inst__1356_/A2 spi_regs_inst_wire249/Z
+ fanout537/Z spi_regs_inst__1205_/A1 VDD VDD VSS VSS gf180mcu_fd_sc_mcu7t5v0__aoi22_1
XFILLER_114_107 VDD VDD VSS VSS gf180mcu_fd_sc_mcu7t5v0__fill_2
XFILLER_53_8 VDD VDD VSS VSS gf180mcu_fd_sc_mcu7t5v0__fill_1
XFILLER_142_449 VDD VDD VSS VSS gf180mcu_fd_sc_mcu7t5v0__fillcap_4
XTAP_TAPCELL_ROW_114_1755 VDD VSS gf180mcu_fd_sc_mcu7t5v0__filltie
Xsignal_processor_y_inst__200_ signal_processor_y_inst__202_/A1 signal_processor_y_inst__200_/A2
+ signal_processor_y_inst__200_/A3 signal_processor_y_inst__218_/D VDD VDD VSS VSS
+ gf180mcu_fd_sc_mcu7t5v0__nor3_1
XFILLER_146_80 VDD VDD VSS VSS gf180mcu_fd_sc_mcu7t5v0__fillcap_16
XTAP_TAPCELL_ROW_114_1766 VDD VSS gf180mcu_fd_sc_mcu7t5v0__filltie
XFILLER_39_6 VDD VDD VSS VSS gf180mcu_fd_sc_mcu7t5v0__fill_2
Xsignal_processor_y_inst__131_ signal_processor_y_inst__240_/Q signal_processor_y_inst__241_/Q
+ signal_processor_y_inst__242_/Q signal_processor_y_inst__132_/A3 VDD VDD VSS VSS
+ gf180mcu_fd_sc_mcu7t5v0__nand3_1
XFILLER_1_492 VDD VDD VSS VSS gf180mcu_fd_sc_mcu7t5v0__fillcap_8
XFILLER_110_379 VDD VDD VSS VSS gf180mcu_fd_sc_mcu7t5v0__fillcap_4
XFILLER_49_463 VDD VDD VSS VSS gf180mcu_fd_sc_mcu7t5v0__fillcap_4
XFILLER_64_400 VDD VDD VSS VSS gf180mcu_fd_sc_mcu7t5v0__fill_1
XFILLER_77_772 VDD VDD VSS VSS gf180mcu_fd_sc_mcu7t5v0__fillcap_32
XTAP_TAPCELL_ROW_147_2298 VDD VSS gf180mcu_fd_sc_mcu7t5v0__filltie
XFILLER_36_102 VDD VDD VSS VSS gf180mcu_fd_sc_mcu7t5v0__fill_2
XFILLER_36_124 VDD VDD VSS VSS gf180mcu_fd_sc_mcu7t5v0__fill_1
XFILLER_64_411 VDD VDD VSS VSS gf180mcu_fd_sc_mcu7t5v0__fillcap_8
XTAP_TAPCELL_ROW_164_2590 VDD VSS gf180mcu_fd_sc_mcu7t5v0__filltie
Xspi_regs_inst__0965_ spi_regs_inst__1019_/A2 spi_regs_inst__1029_/A2 spi_regs_inst__1353_/A2
+ VDD VDD VSS VSS gf180mcu_fd_sc_mcu7t5v0__nor2_1
XFILLER_80_926 VDD VDD VSS VSS gf180mcu_fd_sc_mcu7t5v0__fill_2
Xspi_regs_inst__0896_ spi_regs_inst__0896_/I spi_regs_inst__1625_/D VDD VDD VSS VSS
+ gf180mcu_fd_sc_mcu7t5v0__clkinv_1
XFILLER_17_360 VDD VDD VSS VSS gf180mcu_fd_sc_mcu7t5v0__fill_2
XFILLER_32_363 VDD VDD VSS VSS gf180mcu_fd_sc_mcu7t5v0__fillcap_16
XFILLER_60_672 VDD VDD VSS VSS gf180mcu_fd_sc_mcu7t5v0__fill_2
Xspi_regs_inst__1517_ spi_regs_inst__1517_/D fanout588/Z clkbuf_leaf_13_clk/Z spi_regs_inst__1517_/Q
+ VDD VDD VSS VSS gf180mcu_fd_sc_mcu7t5v0__dffrnq_1
XFILLER_165_508 VDD VDD VSS VSS gf180mcu_fd_sc_mcu7t5v0__fillcap_4
Xwave_controller_x_inst__2160_ wire462/I spi_regs_inst__1112_/A1 wave_controller_x_inst__2162_/B
+ VDD VDD VSS VSS gf180mcu_fd_sc_mcu7t5v0__xor2_1
XFILLER_146_711 VDD VDD VSS VSS gf180mcu_fd_sc_mcu7t5v0__fill_2
XFILLER_146_733 VDD VDD VSS VSS gf180mcu_fd_sc_mcu7t5v0__fill_2
XTAP_TAPCELL_ROW_80_1191 VDD VSS gf180mcu_fd_sc_mcu7t5v0__filltie
Xspi_regs_inst__1448_ spi_regs_inst__1516_/Q spi_regs_inst__1448_/I1 spi_regs_inst__1448_/S
+ spi_regs_inst__1516_/D VDD VDD VSS VSS gf180mcu_fd_sc_mcu7t5v0__mux2_2
XFILLER_145_232 VDD VDD VSS VSS gf180mcu_fd_sc_mcu7t5v0__fill_2
Xwave_controller_x_inst__2091_ wave_controller_x_inst__2138_/A2 wave_controller_x_inst__2091_/A2
+ wave_controller_x_inst__2093_/B1 VDD VDD VSS VSS gf180mcu_fd_sc_mcu7t5v0__nor2_1
Xspi_regs_inst__1379_ spi_regs_inst__1636_/Q spi_regs_inst__1379_/I1 spi_regs_inst__1379_/S
+ spi_regs_inst__1659_/D VDD VDD VSS VSS gf180mcu_fd_sc_mcu7t5v0__mux2_2
XFILLER_105_118 VDD VDD VSS VSS gf180mcu_fd_sc_mcu7t5v0__fillcap_4
XFILLER_126_17 VDD VDD VSS VSS gf180mcu_fd_sc_mcu7t5v0__fillcap_16
Xanalog_block_inst_analog_comp_y_inst__0_ analog[3] clkbuf_leaf_0_clk/Z wave_controller_y_inst__1952_/A2
+ VDD VDD VSS VSS gf180mcu_fd_sc_mcu7t5v0__dffq_1
XFILLER_99_352 VDD VDD VSS VSS gf180mcu_fd_sc_mcu7t5v0__fillcap_16
XTAP_TAPCELL_ROW_30_1_557 VDD VSS gf180mcu_fd_sc_mcu7t5v0__filltie
XFILLER_113_173 VDD VDD VSS VSS gf180mcu_fd_sc_mcu7t5v0__fill_2
XFILLER_141_482 VDD VDD VSS VSS gf180mcu_fd_sc_mcu7t5v0__fillcap_8
Xwave_controller_y_inst__1960_ wave_controller_y_inst__1960_/I wave_controller_y_inst__1962_/B
+ VDD VDD VSS VSS gf180mcu_fd_sc_mcu7t5v0__clkinv_1
Xwave_controller_x_inst__2993_ wave_controller_x_inst__1785_/I fanout535/I wave_controller_x_inst__2989_/B
+ wave_controller_x_inst__2993_/B2 wave_controller_x_inst__3077_/A2 VDD VDD VSS VSS
+ gf180mcu_fd_sc_mcu7t5v0__oai22_1
Xwave_controller_x_inst__1944_ wave_controller_x_inst__1944_/A1 wave_controller_x_inst__1944_/A2
+ wave_controller_x_inst__1944_/B wave_controller_x_inst__1946_/A1 VDD VDD VSS VSS
+ gf180mcu_fd_sc_mcu7t5v0__oai21_1
XFILLER_101_368 VDD VDD VSS VSS gf180mcu_fd_sc_mcu7t5v0__fill_2
Xwave_controller_y_inst__1891_ wave_controller_y_inst__1891_/I wave_controller_y_inst__3258_/A2
+ VDD VDD VSS VSS gf180mcu_fd_sc_mcu7t5v0__clkinv_1
Xwave_controller_x_inst__1875_ spi_regs_inst__1311_/B2 wave_controller_x_inst__3515_/B2
+ VDD VDD VSS VSS gf180mcu_fd_sc_mcu7t5v0__clkinv_1
XFILLER_55_422 VDD VDD VSS VSS gf180mcu_fd_sc_mcu7t5v0__fillcap_4
XFILLER_67_282 VDD VDD VSS VSS gf180mcu_fd_sc_mcu7t5v0__fillcap_64
XTAP_TAPCELL_ROW_87_1312 VDD VSS gf180mcu_fd_sc_mcu7t5v0__filltie
Xwave_controller_y_inst__3630_ wave_controller_y_inst__3630_/D wave_controller_y_inst__3673_/RN
+ clkbuf_leaf_35_clk/Z spi_regs_inst__1139_/A1 VDD VDD VSS VSS gf180mcu_fd_sc_mcu7t5v0__dffrnq_1
Xwave_controller_x_inst__3614_ wave_controller_x_inst__3614_/D fanout596/Z clkbuf_leaf_20_clk/Z
+ wave_controller_x_inst__3614_/Q VDD VDD VSS VSS gf180mcu_fd_sc_mcu7t5v0__dffrnq_1
XFILLER_76_1008 VDD VDD VSS VSS gf180mcu_fd_sc_mcu7t5v0__fillcap_4
XTAP_TAPCELL_ROW_66_962 VDD VSS gf180mcu_fd_sc_mcu7t5v0__filltie
XTAP_TAPCELL_ROW_66_973 VDD VSS gf180mcu_fd_sc_mcu7t5v0__filltie
Xwave_controller_y_inst__3561_ wave_controller_y_inst__3595_/I0 spi_regs_inst__1101_/A1
+ wave_controller_y_inst_wire48/Z wave_controller_y_inst__3650_/D VDD VDD VSS VSS
+ gf180mcu_fd_sc_mcu7t5v0__mux2_2
Xwave_controller_x_inst__3545_ wave_controller_x_inst__3557_/A1 wave_controller_x_inst__3545_/A2
+ wave_controller_x_inst__3545_/A3 wave_controller_x_inst__3545_/B1 wave_controller_x_inst__3545_/B2
+ wave_controller_x_inst__3644_/D VDD VDD VSS VSS gf180mcu_fd_sc_mcu7t5v0__oai32_1
XFILLER_27_179 VDD VDD VSS VSS gf180mcu_fd_sc_mcu7t5v0__fill_1
XFILLER_82_263 VDD VDD VSS VSS gf180mcu_fd_sc_mcu7t5v0__fillcap_4
Xwave_controller_y_inst__2512_ wave_controller_y_inst__2521_/A1 spi_regs_inst__1312_/B2
+ wave_controller_y_inst__2555_/A1 VDD VDD VSS VSS gf180mcu_fd_sc_mcu7t5v0__nand2_1
Xsignal_processor_x_inst__220_ signal_processor_x_inst__220_/D signal_processor_x_inst__242_/RN
+ clkload23/I spi_regs_inst__1098_/A1 VDD VDD VSS VSS gf180mcu_fd_sc_mcu7t5v0__dffrnq_1
XFILLER_42_149 VDD VDD VSS VSS gf180mcu_fd_sc_mcu7t5v0__fillcap_16
XPHY_EDGE_ROW_32_1_Right_31 VDD VSS gf180mcu_fd_sc_mcu7t5v0__endcap
Xwave_controller_y_inst__3492_ wave_controller_y_inst__3492_/A1 wave_controller_y_inst__3524_/B1
+ wave_controller_y_inst__3492_/B1 wave_controller_y_inst__3492_/B2 wave_controller_y_inst__3627_/D
+ VDD VDD VSS VSS gf180mcu_fd_sc_mcu7t5v0__oai22_1
Xwave_controller_x_inst__3476_ spi_regs_inst__1305_/B2 wave_controller_x_inst__3487_/A2
+ wave_controller_x_inst__3477_/B VDD VDD VSS VSS gf180mcu_fd_sc_mcu7t5v0__nand2_1
Xwave_controller_y_inst__2443_ wave_controller_y_inst__2450_/A2 wave_controller_y_inst__2442_/Z
+ wave_controller_y_inst__2443_/B wave_controller_y_inst__2449_/C VDD VDD VSS VSS
+ gf180mcu_fd_sc_mcu7t5v0__oai21_1
Xwave_controller_x_inst__2427_ wire450/Z wave_controller_x_inst__2426_/Z wave_controller_x_inst__2443_/B
+ VDD VDD VSS VSS gf180mcu_fd_sc_mcu7t5v0__or2_1
Xsignal_processor_x_inst__151_ signal_processor_x_inst__252_/Q signal_processor_x_inst__203_/A2
+ signal_processor_x_inst__151_/B signal_processor_x_inst__229_/D VDD VDD VSS VSS
+ gf180mcu_fd_sc_mcu7t5v0__oai21_1
Xwave_controller_y_inst__2374_ wave_controller_y_inst__2397_/A1 wave_controller_y_inst__2373_/Z
+ wave_controller_y_inst__2376_/A1 VDD VDD VSS VSS gf180mcu_fd_sc_mcu7t5v0__nor2_1
Xwave_controller_x_inst__2358_ wave_controller_x_inst__2358_/A1 wave_controller_x_inst__2337_/Z
+ wave_controller_x_inst__2357_/B wave_controller_x_inst__2359_/I VDD VDD VSS VSS
+ gf180mcu_fd_sc_mcu7t5v0__or3_1
XFILLER_109_424 VDD VDD VSS VSS gf180mcu_fd_sc_mcu7t5v0__fill_1
XFILLER_149_571 VDD VDD VSS VSS gf180mcu_fd_sc_mcu7t5v0__fill_2
XFILLER_51_46 VDD VDD VSS VSS gf180mcu_fd_sc_mcu7t5v0__fill_2
Xwave_controller_x_inst__2289_ wave_controller_x_inst__2284_/Z wave_controller_x_inst__2299_/A2
+ wave_controller_x_inst__2292_/A3 VDD VDD VSS VSS gf180mcu_fd_sc_mcu7t5v0__xnor2_1
XFILLER_100_1017 VDD VDD VSS VSS gf180mcu_fd_sc_mcu7t5v0__fillcap_64
XFILLER_164_563 VDD VDD VSS VSS gf180mcu_fd_sc_mcu7t5v0__fill_1
XTAP_TAPCELL_ROW_131_2033 VDD VSS gf180mcu_fd_sc_mcu7t5v0__filltie
XTAP_TAPCELL_ROW_98_1496 VDD VSS gf180mcu_fd_sc_mcu7t5v0__filltie
XFILLER_136_298 VDD VDD VSS VSS gf180mcu_fd_sc_mcu7t5v0__fillcap_4
XTAP_TAPCELL_ROW_131_2044 VDD VSS gf180mcu_fd_sc_mcu7t5v0__filltie
XFILLER_151_257 VDD VDD VSS VSS gf180mcu_fd_sc_mcu7t5v0__fill_2
XFILLER_151_279 VDD VDD VSS VSS gf180mcu_fd_sc_mcu7t5v0__fill_1
XFILLER_116_61 VDD VDD VSS VSS gf180mcu_fd_sc_mcu7t5v0__fill_2
XFILLER_63_1170 VDD VDD VSS VSS gf180mcu_fd_sc_mcu7t5v0__fillcap_4
XFILLER_76_10 VDD VDD VSS VSS gf180mcu_fd_sc_mcu7t5v0__fill_2
XFILLER_78_547 VDD VDD VSS VSS gf180mcu_fd_sc_mcu7t5v0__fill_1
Xfanout560 fanout569/Z fanout560/Z VDD VDD VSS VSS gf180mcu_fd_sc_mcu7t5v0__dlyb_1
XFILLER_120_699 VDD VDD VSS VSS gf180mcu_fd_sc_mcu7t5v0__fill_1
XFILLER_150_1151 VDD VDD VSS VSS gf180mcu_fd_sc_mcu7t5v0__fillcap_4
XFILLER_65_208 VDD VDD VSS VSS gf180mcu_fd_sc_mcu7t5v0__fill_2
Xfanout593 fanout608/Z wire594/I VDD VDD VSS VSS gf180mcu_fd_sc_mcu7t5v0__dlyb_1
Xfanout582 fanout583/Z fanout582/Z VDD VDD VSS VSS gf180mcu_fd_sc_mcu7t5v0__dlyb_1
XFILLER_150_1173 VDD VDD VSS VSS gf180mcu_fd_sc_mcu7t5v0__fill_1
XFILLER_74_775 VDD VDD VSS VSS gf180mcu_fd_sc_mcu7t5v0__fill_1
Xspi_regs_inst__0750_ spi_regs_inst__0940_/A1 spi_regs_inst__1455_/Q spi_regs_inst__1457_/Q
+ spi_regs_inst_wire346/I VDD VDD VSS VSS gf180mcu_fd_sc_mcu7t5v0__nor3_1
XFILLER_132_82 VDD VDD VSS VSS gf180mcu_fd_sc_mcu7t5v0__fillcap_16
XFILLER_61_414 VDD VDD VSS VSS gf180mcu_fd_sc_mcu7t5v0__fillcap_4
XFILLER_128_711 VDD VDD VSS VSS gf180mcu_fd_sc_mcu7t5v0__fill_2
Xspi_regs_inst__1302_ spi_regs_inst__1534_/Q spi_regs_inst_wire269/Z spi_regs_inst__1328_/A1
+ VDD VDD VSS VSS gf180mcu_fd_sc_mcu7t5v0__nand2_1
XFILLER_155_530 VDD VDD VSS VSS gf180mcu_fd_sc_mcu7t5v0__fillcap_4
Xspi_regs_inst__1233_ spi_regs_inst__1233_/A1 spi_regs_inst__1233_/A2 spi_regs_inst__1233_/A3
+ spi_regs_inst__1233_/A4 spi_regs_inst__1243_/A2 VDD VDD VSS VSS gf180mcu_fd_sc_mcu7t5v0__nand4_1
XFILLER_115_416 VDD VDD VSS VSS gf180mcu_fd_sc_mcu7t5v0__fillcap_4
XFILLER_127_298 VDD VDD VSS VSS gf180mcu_fd_sc_mcu7t5v0__fillcap_32
Xspi_regs_inst__1164_ spi_regs_inst__1559_/Q spi_regs_inst__1180_/A2 spi_regs_inst__1340_/B1
+ spi_regs_inst__1609_/Q spi_regs_inst__1165_/A4 VDD VDD VSS VSS gf180mcu_fd_sc_mcu7t5v0__aoi22_1
XFILLER_108_490 VDD VDD VSS VSS gf180mcu_fd_sc_mcu7t5v0__fill_1
XFILLER_131_909 VDD VDD VSS VSS gf180mcu_fd_sc_mcu7t5v0__fill_1
XFILLER_143_769 VDD VDD VSS VSS gf180mcu_fd_sc_mcu7t5v0__fill_1
XFILLER_68_1081 VDD VDD VSS VSS gf180mcu_fd_sc_mcu7t5v0__fillcap_4
Xspi_regs_inst__1095_ fanout509/Z spi_regs_inst__1231_/A2 spi_regs_inst__1353_/B1
+ spi_regs_inst__1095_/B2 spi_regs_inst__1118_/A1 VDD VDD VSS VSS gf180mcu_fd_sc_mcu7t5v0__aoi22_1
XFILLER_111_622 VDD VDD VSS VSS gf180mcu_fd_sc_mcu7t5v0__fillcap_8
XFILLER_97_823 VDD VDD VSS VSS gf180mcu_fd_sc_mcu7t5v0__fillcap_4
XTAP_TAPCELL_ROW_149_2338 VDD VSS gf180mcu_fd_sc_mcu7t5v0__filltie
XFILLER_111_655 VDD VDD VSS VSS gf180mcu_fd_sc_mcu7t5v0__fill_2
XFILLER_96_355 VDD VDD VSS VSS gf180mcu_fd_sc_mcu7t5v0__fillcap_4
XPHY_EDGE_ROW_102_Left_269 VDD VSS gf180mcu_fd_sc_mcu7t5v0__endcap
Xsignal_processor_y_inst__114_ spi_regs_inst__1184_/A1 signal_processor_y_inst__203_/B2
+ VDD VDD VSS VSS gf180mcu_fd_sc_mcu7t5v0__clkinv_1
XFILLER_37_422 VDD VDD VSS VSS gf180mcu_fd_sc_mcu7t5v0__fillcap_4
XFILLER_49_282 VDD VDD VSS VSS gf180mcu_fd_sc_mcu7t5v0__fill_1
XTAP_TAPCELL_ROW_162_2549 VDD VSS gf180mcu_fd_sc_mcu7t5v0__filltie
XTAP_TAPCELL_ROW_69_1020 VDD VSS gf180mcu_fd_sc_mcu7t5v0__filltie
XTAP_TAPCELL_ROW_127_1968 VDD VSS gf180mcu_fd_sc_mcu7t5v0__filltie
XTAP_TAPCELL_ROW_127_1979 VDD VSS gf180mcu_fd_sc_mcu7t5v0__filltie
Xspi_regs_inst__0948_ spi_regs_inst__1374_/A1 spi_regs_inst__1372_/A1 spi_regs_inst__1634_/Q
+ spi_regs_inst__1030_/A1 VDD VDD VSS VSS gf180mcu_fd_sc_mcu7t5v0__nand3_1
XFILLER_37_488 VDD VDD VSS VSS gf180mcu_fd_sc_mcu7t5v0__fill_2
XFILLER_64_263 VDD VDD VSS VSS gf180mcu_fd_sc_mcu7t5v0__fillcap_4
XTAP_TAPCELL_ROW_63_910 VDD VSS gf180mcu_fd_sc_mcu7t5v0__filltie
XTAP_TAPCELL_ROW_63_921 VDD VSS gf180mcu_fd_sc_mcu7t5v0__filltie
XFILLER_64_296 VDD VDD VSS VSS gf180mcu_fd_sc_mcu7t5v0__fillcap_16
XTAP_TAPCELL_ROW_82_1231 VDD VSS gf180mcu_fd_sc_mcu7t5v0__filltie
Xwave_controller_x_inst__3330_ wave_controller_x_inst__3326_/Z wave_controller_x_inst__3398_/A2
+ wave_controller_x_inst__3333_/B VDD VDD VSS VSS gf180mcu_fd_sc_mcu7t5v0__nor2_1
Xspi_regs_inst__0879_ spi_regs_inst__1614_/Q spi_regs_inst__1412_/I1 spi_regs_inst__0879_/S
+ spi_regs_inst__1614_/D VDD VDD VSS VSS gf180mcu_fd_sc_mcu7t5v0__mux2_2
XFILLER_162_1011 VDD VDD VSS VSS gf180mcu_fd_sc_mcu7t5v0__fillcap_4
XFILLER_75_1052 VDD VDD VSS VSS gf180mcu_fd_sc_mcu7t5v0__fillcap_64
XPHY_EDGE_ROW_111_Left_278 VDD VSS gf180mcu_fd_sc_mcu7t5v0__endcap
Xwave_controller_x_inst__3261_ wave_controller_x_inst__3189_/C spi_regs_inst__1538_/Q
+ wave_controller_x_inst__3338_/B VDD VDD VSS VSS gf180mcu_fd_sc_mcu7t5v0__nand2_1
XFILLER_20_333 VDD VDD VSS VSS gf180mcu_fd_sc_mcu7t5v0__fill_2
XFILLER_32_160 VDD VDD VSS VSS gf180mcu_fd_sc_mcu7t5v0__fill_2
XFILLER_60_491 VDD VDD VSS VSS gf180mcu_fd_sc_mcu7t5v0__fillcap_8
Xwave_controller_x_inst__2212_ wave_controller_x_inst__2209_/I wave_controller_x_inst__2248_/A2
+ wave_controller_x_inst__2212_/Z VDD VDD VSS VSS gf180mcu_fd_sc_mcu7t5v0__xor2_1
XFILLER_119_722 VDD VDD VSS VSS gf180mcu_fd_sc_mcu7t5v0__fill_2
XFILLER_20_344 VDD VDD VSS VSS gf180mcu_fd_sc_mcu7t5v0__fillcap_8
Xwave_controller_x_inst__3192_ wave_controller_x_inst__3255_/A1 wave_controller_x_inst__3255_/A2
+ wave_controller_x_inst__3192_/B wave_controller_x_inst__3256_/A1 VDD VDD VSS VSS
+ gf180mcu_fd_sc_mcu7t5v0__oai21_1
XFILLER_119_733 VDD VDD VSS VSS gf180mcu_fd_sc_mcu7t5v0__fillcap_32
Xwave_controller_x_inst__2143_ wave_controller_x_inst__3731_/Q wave_controller_x_inst__2149_/A1
+ wave_controller_x_inst__2143_/A3 wave_controller_x_inst__3731_/D VDD VDD VSS VSS
+ gf180mcu_fd_sc_mcu7t5v0__xor3_1
XFILLER_107_917 VDD VDD VSS VSS gf180mcu_fd_sc_mcu7t5v0__fillcap_32
XFILLER_134_703 VDD VDD VSS VSS gf180mcu_fd_sc_mcu7t5v0__fillcap_4
Xwave_controller_y_inst__2090_ wave_controller_y_inst__2090_/A1 wave_controller_y_inst__2083_/B
+ wave_controller_y_inst__2124_/B wave_controller_y_inst__2100_/A1 VDD VDD VSS VSS
+ gf180mcu_fd_sc_mcu7t5v0__oai21_1
Xwave_controller_x_inst__2074_ wave_controller_x_inst__2114_/B wave_controller_x_inst__2109_/B
+ wave_controller_x_inst__2074_/A3 wave_controller_x_inst__2074_/A4 wave_controller_x_inst__2074_/Z
+ VDD VDD VSS VSS gf180mcu_fd_sc_mcu7t5v0__and4_1
XFILLER_106_438 VDD VDD VSS VSS gf180mcu_fd_sc_mcu7t5v0__fill_2
XFILLER_133_202 VDD VDD VSS VSS gf180mcu_fd_sc_mcu7t5v0__fillcap_8
XFILLER_122_909 VDD VDD VSS VSS gf180mcu_fd_sc_mcu7t5v0__fillcap_32
XFILLER_121_419 VDD VDD VSS VSS gf180mcu_fd_sc_mcu7t5v0__fill_1
XFILLER_88_823 VDD VDD VSS VSS gf180mcu_fd_sc_mcu7t5v0__fillcap_4
XPHY_EDGE_ROW_120_Left_287 VDD VSS gf180mcu_fd_sc_mcu7t5v0__endcap
XTAP_TAPCELL_ROW_12_1_420 VDD VSS gf180mcu_fd_sc_mcu7t5v0__filltie
XFILLER_130_942 VDD VDD VSS VSS gf180mcu_fd_sc_mcu7t5v0__fill_2
XFILLER_99_182 VDD VDD VSS VSS gf180mcu_fd_sc_mcu7t5v0__fill_2
XFILLER_99_193 VDD VDD VSS VSS gf180mcu_fd_sc_mcu7t5v0__fillcap_16
Xwave_controller_y_inst__2992_ wave_controller_y_inst__2992_/I wave_controller_y_inst__2993_/B2
+ VDD VDD VSS VSS gf180mcu_fd_sc_mcu7t5v0__clkinv_1
Xwave_controller_x_inst__2976_ wave_controller_x_inst__3058_/A3 wave_controller_x_inst__2976_/A2
+ wave_controller_x_inst__2976_/B wave_controller_x_inst__3061_/A1 VDD VDD VSS VSS
+ gf180mcu_fd_sc_mcu7t5v0__oai21_1
XFILLER_134_1157 VDD VDD VSS VSS gf180mcu_fd_sc_mcu7t5v0__fillcap_8
Xwave_controller_y_inst__1943_ spi_regs_inst__1559_/Q wave_controller_y_inst__3189_/C
+ spi_regs_inst__1558_/Q wave_controller_y_inst__3004_/B wave_controller_y_inst__1943_/C1
+ wave_controller_y_inst__1943_/C2 wave_controller_y_inst__1944_/A2 VDD VDD VSS VSS
+ gf180mcu_fd_sc_mcu7t5v0__aoi222_1
Xwave_controller_x_inst__1927_ wave_controller_x_inst__3305_/B2 spi_regs_inst__1507_/Q
+ spi_regs_inst__1506_/Q wave_controller_x_inst__3572_/A1 wave_controller_x_inst__1927_/C
+ wave_controller_x_inst__1929_/A1 VDD VDD VSS VSS gf180mcu_fd_sc_mcu7t5v0__aoi221_1
XFILLER_28_422 VDD VDD VSS VSS gf180mcu_fd_sc_mcu7t5v0__fillcap_4
Xwave_controller_y_inst__1874_ spi_regs_inst__1275_/A1 wave_controller_y_inst__3512_/B2
+ VDD VDD VSS VSS gf180mcu_fd_sc_mcu7t5v0__clkinv_1
XFILLER_56_753 VDD VDD VSS VSS gf180mcu_fd_sc_mcu7t5v0__fillcap_4
Xwave_controller_y_inst__3613_ wave_controller_y_inst__3613_/D fanout544/Z clkload1/I
+ wave_controller_y_inst__3613_/Q VDD VDD VSS VSS gf180mcu_fd_sc_mcu7t5v0__dffrnq_1
Xwave_controller_x_inst__1858_ wire456/Z wave_controller_x_inst__2786_/A1 VDD VDD
+ VSS VSS gf180mcu_fd_sc_mcu7t5v0__clkinv_1
XFILLER_43_403 VDD VDD VSS VSS gf180mcu_fd_sc_mcu7t5v0__fillcap_8
XFILLER_71_734 VDD VDD VSS VSS gf180mcu_fd_sc_mcu7t5v0__fill_1
Xwave_controller_x_inst__1789_ wave_controller_x_inst__3711_/Q wave_controller_x_inst__3163_/C
+ VDD VDD VSS VSS gf180mcu_fd_sc_mcu7t5v0__clkinv_1
XFILLER_102_63 VDD VDD VSS VSS gf180mcu_fd_sc_mcu7t5v0__fill_1
XFILLER_70_244 VDD VDD VSS VSS gf180mcu_fd_sc_mcu7t5v0__fill_1
Xwave_controller_y_inst__3544_ max_cap430/I wave_controller_y_inst__3556_/A2 wave_controller_y_inst__3545_/A3
+ VDD VDD VSS VSS gf180mcu_fd_sc_mcu7t5v0__nor2_1
Xwave_controller_x_inst__3528_ wave_controller_x_inst__3712_/Q wave_controller_x_inst__3555_/A2
+ wave_controller_x_inst__3530_/A2 VDD VDD VSS VSS gf180mcu_fd_sc_mcu7t5v0__nor2_1
XFILLER_30_119 VDD VDD VSS VSS gf180mcu_fd_sc_mcu7t5v0__fill_2
Xwave_controller_y_inst__3475_ wave_controller_y_inst__3454_/B wave_controller_y_inst__3475_/A2
+ wave_controller_y_inst__3475_/A3 wave_controller_y_inst__3485_/B wave_controller_y_inst__3480_/C
+ VDD VDD VSS VSS gf180mcu_fd_sc_mcu7t5v0__oai31_1
Xsignal_processor_x_inst__203_ signal_processor_x_inst__203_/A1 signal_processor_x_inst__203_/A2
+ signal_processor_x_inst__187_/B signal_processor_x_inst__203_/B2 signal_processor_x_inst__220_/D
+ VDD VDD VSS VSS gf180mcu_fd_sc_mcu7t5v0__oai22_1
Xwave_controller_y_inst__2426_ spi_regs_inst__1202_/A1 wave_controller_y_inst__2774_/A1
+ wave_controller_y_inst__2438_/B wave_controller_y_inst__2426_/Z VDD VDD VSS VSS
+ gf180mcu_fd_sc_mcu7t5v0__xor3_1
Xwave_controller_x_inst__3459_ wave_controller_x_inst__3490_/A1 wave_controller_x_inst__3459_/A2
+ wave_controller_x_inst__3459_/Z VDD VDD VSS VSS gf180mcu_fd_sc_mcu7t5v0__or2_1
Xsignal_processor_x_inst__134_ signal_processor_x_inst__108_/I signal_processor_x_inst__199_/A2
+ signal_processor_x_inst__211_/A1 VDD VDD VSS VSS gf180mcu_fd_sc_mcu7t5v0__nand2_1
XFILLER_134_2 VDD VDD VSS VSS gf180mcu_fd_sc_mcu7t5v0__fillcap_16
XFILLER_23_193 VDD VDD VSS VSS gf180mcu_fd_sc_mcu7t5v0__fill_1
XFILLER_11_399 VDD VDD VSS VSS gf180mcu_fd_sc_mcu7t5v0__fillcap_16
XFILLER_7_348 VDD VDD VSS VSS gf180mcu_fd_sc_mcu7t5v0__fill_2
Xwave_controller_y_inst__2357_ wave_controller_y_inst__2358_/A1 wave_controller_y_inst__2337_/Z
+ wave_controller_y_inst__2357_/B wave_controller_y_inst__2375_/B VDD VDD VSS VSS
+ gf180mcu_fd_sc_mcu7t5v0__oai21_1
XFILLER_125_714 VDD VDD VSS VSS gf180mcu_fd_sc_mcu7t5v0__fill_2
XFILLER_137_552 VDD VDD VSS VSS gf180mcu_fd_sc_mcu7t5v0__fillcap_8
XFILLER_137_574 VDD VDD VSS VSS gf180mcu_fd_sc_mcu7t5v0__fillcap_4
Xwave_controller_y_inst__2288_ wave_controller_y_inst__2320_/A1 wave_controller_y_inst__2320_/A2
+ wave_controller_y_inst__2288_/B wave_controller_y_inst__2299_/A2 VDD VDD VSS VSS
+ gf180mcu_fd_sc_mcu7t5v0__oai21_1
XFILLER_139_1046 VDD VDD VSS VSS gf180mcu_fd_sc_mcu7t5v0__fillcap_4
XFILLER_3_554 VDD VDD VSS VSS gf180mcu_fd_sc_mcu7t5v0__fill_1
XTAP_TAPCELL_ROW_111_1703 VDD VSS gf180mcu_fd_sc_mcu7t5v0__filltie
XFILLER_97_119 VDD VDD VSS VSS gf180mcu_fd_sc_mcu7t5v0__fill_2
XTAP_TAPCELL_ROW_111_1714 VDD VSS gf180mcu_fd_sc_mcu7t5v0__filltie
XFILLER_66_539 VDD VDD VSS VSS gf180mcu_fd_sc_mcu7t5v0__fill_1
XFILLER_93_336 VDD VDD VSS VSS gf180mcu_fd_sc_mcu7t5v0__fill_2
XTAP_TAPCELL_ROW_144_2246 VDD VSS gf180mcu_fd_sc_mcu7t5v0__filltie
Xsignal_processor_x_inst_max_cap350 signal_processor_x_inst__140_/A2 signal_processor_x_inst__141_/A2
+ VDD VDD VSS VSS gf180mcu_fd_sc_mcu7t5v0__clkbuf_1
XTAP_TAPCELL_ROW_144_2257 VDD VSS gf180mcu_fd_sc_mcu7t5v0__filltie
Xspi_regs_inst__0802_ spi_regs_inst_wire480/Z spi_regs_inst__1552_/Q spi_regs_inst__0803_/S
+ spi_regs_inst__1552_/D VDD VDD VSS VSS gf180mcu_fd_sc_mcu7t5v0__mux2_2
XFILLER_34_414 VDD VDD VSS VSS gf180mcu_fd_sc_mcu7t5v0__fillcap_8
XFILLER_74_594 VDD VDD VSS VSS gf180mcu_fd_sc_mcu7t5v0__fill_1
XTAP_TAPCELL_ROW_109_1676 VDD VSS gf180mcu_fd_sc_mcu7t5v0__filltie
Xspi_regs_inst__0733_ spi_regs_inst__1623_/Q spi_regs_inst__0901_/A1 VDD VDD VSS VSS
+ gf180mcu_fd_sc_mcu7t5v0__clkinv_1
XFILLER_146_1017 VDD VDD VSS VSS gf180mcu_fd_sc_mcu7t5v0__fillcap_64
XFILLER_34_469 VDD VDD VSS VSS gf180mcu_fd_sc_mcu7t5v0__fill_1
Xspi_regs_inst_max_cap272 spi_regs_inst__1317_/A2 spi_regs_inst__1347_/A2 VDD VDD
+ VSS VSS gf180mcu_fd_sc_mcu7t5v0__buf_2
Xspi_regs_inst_max_cap261 spi_regs_inst__1246_/B1 spi_regs_inst__1343_/A2 VDD VDD
+ VSS VSS gf180mcu_fd_sc_mcu7t5v0__buf_2
Xspi_regs_inst_max_cap250 spi_regs_inst_wire251/Z spi_regs_inst__1340_/B1 VDD VDD
+ VSS VSS gf180mcu_fd_sc_mcu7t5v0__buf_2
XFILLER_14_171 VDD VDD VSS VSS gf180mcu_fd_sc_mcu7t5v0__fillcap_4
XFILLER_42_491 VDD VDD VSS VSS gf180mcu_fd_sc_mcu7t5v0__fillcap_4
XTAP_TAPCELL_ROW_122_1887 VDD VSS gf180mcu_fd_sc_mcu7t5v0__filltie
XTAP_TAPCELL_ROW_122_1898 VDD VSS gf180mcu_fd_sc_mcu7t5v0__filltie
Xspi_regs_inst_max_cap294 spi_regs_inst__1292_/A2 spi_regs_inst__1304_/A2 VDD VDD
+ VSS VSS gf180mcu_fd_sc_mcu7t5v0__buf_2
XFILLER_147_305 VDD VDD VSS VSS gf180mcu_fd_sc_mcu7t5v0__fillcap_8
XFILLER_14_193 VDD VDD VSS VSS gf180mcu_fd_sc_mcu7t5v0__fill_1
XFILLER_159_198 VDD VDD VSS VSS gf180mcu_fd_sc_mcu7t5v0__fillcap_4
Xspi_regs_inst__1216_ spi_regs_inst__1602_/Q spi_regs_inst_wire286/I spi_regs_inst_wire222/Z
+ spi_regs_inst__1216_/B2 spi_regs_inst__1219_/A2 VDD VDD VSS VSS gf180mcu_fd_sc_mcu7t5v0__aoi22_1
XFILLER_143_566 VDD VDD VSS VSS gf180mcu_fd_sc_mcu7t5v0__fill_2
XFILLER_6_381 VDD VDD VSS VSS gf180mcu_fd_sc_mcu7t5v0__fillcap_4
Xspi_regs_inst__1147_ spi_regs_inst__1147_/A1 spi_regs_inst__1147_/A2 spi_regs_inst__1147_/A3
+ spi_regs_inst__1147_/A4 spi_regs_inst__1153_/A2 VDD VDD VSS VSS gf180mcu_fd_sc_mcu7t5v0__nand4_1
XFILLER_124_791 VDD VDD VSS VSS gf180mcu_fd_sc_mcu7t5v0__fill_2
XFILLER_97_642 VDD VDD VSS VSS gf180mcu_fd_sc_mcu7t5v0__fill_2
Xwave_controller_x_inst__2830_ spi_regs_inst__1284_/A1 wave_controller_x_inst__2831_/A2
+ wave_controller_x_inst__2831_/B VDD VDD VSS VSS gf180mcu_fd_sc_mcu7t5v0__nand2_1
Xspi_regs_inst__1078_ spi_regs_inst__1078_/A1 spi_regs_inst__1234_/A2 spi_regs_inst__1104_/A1
+ VDD VDD VSS VSS gf180mcu_fd_sc_mcu7t5v0__nand2_1
XFILLER_111_463 VDD VDD VSS VSS gf180mcu_fd_sc_mcu7t5v0__fill_1
Xwave_controller_x_inst__2761_ fanout399/Z wave_controller_x_inst__3092_/A1 wave_controller_x_inst_wire166/I
+ VDD VDD VSS VSS gf180mcu_fd_sc_mcu7t5v0__nand2_1
XFILLER_84_314 VDD VDD VSS VSS gf180mcu_fd_sc_mcu7t5v0__fill_1
Xwave_controller_x_inst__2692_ fanout535/Z spi_regs_inst__1337_/A1 wave_controller_x_inst__2689_/Z
+ wave_controller_x_inst__2693_/B VDD VDD VSS VSS gf180mcu_fd_sc_mcu7t5v0__xor3_1
XFILLER_93_870 VDD VDD VSS VSS gf180mcu_fd_sc_mcu7t5v0__fill_2
XTAP_TAPCELL_ROW_15_1_446 VDD VSS gf180mcu_fd_sc_mcu7t5v0__filltie
Xwave_controller_x_inst__3313_ wave_controller_x_inst__3313_/I wave_controller_x_inst__3358_/A3
+ VDD VDD VSS VSS gf180mcu_fd_sc_mcu7t5v0__clkinv_1
XFILLER_12_119 VDD VDD VSS VSS gf180mcu_fd_sc_mcu7t5v0__fill_2
XFILLER_80_597 VDD VDD VSS VSS gf180mcu_fd_sc_mcu7t5v0__fillcap_8
Xwave_controller_y_inst__3260_ wave_controller_y_inst__3189_/C spi_regs_inst__1617_/Q
+ wave_controller_y_inst__3399_/A1 VDD VDD VSS VSS gf180mcu_fd_sc_mcu7t5v0__nor2_1
XFILLER_20_141 VDD VDD VSS VSS gf180mcu_fd_sc_mcu7t5v0__fillcap_16
XFILLER_32_37 VDD VDD VSS VSS gf180mcu_fd_sc_mcu7t5v0__fillcap_4
Xwave_controller_y_inst__2211_ wave_controller_y_inst__2248_/A1 wave_controller_y_inst__2248_/A2
+ wave_controller_y_inst__2231_/A1 VDD VDD VSS VSS gf180mcu_fd_sc_mcu7t5v0__nor2_1
Xwave_controller_x_inst__3244_ fanout536/I wave_controller_x_inst__3244_/A2 wave_controller_x_inst__3204_/Z
+ wave_controller_x_inst__3244_/B2 wave_controller_x_inst__3245_/B2 VDD VDD VSS VSS
+ gf180mcu_fd_sc_mcu7t5v0__aoi22_1
Xwave_controller_y_inst__3191_ wave_controller_y_inst__2124_/B spi_regs_inst__1582_/Q
+ wave_controller_y_inst__3192_/B VDD VDD VSS VSS gf180mcu_fd_sc_mcu7t5v0__xor2_1
Xwave_controller_x_inst__3175_ wave_controller_x_inst__3718_/Q spi_regs_inst__1516_/Q
+ wave_controller_x_inst__3175_/Z VDD VDD VSS VSS gf180mcu_fd_sc_mcu7t5v0__xor2_1
Xwave_controller_y_inst__2142_ wave_controller_y_inst__2754_/A2 wave_controller_y_inst__2139_/Z
+ wave_controller_y_inst__3731_/Q wave_controller_y_inst__2149_/A2 VDD VDD VSS VSS
+ gf180mcu_fd_sc_mcu7t5v0__aoi21_1
Xwave_controller_x_inst__2126_ wave_controller_x_inst__2058_/C wave_controller_x_inst__2051_/Z
+ wave_controller_x_inst__2138_/B1 wave_controller_x_inst__2130_/A2 VDD VDD VSS VSS
+ gf180mcu_fd_sc_mcu7t5v0__nand3_1
Xwave_controller_y_inst__2073_ wave_controller_y_inst__2073_/A1 wave_controller_y_inst_wire356/Z
+ wave_controller_y_inst__2074_/A4 VDD VDD VSS VSS gf180mcu_fd_sc_mcu7t5v0__nand2_1
XTAP_TAPCELL_ROW_95_1444 VDD VSS gf180mcu_fd_sc_mcu7t5v0__filltie
XFILLER_161_352 VDD VDD VSS VSS gf180mcu_fd_sc_mcu7t5v0__fillcap_8
XPHY_EDGE_ROW_19_1_Left_186 VDD VSS gf180mcu_fd_sc_mcu7t5v0__endcap
Xwave_controller_x_inst__2057_ wave_controller_x_inst__2079_/A1 wave_controller_x_inst__2093_/A3
+ wave_controller_x_inst__2058_/B VDD VDD VSS VSS gf180mcu_fd_sc_mcu7t5v0__nor2_1
XFILLER_0_502 VDD VDD VSS VSS gf180mcu_fd_sc_mcu7t5v0__fillcap_4
XFILLER_115_780 VDD VDD VSS VSS gf180mcu_fd_sc_mcu7t5v0__fill_2
XFILLER_161_385 VDD VDD VSS VSS gf180mcu_fd_sc_mcu7t5v0__fill_1
XFILLER_0_546 VDD VDD VSS VSS gf180mcu_fd_sc_mcu7t5v0__fillcap_8
XFILLER_161_396 VDD VDD VSS VSS gf180mcu_fd_sc_mcu7t5v0__fillcap_16
Xwave_controller_x_inst_fanout325 wave_controller_x_inst__2905_/ZN wave_controller_x_inst__3487_/A2
+ VDD VDD VSS VSS gf180mcu_fd_sc_mcu7t5v0__dlyb_1
XFILLER_88_664 VDD VDD VSS VSS gf180mcu_fd_sc_mcu7t5v0__fill_1
Xwave_controller_y_inst__2975_ wave_controller_y_inst__1792_/I fanout501/Z wave_controller_y_inst__2976_/A2
+ VDD VDD VSS VSS gf180mcu_fd_sc_mcu7t5v0__nor2_1
XFILLER_60_1151 VDD VDD VSS VSS gf180mcu_fd_sc_mcu7t5v0__fillcap_4
Xwave_controller_y_inst__1926_ wave_controller_y_inst__1926_/A1 wave_controller_y_inst__1926_/A2
+ wave_controller_y_inst__1927_/C VDD VDD VSS VSS gf180mcu_fd_sc_mcu7t5v0__nor2_1
Xwave_controller_x_inst_fanout369 wave_controller_x_inst_wire370/Z wave_controller_x_inst__3454_/A2
+ VDD VDD VSS VSS gf180mcu_fd_sc_mcu7t5v0__dlyb_1
Xwave_controller_x_inst__2959_ wave_controller_x_inst__3703_/Q fanout528/Z wave_controller_x_inst__2960_/I
+ VDD VDD VSS VSS gf180mcu_fd_sc_mcu7t5v0__nand2_1
XFILLER_57_89 VDD VDD VSS VSS gf180mcu_fd_sc_mcu7t5v0__fill_2
XFILLER_60_1173 VDD VDD VSS VSS gf180mcu_fd_sc_mcu7t5v0__fill_1
XFILLER_75_369 VDD VDD VSS VSS gf180mcu_fd_sc_mcu7t5v0__fill_1
XFILLER_113_62 VDD VDD VSS VSS gf180mcu_fd_sc_mcu7t5v0__fill_2
XFILLER_90_317 VDD VDD VSS VSS gf180mcu_fd_sc_mcu7t5v0__fillcap_8
Xwave_controller_y_inst__1857_ spi_regs_inst__1353_/A1 wave_controller_y_inst__2789_/A1
+ VDD VDD VSS VSS gf180mcu_fd_sc_mcu7t5v0__clkinv_1
Xwave_controller_y_inst__1788_ wave_controller_y_inst__3712_/Q wave_controller_y_inst__3312_/A1
+ VDD VDD VSS VSS gf180mcu_fd_sc_mcu7t5v0__clkinv_1
XFILLER_71_564 VDD VDD VSS VSS gf180mcu_fd_sc_mcu7t5v0__fill_1
XTAP_TAPCELL_ROW_54_762 VDD VSS gf180mcu_fd_sc_mcu7t5v0__filltie
XTAP_TAPCELL_ROW_54_773 VDD VSS gf180mcu_fd_sc_mcu7t5v0__filltie
Xwave_controller_y_inst__3527_ wave_controller_y_inst__3554_/A1 wave_controller_y_inst__3527_/A2
+ wave_controller_y_inst__3527_/A3 wave_controller_y_inst_wire139/I wave_controller_y_inst__3527_/B2
+ wave_controller_y_inst__3638_/D VDD VDD VSS VSS gf180mcu_fd_sc_mcu7t5v0__oai32_1
Xwave_controller_x_inst_max_cap375 wave_controller_x_inst__2068_/A2 wave_controller_x_inst__2125_/A2
+ VDD VDD VSS VSS gf180mcu_fd_sc_mcu7t5v0__buf_2
XFILLER_156_102 VDD VDD VSS VSS gf180mcu_fd_sc_mcu7t5v0__fill_2
XTAP_TAPCELL_ROW_104_1595 VDD VSS gf180mcu_fd_sc_mcu7t5v0__filltie
Xwave_controller_y_inst__3458_ wave_controller_y_inst__3458_/A1 wave_controller_y_inst__3489_/A2
+ wave_controller_y_inst__3489_/C wave_controller_y_inst__3459_/A2 VDD VDD VSS VSS
+ gf180mcu_fd_sc_mcu7t5v0__aoi21_1
XFILLER_129_338 VDD VDD VSS VSS gf180mcu_fd_sc_mcu7t5v0__fillcap_4
Xwave_controller_y_inst__2409_ wave_controller_y_inst__2409_/I wave_controller_y_inst__2422_/A2
+ VDD VDD VSS VSS gf180mcu_fd_sc_mcu7t5v0__clkinv_1
Xwave_controller_y_inst__3389_ wave_controller_y_inst__3212_/B wave_controller_y_inst__3364_/Z
+ wave_controller_y_inst__3390_/C VDD VDD VSS VSS gf180mcu_fd_sc_mcu7t5v0__nor2_1
Xsignal_processor_x_inst__117_ signal_processor_x_inst__128_/A1 signal_processor_x_inst__253_/Q
+ signal_processor_x_inst__254_/D VDD VDD VSS VSS gf180mcu_fd_sc_mcu7t5v0__and2_1
XFILLER_138_872 VDD VDD VSS VSS gf180mcu_fd_sc_mcu7t5v0__fill_2
XFILLER_153_842 VDD VDD VSS VSS gf180mcu_fd_sc_mcu7t5v0__fillcap_64
Xstate_machine_inst__31_ spi_regs_inst__1058_/B2 state_machine_inst__37_/A1 state_machine_inst__31_/B
+ state_machine_inst__38_/D VDD VDD VSS VSS gf180mcu_fd_sc_mcu7t5v0__aoi21_1
Xspi_regs_inst__1001_ spi_regs_inst__1024_/A1 spi_regs_inst__1029_/A1 spi_regs_inst__1322_/A2
+ VDD VDD VSS VSS gf180mcu_fd_sc_mcu7t5v0__nor2_1
XFILLER_125_577 VDD VDD VSS VSS gf180mcu_fd_sc_mcu7t5v0__fillcap_32
XFILLER_121_761 VDD VDD VSS VSS gf180mcu_fd_sc_mcu7t5v0__fill_1
XFILLER_67_815 VDD VDD VSS VSS gf180mcu_fd_sc_mcu7t5v0__fillcap_4
XFILLER_79_675 VDD VDD VSS VSS gf180mcu_fd_sc_mcu7t5v0__fill_1
XFILLER_152_1087 VDD VDD VSS VSS gf180mcu_fd_sc_mcu7t5v0__fillcap_64
XFILLER_66_358 VDD VDD VSS VSS gf180mcu_fd_sc_mcu7t5v0__fillcap_8
XFILLER_82_807 VDD VDD VSS VSS gf180mcu_fd_sc_mcu7t5v0__fillcap_16
XFILLER_93_133 VDD VDD VSS VSS gf180mcu_fd_sc_mcu7t5v0__fillcap_4
XFILLER_94_667 VDD VDD VSS VSS gf180mcu_fd_sc_mcu7t5v0__fill_2
XFILLER_93_177 VDD VDD VSS VSS gf180mcu_fd_sc_mcu7t5v0__fill_1
XFILLER_93_188 VDD VDD VSS VSS gf180mcu_fd_sc_mcu7t5v0__fillcap_4
XTAP_TAPCELL_ROW_124_1916 VDD VSS gf180mcu_fd_sc_mcu7t5v0__filltie
XTAP_TAPCELL_ROW_124_1927 VDD VSS gf180mcu_fd_sc_mcu7t5v0__filltie
XFILLER_34_211 VDD VDD VSS VSS gf180mcu_fd_sc_mcu7t5v0__fillcap_4
XFILLER_62_531 VDD VDD VSS VSS gf180mcu_fd_sc_mcu7t5v0__fill_2
XFILLER_90_862 VDD VDD VSS VSS gf180mcu_fd_sc_mcu7t5v0__fillcap_8
XFILLER_62_597 VDD VDD VSS VSS gf180mcu_fd_sc_mcu7t5v0__fillcap_4
XFILLER_72_1011 VDD VDD VSS VSS gf180mcu_fd_sc_mcu7t5v0__fillcap_4
XFILLER_97_2 VDD VDD VSS VSS gf180mcu_fd_sc_mcu7t5v0__fillcap_8
XFILLER_147_124 VDD VDD VSS VSS gf180mcu_fd_sc_mcu7t5v0__fill_1
XFILLER_148_647 VDD VDD VSS VSS gf180mcu_fd_sc_mcu7t5v0__fillcap_8
XFILLER_129_850 VDD VDD VSS VSS gf180mcu_fd_sc_mcu7t5v0__fill_1
XFILLER_30_494 VDD VDD VSS VSS gf180mcu_fd_sc_mcu7t5v0__fill_1
XFILLER_118_18 VDD VDD VSS VSS gf180mcu_fd_sc_mcu7t5v0__fillcap_8
XFILLER_129_894 VDD VDD VSS VSS gf180mcu_fd_sc_mcu7t5v0__fillcap_4
XFILLER_135_319 VDD VDD VSS VSS gf180mcu_fd_sc_mcu7t5v0__fillcap_4
XTAP_TAPCELL_ROW_77_1141 VDD VSS gf180mcu_fd_sc_mcu7t5v0__filltie
XTAP_TAPCELL_ROW_77_1152 VDD VSS gf180mcu_fd_sc_mcu7t5v0__filltie
XFILLER_103_216 VDD VDD VSS VSS gf180mcu_fd_sc_mcu7t5v0__fill_2
XFILLER_131_547 VDD VDD VSS VSS gf180mcu_fd_sc_mcu7t5v0__fillcap_8
XFILLER_112_750 VDD VDD VSS VSS gf180mcu_fd_sc_mcu7t5v0__fill_2
XFILLER_69_130 VDD VDD VSS VSS gf180mcu_fd_sc_mcu7t5v0__fillcap_8
XPHY_EDGE_ROW_41_1_Right_40 VDD VSS gf180mcu_fd_sc_mcu7t5v0__endcap
XTAP_TAPCELL_ROW_90_1363 VDD VSS gf180mcu_fd_sc_mcu7t5v0__filltie
XFILLER_111_282 VDD VDD VSS VSS gf180mcu_fd_sc_mcu7t5v0__fillcap_32
XFILLER_131_1116 VDD VDD VSS VSS gf180mcu_fd_sc_mcu7t5v0__fillcap_4
XFILLER_69_163 VDD VDD VSS VSS gf180mcu_fd_sc_mcu7t5v0__fillcap_4
Xwave_controller_x_inst__2813_ wave_controller_x_inst__3709_/Q wave_controller_x_inst__2817_/A2
+ wave_controller_x_inst__2813_/B1 wave_controller_x_inst__1792_/I wave_controller_x_inst__2818_/A2
+ VDD VDD VSS VSS gf180mcu_fd_sc_mcu7t5v0__oai22_1
XFILLER_73_807 VDD VDD VSS VSS gf180mcu_fd_sc_mcu7t5v0__fill_2
XFILLER_73_818 VDD VDD VSS VSS gf180mcu_fd_sc_mcu7t5v0__fillcap_8
Xwave_controller_y_inst__2760_ wave_controller_y_inst__3098_/B wave_controller_y_inst__3098_/C
+ wave_controller_y_inst__3092_/A1 VDD VDD VSS VSS gf180mcu_fd_sc_mcu7t5v0__nand2_1
Xwave_controller_x_inst__2744_ spi_regs_inst__1188_/C1 wave_controller_x_inst__2743_/Z
+ wave_controller_x_inst__2753_/A2 VDD VDD VSS VSS gf180mcu_fd_sc_mcu7t5v0__nor2_1
XFILLER_25_200 VDD VDD VSS VSS gf180mcu_fd_sc_mcu7t5v0__fill_2
XFILLER_38_550 VDD VDD VSS VSS gf180mcu_fd_sc_mcu7t5v0__fillcap_4
XFILLER_66_870 VDD VDD VSS VSS gf180mcu_fd_sc_mcu7t5v0__fillcap_4
XFILLER_72_317 VDD VDD VSS VSS gf180mcu_fd_sc_mcu7t5v0__fill_1
Xwave_controller_y_inst__2691_ wave_controller_y_inst__3245_/A1 wave_controller_y_inst__2689_/Z
+ wave_controller_y_inst__2705_/B VDD VDD VSS VSS gf180mcu_fd_sc_mcu7t5v0__nand2_1
XFILLER_53_520 VDD VDD VSS VSS gf180mcu_fd_sc_mcu7t5v0__fill_2
XFILLER_65_380 VDD VDD VSS VSS gf180mcu_fd_sc_mcu7t5v0__fill_1
Xwave_controller_x_inst__2675_ spi_regs_inst__1284_/A1 wave_controller_x_inst__2675_/A2
+ wave_controller_x_inst__2675_/B wave_controller_x_inst__2678_/A2 VDD VDD VSS VSS
+ gf180mcu_fd_sc_mcu7t5v0__aoi21_1
XFILLER_25_277 VDD VDD VSS VSS gf180mcu_fd_sc_mcu7t5v0__fill_2
Xwave_controller_y_inst__3312_ wave_controller_y_inst__3312_/A1 spi_regs_inst__1610_/Q
+ wave_controller_y_inst__3312_/B1 wave_controller_y_inst__3163_/C wave_controller_y_inst__3313_/I
+ VDD VDD VSS VSS gf180mcu_fd_sc_mcu7t5v0__aoi22_1
XFILLER_40_247 VDD VDD VSS VSS gf180mcu_fd_sc_mcu7t5v0__fillcap_8
XFILLER_139_636 VDD VDD VSS VSS gf180mcu_fd_sc_mcu7t5v0__fill_2
XFILLER_139_647 VDD VDD VSS VSS gf180mcu_fd_sc_mcu7t5v0__fillcap_8
Xwave_controller_y_inst__3243_ wave_controller_y_inst__3243_/A1 wave_controller_y_inst__3243_/A2
+ wave_controller_y_inst__3243_/Z VDD VDD VSS VSS gf180mcu_fd_sc_mcu7t5v0__or2_1
Xwave_controller_x_inst__3227_ wave_controller_x_inst__3227_/A1 wave_controller_x_inst__3232_/B1
+ wave_controller_x_inst__3137_/B wave_controller_x_inst__3228_/A2 VDD VDD VSS VSS
+ gf180mcu_fd_sc_mcu7t5v0__nand3_1
Xwave_controller_y_inst__3174_ wave_controller_y_inst__3197_/A1 wave_controller_y_inst__3174_/A2
+ wave_controller_y_inst__3173_/Z wave_controller_y_inst__3174_/B1 wave_controller_y_inst__3716_/Q
+ wave_controller_y_inst__3252_/A2 VDD VDD VSS VSS gf180mcu_fd_sc_mcu7t5v0__oai32_1
XFILLER_138_179 VDD VDD VSS VSS gf180mcu_fd_sc_mcu7t5v0__fill_1
Xwave_controller_y_inst__2125_ wave_controller_y_inst__2125_/A1 wave_controller_y_inst__2125_/A2
+ wave_controller_y_inst__2125_/B wave_controller_y_inst__2125_/C wave_controller_y_inst__2138_/B1
+ VDD VDD VSS VSS gf180mcu_fd_sc_mcu7t5v0__oai211_1
Xwave_controller_x_inst__3158_ wave_controller_x_inst__3158_/I wave_controller_x_inst__3159_/B
+ VDD VDD VSS VSS gf180mcu_fd_sc_mcu7t5v0__clkinv_1
XFILLER_107_555 VDD VDD VSS VSS gf180mcu_fd_sc_mcu7t5v0__fillcap_4
XFILLER_135_842 VDD VDD VSS VSS gf180mcu_fd_sc_mcu7t5v0__fillcap_8
XFILLER_153_138 VDD VDD VSS VSS gf180mcu_fd_sc_mcu7t5v0__fill_2
XFILLER_162_650 VDD VDD VSS VSS gf180mcu_fd_sc_mcu7t5v0__fillcap_8
Xwave_controller_x_inst__3089_ wave_controller_x_inst__3719_/Q wave_controller_x_inst__3089_/A2
+ wave_controller_x_inst__3089_/B wave_controller_x_inst__3090_/A3 VDD VDD VSS VSS
+ gf180mcu_fd_sc_mcu7t5v0__aoi21_1
Xwave_controller_x_inst__2109_ wave_controller_x_inst__2037_/Z wave_controller_x_inst__2109_/A2
+ wave_controller_x_inst__2109_/B wave_controller_x_inst__2144_/A2 VDD VDD VSS VSS
+ gf180mcu_fd_sc_mcu7t5v0__aoi21_1
XFILLER_107_577 VDD VDD VSS VSS gf180mcu_fd_sc_mcu7t5v0__fillcap_8
XFILLER_134_363 VDD VDD VSS VSS gf180mcu_fd_sc_mcu7t5v0__fillcap_4
XFILLER_135_897 VDD VDD VSS VSS gf180mcu_fd_sc_mcu7t5v0__fillcap_8
Xwave_controller_y_inst__2056_ wave_controller_y_inst__2092_/A2 wave_controller_y_inst__2125_/B
+ wave_controller_y_inst__2093_/A3 VDD VDD VSS VSS gf180mcu_fd_sc_mcu7t5v0__nor2_1
Xspi_regs_inst_fanout612 fanout620/Z spi_regs_inst__1527_/RN VDD VDD VSS VSS gf180mcu_fd_sc_mcu7t5v0__dlyb_1
XFILLER_122_569 VDD VDD VSS VSS gf180mcu_fd_sc_mcu7t5v0__fill_1
XFILLER_68_77 VDD VDD VSS VSS gf180mcu_fd_sc_mcu7t5v0__fillcap_16
XFILLER_0_376 VDD VDD VSS VSS gf180mcu_fd_sc_mcu7t5v0__fillcap_32
XFILLER_103_772 VDD VDD VSS VSS gf180mcu_fd_sc_mcu7t5v0__fillcap_8
XFILLER_64_807 VDD VDD VSS VSS gf180mcu_fd_sc_mcu7t5v0__fillcap_4
XFILLER_76_667 VDD VDD VSS VSS gf180mcu_fd_sc_mcu7t5v0__fill_2
XTAP_TAPCELL_ROW_59_843 VDD VSS gf180mcu_fd_sc_mcu7t5v0__filltie
XTAP_TAPCELL_ROW_59_854 VDD VSS gf180mcu_fd_sc_mcu7t5v0__filltie
Xwave_controller_y_inst__2958_ wave_controller_y_inst__3704_/Q wave_controller_y_inst__1826_/I
+ wave_controller_y_inst__2969_/B VDD VDD VSS VSS gf180mcu_fd_sc_mcu7t5v0__nand2_1
XFILLER_63_306 VDD VDD VSS VSS gf180mcu_fd_sc_mcu7t5v0__fillcap_8
XFILLER_75_188 VDD VDD VSS VSS gf180mcu_fd_sc_mcu7t5v0__fill_1
XTAP_TAPCELL_ROW_141_2205 VDD VSS gf180mcu_fd_sc_mcu7t5v0__filltie
Xwave_controller_y_inst__2889_ wave_controller_y_inst__2768_/Z wave_controller_y_inst__2889_/A2
+ wave_controller_y_inst__2889_/B wave_controller_y_inst__3465_/B wave_controller_y_inst__2909_/A2
+ VDD VDD VSS VSS gf180mcu_fd_sc_mcu7t5v0__oai211_1
Xwave_controller_y_inst__1909_ spi_regs_inst__1310_/A1 wave_controller_y_inst__3482_/A1
+ VDD VDD VSS VSS gf180mcu_fd_sc_mcu7t5v0__clkinv_1
XFILLER_16_222 VDD VDD VSS VSS gf180mcu_fd_sc_mcu7t5v0__fillcap_4
XTAP_TAPCELL_ROW_106_1624 VDD VSS gf180mcu_fd_sc_mcu7t5v0__filltie
XFILLER_56_1017 VDD VDD VSS VSS gf180mcu_fd_sc_mcu7t5v0__fillcap_64
Xspi_regs_inst__1550_ spi_regs_inst__1550_/D spi_regs_inst__1551_/RN clkload30/I spi_regs_inst__1550_/Q
+ VDD VDD VSS VSS gf180mcu_fd_sc_mcu7t5v0__dffrnq_1
XFILLER_140_82 VDD VDD VSS VSS gf180mcu_fd_sc_mcu7t5v0__fillcap_16
XFILLER_16_299 VDD VDD VSS VSS gf180mcu_fd_sc_mcu7t5v0__fillcap_4
Xwave_controller_x_inst_max_cap172 wave_controller_x_inst_wire173/Z wave_controller_x_inst__2090_/A1
+ VDD VDD VSS VSS gf180mcu_fd_sc_mcu7t5v0__clkbuf_1
Xspi_regs_inst__1481_ spi_regs_inst__1481_/D wire594/Z clkbuf_leaf_11_clk/Z fanout516/I
+ VDD VDD VSS VSS gf180mcu_fd_sc_mcu7t5v0__dffrnq_1
XFILLER_129_124 VDD VDD VSS VSS gf180mcu_fd_sc_mcu7t5v0__fillcap_4
XFILLER_157_422 VDD VDD VSS VSS gf180mcu_fd_sc_mcu7t5v0__fillcap_64
XTAP_TAPCELL_ROW_139_2167 VDD VSS gf180mcu_fd_sc_mcu7t5v0__filltie
XTAP_TAPCELL_ROW_139_2178 VDD VSS gf180mcu_fd_sc_mcu7t5v0__filltie
XFILLER_149_80 VDD VDD VSS VSS gf180mcu_fd_sc_mcu7t5v0__fillcap_16
XFILLER_33_80 VDD VDD VSS VSS gf180mcu_fd_sc_mcu7t5v0__fillcap_16
XPHY_EDGE_ROW_144_Right_144 VDD VSS gf180mcu_fd_sc_mcu7t5v0__endcap
XTAP_TAPCELL_ROW_152_2378 VDD VSS gf180mcu_fd_sc_mcu7t5v0__filltie
XTAP_TAPCELL_ROW_152_2389 VDD VSS gf180mcu_fd_sc_mcu7t5v0__filltie
XFILLER_153_672 VDD VDD VSS VSS gf180mcu_fd_sc_mcu7t5v0__fillcap_8
XFILLER_141_856 VDD VDD VSS VSS gf180mcu_fd_sc_mcu7t5v0__fillcap_32
XFILLER_152_193 VDD VDD VSS VSS gf180mcu_fd_sc_mcu7t5v0__fillcap_4
XFILLER_98_247 VDD VDD VSS VSS gf180mcu_fd_sc_mcu7t5v0__fillcap_16
XTAP_TAPCELL_ROW_14_1_434 VDD VSS gf180mcu_fd_sc_mcu7t5v0__filltie
XFILLER_67_601 VDD VDD VSS VSS gf180mcu_fd_sc_mcu7t5v0__fill_2
XTAP_TAPCELL_ROW_72_1060 VDD VSS gf180mcu_fd_sc_mcu7t5v0__filltie
XFILLER_140_377 VDD VDD VSS VSS gf180mcu_fd_sc_mcu7t5v0__fillcap_8
XFILLER_140_399 VDD VDD VSS VSS gf180mcu_fd_sc_mcu7t5v0__fill_2
XFILLER_67_612 VDD VDD VSS VSS gf180mcu_fd_sc_mcu7t5v0__fillcap_4
XTAP_TAPCELL_ROW_72_1071 VDD VSS gf180mcu_fd_sc_mcu7t5v0__filltie
XFILLER_12_2 VDD VDD VSS VSS gf180mcu_fd_sc_mcu7t5v0__fillcap_32
XFILLER_67_656 VDD VDD VSS VSS gf180mcu_fd_sc_mcu7t5v0__fill_1
XFILLER_66_177 VDD VDD VSS VSS gf180mcu_fd_sc_mcu7t5v0__fillcap_4
XFILLER_35_531 VDD VDD VSS VSS gf180mcu_fd_sc_mcu7t5v0__fill_2
Xwave_controller_y_inst_wire318 wave_controller_y_inst__2114_/C wave_controller_y_inst__2144_/B
+ VDD VDD VSS VSS gf180mcu_fd_sc_mcu7t5v0__buf_2
XFILLER_35_553 VDD VDD VSS VSS gf180mcu_fd_sc_mcu7t5v0__fill_2
XFILLER_81_158 VDD VDD VSS VSS gf180mcu_fd_sc_mcu7t5v0__fill_2
Xwave_controller_x_inst__2460_ max_cap461/I max_cap466/I wave_controller_x_inst__2462_/B
+ VDD VDD VSS VSS gf180mcu_fd_sc_mcu7t5v0__xor2_1
XFILLER_22_214 VDD VDD VSS VSS gf180mcu_fd_sc_mcu7t5v0__fill_2
XFILLER_62_372 VDD VDD VSS VSS gf180mcu_fd_sc_mcu7t5v0__fill_1
Xwave_controller_x_inst__2391_ wave_controller_x_inst__2394_/A1 wave_controller_x_inst__2391_/A2
+ wave_controller_x_inst__2391_/B wave_controller_x_inst__2392_/A2 VDD VDD VSS VSS
+ gf180mcu_fd_sc_mcu7t5v0__oai21_1
XFILLER_149_912 VDD VDD VSS VSS gf180mcu_fd_sc_mcu7t5v0__fillcap_64
XFILLER_22_247 VDD VDD VSS VSS gf180mcu_fd_sc_mcu7t5v0__fill_1
XFILLER_148_433 VDD VDD VSS VSS gf180mcu_fd_sc_mcu7t5v0__fillcap_4
Xwave_controller_x_inst__3012_ wave_controller_x_inst__3012_/A1 wave_controller_x_inst__3015_/A2
+ wave_controller_x_inst__3692_/D VDD VDD VSS VSS gf180mcu_fd_sc_mcu7t5v0__and2_1
XFILLER_108_319 VDD VDD VSS VSS gf180mcu_fd_sc_mcu7t5v0__fill_1
XFILLER_136_628 VDD VDD VSS VSS gf180mcu_fd_sc_mcu7t5v0__fill_2
XFILLER_148_477 VDD VDD VSS VSS gf180mcu_fd_sc_mcu7t5v0__fill_1
XFILLER_163_403 VDD VDD VSS VSS gf180mcu_fd_sc_mcu7t5v0__fillcap_4
XPHY_EDGE_ROW_111_Right_111 VDD VSS gf180mcu_fd_sc_mcu7t5v0__endcap
XTAP_TAPCELL_ROW_92_1403 VDD VSS gf180mcu_fd_sc_mcu7t5v0__filltie
XFILLER_117_897 VDD VDD VSS VSS gf180mcu_fd_sc_mcu7t5v0__fillcap_8
XFILLER_132_823 VDD VDD VSS VSS gf180mcu_fd_sc_mcu7t5v0__fill_2
XFILLER_144_650 VDD VDD VSS VSS gf180mcu_fd_sc_mcu7t5v0__fill_2
XFILLER_104_547 VDD VDD VSS VSS gf180mcu_fd_sc_mcu7t5v0__fillcap_8
XFILLER_145_38 VDD VDD VSS VSS gf180mcu_fd_sc_mcu7t5v0__fill_1
XFILLER_132_889 VDD VDD VSS VSS gf180mcu_fd_sc_mcu7t5v0__fill_2
XFILLER_89_269 VDD VDD VSS VSS gf180mcu_fd_sc_mcu7t5v0__fillcap_4
XFILLER_38_69 VDD VDD VSS VSS gf180mcu_fd_sc_mcu7t5v0__fill_2
XFILLER_57_133 VDD VDD VSS VSS gf180mcu_fd_sc_mcu7t5v0__fillcap_4
XFILLER_85_453 VDD VDD VSS VSS gf180mcu_fd_sc_mcu7t5v0__fill_1
Xwave_controller_y_inst__2812_ wave_controller_y_inst__1792_/I wave_controller_y_inst__2813_/B1
+ wave_controller_y_inst__2812_/B1 wave_controller_y_inst__2812_/B2 wave_controller_y_inst__2818_/A1
+ VDD VDD VSS VSS gf180mcu_fd_sc_mcu7t5v0__aoi22_1
XFILLER_45_317 VDD VDD VSS VSS gf180mcu_fd_sc_mcu7t5v0__fillcap_8
XFILLER_73_604 VDD VDD VSS VSS gf180mcu_fd_sc_mcu7t5v0__fillcap_8
XTAP_TAPCELL_ROW_56_802 VDD VSS gf180mcu_fd_sc_mcu7t5v0__filltie
Xwave_controller_y_inst__2743_ spi_regs_inst__1234_/A1 wave_controller_y_inst__3557_/B2
+ wave_controller_y_inst__2743_/A3 wave_controller_y_inst__2743_/Z VDD VDD VSS VSS
+ gf180mcu_fd_sc_mcu7t5v0__xor3_1
XFILLER_73_648 VDD VDD VSS VSS gf180mcu_fd_sc_mcu7t5v0__fillcap_4
Xwave_controller_x_inst__2727_ wave_controller_x_inst__2737_/A2 wave_controller_x_inst__2727_/A2
+ spi_regs_inst__1111_/B2 VDD VDD VSS VSS gf180mcu_fd_sc_mcu7t5v0__xnor2_1
XFILLER_72_158 VDD VDD VSS VSS gf180mcu_fd_sc_mcu7t5v0__fillcap_16
XTAP_TAPCELL_ROW_0_1_2667 VDD VSS gf180mcu_fd_sc_mcu7t5v0__filltie
Xwave_controller_y_inst__2674_ wave_controller_y_inst__3539_/B2 wave_controller_y_inst__2672_/Z
+ wave_controller_y_inst__2674_/Z VDD VDD VSS VSS gf180mcu_fd_sc_mcu7t5v0__xor2_1
Xwave_controller_x_inst__2658_ wave_controller_x_inst__3244_/B2 wave_controller_x_inst__2660_/A3
+ wave_controller_x_inst__2675_/B VDD VDD VSS VSS gf180mcu_fd_sc_mcu7t5v0__nor2_1
Xwave_controller_x_inst__2589_ fanout521/Z wave_controller_x_inst__3524_/B2 wave_controller_x_inst__2589_/A3
+ wave_controller_x_inst__2590_/B VDD VDD VSS VSS gf180mcu_fd_sc_mcu7t5v0__xor3_1
XTAP_TAPCELL_ROW_101_1543 VDD VSS gf180mcu_fd_sc_mcu7t5v0__filltie
XFILLER_139_466 VDD VDD VSS VSS gf180mcu_fd_sc_mcu7t5v0__fillcap_8
Xwave_controller_y_inst__3226_ wave_controller_y_inst__3374_/B wave_controller_y_inst__3234_/A2
+ wave_controller_y_inst__3235_/B1 VDD VDD VSS VSS gf180mcu_fd_sc_mcu7t5v0__nand2_1
XFILLER_79_10 VDD VDD VSS VSS gf180mcu_fd_sc_mcu7t5v0__fill_2
Xwave_controller_y_inst__3157_ wave_controller_y_inst__3711_/Q spi_regs_inst__1593_/Q
+ wave_controller_y_inst__3158_/I VDD VDD VSS VSS gf180mcu_fd_sc_mcu7t5v0__xor2_1
XFILLER_107_352 VDD VDD VSS VSS gf180mcu_fd_sc_mcu7t5v0__fillcap_16
XFILLER_108_864 VDD VDD VSS VSS gf180mcu_fd_sc_mcu7t5v0__fill_1
XFILLER_135_661 VDD VDD VSS VSS gf180mcu_fd_sc_mcu7t5v0__fillcap_16
XFILLER_141_119 VDD VDD VSS VSS gf180mcu_fd_sc_mcu7t5v0__fillcap_16
XTAP_TAPCELL_ROW_134_2086 VDD VSS gf180mcu_fd_sc_mcu7t5v0__filltie
Xwave_controller_y_inst__3088_ wave_controller_y_inst__3407_/B wave_controller_y_inst__3087_/Z
+ wave_controller_y_inst__3719_/D VDD VDD VSS VSS gf180mcu_fd_sc_mcu7t5v0__nor2_1
Xwave_controller_y_inst__2108_ wave_controller_y_inst__2114_/B wave_controller_y_inst__2092_/B
+ wave_controller_y_inst__2108_/B wave_controller_y_inst__2108_/C wave_controller_y_inst__2110_/B
+ VDD VDD VSS VSS gf180mcu_fd_sc_mcu7t5v0__aoi211_1
XFILLER_107_385 VDD VDD VSS VSS gf180mcu_fd_sc_mcu7t5v0__fill_1
XFILLER_122_311 VDD VDD VSS VSS gf180mcu_fd_sc_mcu7t5v0__fillcap_4
XFILLER_122_322 VDD VDD VSS VSS gf180mcu_fd_sc_mcu7t5v0__fillcap_8
XFILLER_123_856 VDD VDD VSS VSS gf180mcu_fd_sc_mcu7t5v0__fillcap_16
Xwave_controller_y_inst__2039_ wave_controller_y_inst__2033_/Z wave_controller_y_inst_wire358/Z
+ wave_controller_y_inst__2039_/B wave_controller_y_inst__2092_/B VDD VDD VSS VSS
+ gf180mcu_fd_sc_mcu7t5v0__aoi21_1
XFILLER_150_664 VDD VDD VSS VSS gf180mcu_fd_sc_mcu7t5v0__fill_1
XFILLER_95_217 VDD VDD VSS VSS gf180mcu_fd_sc_mcu7t5v0__fill_2
XFILLER_62_1087 VDD VDD VSS VSS gf180mcu_fd_sc_mcu7t5v0__fillcap_64
Xspi_regs_inst_fanout497 spi_regs_inst__1657_/Q spi_regs_inst__1429_/I1 VDD VDD VSS
+ VSS gf180mcu_fd_sc_mcu7t5v0__dlyb_1
Xspi_regs_inst_fanout486 spi_regs_inst__1659_/Q spi_regs_inst_wire487/I VDD VDD VSS
+ VSS gf180mcu_fd_sc_mcu7t5v0__dlyb_1
Xspi_regs_inst_fanout475 spi_regs_inst__1661_/Q spi_regs_inst__1391_/I1 VDD VDD VSS
+ VSS gf180mcu_fd_sc_mcu7t5v0__dlyb_1
Xspi_regs_inst__0981_ spi_regs_inst__1009_/A1 spi_regs_inst__1016_/A2 spi_regs_inst_wire269/I
+ VDD VDD VSS VSS gf180mcu_fd_sc_mcu7t5v0__nor2_1
X_90_ _90_/I _90_/Z VDD VDD VSS VSS gf180mcu_fd_sc_mcu7t5v0__buf_1
XFILLER_36_317 VDD VDD VSS VSS gf180mcu_fd_sc_mcu7t5v0__fillcap_32
XFILLER_91_412 VDD VDD VSS VSS gf180mcu_fd_sc_mcu7t5v0__fill_2
XFILLER_92_924 VDD VDD VSS VSS gf180mcu_fd_sc_mcu7t5v0__fill_1
XFILLER_29_380 VDD VDD VSS VSS gf180mcu_fd_sc_mcu7t5v0__fill_1
XFILLER_151_92 VDD VDD VSS VSS gf180mcu_fd_sc_mcu7t5v0__fill_1
XFILLER_17_553 VDD VDD VSS VSS gf180mcu_fd_sc_mcu7t5v0__fill_2
Xspi_regs_inst__1602_ spi_regs_inst__1602_/D spi_regs_inst__1605_/RN clkload19/I spi_regs_inst__1602_/Q
+ VDD VDD VSS VSS gf180mcu_fd_sc_mcu7t5v0__dffrnq_1
Xspi_regs_inst__1533_ spi_regs_inst__1533_/D fanout591/Z clkbuf_leaf_11_clk/Z spi_regs_inst__1533_/Q
+ VDD VDD VSS VSS gf180mcu_fd_sc_mcu7t5v0__dffrnq_1
Xspi_regs_inst__1464_ spi_regs_inst__1464_/D spi_regs_inst__1551_/RN clkload30/I fanout539/I
+ VDD VDD VSS VSS gf180mcu_fd_sc_mcu7t5v0__dffrnq_1
XFILLER_157_230 VDD VDD VSS VSS gf180mcu_fd_sc_mcu7t5v0__fillcap_32
XTAP_TAPCELL_ROW_154_2418 VDD VSS gf180mcu_fd_sc_mcu7t5v0__filltie
XPHY_EDGE_ROW_33_1_Left_200 VDD VSS gf180mcu_fd_sc_mcu7t5v0__endcap
XTAP_TAPCELL_ROW_119_1837 VDD VSS gf180mcu_fd_sc_mcu7t5v0__filltie
XTAP_TAPCELL_ROW_119_1848 VDD VSS gf180mcu_fd_sc_mcu7t5v0__filltie
Xspi_regs_inst__1395_ spi_regs_inst__1395_/A1 spi_regs_inst__1437_/A3 spi_regs_inst__1403_/S
+ VDD VDD VSS VSS gf180mcu_fd_sc_mcu7t5v0__nor2_2
XFILLER_114_801 VDD VDD VSS VSS gf180mcu_fd_sc_mcu7t5v0__fillcap_4
XTAP_TAPCELL_ROW_74_1100 VDD VSS gf180mcu_fd_sc_mcu7t5v0__filltie
XFILLER_125_193 VDD VDD VSS VSS gf180mcu_fd_sc_mcu7t5v0__fill_1
Xwave_controller_x_inst__1960_ wave_controller_x_inst__1960_/I wave_controller_x_inst__1962_/B
+ VDD VDD VSS VSS gf180mcu_fd_sc_mcu7t5v0__clkinv_1
XFILLER_68_910 VDD VDD VSS VSS gf180mcu_fd_sc_mcu7t5v0__fill_1
XFILLER_86_228 VDD VDD VSS VSS gf180mcu_fd_sc_mcu7t5v0__fillcap_16
XFILLER_80_1165 VDD VDD VSS VSS gf180mcu_fd_sc_mcu7t5v0__fill_1
Xwave_controller_x_inst__3630_ wave_controller_x_inst__3630_/D wave_controller_x_inst__3706_/RN
+ clkload36/I max_cap466/I VDD VDD VSS VSS gf180mcu_fd_sc_mcu7t5v0__dffrnq_1
Xwave_controller_x_inst__1891_ wave_controller_x_inst__1891_/I wave_controller_x_inst__3258_/A2
+ VDD VDD VSS VSS gf180mcu_fd_sc_mcu7t5v0__clkinv_1
XFILLER_83_924 VDD VDD VSS VSS gf180mcu_fd_sc_mcu7t5v0__fillcap_8
XFILLER_131_18 VDD VDD VSS VSS gf180mcu_fd_sc_mcu7t5v0__fill_2
Xwave_controller_x_inst__3561_ wave_controller_x_inst__3595_/I0 wire462/I wave_controller_x_inst__3569_/S
+ wave_controller_x_inst__3650_/D VDD VDD VSS VSS gf180mcu_fd_sc_mcu7t5v0__mux2_2
XFILLER_70_618 VDD VDD VSS VSS gf180mcu_fd_sc_mcu7t5v0__fill_1
Xwave_controller_x_inst__3492_ wave_controller_x_inst__3492_/A1 wave_controller_x_inst__3557_/B1
+ wave_controller_x_inst__3492_/B1 wave_controller_x_inst__3492_/B2 wave_controller_x_inst__3627_/D
+ VDD VDD VSS VSS gf180mcu_fd_sc_mcu7t5v0__oai22_1
Xwave_controller_x_inst__2512_ wave_controller_x_inst__2521_/A1 spi_regs_inst__1311_/B2
+ wave_controller_x_inst__2555_/A1 VDD VDD VSS VSS gf180mcu_fd_sc_mcu7t5v0__nand2_1
XPHY_EDGE_ROW_28_1_Left_195 VDD VSS gf180mcu_fd_sc_mcu7t5v0__endcap
XTAP_TAPCELL_ROW_85_1273 VDD VSS gf180mcu_fd_sc_mcu7t5v0__filltie
XTAP_TAPCELL_ROW_85_1284 VDD VSS gf180mcu_fd_sc_mcu7t5v0__filltie
Xwave_controller_x_inst__2443_ wave_controller_x_inst__2450_/A2 wave_controller_x_inst__2442_/Z
+ wave_controller_x_inst__2443_/B wave_controller_x_inst__2449_/C VDD VDD VSS VSS
+ gf180mcu_fd_sc_mcu7t5v0__oai21_1
XFILLER_24_49 VDD VDD VSS VSS gf180mcu_fd_sc_mcu7t5v0__fill_2
Xwave_controller_y_inst__2390_ wave_controller_y_inst__2396_/C wave_controller_y_inst__2389_/Z
+ wave_controller_y_inst__2392_/A1 VDD VDD VSS VSS gf180mcu_fd_sc_mcu7t5v0__nor2_1
Xwave_controller_x_inst__2374_ wave_controller_x_inst_wire78/Z wave_controller_x_inst__2373_/Z
+ wave_controller_x_inst__2376_/A1 VDD VDD VSS VSS gf180mcu_fd_sc_mcu7t5v0__nor2_1
XTAP_TAPCELL_ROW_61_882 VDD VSS gf180mcu_fd_sc_mcu7t5v0__filltie
XFILLER_109_628 VDD VDD VSS VSS gf180mcu_fd_sc_mcu7t5v0__fill_2
Xchip_core_649 bidir_pd[4] VDD VDD VSS VSS gf180mcu_fd_sc_mcu7t5v0__tiel
Xchip_core_638 bidir_ie[6] VDD VDD VSS VSS gf180mcu_fd_sc_mcu7t5v0__tiel
XFILLER_163_233 VDD VDD VSS VSS gf180mcu_fd_sc_mcu7t5v0__fill_2
XFILLER_40_37 VDD VDD VSS VSS gf180mcu_fd_sc_mcu7t5v0__fillcap_4
Xwave_controller_y_inst__3011_ wave_controller_y_inst__3692_/Q wave_controller_y_inst__3016_/A3
+ wave_controller_y_inst__3015_/A2 VDD VDD VSS VSS gf180mcu_fd_sc_mcu7t5v0__nand2_1
XFILLER_102_1081 VDD VDD VSS VSS gf180mcu_fd_sc_mcu7t5v0__fillcap_4
XFILLER_151_417 VDD VDD VSS VSS gf180mcu_fd_sc_mcu7t5v0__fill_2
XFILLER_156_37 VDD VDD VSS VSS gf180mcu_fd_sc_mcu7t5v0__fillcap_8
XFILLER_105_834 VDD VDD VSS VSS gf180mcu_fd_sc_mcu7t5v0__fillcap_4
XFILLER_137_1122 VDD VDD VSS VSS gf180mcu_fd_sc_mcu7t5v0__fillcap_32
XFILLER_163_299 VDD VDD VSS VSS gf180mcu_fd_sc_mcu7t5v0__fill_2
XFILLER_104_333 VDD VDD VSS VSS gf180mcu_fd_sc_mcu7t5v0__fillcap_4
XFILLER_116_193 VDD VDD VSS VSS gf180mcu_fd_sc_mcu7t5v0__fillcap_4
XFILLER_104_366 VDD VDD VSS VSS gf180mcu_fd_sc_mcu7t5v0__fill_2
XFILLER_104_377 VDD VDD VSS VSS gf180mcu_fd_sc_mcu7t5v0__fillcap_8
XFILLER_132_675 VDD VDD VSS VSS gf180mcu_fd_sc_mcu7t5v0__fill_2
XFILLER_131_185 VDD VDD VSS VSS gf180mcu_fd_sc_mcu7t5v0__fill_2
XFILLER_100_594 VDD VDD VSS VSS gf180mcu_fd_sc_mcu7t5v0__fill_1
XFILLER_105_85 VDD VDD VSS VSS gf180mcu_fd_sc_mcu7t5v0__fill_1
Xwave_controller_y_inst__2726_ wave_controller_y_inst__2737_/A1 wave_controller_y_inst__2714_/Z
+ wave_controller_y_inst__2726_/B wave_controller_y_inst__2727_/A2 VDD VDD VSS VSS
+ gf180mcu_fd_sc_mcu7t5v0__oai21_1
XFILLER_14_512 VDD VDD VSS VSS gf180mcu_fd_sc_mcu7t5v0__fill_1
XFILLER_164_2 VDD VDD VSS VSS gf180mcu_fd_sc_mcu7t5v0__fillcap_32
XFILLER_54_692 VDD VDD VSS VSS gf180mcu_fd_sc_mcu7t5v0__fillcap_8
XFILLER_60_117 VDD VDD VSS VSS gf180mcu_fd_sc_mcu7t5v0__fill_1
XFILLER_61_629 VDD VDD VSS VSS gf180mcu_fd_sc_mcu7t5v0__fill_1
Xwave_controller_y_inst__2657_ wave_controller_y_inst__2688_/B1 wave_controller_y_inst__2686_/A1
+ wave_controller_y_inst__2660_/A3 VDD VDD VSS VSS gf180mcu_fd_sc_mcu7t5v0__xnor2_1
Xwave_controller_y_inst__2588_ wave_controller_y_inst__1823_/I wave_controller_y_inst__2589_/A3
+ wave_controller_y_inst__2588_/Z VDD VDD VSS VSS gf180mcu_fd_sc_mcu7t5v0__and2_1
XFILLER_41_397 VDD VDD VSS VSS gf180mcu_fd_sc_mcu7t5v0__fill_2
XFILLER_81_88 VDD VDD VSS VSS gf180mcu_fd_sc_mcu7t5v0__fill_1
XTAP_TAPCELL_ROW_136_2115 VDD VSS gf180mcu_fd_sc_mcu7t5v0__filltie
XTAP_TAPCELL_ROW_136_2126 VDD VSS gf180mcu_fd_sc_mcu7t5v0__filltie
XTAP_TAPCELL_ROW_21_1_490 VDD VSS gf180mcu_fd_sc_mcu7t5v0__filltie
XFILLER_167_572 VDD VDD VSS VSS gf180mcu_fd_sc_mcu7t5v0__fillcap_4
Xwave_controller_y_inst__3209_ wave_controller_y_inst__3207_/Z wave_controller_y_inst__3210_/A3
+ wave_controller_y_inst__3209_/B wave_controller_y_inst__3241_/C VDD VDD VSS VSS
+ gf180mcu_fd_sc_mcu7t5v0__aoi21_1
Xspi_regs_inst__1180_ spi_regs_inst__1560_/Q spi_regs_inst__1180_/A2 spi_regs_inst__1180_/B1
+ max_cap423/Z spi_regs_inst__1201_/A1 VDD VDD VSS VSS gf180mcu_fd_sc_mcu7t5v0__aoi22_1
XFILLER_115_609 VDD VDD VSS VSS gf180mcu_fd_sc_mcu7t5v0__fillcap_16
XFILLER_154_255 VDD VDD VSS VSS gf180mcu_fd_sc_mcu7t5v0__fill_2
XFILLER_107_182 VDD VDD VSS VSS gf180mcu_fd_sc_mcu7t5v0__fillcap_8
XFILLER_108_683 VDD VDD VSS VSS gf180mcu_fd_sc_mcu7t5v0__fillcap_8
XFILLER_135_480 VDD VDD VSS VSS gf180mcu_fd_sc_mcu7t5v0__fill_2
XFILLER_30_70 VDD VDD VSS VSS gf180mcu_fd_sc_mcu7t5v0__fill_1
XFILLER_5_276 VDD VDD VSS VSS gf180mcu_fd_sc_mcu7t5v0__fillcap_4
XTAP_TAPCELL_ROW_114_1756 VDD VSS gf180mcu_fd_sc_mcu7t5v0__filltie
XFILLER_123_653 VDD VDD VSS VSS gf180mcu_fd_sc_mcu7t5v0__fill_1
XFILLER_69_718 VDD VDD VSS VSS gf180mcu_fd_sc_mcu7t5v0__fill_1
XFILLER_111_815 VDD VDD VSS VSS gf180mcu_fd_sc_mcu7t5v0__fillcap_16
XFILLER_122_174 VDD VDD VSS VSS gf180mcu_fd_sc_mcu7t5v0__fill_1
XFILLER_123_697 VDD VDD VSS VSS gf180mcu_fd_sc_mcu7t5v0__fill_2
XFILLER_150_461 VDD VDD VSS VSS gf180mcu_fd_sc_mcu7t5v0__fill_2
Xsignal_processor_y_inst__130_ signal_processor_y_inst__230_/Q signal_processor_y_inst__256_/Q
+ signal_processor_y_inst__203_/A1 VDD VDD VSS VSS gf180mcu_fd_sc_mcu7t5v0__nand2_1
XFILLER_68_239 VDD VDD VSS VSS gf180mcu_fd_sc_mcu7t5v0__fillcap_4
XTAP_TAPCELL_ROW_147_2299 VDD VSS gf180mcu_fd_sc_mcu7t5v0__filltie
Xspi_regs_inst__0964_ spi_regs_inst__1629_/Q spi_regs_inst__1364_/A1 spi_regs_inst__0918_/Z
+ spi_regs_inst__1029_/A2 VDD VDD VSS VSS gf180mcu_fd_sc_mcu7t5v0__nand3_1
XFILLER_49_486 VDD VDD VSS VSS gf180mcu_fd_sc_mcu7t5v0__fillcap_4
XFILLER_49_497 VDD VDD VSS VSS gf180mcu_fd_sc_mcu7t5v0__fillcap_8
XFILLER_64_423 VDD VDD VSS VSS gf180mcu_fd_sc_mcu7t5v0__fill_1
XFILLER_65_968 VDD VDD VSS VSS gf180mcu_fd_sc_mcu7t5v0__fillcap_8
XTAP_TAPCELL_ROW_164_2580 VDD VSS gf180mcu_fd_sc_mcu7t5v0__filltie
XTAP_TAPCELL_ROW_164_2591 VDD VSS gf180mcu_fd_sc_mcu7t5v0__filltie
XFILLER_36_169 VDD VDD VSS VSS gf180mcu_fd_sc_mcu7t5v0__fill_1
Xspi_regs_inst__0895_ spi_regs_inst__1625_/Q spi_regs_inst__0897_/A2 spi_regs_inst__0894_/Z
+ spi_regs_inst__0939_/S spi_regs_inst__0896_/I VDD VDD VSS VSS gf180mcu_fd_sc_mcu7t5v0__aoi22_1
XFILLER_51_117 VDD VDD VSS VSS gf180mcu_fd_sc_mcu7t5v0__fill_1
XFILLER_64_489 VDD VDD VSS VSS gf180mcu_fd_sc_mcu7t5v0__fillcap_4
XFILLER_17_394 VDD VDD VSS VSS gf180mcu_fd_sc_mcu7t5v0__fill_1
XFILLER_32_331 VDD VDD VSS VSS gf180mcu_fd_sc_mcu7t5v0__fillcap_32
XFILLER_51_139 VDD VDD VSS VSS gf180mcu_fd_sc_mcu7t5v0__fill_1
XFILLER_20_515 VDD VDD VSS VSS gf180mcu_fd_sc_mcu7t5v0__fill_1
Xspi_regs_inst__1516_ spi_regs_inst__1516_/D fanout588/Z clkload22/I spi_regs_inst__1516_/Q
+ VDD VDD VSS VSS gf180mcu_fd_sc_mcu7t5v0__dffrnq_1
XFILLER_118_403 VDD VDD VSS VSS gf180mcu_fd_sc_mcu7t5v0__fill_2
XFILLER_146_701 VDD VDD VSS VSS gf180mcu_fd_sc_mcu7t5v0__fillcap_4
XTAP_TAPCELL_ROW_80_1192 VDD VSS gf180mcu_fd_sc_mcu7t5v0__filltie
Xwave_controller_x_inst__2090_ wave_controller_x_inst__2090_/A1 wave_controller_x_inst__2083_/B
+ wave_controller_x_inst__2124_/B wave_controller_x_inst__2100_/A1 VDD VDD VSS VSS
+ gf180mcu_fd_sc_mcu7t5v0__oai21_1
Xspi_regs_inst__1447_ spi_regs_inst__1515_/Q spi_regs_inst__1447_/I1 spi_regs_inst__1448_/S
+ spi_regs_inst__1515_/D VDD VDD VSS VSS gf180mcu_fd_sc_mcu7t5v0__mux2_2
Xspi_regs_inst__1378_ spi_regs_inst__1635_/Q spi_regs_inst__1378_/I1 spi_regs_inst__1379_/S
+ spi_regs_inst__1658_/D VDD VDD VSS VSS gf180mcu_fd_sc_mcu7t5v0__mux2_2
XFILLER_133_417 VDD VDD VSS VSS gf180mcu_fd_sc_mcu7t5v0__fill_2
XFILLER_133_428 VDD VDD VSS VSS gf180mcu_fd_sc_mcu7t5v0__fillcap_16
XFILLER_160_236 VDD VDD VSS VSS gf180mcu_fd_sc_mcu7t5v0__fillcap_8
XFILLER_102_804 VDD VDD VSS VSS gf180mcu_fd_sc_mcu7t5v0__fill_1
XFILLER_160_247 VDD VDD VSS VSS gf180mcu_fd_sc_mcu7t5v0__fillcap_16
XFILLER_99_386 VDD VDD VSS VSS gf180mcu_fd_sc_mcu7t5v0__fillcap_8
XTAP_TAPCELL_ROW_30_1_558 VDD VSS gf180mcu_fd_sc_mcu7t5v0__filltie
Xwave_controller_x_inst__2992_ wave_controller_x_inst__2992_/I wave_controller_x_inst__2993_/B2
+ VDD VDD VSS VSS gf180mcu_fd_sc_mcu7t5v0__clkinv_1
XFILLER_101_347 VDD VDD VSS VSS gf180mcu_fd_sc_mcu7t5v0__fill_2
Xwave_controller_x_inst__1943_ spi_regs_inst__1496_/Q wave_controller_x_inst__3189_/C
+ spi_regs_inst__1495_/Q wave_controller_x_inst__3004_/B wave_controller_x_inst__1943_/C1
+ wave_controller_x_inst__1943_/C2 wave_controller_x_inst__1944_/A2 VDD VDD VSS VSS
+ gf180mcu_fd_sc_mcu7t5v0__aoi222_1
XFILLER_67_261 VDD VDD VSS VSS gf180mcu_fd_sc_mcu7t5v0__fill_1
Xwave_controller_y_inst__1890_ wave_controller_y_inst__1890_/I wave_controller_y_inst__3105_/A2
+ VDD VDD VSS VSS gf180mcu_fd_sc_mcu7t5v0__clkinv_1
Xwave_controller_x_inst__1874_ spi_regs_inst__1286_/B2 wave_controller_x_inst__3512_/B2
+ VDD VDD VSS VSS gf180mcu_fd_sc_mcu7t5v0__clkinv_1
XTAP_TAPCELL_ROW_87_1313 VDD VSS gf180mcu_fd_sc_mcu7t5v0__filltie
Xwave_controller_x_inst__3613_ wave_controller_x_inst__3613_/D fanout596/Z clkbuf_leaf_19_clk/Z
+ wave_controller_x_inst__3613_/Q VDD VDD VSS VSS gf180mcu_fd_sc_mcu7t5v0__dffrnq_1
XFILLER_27_158 VDD VDD VSS VSS gf180mcu_fd_sc_mcu7t5v0__fillcap_4
XFILLER_55_456 VDD VDD VSS VSS gf180mcu_fd_sc_mcu7t5v0__fill_2
XFILLER_71_916 VDD VDD VSS VSS gf180mcu_fd_sc_mcu7t5v0__fillcap_8
XTAP_TAPCELL_ROW_66_963 VDD VSS gf180mcu_fd_sc_mcu7t5v0__filltie
Xwave_controller_y_inst__3560_ wave_controller_y_inst__3560_/A1 wave_controller_y_inst_wire323/I
+ wave_controller_y_inst__3595_/I0 VDD VDD VSS VSS gf180mcu_fd_sc_mcu7t5v0__nor2_1
Xwave_controller_x_inst__3544_ spi_regs_inst__1038_/A1 wave_controller_x_inst__3556_/A2
+ wave_controller_x_inst__3545_/A3 VDD VDD VSS VSS gf180mcu_fd_sc_mcu7t5v0__nor2_1
XFILLER_167_1148 VDD VDD VSS VSS gf180mcu_fd_sc_mcu7t5v0__fillcap_4
XFILLER_83_787 VDD VDD VSS VSS gf180mcu_fd_sc_mcu7t5v0__fill_2
XTAP_TAPCELL_ROW_66_974 VDD VSS gf180mcu_fd_sc_mcu7t5v0__filltie
Xwave_controller_y_inst__2511_ max_cap433/I wave_controller_y_inst__2511_/A2 wave_controller_y_inst__2511_/B
+ wave_controller_y_inst__2543_/B1 VDD VDD VSS VSS gf180mcu_fd_sc_mcu7t5v0__aoi21_1
Xwave_controller_y_inst__3491_ wave_controller_y_inst__3485_/B wave_controller_y_inst__3488_/I
+ wave_controller_y_inst__3491_/B wave_controller_y_inst__3492_/B2 VDD VDD VSS VSS
+ gf180mcu_fd_sc_mcu7t5v0__oai21_1
Xwave_controller_y_inst__2442_ spi_regs_inst__1204_/B2 wave_controller_y_inst__2445_/A3
+ wave_controller_y_inst__2442_/Z VDD VDD VSS VSS gf180mcu_fd_sc_mcu7t5v0__and2_1
Xwave_controller_x_inst__3475_ wave_controller_x_inst__3454_/B wave_controller_x_inst__3475_/A2
+ wave_controller_x_inst__3475_/A3 wave_controller_x_inst__3485_/B wave_controller_x_inst__3480_/C
+ VDD VDD VSS VSS gf180mcu_fd_sc_mcu7t5v0__oai31_1
XFILLER_11_515 VDD VDD VSS VSS gf180mcu_fd_sc_mcu7t5v0__fill_2
Xwave_controller_x_inst__2426_ spi_regs_inst__1198_/B2 wave_controller_x_inst__2774_/A1
+ wave_controller_x_inst__2438_/B wave_controller_x_inst__2426_/Z VDD VDD VSS VSS
+ gf180mcu_fd_sc_mcu7t5v0__xor3_1
Xsignal_processor_x_inst__150_ signal_processor_x_inst__108_/I signal_processor_x_inst__229_/Q
+ signal_processor_x_inst__203_/A2 VDD VDD VSS VSS gf180mcu_fd_sc_mcu7t5v0__nand2_1
XFILLER_136_6 VDD VDD VSS VSS gf180mcu_fd_sc_mcu7t5v0__fill_2
Xwave_controller_y_inst__2373_ wave_controller_y_inst__2373_/A1 wave_controller_y_inst__2373_/A2
+ wave_controller_y_inst__2373_/Z VDD VDD VSS VSS gf180mcu_fd_sc_mcu7t5v0__or2_1
Xwave_controller_x_inst__2357_ wave_controller_x_inst__2358_/A1 wave_controller_x_inst__2337_/Z
+ wave_controller_x_inst__2357_/B wave_controller_x_inst__2375_/B VDD VDD VSS VSS
+ gf180mcu_fd_sc_mcu7t5v0__oai21_1
XFILLER_143_1170 VDD VDD VSS VSS gf180mcu_fd_sc_mcu7t5v0__fillcap_4
XFILLER_167_36 VDD VDD VSS VSS gf180mcu_fd_sc_mcu7t5v0__fillcap_8
XFILLER_7_508 VDD VDD VSS VSS gf180mcu_fd_sc_mcu7t5v0__fill_1
XFILLER_136_233 VDD VDD VSS VSS gf180mcu_fd_sc_mcu7t5v0__fillcap_8
XFILLER_87_1116 VDD VDD VSS VSS gf180mcu_fd_sc_mcu7t5v0__fillcap_4
Xwave_controller_x_inst__2288_ wave_controller_x_inst_wire170/Z wave_controller_x_inst__2320_/A2
+ wave_controller_x_inst__2288_/B wave_controller_x_inst__2299_/A2 VDD VDD VSS VSS
+ gf180mcu_fd_sc_mcu7t5v0__oai21_1
XFILLER_125_918 VDD VDD VSS VSS gf180mcu_fd_sc_mcu7t5v0__fillcap_32
XTAP_TAPCELL_ROW_98_1497 VDD VSS gf180mcu_fd_sc_mcu7t5v0__filltie
XTAP_TAPCELL_ROW_98_1486 VDD VSS gf180mcu_fd_sc_mcu7t5v0__filltie
XFILLER_105_620 VDD VDD VSS VSS gf180mcu_fd_sc_mcu7t5v0__fillcap_8
XFILLER_151_214 VDD VDD VSS VSS gf180mcu_fd_sc_mcu7t5v0__fill_1
XFILLER_152_737 VDD VDD VSS VSS gf180mcu_fd_sc_mcu7t5v0__fillcap_8
XFILLER_164_597 VDD VDD VSS VSS gf180mcu_fd_sc_mcu7t5v0__fill_2
XTAP_TAPCELL_ROW_131_2034 VDD VSS gf180mcu_fd_sc_mcu7t5v0__filltie
XTAP_TAPCELL_ROW_131_2045 VDD VSS gf180mcu_fd_sc_mcu7t5v0__filltie
XTAP_TAPCELL_ROW_16_1_448 VDD VSS gf180mcu_fd_sc_mcu7t5v0__filltie
XFILLER_105_686 VDD VDD VSS VSS gf180mcu_fd_sc_mcu7t5v0__fillcap_8
Xfanout583 fanout590/Z fanout583/Z VDD VDD VSS VSS gf180mcu_fd_sc_mcu7t5v0__dlyb_1
Xfanout561 fanout563/Z fanout561/Z VDD VDD VSS VSS gf180mcu_fd_sc_mcu7t5v0__dlyb_1
XFILLER_46_423 VDD VDD VSS VSS gf180mcu_fd_sc_mcu7t5v0__fill_1
XFILLER_76_77 VDD VDD VSS VSS gf180mcu_fd_sc_mcu7t5v0__fillcap_8
XFILLER_100_391 VDD VDD VSS VSS gf180mcu_fd_sc_mcu7t5v0__fill_2
XFILLER_46_489 VDD VDD VSS VSS gf180mcu_fd_sc_mcu7t5v0__fillcap_8
XFILLER_73_286 VDD VDD VSS VSS gf180mcu_fd_sc_mcu7t5v0__fill_1
Xwave_controller_y_inst__2709_ wave_controller_y_inst__2709_/A1 wave_controller_y_inst__2712_/C
+ wave_controller_y_inst__2694_/Z wave_controller_y_inst__2712_/A2 VDD VDD VSS VSS
+ gf180mcu_fd_sc_mcu7t5v0__nor3_1
XFILLER_14_331 VDD VDD VSS VSS gf180mcu_fd_sc_mcu7t5v0__fill_1
Xwave_controller_y_inst__3689_ wave_controller_y_inst__3689_/D wave_controller_y_inst__3689_/RN
+ clkbuf_leaf_9_clk/Z spi_regs_inst__1202_/A1 VDD VDD VSS VSS gf180mcu_fd_sc_mcu7t5v0__dffrnq_1
XFILLER_148_1081 VDD VDD VSS VSS gf180mcu_fd_sc_mcu7t5v0__fillcap_4
XFILLER_14_353 VDD VDD VSS VSS gf180mcu_fd_sc_mcu7t5v0__fill_2
XFILLER_159_347 VDD VDD VSS VSS gf180mcu_fd_sc_mcu7t5v0__fill_2
XFILLER_159_358 VDD VDD VSS VSS gf180mcu_fd_sc_mcu7t5v0__fill_1
Xspi_regs_inst__1301_ spi_regs_inst__1301_/A1 spi_regs_inst__1337_/A2 spi_regs_inst__1301_/B1
+ spi_regs_inst__1301_/B2 spi_regs_inst__1326_/A1 VDD VDD VSS VSS gf180mcu_fd_sc_mcu7t5v0__aoi22_1
XFILLER_41_194 VDD VDD VSS VSS gf180mcu_fd_sc_mcu7t5v0__fillcap_16
Xspi_regs_inst__1232_ spi_regs_inst__1532_/Q spi_regs_inst__1348_/B1 spi_regs_inst__1232_/B1
+ spi_regs_inst__1232_/B2 spi_regs_inst__1233_/A4 VDD VDD VSS VSS gf180mcu_fd_sc_mcu7t5v0__aoi22_1
XFILLER_127_255 VDD VDD VSS VSS gf180mcu_fd_sc_mcu7t5v0__fillcap_16
XFILLER_143_704 VDD VDD VSS VSS gf180mcu_fd_sc_mcu7t5v0__fill_1
Xspi_regs_inst__1163_ spi_regs_inst__1538_/Q spi_regs_inst__1207_/B1 spi_regs_inst__1241_/B1
+ spi_regs_inst_wire38/Z spi_regs_inst__1165_/A3 VDD VDD VSS VSS gf180mcu_fd_sc_mcu7t5v0__aoi22_1
XFILLER_142_236 VDD VDD VSS VSS gf180mcu_fd_sc_mcu7t5v0__fill_1
Xspi_regs_inst__1094_ spi_regs_inst__1094_/A1 spi_regs_inst_wire288/Z spi_regs_inst__1146_/B1
+ max_cap467/Z spi_regs_inst__1117_/A2 VDD VDD VSS VSS gf180mcu_fd_sc_mcu7t5v0__aoi22_1
XFILLER_155_1052 VDD VDD VSS VSS gf180mcu_fd_sc_mcu7t5v0__fillcap_64
XTAP_TAPCELL_ROW_149_2328 VDD VSS gf180mcu_fd_sc_mcu7t5v0__filltie
XTAP_TAPCELL_ROW_149_2339 VDD VSS gf180mcu_fd_sc_mcu7t5v0__filltie
XTAP_TAPCELL_ROW_166_2620 VDD VSS gf180mcu_fd_sc_mcu7t5v0__filltie
XFILLER_69_559 VDD VDD VSS VSS gf180mcu_fd_sc_mcu7t5v0__fill_1
Xsignal_processor_y_inst__113_ _92_/I signal_processor_y_inst__196_/A2 VDD VDD VSS
+ VSS gf180mcu_fd_sc_mcu7t5v0__clkinv_1
XFILLER_111_689 VDD VDD VSS VSS gf180mcu_fd_sc_mcu7t5v0__fillcap_4
XFILLER_110_177 VDD VDD VSS VSS gf180mcu_fd_sc_mcu7t5v0__fillcap_4
XFILLER_65_710 VDD VDD VSS VSS gf180mcu_fd_sc_mcu7t5v0__fill_1
XTAP_TAPCELL_ROW_69_1010 VDD VSS gf180mcu_fd_sc_mcu7t5v0__filltie
XTAP_TAPCELL_ROW_69_1021 VDD VSS gf180mcu_fd_sc_mcu7t5v0__filltie
XTAP_TAPCELL_ROW_127_1969 VDD VSS gf180mcu_fd_sc_mcu7t5v0__filltie
Xspi_regs_inst__0947_ spi_regs_inst__1630_/Q spi_regs_inst__1370_/A1 spi_regs_inst__1008_/A3
+ spi_regs_inst__1002_/A2 VDD VDD VSS VSS gf180mcu_fd_sc_mcu7t5v0__nand3_1
XTAP_TAPCELL_ROW_63_911 VDD VSS gf180mcu_fd_sc_mcu7t5v0__filltie
XTAP_TAPCELL_ROW_63_922 VDD VSS gf180mcu_fd_sc_mcu7t5v0__filltie
Xspi_regs_inst__0878_ spi_regs_inst__1613_/Q spi_regs_inst__1411_/I1 spi_regs_inst__0879_/S
+ spi_regs_inst__1613_/D VDD VDD VSS VSS gf180mcu_fd_sc_mcu7t5v0__mux2_2
XFILLER_80_757 VDD VDD VSS VSS gf180mcu_fd_sc_mcu7t5v0__fill_2
XTAP_TAPCELL_ROW_82_1232 VDD VSS gf180mcu_fd_sc_mcu7t5v0__filltie
XFILLER_61_982 VDD VDD VSS VSS gf180mcu_fd_sc_mcu7t5v0__fillcap_64
Xwave_controller_x_inst__3260_ wave_controller_x_inst__3189_/C spi_regs_inst__1538_/Q
+ wave_controller_x_inst__3399_/A1 VDD VDD VSS VSS gf180mcu_fd_sc_mcu7t5v0__nor2_1
XFILLER_127_1154 VDD VDD VSS VSS gf180mcu_fd_sc_mcu7t5v0__fillcap_16
XFILLER_166_807 VDD VDD VSS VSS gf180mcu_fd_sc_mcu7t5v0__fillcap_64
Xwave_controller_x_inst__3191_ wave_controller_x_inst__2124_/B spi_regs_inst__1519_/Q
+ wave_controller_x_inst__3192_/B VDD VDD VSS VSS gf180mcu_fd_sc_mcu7t5v0__xor2_1
Xwave_controller_x_inst__2211_ wave_controller_x_inst__2248_/A1 wave_controller_x_inst__2248_/A2
+ wave_controller_x_inst__2231_/A1 VDD VDD VSS VSS gf180mcu_fd_sc_mcu7t5v0__nor2_1
XFILLER_146_520 VDD VDD VSS VSS gf180mcu_fd_sc_mcu7t5v0__fillcap_4
Xwave_controller_x_inst__2142_ wave_controller_x_inst__2153_/A2 wave_controller_x_inst__2139_/Z
+ wave_controller_x_inst__3731_/Q wave_controller_x_inst__2149_/A2 VDD VDD VSS VSS
+ gf180mcu_fd_sc_mcu7t5v0__aoi21_1
XFILLER_118_233 VDD VDD VSS VSS gf180mcu_fd_sc_mcu7t5v0__fillcap_8
Xwave_controller_x_inst__2073_ wave_controller_x_inst_wire377/Z wave_controller_x_inst__2073_/A2
+ wave_controller_x_inst__2074_/A4 VDD VDD VSS VSS gf180mcu_fd_sc_mcu7t5v0__nand2_1
XFILLER_133_225 VDD VDD VSS VSS gf180mcu_fd_sc_mcu7t5v0__fillcap_4
XFILLER_134_737 VDD VDD VSS VSS gf180mcu_fd_sc_mcu7t5v0__fillcap_8
XFILLER_146_597 VDD VDD VSS VSS gf180mcu_fd_sc_mcu7t5v0__fillcap_8
XFILLER_133_236 VDD VDD VSS VSS gf180mcu_fd_sc_mcu7t5v0__fillcap_8
XFILLER_133_258 VDD VDD VSS VSS gf180mcu_fd_sc_mcu7t5v0__fillcap_16
XFILLER_87_301 VDD VDD VSS VSS gf180mcu_fd_sc_mcu7t5v0__fill_2
XFILLER_99_150 VDD VDD VSS VSS gf180mcu_fd_sc_mcu7t5v0__fillcap_32
XTAP_TAPCELL_ROW_12_1_421 VDD VSS gf180mcu_fd_sc_mcu7t5v0__filltie
XFILLER_142_792 VDD VDD VSS VSS gf180mcu_fd_sc_mcu7t5v0__fillcap_4
Xwave_controller_y_inst__2991_ wave_controller_y_inst__1785_/I fanout513/Z wave_controller_y_inst__1818_/I
+ wave_controller_y_inst__3713_/Q wave_controller_y_inst__2992_/I VDD VDD VSS VSS
+ gf180mcu_fd_sc_mcu7t5v0__aoi22_1
Xwave_controller_x_inst__2975_ wave_controller_x_inst__1792_/I wave_controller_x_inst__3238_/A1
+ wave_controller_x_inst__2976_/A2 VDD VDD VSS VSS gf180mcu_fd_sc_mcu7t5v0__nor2_1
XFILLER_134_1169 VDD VDD VSS VSS gf180mcu_fd_sc_mcu7t5v0__fill_1
XFILLER_47_209 VDD VDD VSS VSS gf180mcu_fd_sc_mcu7t5v0__fill_1
Xwave_controller_y_inst__1942_ wave_controller_y_inst__1778_/I wave_controller_y_inst__1942_/A2
+ wave_controller_y_inst__1942_/B wave_controller_y_inst__1943_/C2 VDD VDD VSS VSS
+ gf180mcu_fd_sc_mcu7t5v0__oai21_1
Xwave_controller_x_inst__1926_ wave_controller_x_inst__1926_/A1 wave_controller_x_inst__1926_/A2
+ wave_controller_x_inst__1927_/C VDD VDD VSS VSS gf180mcu_fd_sc_mcu7t5v0__nor2_1
Xwave_controller_y_inst__1873_ max_cap433/Z wave_controller_y_inst__3509_/B2 VDD VDD
+ VSS VSS gf180mcu_fd_sc_mcu7t5v0__clkinv_1
XFILLER_46_58 VDD VDD VSS VSS gf180mcu_fd_sc_mcu7t5v0__fill_1
XFILLER_56_765 VDD VDD VSS VSS gf180mcu_fd_sc_mcu7t5v0__fill_2
Xwave_controller_y_inst__3612_ wave_controller_y_inst__3612_/D fanout545/Z clkload5/I
+ wave_controller_y_inst__3612_/Q VDD VDD VSS VSS gf180mcu_fd_sc_mcu7t5v0__dffrnq_1
Xwave_controller_x_inst__1857_ max_cap457/I wave_controller_x_inst__2789_/A1 VDD VDD
+ VSS VSS gf180mcu_fd_sc_mcu7t5v0__clkinv_1
XFILLER_28_478 VDD VDD VSS VSS gf180mcu_fd_sc_mcu7t5v0__fill_1
XFILLER_43_415 VDD VDD VSS VSS gf180mcu_fd_sc_mcu7t5v0__fillcap_4
XFILLER_56_787 VDD VDD VSS VSS gf180mcu_fd_sc_mcu7t5v0__fillcap_16
XFILLER_71_702 VDD VDD VSS VSS gf180mcu_fd_sc_mcu7t5v0__fillcap_16
XFILLER_83_573 VDD VDD VSS VSS gf180mcu_fd_sc_mcu7t5v0__fill_1
Xwave_controller_x_inst__1788_ wave_controller_x_inst__3712_/Q wave_controller_x_inst__3312_/A1
+ VDD VDD VSS VSS gf180mcu_fd_sc_mcu7t5v0__clkinv_1
XFILLER_102_53 VDD VDD VSS VSS gf180mcu_fd_sc_mcu7t5v0__fillcap_8
XFILLER_15_128 VDD VDD VSS VSS gf180mcu_fd_sc_mcu7t5v0__fill_2
XFILLER_71_757 VDD VDD VSS VSS gf180mcu_fd_sc_mcu7t5v0__fillcap_8
Xwave_controller_y_inst__3543_ wave_controller_y_inst__3717_/Q wave_controller_y_inst__3555_/A2
+ wave_controller_y_inst__3545_/A2 VDD VDD VSS VSS gf180mcu_fd_sc_mcu7t5v0__nor2_1
Xwave_controller_x_inst__3527_ wave_controller_x_inst__3557_/A1 wave_controller_x_inst__3527_/A2
+ wave_controller_x_inst__3527_/A3 wave_controller_x_inst__3545_/B1 wave_controller_x_inst__3527_/B2
+ wave_controller_x_inst__3638_/D VDD VDD VSS VSS gf180mcu_fd_sc_mcu7t5v0__oai32_1
XFILLER_102_97 VDD VDD VSS VSS gf180mcu_fd_sc_mcu7t5v0__fillcap_8
XFILLER_62_24 VDD VDD VSS VSS gf180mcu_fd_sc_mcu7t5v0__fill_1
Xwave_controller_y_inst__3474_ spi_regs_inst__1310_/A1 wave_controller_y_inst_wire352/Z
+ wave_controller_y_inst__3475_/A3 VDD VDD VSS VSS gf180mcu_fd_sc_mcu7t5v0__nor2_1
Xwave_controller_x_inst__3458_ wave_controller_x_inst__3458_/A1 wave_controller_x_inst_wire84/Z
+ wave_controller_x_inst__3489_/C wave_controller_x_inst__3459_/A2 VDD VDD VSS VSS
+ gf180mcu_fd_sc_mcu7t5v0__aoi21_1
Xsignal_processor_x_inst__202_ signal_processor_x_inst__202_/A1 signal_processor_x_inst__202_/A2
+ signal_processor_x_inst__203_/A1 signal_processor_x_inst__202_/B signal_processor_x_inst__219_/D
+ VDD VDD VSS VSS gf180mcu_fd_sc_mcu7t5v0__oai31_1
XFILLER_51_470 VDD VDD VSS VSS gf180mcu_fd_sc_mcu7t5v0__fill_1
Xwave_controller_y_inst__2425_ wave_controller_y_inst__2399_/Z wave_controller_y_inst__2411_/Z
+ wave_controller_y_inst__2425_/A3 spi_regs_inst__1150_/A1 wave_controller_y_inst__2425_/B2
+ wave_controller_y_inst__2438_/B VDD VDD VSS VSS gf180mcu_fd_sc_mcu7t5v0__oai32_1
Xwave_controller_x_inst__2409_ wave_controller_x_inst__2409_/I wave_controller_x_inst__2422_/A2
+ VDD VDD VSS VSS gf180mcu_fd_sc_mcu7t5v0__clkinv_1
Xsignal_processor_x_inst__133_ signal_processor_x_inst__195_/B signal_processor_x_inst__199_/A2
+ VDD VDD VSS VSS gf180mcu_fd_sc_mcu7t5v0__clkinv_1
XFILLER_11_345 VDD VDD VSS VSS gf180mcu_fd_sc_mcu7t5v0__fill_1
Xwave_controller_y_inst__2356_ wave_controller_y_inst__2944_/A2 wave_controller_y_inst__2831_/A1
+ wave_controller_y_inst__2356_/A3 wave_controller_y_inst__2357_/B VDD VDD VSS VSS
+ gf180mcu_fd_sc_mcu7t5v0__xor3_1
Xwave_controller_x_inst__3389_ fanout542/Z wave_controller_x_inst__3364_/Z wave_controller_x_inst__3390_/C
+ VDD VDD VSS VSS gf180mcu_fd_sc_mcu7t5v0__nor2_1
XFILLER_127_2 VDD VDD VSS VSS gf180mcu_fd_sc_mcu7t5v0__fillcap_8
Xwave_controller_y_inst__2287_ spi_regs_inst__1109_/A1 wave_controller_y_inst__2815_/A1
+ wave_controller_y_inst__2286_/Z spi_regs_inst__1033_/C2 wave_controller_y_inst__2288_/B
+ VDD VDD VSS VSS gf180mcu_fd_sc_mcu7t5v0__aoi22_1
XFILLER_124_203 VDD VDD VSS VSS gf180mcu_fd_sc_mcu7t5v0__fillcap_4
XFILLER_106_940 VDD VDD VSS VSS gf180mcu_fd_sc_mcu7t5v0__fillcap_4
XFILLER_11_72 VDD VDD VSS VSS gf180mcu_fd_sc_mcu7t5v0__fillcap_32
XFILLER_152_556 VDD VDD VSS VSS gf180mcu_fd_sc_mcu7t5v0__fillcap_4
XTAP_TAPCELL_ROW_111_1704 VDD VSS gf180mcu_fd_sc_mcu7t5v0__filltie
XFILLER_105_472 VDD VDD VSS VSS gf180mcu_fd_sc_mcu7t5v0__fill_2
XFILLER_127_72 VDD VDD VSS VSS gf180mcu_fd_sc_mcu7t5v0__fillcap_16
XTAP_TAPCELL_ROW_111_1715 VDD VSS gf180mcu_fd_sc_mcu7t5v0__filltie
XFILLER_132_280 VDD VDD VSS VSS gf180mcu_fd_sc_mcu7t5v0__fillcap_16
XFILLER_121_976 VDD VDD VSS VSS gf180mcu_fd_sc_mcu7t5v0__fillcap_4
XFILLER_94_827 VDD VDD VSS VSS gf180mcu_fd_sc_mcu7t5v0__fill_2
XFILLER_143_60 VDD VDD VSS VSS gf180mcu_fd_sc_mcu7t5v0__fillcap_4
XTAP_TAPCELL_ROW_144_2247 VDD VSS gf180mcu_fd_sc_mcu7t5v0__filltie
XFILLER_46_242 VDD VDD VSS VSS gf180mcu_fd_sc_mcu7t5v0__fill_2
XTAP_TAPCELL_ROW_144_2258 VDD VSS gf180mcu_fd_sc_mcu7t5v0__filltie
Xspi_regs_inst__0801_ spi_regs_inst__1407_/I1 spi_regs_inst__1551_/Q spi_regs_inst__0803_/S
+ spi_regs_inst__1551_/D VDD VDD VSS VSS gf180mcu_fd_sc_mcu7t5v0__mux2_2
XTAP_TAPCELL_ROW_109_1677 VDD VSS gf180mcu_fd_sc_mcu7t5v0__filltie
Xspi_regs_inst__0732_ spi_regs_inst__1457_/Q spi_regs_inst__1453_/D VDD VDD VSS VSS
+ gf180mcu_fd_sc_mcu7t5v0__clkinv_1
XFILLER_34_426 VDD VDD VSS VSS gf180mcu_fd_sc_mcu7t5v0__fill_1
XFILLER_61_212 VDD VDD VSS VSS gf180mcu_fd_sc_mcu7t5v0__fillcap_16
Xspi_regs_inst_max_cap273 spi_regs_inst__1317_/A2 spi_regs_inst__1281_/B1 VDD VDD
+ VSS VSS gf180mcu_fd_sc_mcu7t5v0__buf_2
Xspi_regs_inst_max_cap262 spi_regs_inst__1246_/B1 spi_regs_inst__1312_/B1 VDD VDD
+ VSS VSS gf180mcu_fd_sc_mcu7t5v0__buf_2
XFILLER_148_807 VDD VDD VSS VSS gf180mcu_fd_sc_mcu7t5v0__fillcap_64
XTAP_TAPCELL_ROW_122_1888 VDD VSS gf180mcu_fd_sc_mcu7t5v0__filltie
Xspi_regs_inst_max_cap295 spi_regs_inst__1260_/A2 spi_regs_inst__1180_/A2 VDD VDD
+ VSS VSS gf180mcu_fd_sc_mcu7t5v0__buf_2
Xspi_regs_inst__1215_ spi_regs_inst__1215_/A1 spi_regs_inst__1215_/A2 spi_regs_inst_wire241/Z
+ max_cap460/Z spi_regs_inst__1219_/A1 VDD VDD VSS VSS gf180mcu_fd_sc_mcu7t5v0__aoi22_1
XFILLER_116_715 VDD VDD VSS VSS gf180mcu_fd_sc_mcu7t5v0__fill_1
Xspi_regs_inst__1146_ spi_regs_inst__1146_/A1 spi_regs_inst__1146_/A2 spi_regs_inst__1146_/B1
+ max_cap466/Z spi_regs_inst__1147_/A4 VDD VDD VSS VSS gf180mcu_fd_sc_mcu7t5v0__aoi22_1
XFILLER_124_781 VDD VDD VSS VSS gf180mcu_fd_sc_mcu7t5v0__fill_2
XFILLER_42_2 VDD VDD VSS VSS gf180mcu_fd_sc_mcu7t5v0__fillcap_16
Xspi_regs_inst__1077_ spi_regs_inst__1643_/Q spi_regs_inst__1266_/S spi_regs_inst__1126_/B
+ VDD VDD VSS VSS gf180mcu_fd_sc_mcu7t5v0__nand2_1
XFILLER_112_943 VDD VDD VSS VSS gf180mcu_fd_sc_mcu7t5v0__fill_2
XFILLER_69_334 VDD VDD VSS VSS gf180mcu_fd_sc_mcu7t5v0__fill_1
Xwave_controller_x_inst__2760_ wave_controller_x_inst__3098_/B wave_controller_x_inst__3098_/C
+ wave_controller_x_inst__3092_/A1 VDD VDD VSS VSS gf180mcu_fd_sc_mcu7t5v0__nand2_1
XFILLER_37_220 VDD VDD VSS VSS gf180mcu_fd_sc_mcu7t5v0__fillcap_8
Xwave_controller_x_inst__2691_ wave_controller_x_inst__3245_/A1 wave_controller_x_inst__2689_/Z
+ wave_controller_x_inst__2705_/B VDD VDD VSS VSS gf180mcu_fd_sc_mcu7t5v0__nand2_1
XFILLER_25_415 VDD VDD VSS VSS gf180mcu_fd_sc_mcu7t5v0__fillcap_4
XFILLER_65_562 VDD VDD VSS VSS gf180mcu_fd_sc_mcu7t5v0__fillcap_8
XFILLER_80_510 VDD VDD VSS VSS gf180mcu_fd_sc_mcu7t5v0__fill_1
Xwave_controller_y_inst_load_slew552 wave_controller_y_inst__3648_/RN wave_controller_y_inst__3721_/RN
+ VDD VDD VSS VSS gf180mcu_fd_sc_mcu7t5v0__buf_4
XFILLER_65_595 VDD VDD VSS VSS gf180mcu_fd_sc_mcu7t5v0__fill_1
XFILLER_92_381 VDD VDD VSS VSS gf180mcu_fd_sc_mcu7t5v0__fillcap_4
XFILLER_52_267 VDD VDD VSS VSS gf180mcu_fd_sc_mcu7t5v0__fill_1
XTAP_TAPCELL_ROW_15_1_447 VDD VSS gf180mcu_fd_sc_mcu7t5v0__filltie
Xwave_controller_x_inst__3312_ wave_controller_x_inst__3312_/A1 spi_regs_inst__1552_/Q
+ wave_controller_x_inst__3312_/B1 wave_controller_x_inst__3163_/C wave_controller_x_inst__3313_/I
+ VDD VDD VSS VSS gf180mcu_fd_sc_mcu7t5v0__aoi22_1
XPHY_EDGE_ROW_158_Right_158 VDD VSS gf180mcu_fd_sc_mcu7t5v0__endcap
XFILLER_138_317 VDD VDD VSS VSS gf180mcu_fd_sc_mcu7t5v0__fillcap_16
XFILLER_33_492 VDD VDD VSS VSS gf180mcu_fd_sc_mcu7t5v0__fillcap_8
Xwave_controller_y_inst__2210_ wave_controller_y_inst__3043_/A2 wave_controller_y_inst__2196_/Z
+ wave_controller_y_inst__2210_/B wave_controller_y_inst__2248_/A2 VDD VDD VSS VSS
+ gf180mcu_fd_sc_mcu7t5v0__aoi21_1
Xwave_controller_x_inst__3243_ wave_controller_x_inst__3243_/A1 wave_controller_x_inst__3243_/A2
+ wave_controller_x_inst__3243_/Z VDD VDD VSS VSS gf180mcu_fd_sc_mcu7t5v0__or2_1
XFILLER_165_136 VDD VDD VSS VSS gf180mcu_fd_sc_mcu7t5v0__fillcap_4
Xwave_controller_y_inst__3190_ wave_controller_y_inst__3190_/A1 wave_controller_y_inst__3190_/A2
+ wave_controller_y_inst__3255_/A2 VDD VDD VSS VSS gf180mcu_fd_sc_mcu7t5v0__nand2_1
Xwave_controller_x_inst__3174_ wave_controller_x_inst__3197_/A1 wave_controller_x_inst__3174_/A2
+ wave_controller_x_inst__3173_/Z wave_controller_x_inst__3174_/B1 wave_controller_x_inst__1781_/I
+ wave_controller_x_inst__3252_/A2 VDD VDD VSS VSS gf180mcu_fd_sc_mcu7t5v0__oai32_1
XFILLER_140_1151 VDD VDD VSS VSS gf180mcu_fd_sc_mcu7t5v0__fillcap_4
XFILLER_153_309 VDD VDD VSS VSS gf180mcu_fd_sc_mcu7t5v0__fill_1
Xwave_controller_y_inst__2141_ wave_controller_y_inst__3731_/Q wave_controller_y_inst__2754_/A2
+ wave_controller_y_inst__2139_/Z wave_controller_y_inst__2149_/B VDD VDD VSS VSS
+ gf180mcu_fd_sc_mcu7t5v0__nand3_1
Xwave_controller_x_inst__2125_ wave_controller_x_inst__2125_/A1 wave_controller_x_inst__2125_/A2
+ wave_controller_x_inst__2125_/B wave_controller_x_inst__2125_/C wave_controller_x_inst__2138_/B1
+ VDD VDD VSS VSS gf180mcu_fd_sc_mcu7t5v0__oai211_1
XFILLER_119_575 VDD VDD VSS VSS gf180mcu_fd_sc_mcu7t5v0__fill_1
XFILLER_119_597 VDD VDD VSS VSS gf180mcu_fd_sc_mcu7t5v0__fill_2
XFILLER_140_1173 VDD VDD VSS VSS gf180mcu_fd_sc_mcu7t5v0__fill_1
XPHY_EDGE_ROW_13_1_Right_12 VDD VSS gf180mcu_fd_sc_mcu7t5v0__endcap
Xwave_controller_y_inst__2072_ wave_controller_y_inst__2070_/Z wave_controller_y_inst__2072_/A2
+ wave_controller_y_inst__2072_/B wave_controller_y_inst__2076_/A1 VDD VDD VSS VSS
+ gf180mcu_fd_sc_mcu7t5v0__aoi21_1
XTAP_TAPCELL_ROW_95_1445 VDD VSS gf180mcu_fd_sc_mcu7t5v0__filltie
XFILLER_106_247 VDD VDD VSS VSS gf180mcu_fd_sc_mcu7t5v0__fillcap_64
Xwave_controller_x_inst__2056_ wave_controller_x_inst__2125_/A2 wave_controller_x_inst__2039_/B
+ wave_controller_x_inst__2093_/A3 VDD VDD VSS VSS gf180mcu_fd_sc_mcu7t5v0__nor2_1
XFILLER_161_364 VDD VDD VSS VSS gf180mcu_fd_sc_mcu7t5v0__fill_1
XFILLER_164_37 VDD VDD VSS VSS gf180mcu_fd_sc_mcu7t5v0__fillcap_64
XFILLER_103_976 VDD VDD VSS VSS gf180mcu_fd_sc_mcu7t5v0__fillcap_4
XFILLER_87_142 VDD VDD VSS VSS gf180mcu_fd_sc_mcu7t5v0__fill_2
XFILLER_87_153 VDD VDD VSS VSS gf180mcu_fd_sc_mcu7t5v0__fill_2
Xwave_controller_y_inst__2974_ wave_controller_y_inst__3055_/A2 wave_controller_y_inst__3055_/B
+ wave_controller_y_inst__2974_/B wave_controller_y_inst__3058_/A3 VDD VDD VSS VSS
+ gf180mcu_fd_sc_mcu7t5v0__aoi21_1
XFILLER_57_68 VDD VDD VSS VSS gf180mcu_fd_sc_mcu7t5v0__fill_2
XFILLER_75_304 VDD VDD VSS VSS gf180mcu_fd_sc_mcu7t5v0__fillcap_4
Xwave_controller_y_inst__1925_ spi_regs_inst__1569_/Q wave_controller_y_inst__3572_/A1
+ spi_regs_inst__1568_/Q wave_controller_y_inst__3570_/A1 wave_controller_y_inst__1926_/A2
+ VDD VDD VSS VSS gf180mcu_fd_sc_mcu7t5v0__oai22_1
Xwave_controller_x_inst__2958_ wave_controller_x_inst__3704_/Q spi_regs_inst__1473_/Q
+ wave_controller_x_inst__2969_/B VDD VDD VSS VSS gf180mcu_fd_sc_mcu7t5v0__nand2_1
Xwave_controller_x_inst__2889_ wave_controller_x_inst__2768_/Z wave_controller_x_inst__2889_/A2
+ wave_controller_x_inst__2889_/B wave_controller_x_inst__3465_/B wave_controller_x_inst__2909_/A2
+ VDD VDD VSS VSS gf180mcu_fd_sc_mcu7t5v0__oai211_1
Xwave_controller_x_inst__1909_ spi_regs_inst__1305_/B2 wave_controller_x_inst__3482_/A1
+ VDD VDD VSS VSS gf180mcu_fd_sc_mcu7t5v0__clkinv_1
XFILLER_84_871 VDD VDD VSS VSS gf180mcu_fd_sc_mcu7t5v0__fillcap_4
Xwave_controller_y_inst__1856_ spi_regs_inst__1316_/A1 wave_controller_y_inst__2521_/A1
+ VDD VDD VSS VSS gf180mcu_fd_sc_mcu7t5v0__clkinv_1
XFILLER_16_437 VDD VDD VSS VSS gf180mcu_fd_sc_mcu7t5v0__fill_1
XFILLER_16_448 VDD VDD VSS VSS gf180mcu_fd_sc_mcu7t5v0__fill_1
XFILLER_43_212 VDD VDD VSS VSS gf180mcu_fd_sc_mcu7t5v0__fillcap_4
XFILLER_43_223 VDD VDD VSS VSS gf180mcu_fd_sc_mcu7t5v0__fillcap_4
XFILLER_71_532 VDD VDD VSS VSS gf180mcu_fd_sc_mcu7t5v0__fillcap_4
XFILLER_73_45 VDD VDD VSS VSS gf180mcu_fd_sc_mcu7t5v0__fill_2
XFILLER_83_381 VDD VDD VSS VSS gf180mcu_fd_sc_mcu7t5v0__fillcap_8
Xwave_controller_y_inst__1787_ spi_regs_inst__1574_/Q wave_controller_y_inst__1934_/B2
+ VDD VDD VSS VSS gf180mcu_fd_sc_mcu7t5v0__clkinv_1
XFILLER_71_554 VDD VDD VSS VSS gf180mcu_fd_sc_mcu7t5v0__fillcap_4
XTAP_TAPCELL_ROW_54_763 VDD VSS gf180mcu_fd_sc_mcu7t5v0__filltie
Xwave_controller_y_inst__3526_ max_cap432/I wave_controller_y_inst__3529_/A2 wave_controller_y_inst__3527_/A3
+ VDD VDD VSS VSS gf180mcu_fd_sc_mcu7t5v0__nor2_1
XFILLER_43_278 VDD VDD VSS VSS gf180mcu_fd_sc_mcu7t5v0__fill_2
XFILLER_58_1081 VDD VDD VSS VSS gf180mcu_fd_sc_mcu7t5v0__fillcap_4
XPHY_EDGE_ROW_125_Right_125 VDD VSS gf180mcu_fd_sc_mcu7t5v0__endcap
XTAP_TAPCELL_ROW_104_1585 VDD VSS gf180mcu_fd_sc_mcu7t5v0__filltie
XTAP_TAPCELL_ROW_54_774 VDD VSS gf180mcu_fd_sc_mcu7t5v0__filltie
Xwave_controller_x_inst_max_cap376 wave_controller_x_inst__2071_/A1 wave_controller_x_inst__2125_/A1
+ VDD VDD VSS VSS gf180mcu_fd_sc_mcu7t5v0__buf_2
XFILLER_129_306 VDD VDD VSS VSS gf180mcu_fd_sc_mcu7t5v0__fill_1
XTAP_TAPCELL_ROW_104_1596 VDD VSS gf180mcu_fd_sc_mcu7t5v0__filltie
Xwave_controller_y_inst__3457_ wave_controller_y_inst__3493_/A2 wave_controller_y_inst__3461_/A2
+ wave_controller_y_inst__3460_/A1 VDD VDD VSS VSS gf180mcu_fd_sc_mcu7t5v0__nand2_1
Xwave_controller_y_inst__2408_ wave_controller_y_inst__2407_/B wave_controller_y_inst__2408_/A2
+ wave_controller_y_inst__2409_/I VDD VDD VSS VSS gf180mcu_fd_sc_mcu7t5v0__xor2_1
Xwave_controller_y_inst__3388_ wave_controller_y_inst__3212_/B wave_controller_y_inst__3364_/Z
+ wave_controller_y_inst__3388_/B wave_controller_y_inst__3390_/B2 VDD VDD VSS VSS
+ gf180mcu_fd_sc_mcu7t5v0__aoi21_1
Xsignal_processor_x_inst__116_ signal_processor_x_inst__128_/A1 wave_controller_x_inst__3616_/Q
+ signal_processor_x_inst__253_/D VDD VDD VSS VSS gf180mcu_fd_sc_mcu7t5v0__and2_1
Xwave_controller_y_inst__2339_ wave_controller_y_inst__2616_/A1 wave_controller_y_inst__2325_/Z
+ wave_controller_y_inst__2339_/B wave_controller_y_inst__2341_/A2 VDD VDD VSS VSS
+ gf180mcu_fd_sc_mcu7t5v0__oai21_1
XFILLER_138_93 VDD VDD VSS VSS gf180mcu_fd_sc_mcu7t5v0__fillcap_8
XFILLER_98_20 VDD VDD VSS VSS gf180mcu_fd_sc_mcu7t5v0__fillcap_8
XFILLER_98_53 VDD VDD VSS VSS gf180mcu_fd_sc_mcu7t5v0__fillcap_8
Xstate_machine_inst__30_ spi_regs_inst__1058_/B2 state_machine_inst__37_/A1 state_machine_inst__30_/B
+ state_machine_inst__31_/B VDD VDD VSS VSS gf180mcu_fd_sc_mcu7t5v0__oai21_1
Xspi_regs_inst__1000_ spi_regs_inst__1031_/A1 spi_regs_inst__1027_/A2 spi_regs_inst__1240_/A2
+ VDD VDD VSS VSS gf180mcu_fd_sc_mcu7t5v0__nor2_1
XFILLER_113_718 VDD VDD VSS VSS gf180mcu_fd_sc_mcu7t5v0__fill_2
XFILLER_3_352 VDD VDD VSS VSS gf180mcu_fd_sc_mcu7t5v0__fillcap_16
XFILLER_112_239 VDD VDD VSS VSS gf180mcu_fd_sc_mcu7t5v0__fillcap_4
XFILLER_140_548 VDD VDD VSS VSS gf180mcu_fd_sc_mcu7t5v0__fillcap_4
XFILLER_140_559 VDD VDD VSS VSS gf180mcu_fd_sc_mcu7t5v0__fillcap_4
XFILLER_152_1011 VDD VDD VSS VSS gf180mcu_fd_sc_mcu7t5v0__fillcap_4
XFILLER_3_374 VDD VDD VSS VSS gf180mcu_fd_sc_mcu7t5v0__fill_1
XFILLER_65_1052 VDD VDD VSS VSS gf180mcu_fd_sc_mcu7t5v0__fillcap_64
XFILLER_79_632 VDD VDD VSS VSS gf180mcu_fd_sc_mcu7t5v0__fillcap_16
XFILLER_98_97 VDD VDD VSS VSS gf180mcu_fd_sc_mcu7t5v0__fillcap_8
XFILLER_121_751 VDD VDD VSS VSS gf180mcu_fd_sc_mcu7t5v0__fillcap_8
XFILLER_67_838 VDD VDD VSS VSS gf180mcu_fd_sc_mcu7t5v0__fill_2
XTAP_TAPCELL_ROW_124_1917 VDD VSS gf180mcu_fd_sc_mcu7t5v0__filltie
XFILLER_34_223 VDD VDD VSS VSS gf180mcu_fd_sc_mcu7t5v0__fillcap_16
XFILLER_90_841 VDD VDD VSS VSS gf180mcu_fd_sc_mcu7t5v0__fillcap_8
XTAP_TAPCELL_ROW_124_1928 VDD VSS gf180mcu_fd_sc_mcu7t5v0__filltie
XFILLER_90_874 VDD VDD VSS VSS gf180mcu_fd_sc_mcu7t5v0__fill_1
XFILLER_90_885 VDD VDD VSS VSS gf180mcu_fd_sc_mcu7t5v0__fillcap_4
XFILLER_15_492 VDD VDD VSS VSS gf180mcu_fd_sc_mcu7t5v0__fillcap_32
XFILLER_124_1157 VDD VDD VSS VSS gf180mcu_fd_sc_mcu7t5v0__fillcap_16
XFILLER_147_136 VDD VDD VSS VSS gf180mcu_fd_sc_mcu7t5v0__fillcap_4
XFILLER_116_501 VDD VDD VSS VSS gf180mcu_fd_sc_mcu7t5v0__fillcap_16
XFILLER_116_556 VDD VDD VSS VSS gf180mcu_fd_sc_mcu7t5v0__fill_2
XFILLER_143_331 VDD VDD VSS VSS gf180mcu_fd_sc_mcu7t5v0__fill_1
XTAP_TAPCELL_ROW_77_1142 VDD VSS gf180mcu_fd_sc_mcu7t5v0__filltie
XTAP_TAPCELL_ROW_77_1153 VDD VSS gf180mcu_fd_sc_mcu7t5v0__filltie
XFILLER_103_206 VDD VDD VSS VSS gf180mcu_fd_sc_mcu7t5v0__fillcap_4
XFILLER_131_504 VDD VDD VSS VSS gf180mcu_fd_sc_mcu7t5v0__fill_1
XFILLER_131_515 VDD VDD VSS VSS gf180mcu_fd_sc_mcu7t5v0__fillcap_32
Xspi_regs_inst__1129_ spi_regs_inst__1129_/A1 spi_regs_inst_wire247/Z spi_regs_inst__1142_/A1
+ VDD VDD VSS VSS gf180mcu_fd_sc_mcu7t5v0__nand2_1
XFILLER_131_559 VDD VDD VSS VSS gf180mcu_fd_sc_mcu7t5v0__fill_1
XFILLER_134_18 VDD VDD VSS VSS gf180mcu_fd_sc_mcu7t5v0__fill_1
XFILLER_69_142 VDD VDD VSS VSS gf180mcu_fd_sc_mcu7t5v0__fillcap_4
XFILLER_97_440 VDD VDD VSS VSS gf180mcu_fd_sc_mcu7t5v0__fillcap_4
XTAP_TAPCELL_ROW_90_1364 VDD VSS gf180mcu_fd_sc_mcu7t5v0__filltie
Xwave_controller_x_inst__2812_ wave_controller_x_inst__1792_/I wave_controller_x_inst__2813_/B1
+ wave_controller_x_inst__2812_/B1 wave_controller_x_inst__2812_/B2 wave_controller_x_inst__2818_/A1
+ VDD VDD VSS VSS gf180mcu_fd_sc_mcu7t5v0__aoi22_1
XFILLER_84_123 VDD VDD VSS VSS gf180mcu_fd_sc_mcu7t5v0__fill_2
Xwave_controller_x_inst__2743_ spi_regs_inst__1225_/A1 wave_controller_x_inst__3557_/B2
+ wave_controller_x_inst__2743_/A3 wave_controller_x_inst__2743_/Z VDD VDD VSS VSS
+ gf180mcu_fd_sc_mcu7t5v0__xor3_1
Xwave_controller_y_inst__2690_ wave_controller_y_inst__3245_/A1 wave_controller_y_inst__2689_/Z
+ wave_controller_y_inst__2705_/A2 VDD VDD VSS VSS gf180mcu_fd_sc_mcu7t5v0__nor2_1
Xwave_controller_x_inst__2674_ wave_controller_x_inst__3539_/B2 wave_controller_x_inst__2672_/Z
+ wave_controller_x_inst__2674_/Z VDD VDD VSS VSS gf180mcu_fd_sc_mcu7t5v0__xor2_1
XFILLER_25_212 VDD VDD VSS VSS gf180mcu_fd_sc_mcu7t5v0__fillcap_4
XFILLER_66_893 VDD VDD VSS VSS gf180mcu_fd_sc_mcu7t5v0__fillcap_8
XFILLER_129_1046 VDD VDD VSS VSS gf180mcu_fd_sc_mcu7t5v0__fillcap_4
XFILLER_80_351 VDD VDD VSS VSS gf180mcu_fd_sc_mcu7t5v0__fillcap_4
XFILLER_40_226 VDD VDD VSS VSS gf180mcu_fd_sc_mcu7t5v0__fillcap_8
Xwave_controller_y_inst__3311_ wave_controller_y_inst__3712_/Q wave_controller_y_inst__3311_/A2
+ wave_controller_y_inst__3311_/B wave_controller_y_inst__3312_/B1 VDD VDD VSS VSS
+ gf180mcu_fd_sc_mcu7t5v0__aoi21_1
XFILLER_139_604 VDD VDD VSS VSS gf180mcu_fd_sc_mcu7t5v0__fill_2
XFILLER_166_401 VDD VDD VSS VSS gf180mcu_fd_sc_mcu7t5v0__fillcap_8
XFILLER_167_902 VDD VDD VSS VSS gf180mcu_fd_sc_mcu7t5v0__fill_2
XFILLER_40_259 VDD VDD VSS VSS gf180mcu_fd_sc_mcu7t5v0__fill_2
XFILLER_90_1167 VDD VDD VSS VSS gf180mcu_fd_sc_mcu7t5v0__fill_1
Xwave_controller_y_inst__3242_ wave_controller_y_inst__1819_/I wave_controller_y_inst__3202_/Z
+ wave_controller_y_inst__3242_/A3 wave_controller_y_inst__3242_/B1 fanout517/Z wave_controller_y_inst__3243_/A2
+ VDD VDD VSS VSS gf180mcu_fd_sc_mcu7t5v0__oai32_1
Xwave_controller_x_inst__3226_ wave_controller_x_inst__3374_/B wave_controller_x_inst__3234_/A2
+ wave_controller_x_inst__3235_/B1 VDD VDD VSS VSS gf180mcu_fd_sc_mcu7t5v0__nand2_1
XFILLER_154_607 VDD VDD VSS VSS gf180mcu_fd_sc_mcu7t5v0__fill_1
XFILLER_21_484 VDD VDD VSS VSS gf180mcu_fd_sc_mcu7t5v0__fillcap_4
Xwave_controller_y_inst__3173_ wave_controller_y_inst__3107_/Z wave_controller_y_inst__3171_/Z
+ wave_controller_y_inst__3173_/Z VDD VDD VSS VSS gf180mcu_fd_sc_mcu7t5v0__or2_1
XFILLER_166_489 VDD VDD VSS VSS gf180mcu_fd_sc_mcu7t5v0__fillcap_4
Xwave_controller_y_inst__2124_ wave_controller_y_inst__2124_/A1 wave_controller_y_inst__2124_/A2
+ wave_controller_y_inst__2124_/B wave_controller_y_inst__2145_/I1 VDD VDD VSS VSS
+ gf180mcu_fd_sc_mcu7t5v0__oai21_1
Xwave_controller_x_inst__3157_ wave_controller_x_inst__3711_/Q spi_regs_inst__1530_/Q
+ wave_controller_x_inst__3158_/I VDD VDD VSS VSS gf180mcu_fd_sc_mcu7t5v0__xor2_1
XFILLER_134_331 VDD VDD VSS VSS gf180mcu_fd_sc_mcu7t5v0__fillcap_32
XFILLER_135_865 VDD VDD VSS VSS gf180mcu_fd_sc_mcu7t5v0__fillcap_32
Xwave_controller_x_inst__3088_ wave_controller_x_inst__3407_/B wave_controller_x_inst__3087_/Z
+ wave_controller_x_inst__3719_/D VDD VDD VSS VSS gf180mcu_fd_sc_mcu7t5v0__nor2_1
Xwave_controller_x_inst__2108_ wave_controller_x_inst__2114_/B wave_controller_x_inst__2092_/B
+ wave_controller_x_inst__2125_/C wave_controller_x_inst__2108_/C wave_controller_x_inst__2110_/B
+ VDD VDD VSS VSS gf180mcu_fd_sc_mcu7t5v0__aoi211_1
XFILLER_162_662 VDD VDD VSS VSS gf180mcu_fd_sc_mcu7t5v0__fill_2
Xwave_controller_y_inst__2055_ wave_controller_y_inst__2073_/A1 wave_controller_y_inst__2108_/B
+ wave_controller_y_inst__2079_/A1 VDD VDD VSS VSS gf180mcu_fd_sc_mcu7t5v0__nand2_1
Xwave_controller_x_inst__2039_ wave_controller_x_inst_wire377/Z wave_controller_x_inst__2035_/Z
+ wave_controller_x_inst__2039_/B wave_controller_x_inst__2092_/B VDD VDD VSS VSS
+ gf180mcu_fd_sc_mcu7t5v0__aoi21_1
XFILLER_136_1017 VDD VDD VSS VSS gf180mcu_fd_sc_mcu7t5v0__fillcap_64
XFILLER_68_34 VDD VDD VSS VSS gf180mcu_fd_sc_mcu7t5v0__fill_1
Xspi_regs_inst_fanout613 fanout620/Z spi_regs_inst__1551_/RN VDD VDD VSS VSS gf180mcu_fd_sc_mcu7t5v0__dlyb_1
XFILLER_103_762 VDD VDD VSS VSS gf180mcu_fd_sc_mcu7t5v0__fillcap_8
XFILLER_102_272 VDD VDD VSS VSS gf180mcu_fd_sc_mcu7t5v0__fillcap_4
XFILLER_103_784 VDD VDD VSS VSS gf180mcu_fd_sc_mcu7t5v0__fill_2
XFILLER_130_592 VDD VDD VSS VSS gf180mcu_fd_sc_mcu7t5v0__fill_2
XFILLER_76_646 VDD VDD VSS VSS gf180mcu_fd_sc_mcu7t5v0__fillcap_16
XTAP_TAPCELL_ROW_59_844 VDD VSS gf180mcu_fd_sc_mcu7t5v0__filltie
XTAP_TAPCELL_ROW_59_855 VDD VSS gf180mcu_fd_sc_mcu7t5v0__filltie
Xwave_controller_y_inst__2957_ wave_controller_y_inst__3705_/Q fanout505/I wave_controller_y_inst__2957_/Z
+ VDD VDD VSS VSS gf180mcu_fd_sc_mcu7t5v0__or2_1
XFILLER_63_318 VDD VDD VSS VSS gf180mcu_fd_sc_mcu7t5v0__fill_1
XFILLER_76_679 VDD VDD VSS VSS gf180mcu_fd_sc_mcu7t5v0__fill_2
XFILLER_90_104 VDD VDD VSS VSS gf180mcu_fd_sc_mcu7t5v0__fill_1
XTAP_TAPCELL_ROW_141_2206 VDD VSS gf180mcu_fd_sc_mcu7t5v0__filltie
Xwave_controller_y_inst__2888_ wave_controller_y_inst__2856_/Z wave_controller_y_inst__2889_/B
+ wave_controller_y_inst__3419_/B VDD VDD VSS VSS gf180mcu_fd_sc_mcu7t5v0__and2_1
Xwave_controller_y_inst__1908_ spi_regs_inst__1270_/A1 wave_controller_y_inst__3472_/A1
+ VDD VDD VSS VSS gf180mcu_fd_sc_mcu7t5v0__clkinv_1
XFILLER_90_115 VDD VDD VSS VSS gf180mcu_fd_sc_mcu7t5v0__fillcap_4
XFILLER_99_1170 VDD VDD VSS VSS gf180mcu_fd_sc_mcu7t5v0__fillcap_4
XTAP_TAPCELL_ROW_106_1625 VDD VSS gf180mcu_fd_sc_mcu7t5v0__filltie
Xwave_controller_y_inst__1839_ spi_regs_inst__1354_/A1 wave_controller_y_inst__2236_/A1
+ VDD VDD VSS VSS gf180mcu_fd_sc_mcu7t5v0__clkinv_1
XFILLER_72_874 VDD VDD VSS VSS gf180mcu_fd_sc_mcu7t5v0__fill_1
XFILLER_90_159 VDD VDD VSS VSS gf180mcu_fd_sc_mcu7t5v0__fillcap_16
Xspi_regs_inst__1480_ spi_regs_inst__1480_/D spi_regs_inst__1610_/RN clkload13/I fanout517/I
+ VDD VDD VSS VSS gf180mcu_fd_sc_mcu7t5v0__dffrnq_1
Xwave_controller_y_inst__3509_ wave_controller_y_inst_wire144/Z wave_controller_y_inst__3509_/A2
+ wave_controller_y_inst__3509_/A3 wave_controller_y_inst_wire139/Z wave_controller_y_inst__3509_/B2
+ wave_controller_y_inst__3632_/D VDD VDD VSS VSS gf180mcu_fd_sc_mcu7t5v0__oai32_1
XFILLER_129_114 VDD VDD VSS VSS gf180mcu_fd_sc_mcu7t5v0__fill_1
XFILLER_12_451 VDD VDD VSS VSS gf180mcu_fd_sc_mcu7t5v0__fillcap_4
XFILLER_12_473 VDD VDD VSS VSS gf180mcu_fd_sc_mcu7t5v0__fillcap_4
XFILLER_8_411 VDD VDD VSS VSS gf180mcu_fd_sc_mcu7t5v0__fill_1
XTAP_TAPCELL_ROW_139_2168 VDD VSS gf180mcu_fd_sc_mcu7t5v0__filltie
XFILLER_129_158 VDD VDD VSS VSS gf180mcu_fd_sc_mcu7t5v0__fill_1
XFILLER_12_495 VDD VDD VSS VSS gf180mcu_fd_sc_mcu7t5v0__fillcap_4
XFILLER_126_821 VDD VDD VSS VSS gf180mcu_fd_sc_mcu7t5v0__fillcap_16
XTAP_TAPCELL_ROW_48_1_690 VDD VSS gf180mcu_fd_sc_mcu7t5v0__filltie
XFILLER_144_128 VDD VDD VSS VSS gf180mcu_fd_sc_mcu7t5v0__fillcap_4
XFILLER_153_640 VDD VDD VSS VSS gf180mcu_fd_sc_mcu7t5v0__fillcap_4
XTAP_TAPCELL_ROW_152_2379 VDD VSS gf180mcu_fd_sc_mcu7t5v0__filltie
XFILLER_153_684 VDD VDD VSS VSS gf180mcu_fd_sc_mcu7t5v0__fill_2
XTAP_TAPCELL_ROW_14_1_435 VDD VSS gf180mcu_fd_sc_mcu7t5v0__filltie
XFILLER_140_345 VDD VDD VSS VSS gf180mcu_fd_sc_mcu7t5v0__fillcap_32
XTAP_TAPCELL_ROW_72_1061 VDD VSS gf180mcu_fd_sc_mcu7t5v0__filltie
XFILLER_79_484 VDD VDD VSS VSS gf180mcu_fd_sc_mcu7t5v0__fillcap_4
XTAP_TAPCELL_ROW_72_1072 VDD VSS gf180mcu_fd_sc_mcu7t5v0__filltie
XFILLER_94_454 VDD VDD VSS VSS gf180mcu_fd_sc_mcu7t5v0__fill_1
XFILLER_55_819 VDD VDD VSS VSS gf180mcu_fd_sc_mcu7t5v0__fillcap_8
XFILLER_82_605 VDD VDD VSS VSS gf180mcu_fd_sc_mcu7t5v0__fill_1
XFILLER_54_329 VDD VDD VSS VSS gf180mcu_fd_sc_mcu7t5v0__fillcap_4
XFILLER_81_137 VDD VDD VSS VSS gf180mcu_fd_sc_mcu7t5v0__fill_2
XFILLER_63_874 VDD VDD VSS VSS gf180mcu_fd_sc_mcu7t5v0__fillcap_8
Xwave_controller_y_inst_wire319 wave_controller_y_inst__2032_/Z wave_controller_y_inst__2058_/C
+ VDD VDD VSS VSS gf180mcu_fd_sc_mcu7t5v0__clkbuf_2
XFILLER_63_896 VDD VDD VSS VSS gf180mcu_fd_sc_mcu7t5v0__fillcap_8
XFILLER_90_671 VDD VDD VSS VSS gf180mcu_fd_sc_mcu7t5v0__fill_2
Xwave_controller_x_inst__2390_ wave_controller_x_inst__2396_/C wave_controller_x_inst__2389_/Z
+ wave_controller_x_inst__2392_/A1 VDD VDD VSS VSS gf180mcu_fd_sc_mcu7t5v0__nor2_1
XFILLER_30_281 VDD VDD VSS VSS gf180mcu_fd_sc_mcu7t5v0__fill_1
Xwave_controller_x_inst__3011_ wave_controller_x_inst__3692_/Q wave_controller_x_inst_wire60/I
+ wave_controller_x_inst__3015_/A2 VDD VDD VSS VSS gf180mcu_fd_sc_mcu7t5v0__nand2_1
XFILLER_129_681 VDD VDD VSS VSS gf180mcu_fd_sc_mcu7t5v0__fillcap_4
XFILLER_135_106 VDD VDD VSS VSS gf180mcu_fd_sc_mcu7t5v0__fillcap_4
XFILLER_128_191 VDD VDD VSS VSS gf180mcu_fd_sc_mcu7t5v0__fill_1
XFILLER_135_139 VDD VDD VSS VSS gf180mcu_fd_sc_mcu7t5v0__fill_1
XFILLER_104_537 VDD VDD VSS VSS gf180mcu_fd_sc_mcu7t5v0__fill_1
XFILLER_89_226 VDD VDD VSS VSS gf180mcu_fd_sc_mcu7t5v0__fill_1
XFILLER_131_334 VDD VDD VSS VSS gf180mcu_fd_sc_mcu7t5v0__fill_1
XFILLER_132_868 VDD VDD VSS VSS gf180mcu_fd_sc_mcu7t5v0__fillcap_4
XFILLER_58_613 VDD VDD VSS VSS gf180mcu_fd_sc_mcu7t5v0__fillcap_4
XFILLER_85_410 VDD VDD VSS VSS gf180mcu_fd_sc_mcu7t5v0__fill_1
XFILLER_86_944 VDD VDD VSS VSS gf180mcu_fd_sc_mcu7t5v0__fill_1
Xwave_controller_y_inst__2811_ wave_controller_y_inst__3570_/A1 wave_controller_y_inst__2806_/I
+ wave_controller_y_inst__2812_/B2 VDD VDD VSS VSS gf180mcu_fd_sc_mcu7t5v0__nand2_1
XFILLER_100_787 VDD VDD VSS VSS gf180mcu_fd_sc_mcu7t5v0__fillcap_16
XFILLER_57_156 VDD VDD VSS VSS gf180mcu_fd_sc_mcu7t5v0__fill_1
XFILLER_58_679 VDD VDD VSS VSS gf180mcu_fd_sc_mcu7t5v0__fillcap_8
XFILLER_73_616 VDD VDD VSS VSS gf180mcu_fd_sc_mcu7t5v0__fill_2
XTAP_TAPCELL_ROW_56_803 VDD VSS gf180mcu_fd_sc_mcu7t5v0__filltie
Xwave_controller_y_inst__2742_ wave_controller_y_inst__2774_/A1 spi_regs_inst__1194_/B2
+ wave_controller_y_inst__2742_/B wave_controller_y_inst__2743_/A3 VDD VDD VSS VSS
+ gf180mcu_fd_sc_mcu7t5v0__aoi21_1
Xwave_controller_x_inst__2726_ wave_controller_x_inst__2737_/A1 wave_controller_x_inst__2714_/Z
+ wave_controller_x_inst__2726_/B wave_controller_x_inst__2727_/A2 VDD VDD VSS VSS
+ gf180mcu_fd_sc_mcu7t5v0__oai21_1
XFILLER_26_521 VDD VDD VSS VSS gf180mcu_fd_sc_mcu7t5v0__fillcap_4
XFILLER_38_381 VDD VDD VSS VSS gf180mcu_fd_sc_mcu7t5v0__fillcap_4
XTAP_TAPCELL_ROW_0_1_2668 VDD VSS gf180mcu_fd_sc_mcu7t5v0__filltie
Xwave_controller_y_inst__2673_ spi_regs_inst__1303_/A1 wave_controller_y_inst__2672_/Z
+ wave_controller_y_inst__2694_/A2 VDD VDD VSS VSS gf180mcu_fd_sc_mcu7t5v0__nand2_1
Xwave_controller_x_inst__2657_ wave_controller_x_inst__2688_/B1 wave_controller_x_inst__2686_/A1
+ wave_controller_x_inst__2660_/A3 VDD VDD VSS VSS gf180mcu_fd_sc_mcu7t5v0__xnor2_1
XFILLER_41_524 VDD VDD VSS VSS gf180mcu_fd_sc_mcu7t5v0__fill_2
Xwave_controller_x_inst__2588_ fanout521/Z wave_controller_x_inst__2589_/A3 wave_controller_x_inst__2588_/Z
+ VDD VDD VSS VSS gf180mcu_fd_sc_mcu7t5v0__and2_1
XFILLER_158_209 VDD VDD VSS VSS gf180mcu_fd_sc_mcu7t5v0__fillcap_4
XFILLER_70_24 VDD VDD VSS VSS gf180mcu_fd_sc_mcu7t5v0__fillcap_4
XTAP_TAPCELL_ROW_101_1544 VDD VSS gf180mcu_fd_sc_mcu7t5v0__filltie
XFILLER_110_97 VDD VDD VSS VSS gf180mcu_fd_sc_mcu7t5v0__fillcap_8
Xwave_controller_y_inst__3225_ wave_controller_y_inst__3225_/A1 wave_controller_y_inst__3225_/A2
+ wave_controller_y_inst__3234_/A2 VDD VDD VSS VSS gf180mcu_fd_sc_mcu7t5v0__nor2_1
XFILLER_139_478 VDD VDD VSS VSS gf180mcu_fd_sc_mcu7t5v0__fill_2
XFILLER_142_1087 VDD VDD VSS VSS gf180mcu_fd_sc_mcu7t5v0__fillcap_64
Xwave_controller_x_inst__3209_ wave_controller_x_inst__3207_/Z wave_controller_x_inst__3210_/A3
+ wave_controller_x_inst__3209_/B wave_controller_x_inst__3241_/C VDD VDD VSS VSS
+ gf180mcu_fd_sc_mcu7t5v0__aoi21_1
XFILLER_108_832 VDD VDD VSS VSS gf180mcu_fd_sc_mcu7t5v0__fillcap_16
Xwave_controller_y_inst__3156_ wave_controller_y_inst__3709_/Q wave_controller_y_inst__3156_/A2
+ wave_controller_y_inst__3156_/B wave_controller_y_inst__3205_/A2 VDD VDD VSS VSS
+ gf180mcu_fd_sc_mcu7t5v0__oai21_1
XFILLER_163_982 VDD VDD VSS VSS gf180mcu_fd_sc_mcu7t5v0__fillcap_64
XTAP_TAPCELL_ROW_134_2087 VDD VSS gf180mcu_fd_sc_mcu7t5v0__filltie
Xwave_controller_y_inst__3087_ wave_controller_y_inst__3189_/C wave_controller_y_inst__3084_/Z
+ wave_controller_y_inst__3087_/Z VDD VDD VSS VSS gf180mcu_fd_sc_mcu7t5v0__xor2_1
Xwave_controller_y_inst__2107_ wave_controller_y_inst_wire356/Z wave_controller_y_inst__2109_/A2
+ wave_controller_y_inst__2107_/B wave_controller_y_inst__2114_/B wave_controller_y_inst__2108_/C
+ VDD VDD VSS VSS gf180mcu_fd_sc_mcu7t5v0__aoi211_1
XFILLER_162_481 VDD VDD VSS VSS gf180mcu_fd_sc_mcu7t5v0__fillcap_4
Xwave_controller_y_inst__2038_ wave_controller_y_inst__1781_/I wave_controller_y_inst__2038_/A2
+ wave_controller_y_inst__2039_/B VDD VDD VSS VSS gf180mcu_fd_sc_mcu7t5v0__xnor2_1
XFILLER_62_1011 VDD VDD VSS VSS gf180mcu_fd_sc_mcu7t5v0__fillcap_4
XPHY_EDGE_ROW_79_Left_246 VDD VSS gf180mcu_fd_sc_mcu7t5v0__endcap
XFILLER_122_378 VDD VDD VSS VSS gf180mcu_fd_sc_mcu7t5v0__fillcap_4
XFILLER_135_61 VDD VDD VSS VSS gf180mcu_fd_sc_mcu7t5v0__fillcap_8
XFILLER_135_72 VDD VDD VSS VSS gf180mcu_fd_sc_mcu7t5v0__fill_2
XFILLER_48_101 VDD VDD VSS VSS gf180mcu_fd_sc_mcu7t5v0__fillcap_4
XFILLER_89_782 VDD VDD VSS VSS gf180mcu_fd_sc_mcu7t5v0__fillcap_8
XFILLER_95_207 VDD VDD VSS VSS gf180mcu_fd_sc_mcu7t5v0__fill_2
XFILLER_48_123 VDD VDD VSS VSS gf180mcu_fd_sc_mcu7t5v0__fillcap_8
Xspi_regs_inst__0980_ spi_regs_inst__1366_/A1 spi_regs_inst__1628_/Q spi_regs_inst__1368_/A1
+ spi_regs_inst__1631_/Q spi_regs_inst__1016_/A2 VDD VDD VSS VSS gf180mcu_fd_sc_mcu7t5v0__nand4_1
XFILLER_76_454 VDD VDD VSS VSS gf180mcu_fd_sc_mcu7t5v0__fill_1
XFILLER_77_977 VDD VDD VSS VSS gf180mcu_fd_sc_mcu7t5v0__fill_2
XFILLER_76_498 VDD VDD VSS VSS gf180mcu_fd_sc_mcu7t5v0__fillcap_8
XFILLER_92_947 VDD VDD VSS VSS gf180mcu_fd_sc_mcu7t5v0__fillcap_64
Xspi_regs_inst__1601_ spi_regs_inst__1601_/D spi_regs_inst__1601_/RN clkbuf_leaf_38_clk/Z
+ spi_regs_inst__1601_/Q VDD VDD VSS VSS gf180mcu_fd_sc_mcu7t5v0__dffrnq_1
XFILLER_32_524 VDD VDD VSS VSS gf180mcu_fd_sc_mcu7t5v0__fill_1
XFILLER_44_373 VDD VDD VSS VSS gf180mcu_fd_sc_mcu7t5v0__fill_2
XFILLER_44_384 VDD VDD VSS VSS gf180mcu_fd_sc_mcu7t5v0__fill_1
XFILLER_44_395 VDD VDD VSS VSS gf180mcu_fd_sc_mcu7t5v0__fill_1
XPHY_EDGE_ROW_88_Left_255 VDD VSS gf180mcu_fd_sc_mcu7t5v0__endcap
Xspi_regs_inst__1532_ spi_regs_inst__1532_/D wire594/Z clkbuf_leaf_11_clk/Z spi_regs_inst__1532_/Q
+ VDD VDD VSS VSS gf180mcu_fd_sc_mcu7t5v0__dffrnq_1
XFILLER_158_732 VDD VDD VSS VSS gf180mcu_fd_sc_mcu7t5v0__fill_2
XFILLER_60_877 VDD VDD VSS VSS gf180mcu_fd_sc_mcu7t5v0__fill_1
Xspi_regs_inst__1463_ spi_regs_inst__1463_/D spi_regs_inst__1551_/RN clkload30/I fanout540/I
+ VDD VDD VSS VSS gf180mcu_fd_sc_mcu7t5v0__dffrnq_1
XTAP_TAPCELL_ROW_154_2419 VDD VSS gf180mcu_fd_sc_mcu7t5v0__filltie
Xspi_regs_inst__1394_ fanout532/Z spi_regs_inst__1412_/I1 spi_regs_inst__1394_/S spi_regs_inst__1469_/D
+ VDD VDD VSS VSS gf180mcu_fd_sc_mcu7t5v0__mux2_2
XFILLER_121_1116 VDD VDD VSS VSS gf180mcu_fd_sc_mcu7t5v0__fillcap_4
XFILLER_145_404 VDD VDD VSS VSS gf180mcu_fd_sc_mcu7t5v0__fillcap_16
XFILLER_145_426 VDD VDD VSS VSS gf180mcu_fd_sc_mcu7t5v0__fill_2
XFILLER_157_264 VDD VDD VSS VSS gf180mcu_fd_sc_mcu7t5v0__fill_1
XFILLER_157_275 VDD VDD VSS VSS gf180mcu_fd_sc_mcu7t5v0__fillcap_4
XFILLER_8_241 VDD VDD VSS VSS gf180mcu_fd_sc_mcu7t5v0__fillcap_4
XTAP_TAPCELL_ROW_119_1838 VDD VSS gf180mcu_fd_sc_mcu7t5v0__filltie
XFILLER_117_139 VDD VDD VSS VSS gf180mcu_fd_sc_mcu7t5v0__fill_1
XTAP_TAPCELL_ROW_74_1101 VDD VSS gf180mcu_fd_sc_mcu7t5v0__filltie
XFILLER_113_301 VDD VDD VSS VSS gf180mcu_fd_sc_mcu7t5v0__fill_1
XFILLER_141_632 VDD VDD VSS VSS gf180mcu_fd_sc_mcu7t5v0__fillcap_4
XFILLER_153_492 VDD VDD VSS VSS gf180mcu_fd_sc_mcu7t5v0__fillcap_16
XPHY_EDGE_ROW_97_Left_264 VDD VSS gf180mcu_fd_sc_mcu7t5v0__endcap
XFILLER_4_491 VDD VDD VSS VSS gf180mcu_fd_sc_mcu7t5v0__fillcap_4
XFILLER_86_218 VDD VDD VSS VSS gf180mcu_fd_sc_mcu7t5v0__fill_2
Xwave_controller_x_inst__1890_ wave_controller_x_inst__1890_/I wave_controller_x_inst__3105_/A2
+ VDD VDD VSS VSS gf180mcu_fd_sc_mcu7t5v0__clkinv_1
XFILLER_55_605 VDD VDD VSS VSS gf180mcu_fd_sc_mcu7t5v0__fillcap_16
XFILLER_54_104 VDD VDD VSS VSS gf180mcu_fd_sc_mcu7t5v0__fill_1
XFILLER_54_115 VDD VDD VSS VSS gf180mcu_fd_sc_mcu7t5v0__fill_2
XFILLER_95_796 VDD VDD VSS VSS gf180mcu_fd_sc_mcu7t5v0__fillcap_4
Xwave_controller_x_inst__3560_ wave_controller_x_inst__3560_/A1 wave_controller_x_inst_wire333/Z
+ wave_controller_x_inst__3595_/I0 VDD VDD VSS VSS gf180mcu_fd_sc_mcu7t5v0__nor2_1
XFILLER_82_457 VDD VDD VSS VSS gf180mcu_fd_sc_mcu7t5v0__fill_1
Xwave_controller_x_inst__3491_ wave_controller_x_inst__3485_/B wave_controller_x_inst__3488_/I
+ wave_controller_x_inst__3496_/B wave_controller_x_inst__3492_/B2 VDD VDD VSS VSS
+ gf180mcu_fd_sc_mcu7t5v0__oai21_1
Xwave_controller_x_inst__2511_ spi_regs_inst__1259_/B2 wave_controller_x_inst__2511_/A2
+ wave_controller_x_inst__2511_/B wave_controller_x_inst__2543_/B1 VDD VDD VSS VSS
+ gf180mcu_fd_sc_mcu7t5v0__aoi21_1
XFILLER_63_682 VDD VDD VSS VSS gf180mcu_fd_sc_mcu7t5v0__fillcap_4
XPHY_EDGE_ROW_22_1_Right_21 VDD VSS gf180mcu_fd_sc_mcu7t5v0__endcap
XTAP_TAPCELL_ROW_85_1274 VDD VSS gf180mcu_fd_sc_mcu7t5v0__filltie
Xwave_controller_y_inst_wire127 wave_controller_y_inst_wire127/I wave_controller_y_inst_wire127/Z
+ VDD VDD VSS VSS gf180mcu_fd_sc_mcu7t5v0__clkbuf_1
Xwave_controller_y_inst_wire149 wave_controller_y_inst_wire149/I wave_controller_y_inst_wire149/Z
+ VDD VDD VSS VSS gf180mcu_fd_sc_mcu7t5v0__clkbuf_1
Xwave_controller_x_inst__2442_ spi_regs_inst__1185_/B2 wave_controller_x_inst__2445_/A3
+ wave_controller_x_inst__2442_/Z VDD VDD VSS VSS gf180mcu_fd_sc_mcu7t5v0__and2_1
XTAP_TAPCELL_ROW_85_1285 VDD VSS gf180mcu_fd_sc_mcu7t5v0__filltie
XFILLER_50_354 VDD VDD VSS VSS gf180mcu_fd_sc_mcu7t5v0__fill_1
Xwave_controller_x_inst__2373_ wave_controller_x_inst__2373_/A1 wave_controller_x_inst__2373_/A2
+ wave_controller_x_inst__2373_/Z VDD VDD VSS VSS gf180mcu_fd_sc_mcu7t5v0__or2_1
XFILLER_148_220 VDD VDD VSS VSS gf180mcu_fd_sc_mcu7t5v0__fill_1
XFILLER_50_387 VDD VDD VSS VSS gf180mcu_fd_sc_mcu7t5v0__fillcap_16
XTAP_TAPCELL_ROW_61_883 VDD VSS gf180mcu_fd_sc_mcu7t5v0__filltie
Xchip_core_639 bidir_ie[7] VDD VDD VSS VSS gf180mcu_fd_sc_mcu7t5v0__tiel
XFILLER_163_212 VDD VDD VSS VSS gf180mcu_fd_sc_mcu7t5v0__fillcap_8
Xwave_controller_y_inst__3010_ wave_controller_y_inst__2117_/B wave_controller_y_inst__2764_/Z
+ wave_controller_y_inst__3094_/A2 wave_controller_y_inst__3010_/B wave_controller_y_inst__3036_/A2
+ VDD VDD VSS VSS gf180mcu_fd_sc_mcu7t5v0__oai31_2
XFILLER_117_640 VDD VDD VSS VSS gf180mcu_fd_sc_mcu7t5v0__fillcap_4
XFILLER_163_256 VDD VDD VSS VSS gf180mcu_fd_sc_mcu7t5v0__fillcap_4
XFILLER_163_267 VDD VDD VSS VSS gf180mcu_fd_sc_mcu7t5v0__fillcap_8
XFILLER_117_684 VDD VDD VSS VSS gf180mcu_fd_sc_mcu7t5v0__fillcap_16
XFILLER_132_610 VDD VDD VSS VSS gf180mcu_fd_sc_mcu7t5v0__fill_1
XFILLER_145_982 VDD VDD VSS VSS gf180mcu_fd_sc_mcu7t5v0__fillcap_64
XFILLER_160_941 VDD VDD VSS VSS gf180mcu_fd_sc_mcu7t5v0__fillcap_4
XFILLER_131_142 VDD VDD VSS VSS gf180mcu_fd_sc_mcu7t5v0__fillcap_4
XFILLER_49_69 VDD VDD VSS VSS gf180mcu_fd_sc_mcu7t5v0__fill_1
XFILLER_58_410 VDD VDD VSS VSS gf180mcu_fd_sc_mcu7t5v0__fillcap_4
XFILLER_86_741 VDD VDD VSS VSS gf180mcu_fd_sc_mcu7t5v0__fill_2
XTAP_TAPCELL_ROW_39_1_621 VDD VSS gf180mcu_fd_sc_mcu7t5v0__filltie
XFILLER_100_562 VDD VDD VSS VSS gf180mcu_fd_sc_mcu7t5v0__fill_2
XFILLER_73_402 VDD VDD VSS VSS gf180mcu_fd_sc_mcu7t5v0__fill_2
XFILLER_100_573 VDD VDD VSS VSS gf180mcu_fd_sc_mcu7t5v0__fill_2
XFILLER_100_584 VDD VDD VSS VSS gf180mcu_fd_sc_mcu7t5v0__fillcap_8
XFILLER_74_947 VDD VDD VSS VSS gf180mcu_fd_sc_mcu7t5v0__fillcap_64
XFILLER_86_796 VDD VDD VSS VSS gf180mcu_fd_sc_mcu7t5v0__fillcap_8
XFILLER_96_1151 VDD VDD VSS VSS gf180mcu_fd_sc_mcu7t5v0__fillcap_4
Xwave_controller_y_inst__2725_ wave_controller_y_inst__2722_/Z wave_controller_y_inst__2739_/A2
+ wave_controller_y_inst__2737_/A2 VDD VDD VSS VSS gf180mcu_fd_sc_mcu7t5v0__xnor2_1
Xwave_controller_x_inst__3689_ wave_controller_x_inst__3689_/D fanout591/Z clkload22/I
+ spi_regs_inst__1198_/B2 VDD VDD VSS VSS gf180mcu_fd_sc_mcu7t5v0__dffrnq_1
Xwave_controller_x_inst__2709_ wave_controller_x_inst__2709_/A1 wave_controller_x_inst__2712_/C
+ wave_controller_x_inst__2694_/Z wave_controller_x_inst__2712_/A2 VDD VDD VSS VSS
+ gf180mcu_fd_sc_mcu7t5v0__nor3_1
XFILLER_54_682 VDD VDD VSS VSS gf180mcu_fd_sc_mcu7t5v0__fillcap_4
XFILLER_60_107 VDD VDD VSS VSS gf180mcu_fd_sc_mcu7t5v0__fillcap_8
Xwave_controller_y_inst__2656_ wave_controller_y_inst__2656_/A1 wave_controller_y_inst__2669_/B
+ wave_controller_y_inst__2686_/A1 VDD VDD VSS VSS gf180mcu_fd_sc_mcu7t5v0__nand2_1
XFILLER_157_2 VDD VDD VSS VSS gf180mcu_fd_sc_mcu7t5v0__fillcap_32
XFILLER_26_395 VDD VDD VSS VSS gf180mcu_fd_sc_mcu7t5v0__fill_1
XFILLER_41_332 VDD VDD VSS VSS gf180mcu_fd_sc_mcu7t5v0__fillcap_16
Xwave_controller_y_inst__2587_ wave_controller_y_inst__1823_/I wave_controller_y_inst__2589_/A3
+ wave_controller_y_inst__2602_/B VDD VDD VSS VSS gf180mcu_fd_sc_mcu7t5v0__or2_1
XFILLER_139_242 VDD VDD VSS VSS gf180mcu_fd_sc_mcu7t5v0__fillcap_4
XTAP_TAPCELL_ROW_136_2116 VDD VSS gf180mcu_fd_sc_mcu7t5v0__filltie
XTAP_TAPCELL_ROW_136_2127 VDD VSS gf180mcu_fd_sc_mcu7t5v0__filltie
XTAP_TAPCELL_ROW_21_1_491 VDD VSS gf180mcu_fd_sc_mcu7t5v0__filltie
XFILLER_155_702 VDD VDD VSS VSS gf180mcu_fd_sc_mcu7t5v0__fill_2
Xwave_controller_y_inst__3208_ wave_controller_y_inst__3115_/Z wave_controller_y_inst__3151_/Z
+ wave_controller_y_inst__3208_/B wave_controller_y_inst__3210_/A3 VDD VDD VSS VSS
+ gf180mcu_fd_sc_mcu7t5v0__oai21_1
XFILLER_108_662 VDD VDD VSS VSS gf180mcu_fd_sc_mcu7t5v0__fill_2
Xwave_controller_y_inst__3139_ wave_controller_y_inst__3564_/A1 spi_regs_inst__1586_/Q
+ wave_controller_y_inst__3142_/B VDD VDD VSS VSS gf180mcu_fd_sc_mcu7t5v0__xor2_1
XFILLER_107_194 VDD VDD VSS VSS gf180mcu_fd_sc_mcu7t5v0__fill_1
XFILLER_122_131 VDD VDD VSS VSS gf180mcu_fd_sc_mcu7t5v0__fill_1
XFILLER_123_632 VDD VDD VSS VSS gf180mcu_fd_sc_mcu7t5v0__fill_2
XFILLER_123_643 VDD VDD VSS VSS gf180mcu_fd_sc_mcu7t5v0__fillcap_8
XFILLER_135_492 VDD VDD VSS VSS gf180mcu_fd_sc_mcu7t5v0__fillcap_4
XFILLER_146_60 VDD VDD VSS VSS gf180mcu_fd_sc_mcu7t5v0__fillcap_8
XTAP_TAPCELL_ROW_114_1757 VDD VSS gf180mcu_fd_sc_mcu7t5v0__filltie
XFILLER_123_676 VDD VDD VSS VSS gf180mcu_fd_sc_mcu7t5v0__fillcap_4
XFILLER_96_527 VDD VDD VSS VSS gf180mcu_fd_sc_mcu7t5v0__fillcap_8
XFILLER_110_337 VDD VDD VSS VSS gf180mcu_fd_sc_mcu7t5v0__fillcap_16
XFILLER_122_197 VDD VDD VSS VSS gf180mcu_fd_sc_mcu7t5v0__fill_1
XFILLER_49_410 VDD VDD VSS VSS gf180mcu_fd_sc_mcu7t5v0__fillcap_4
XFILLER_77_752 VDD VDD VSS VSS gf180mcu_fd_sc_mcu7t5v0__fill_1
Xspi_regs_inst__0963_ spi_regs_inst__1032_/A2 spi_regs_inst__1019_/A2 spi_regs_inst_wire284/I
+ VDD VDD VSS VSS gf180mcu_fd_sc_mcu7t5v0__nor2_1
XFILLER_36_104 VDD VDD VSS VSS gf180mcu_fd_sc_mcu7t5v0__fill_1
XFILLER_65_936 VDD VDD VSS VSS gf180mcu_fd_sc_mcu7t5v0__fillcap_32
XFILLER_76_262 VDD VDD VSS VSS gf180mcu_fd_sc_mcu7t5v0__fillcap_16
XFILLER_92_733 VDD VDD VSS VSS gf180mcu_fd_sc_mcu7t5v0__fill_2
XTAP_TAPCELL_ROW_164_2581 VDD VSS gf180mcu_fd_sc_mcu7t5v0__filltie
XFILLER_36_159 VDD VDD VSS VSS gf180mcu_fd_sc_mcu7t5v0__fillcap_8
XFILLER_64_457 VDD VDD VSS VSS gf180mcu_fd_sc_mcu7t5v0__fillcap_32
Xspi_regs_inst__0894_ spi_regs_inst__1624_/Q spi_regs_inst__1625_/Q spi_regs_inst__0894_/Z
+ VDD VDD VSS VSS gf180mcu_fd_sc_mcu7t5v0__xor2_1
XFILLER_17_362 VDD VDD VSS VSS gf180mcu_fd_sc_mcu7t5v0__fill_1
XFILLER_80_928 VDD VDD VSS VSS gf180mcu_fd_sc_mcu7t5v0__fill_1
XFILLER_32_310 VDD VDD VSS VSS gf180mcu_fd_sc_mcu7t5v0__fillcap_4
XFILLER_32_321 VDD VDD VSS VSS gf180mcu_fd_sc_mcu7t5v0__fillcap_4
Xspi_regs_inst__1515_ spi_regs_inst__1515_/D fanout588/Z clkload22/I spi_regs_inst__1515_/Q
+ VDD VDD VSS VSS gf180mcu_fd_sc_mcu7t5v0__dffrnq_1
XFILLER_20_527 VDD VDD VSS VSS gf180mcu_fd_sc_mcu7t5v0__fillcap_4
XFILLER_146_713 VDD VDD VSS VSS gf180mcu_fd_sc_mcu7t5v0__fill_1
XFILLER_72_2 VDD VDD VSS VSS gf180mcu_fd_sc_mcu7t5v0__fillcap_16
XTAP_TAPCELL_ROW_80_1193 VDD VSS gf180mcu_fd_sc_mcu7t5v0__filltie
Xspi_regs_inst__1446_ spi_regs_inst__1446_/A1 spi_regs_inst__1446_/A2 spi_regs_inst__1448_/S
+ VDD VDD VSS VSS gf180mcu_fd_sc_mcu7t5v0__nor2_1
XFILLER_145_212 VDD VDD VSS VSS gf180mcu_fd_sc_mcu7t5v0__fill_2
Xspi_regs_inst__1377_ spi_regs_inst__1461_/Q spi_regs_inst__1377_/I1 spi_regs_inst__1379_/S
+ spi_regs_inst__1657_/D VDD VDD VSS VSS gf180mcu_fd_sc_mcu7t5v0__mux2_2
XFILLER_145_267 VDD VDD VSS VSS gf180mcu_fd_sc_mcu7t5v0__fillcap_8
XFILLER_126_481 VDD VDD VSS VSS gf180mcu_fd_sc_mcu7t5v0__fill_1
XFILLER_127_982 VDD VDD VSS VSS gf180mcu_fd_sc_mcu7t5v0__fillcap_64
XFILLER_142_941 VDD VDD VSS VSS gf180mcu_fd_sc_mcu7t5v0__fillcap_4
XFILLER_99_332 VDD VDD VSS VSS gf180mcu_fd_sc_mcu7t5v0__fillcap_4
Xwave_controller_x_inst__2991_ wave_controller_x_inst__1785_/I fanout535/I fanout536/Z
+ wave_controller_x_inst__3713_/Q wave_controller_x_inst__2992_/I VDD VDD VSS VSS
+ gf180mcu_fd_sc_mcu7t5v0__aoi22_1
XFILLER_87_516 VDD VDD VSS VSS gf180mcu_fd_sc_mcu7t5v0__fillcap_4
XTAP_TAPCELL_ROW_30_1_559 VDD VSS gf180mcu_fd_sc_mcu7t5v0__filltie
Xwave_controller_x_inst__1942_ wave_controller_x_inst__1778_/I wave_controller_x_inst__1942_/A2
+ wave_controller_x_inst__1942_/B wave_controller_x_inst__1943_/C2 VDD VDD VSS VSS
+ gf180mcu_fd_sc_mcu7t5v0__oai21_1
XFILLER_113_175 VDD VDD VSS VSS gf180mcu_fd_sc_mcu7t5v0__fill_1
XFILLER_142_18 VDD VDD VSS VSS gf180mcu_fd_sc_mcu7t5v0__fillcap_4
Xwave_controller_x_inst__1873_ spi_regs_inst__1259_/B2 wave_controller_x_inst__3509_/B2
+ VDD VDD VSS VSS gf180mcu_fd_sc_mcu7t5v0__clkinv_1
XFILLER_110_893 VDD VDD VSS VSS gf180mcu_fd_sc_mcu7t5v0__fillcap_8
XFILLER_55_413 VDD VDD VSS VSS gf180mcu_fd_sc_mcu7t5v0__fillcap_4
XFILLER_56_947 VDD VDD VSS VSS gf180mcu_fd_sc_mcu7t5v0__fillcap_64
XFILLER_95_571 VDD VDD VSS VSS gf180mcu_fd_sc_mcu7t5v0__fillcap_16
XTAP_TAPCELL_ROW_87_1314 VDD VSS gf180mcu_fd_sc_mcu7t5v0__filltie
Xwave_controller_x_inst__3612_ wave_controller_x_inst__3612_/D fanout598/Z clkbuf_leaf_19_clk/Z
+ wave_controller_x_inst__3612_/Q VDD VDD VSS VSS gf180mcu_fd_sc_mcu7t5v0__dffrnq_1
Xsignal_processor_y_inst__189_ signal_processor_y_inst__187_/B signal_processor_y_inst__189_/A2
+ signal_processor_y_inst__189_/B1 signal_processor_y_inst__189_/B2 signal_processor_y_inst__241_/D
+ VDD VDD VSS VSS gf180mcu_fd_sc_mcu7t5v0__aoi22_1
XFILLER_27_137 VDD VDD VSS VSS gf180mcu_fd_sc_mcu7t5v0__fill_2
XTAP_TAPCELL_ROW_66_964 VDD VSS gf180mcu_fd_sc_mcu7t5v0__filltie
Xwave_controller_x_inst__3543_ wave_controller_x_inst__1778_/I wave_controller_x_inst__3555_/A2
+ wave_controller_x_inst__3545_/A2 VDD VDD VSS VSS gf180mcu_fd_sc_mcu7t5v0__nor2_1
XFILLER_71_928 VDD VDD VSS VSS gf180mcu_fd_sc_mcu7t5v0__fill_2
Xwave_controller_y_inst__2510_ wave_controller_y_inst__2505_/Z wave_controller_y_inst__2510_/A2
+ wave_controller_y_inst__2510_/A3 spi_regs_inst_wire100/I VDD VDD VSS VSS gf180mcu_fd_sc_mcu7t5v0__xnor3_1
Xwave_controller_y_inst__3490_ wave_controller_y_inst__3490_/A1 wave_controller_y_inst__3488_/I
+ wave_controller_y_inst__3490_/B wave_controller_y_inst__3490_/C wave_controller_y_inst__3492_/B1
+ VDD VDD VSS VSS gf180mcu_fd_sc_mcu7t5v0__aoi211_1
XFILLER_70_438 VDD VDD VSS VSS gf180mcu_fd_sc_mcu7t5v0__fillcap_16
Xwave_controller_y_inst__2441_ spi_regs_inst__1204_/B2 wave_controller_y_inst__2445_/A3
+ wave_controller_y_inst__2450_/A2 VDD VDD VSS VSS gf180mcu_fd_sc_mcu7t5v0__nor2_1
Xwave_controller_x_inst__3474_ spi_regs_inst__1305_/B2 wave_controller_x_inst_wire370/Z
+ wave_controller_x_inst__3475_/A3 VDD VDD VSS VSS gf180mcu_fd_sc_mcu7t5v0__nor2_1
Xwave_controller_x_inst__2425_ wave_controller_x_inst__2399_/Z wave_controller_x_inst__2411_/Z
+ wave_controller_x_inst__2425_/A3 wire450/Z wave_controller_x_inst__2425_/B2 wave_controller_x_inst__2438_/B
+ VDD VDD VSS VSS gf180mcu_fd_sc_mcu7t5v0__oai32_1
Xwave_controller_y_inst__2372_ wave_controller_y_inst__2369_/Z wave_controller_y_inst__2372_/A2
+ wave_controller_y_inst__2394_/A1 VDD VDD VSS VSS gf180mcu_fd_sc_mcu7t5v0__xnor2_1
Xwave_controller_x_inst__2356_ wave_controller_x_inst__2944_/A2 wave_controller_x_inst__2831_/A1
+ wave_controller_x_inst__2356_/A3 wave_controller_x_inst__2357_/B VDD VDD VSS VSS
+ gf180mcu_fd_sc_mcu7t5v0__xor3_1
XFILLER_137_702 VDD VDD VSS VSS gf180mcu_fd_sc_mcu7t5v0__fillcap_8
XFILLER_149_562 VDD VDD VSS VSS gf180mcu_fd_sc_mcu7t5v0__fillcap_4
XFILLER_137_757 VDD VDD VSS VSS gf180mcu_fd_sc_mcu7t5v0__fillcap_8
Xwave_controller_x_inst__2287_ spi_regs_inst__1100_/B2 wave_controller_x_inst__2815_/A1
+ wave_controller_x_inst__2286_/Z spi_regs_inst__1068_/B2 wave_controller_x_inst__2288_/B
+ VDD VDD VSS VSS gf180mcu_fd_sc_mcu7t5v0__aoi22_1
XTAP_TAPCELL_ROW_98_1498 VDD VSS gf180mcu_fd_sc_mcu7t5v0__filltie
XTAP_TAPCELL_ROW_98_1487 VDD VSS gf180mcu_fd_sc_mcu7t5v0__filltie
XFILLER_117_470 VDD VDD VSS VSS gf180mcu_fd_sc_mcu7t5v0__fillcap_16
XTAP_TAPCELL_ROW_131_2035 VDD VSS gf180mcu_fd_sc_mcu7t5v0__filltie
XTAP_TAPCELL_ROW_131_2046 VDD VSS gf180mcu_fd_sc_mcu7t5v0__filltie
XTAP_TAPCELL_ROW_16_1_449 VDD VSS gf180mcu_fd_sc_mcu7t5v0__filltie
XFILLER_105_632 VDD VDD VSS VSS gf180mcu_fd_sc_mcu7t5v0__fillcap_8
XFILLER_117_492 VDD VDD VSS VSS gf180mcu_fd_sc_mcu7t5v0__fillcap_32
XFILLER_151_259 VDD VDD VSS VSS gf180mcu_fd_sc_mcu7t5v0__fill_1
XFILLER_2_247 VDD VDD VSS VSS gf180mcu_fd_sc_mcu7t5v0__fillcap_64
XFILLER_105_698 VDD VDD VSS VSS gf180mcu_fd_sc_mcu7t5v0__fill_2
XFILLER_116_52 VDD VDD VSS VSS gf180mcu_fd_sc_mcu7t5v0__fillcap_4
XFILLER_116_74 VDD VDD VSS VSS gf180mcu_fd_sc_mcu7t5v0__fillcap_16
Xfanout540 fanout540/I fanout540/Z VDD VDD VSS VSS gf180mcu_fd_sc_mcu7t5v0__dlyb_1
XFILLER_76_45 VDD VDD VSS VSS gf180mcu_fd_sc_mcu7t5v0__fillcap_8
Xfanout584 fanout590/Z fanout584/Z VDD VDD VSS VSS gf180mcu_fd_sc_mcu7t5v0__dlyb_1
XFILLER_58_262 VDD VDD VSS VSS gf180mcu_fd_sc_mcu7t5v0__fill_2
XFILLER_74_733 VDD VDD VSS VSS gf180mcu_fd_sc_mcu7t5v0__fill_2
XFILLER_76_89 VDD VDD VSS VSS gf180mcu_fd_sc_mcu7t5v0__fill_1
XFILLER_86_593 VDD VDD VSS VSS gf180mcu_fd_sc_mcu7t5v0__fill_2
Xfanout595 fanout597/Z fanout595/Z VDD VDD VSS VSS gf180mcu_fd_sc_mcu7t5v0__dlyb_1
XFILLER_18_148 VDD VDD VSS VSS gf180mcu_fd_sc_mcu7t5v0__fill_1
XFILLER_46_446 VDD VDD VSS VSS gf180mcu_fd_sc_mcu7t5v0__fill_1
XFILLER_46_457 VDD VDD VSS VSS gf180mcu_fd_sc_mcu7t5v0__fill_2
XFILLER_62_928 VDD VDD VSS VSS gf180mcu_fd_sc_mcu7t5v0__fillcap_16
Xwave_controller_y_inst__2708_ wave_controller_y_inst__2676_/Z wave_controller_y_inst__2694_/Z
+ wave_controller_y_inst__2712_/B VDD VDD VSS VSS gf180mcu_fd_sc_mcu7t5v0__nor2_1
Xwave_controller_y_inst__3688_ wave_controller_y_inst__3688_/D fanout564/Z clkload9/I
+ spi_regs_inst__1169_/A1 VDD VDD VSS VSS gf180mcu_fd_sc_mcu7t5v0__dffrnq_1
Xclkbuf_leaf_53_clk clkbuf_leaf_3_clk/I clkload5/I VDD VDD VSS VSS gf180mcu_fd_sc_mcu7t5v0__clkbuf_8
Xwave_controller_y_inst__2639_ wave_controller_y_inst__3391_/A1 wave_controller_y_inst__2638_/Z
+ wave_controller_y_inst__2664_/A1 VDD VDD VSS VSS gf180mcu_fd_sc_mcu7t5v0__nand2_1
XFILLER_14_387 VDD VDD VSS VSS gf180mcu_fd_sc_mcu7t5v0__fillcap_8
Xspi_regs_inst__1300_ spi_regs_inst__1613_/Q spi_regs_inst__1340_/B1 spi_regs_inst__1307_/A1
+ VDD VDD VSS VSS gf180mcu_fd_sc_mcu7t5v0__nand2_1
XFILLER_127_212 VDD VDD VSS VSS gf180mcu_fd_sc_mcu7t5v0__fillcap_16
Xspi_regs_inst__1231_ fanout505/Z spi_regs_inst__1231_/A2 spi_regs_inst__1231_/B1
+ max_cap463/Z spi_regs_inst__1233_/A3 VDD VDD VSS VSS gf180mcu_fd_sc_mcu7t5v0__aoi22_1
XFILLER_155_543 VDD VDD VSS VSS gf180mcu_fd_sc_mcu7t5v0__fill_2
XFILLER_155_554 VDD VDD VSS VSS gf180mcu_fd_sc_mcu7t5v0__fillcap_4
Xspi_regs_inst__1162_ fanout508/Z spi_regs_inst__1231_/A2 spi_regs_inst_wire242/Z
+ spi_regs_inst__1509_/Q spi_regs_inst__1165_/A2 VDD VDD VSS VSS gf180mcu_fd_sc_mcu7t5v0__aoi22_1
XFILLER_109_982 VDD VDD VSS VSS gf180mcu_fd_sc_mcu7t5v0__fillcap_64
XFILLER_143_727 VDD VDD VSS VSS gf180mcu_fd_sc_mcu7t5v0__fillcap_8
XFILLER_157_92 VDD VDD VSS VSS gf180mcu_fd_sc_mcu7t5v0__fill_2
Xspi_regs_inst__1093_ spi_regs_inst_wire39/Z spi_regs_inst__1301_/B1 spi_regs_inst__1176_/B1
+ spi_regs_inst__1093_/B2 spi_regs_inst__1117_/A1 VDD VDD VSS VSS gf180mcu_fd_sc_mcu7t5v0__aoi22_1
XFILLER_123_473 VDD VDD VSS VSS gf180mcu_fd_sc_mcu7t5v0__fill_1
XFILLER_69_527 VDD VDD VSS VSS gf180mcu_fd_sc_mcu7t5v0__fill_2
XTAP_TAPCELL_ROW_149_2329 VDD VSS gf180mcu_fd_sc_mcu7t5v0__filltie
XTAP_TAPCELL_ROW_166_2610 VDD VSS gf180mcu_fd_sc_mcu7t5v0__filltie
XFILLER_110_123 VDD VDD VSS VSS gf180mcu_fd_sc_mcu7t5v0__fillcap_4
XTAP_TAPCELL_ROW_166_2621 VDD VSS gf180mcu_fd_sc_mcu7t5v0__filltie
Xsignal_processor_y_inst__112_ signal_processor_y_inst__241_/Q signal_processor_y_inst__189_/B2
+ VDD VDD VSS VSS gf180mcu_fd_sc_mcu7t5v0__clkinv_1
XFILLER_111_657 VDD VDD VSS VSS gf180mcu_fd_sc_mcu7t5v0__fill_1
XFILLER_84_519 VDD VDD VSS VSS gf180mcu_fd_sc_mcu7t5v0__fillcap_4
XFILLER_96_368 VDD VDD VSS VSS gf180mcu_fd_sc_mcu7t5v0__fillcap_16
XFILLER_77_571 VDD VDD VSS VSS gf180mcu_fd_sc_mcu7t5v0__fillcap_16
XTAP_TAPCELL_ROW_69_1011 VDD VSS gf180mcu_fd_sc_mcu7t5v0__filltie
XFILLER_37_435 VDD VDD VSS VSS gf180mcu_fd_sc_mcu7t5v0__fill_2
XFILLER_49_295 VDD VDD VSS VSS gf180mcu_fd_sc_mcu7t5v0__fillcap_4
XFILLER_64_243 VDD VDD VSS VSS gf180mcu_fd_sc_mcu7t5v0__fill_2
XPHY_EDGE_ROW_139_Right_139 VDD VSS gf180mcu_fd_sc_mcu7t5v0__endcap
XTAP_TAPCELL_ROW_69_1022 VDD VSS gf180mcu_fd_sc_mcu7t5v0__filltie
Xspi_regs_inst__0946_ spi_regs_inst__1629_/Q spi_regs_inst__1628_/Q spi_regs_inst__1008_/A3
+ VDD VDD VSS VSS gf180mcu_fd_sc_mcu7t5v0__nor2_1
XFILLER_92_574 VDD VDD VSS VSS gf180mcu_fd_sc_mcu7t5v0__fillcap_4
XTAP_TAPCELL_ROW_63_912 VDD VSS gf180mcu_fd_sc_mcu7t5v0__filltie
XTAP_TAPCELL_ROW_63_923 VDD VSS gf180mcu_fd_sc_mcu7t5v0__filltie
Xspi_regs_inst__0877_ spi_regs_inst__1612_/Q spi_regs_inst__1410_/I1 spi_regs_inst__0877_/S
+ spi_regs_inst__1612_/D VDD VDD VSS VSS gf180mcu_fd_sc_mcu7t5v0__mux2_2
XFILLER_52_449 VDD VDD VSS VSS gf180mcu_fd_sc_mcu7t5v0__fillcap_4
XTAP_TAPCELL_ROW_82_1222 VDD VSS gf180mcu_fd_sc_mcu7t5v0__filltie
Xclkbuf_leaf_44_clk clkbuf_leaf_9_clk/I clkload21/I VDD VDD VSS VSS gf180mcu_fd_sc_mcu7t5v0__clkbuf_8
XFILLER_127_1122 VDD VDD VSS VSS gf180mcu_fd_sc_mcu7t5v0__fillcap_32
XTAP_TAPCELL_ROW_82_1233 VDD VSS gf180mcu_fd_sc_mcu7t5v0__filltie
XFILLER_32_162 VDD VDD VSS VSS gf180mcu_fd_sc_mcu7t5v0__fill_1
Xwave_controller_x_inst__3190_ wave_controller_x_inst__3190_/A1 wave_controller_x_inst__3190_/A2
+ wave_controller_x_inst__3255_/A2 VDD VDD VSS VSS gf180mcu_fd_sc_mcu7t5v0__nand2_1
Xwave_controller_x_inst__2210_ wave_controller_x_inst__3043_/A2 wave_controller_x_inst__2196_/Z
+ wave_controller_x_inst__2210_/B wave_controller_x_inst__2248_/A2 VDD VDD VSS VSS
+ gf180mcu_fd_sc_mcu7t5v0__aoi21_1
XFILLER_20_335 VDD VDD VSS VSS gf180mcu_fd_sc_mcu7t5v0__fill_1
XFILLER_32_184 VDD VDD VSS VSS gf180mcu_fd_sc_mcu7t5v0__fill_2
XTAP_TAPCELL_ROW_38_1_620 VDD VSS gf180mcu_fd_sc_mcu7t5v0__filltie
Xwave_controller_x_inst__2141_ wave_controller_x_inst__3731_/Q wave_controller_x_inst__2153_/A2
+ wave_controller_x_inst__2139_/Z wave_controller_x_inst__2149_/B VDD VDD VSS VSS
+ gf180mcu_fd_sc_mcu7t5v0__nand3_1
XFILLER_118_201 VDD VDD VSS VSS gf180mcu_fd_sc_mcu7t5v0__fillcap_32
XFILLER_119_724 VDD VDD VSS VSS gf180mcu_fd_sc_mcu7t5v0__fill_1
Xspi_regs_inst__1429_ spi_regs_inst__1499_/Q spi_regs_inst__1429_/I1 spi_regs_inst__1436_/S
+ spi_regs_inst__1499_/D VDD VDD VSS VSS gf180mcu_fd_sc_mcu7t5v0__mux2_2
XFILLER_146_543 VDD VDD VSS VSS gf180mcu_fd_sc_mcu7t5v0__fill_2
Xwave_controller_x_inst__2072_ wave_controller_x_inst__2070_/Z wave_controller_x_inst__2072_/A2
+ wave_controller_x_inst__2072_/B wave_controller_x_inst__2076_/A1 VDD VDD VSS VSS
+ gf180mcu_fd_sc_mcu7t5v0__aoi21_1
XFILLER_114_473 VDD VDD VSS VSS gf180mcu_fd_sc_mcu7t5v0__fillcap_8
XFILLER_88_803 VDD VDD VSS VSS gf180mcu_fd_sc_mcu7t5v0__fill_2
XTAP_TAPCELL_ROW_12_1_422 VDD VSS gf180mcu_fd_sc_mcu7t5v0__filltie
XFILLER_130_944 VDD VDD VSS VSS gf180mcu_fd_sc_mcu7t5v0__fill_1
XFILLER_141_270 VDD VDD VSS VSS gf180mcu_fd_sc_mcu7t5v0__fill_1
XFILLER_99_184 VDD VDD VSS VSS gf180mcu_fd_sc_mcu7t5v0__fill_1
Xwave_controller_y_inst__2990_ wave_controller_y_inst__3265_/A1 fanout513/Z wave_controller_y_inst__2990_/Z
+ VDD VDD VSS VSS gf180mcu_fd_sc_mcu7t5v0__xor2_1
Xwave_controller_x_inst__2974_ wave_controller_x_inst__3055_/A2 wave_controller_x_inst__3055_/B
+ wave_controller_x_inst__2974_/B wave_controller_x_inst__3058_/A3 VDD VDD VSS VSS
+ gf180mcu_fd_sc_mcu7t5v0__aoi21_1
Xwave_controller_y_inst__1941_ wave_controller_y_inst__1941_/A1 wave_controller_y_inst__1941_/A2
+ wave_controller_y_inst__1941_/B wave_controller_y_inst__1942_/B VDD VDD VSS VSS
+ gf180mcu_fd_sc_mcu7t5v0__oai21_1
Xwave_controller_x_inst__1925_ spi_regs_inst__1506_/Q wave_controller_x_inst__3572_/A1
+ spi_regs_inst__1505_/Q wave_controller_x_inst__3570_/A1 wave_controller_x_inst__1926_/A2
+ VDD VDD VSS VSS gf180mcu_fd_sc_mcu7t5v0__oai22_1
Xwave_controller_y_inst__1872_ spi_regs_inst__1183_/A1 wave_controller_y_inst__3506_/B2
+ VDD VDD VSS VSS gf180mcu_fd_sc_mcu7t5v0__clkinv_1
Xwave_controller_x_inst__1856_ spi_regs_inst__1320_/A1 wave_controller_x_inst__2521_/A1
+ VDD VDD VSS VSS gf180mcu_fd_sc_mcu7t5v0__clkinv_1
XFILLER_110_690 VDD VDD VSS VSS gf180mcu_fd_sc_mcu7t5v0__fill_1
XFILLER_46_26 VDD VDD VSS VSS gf180mcu_fd_sc_mcu7t5v0__fillcap_4
XPHY_EDGE_ROW_106_Right_106 VDD VSS gf180mcu_fd_sc_mcu7t5v0__endcap
Xwave_controller_y_inst__3611_ wave_controller_y_inst__3611_/D fanout544/Z clkload1/I
+ wave_controller_y_inst__3611_/Q VDD VDD VSS VSS gf180mcu_fd_sc_mcu7t5v0__dffsnq_1
Xwave_controller_y_inst__3542_ wave_controller_y_inst__3557_/A1 wave_controller_y_inst__3542_/A2
+ wave_controller_y_inst__3542_/A3 wave_controller_y_inst__3557_/B1 wave_controller_y_inst__3542_/B2
+ wave_controller_y_inst__3643_/D VDD VDD VSS VSS gf180mcu_fd_sc_mcu7t5v0__oai32_1
Xwave_controller_x_inst__1787_ spi_regs_inst__1511_/Q wave_controller_x_inst__1934_/B2
+ VDD VDD VSS VSS gf180mcu_fd_sc_mcu7t5v0__clkinv_1
XFILLER_102_32 VDD VDD VSS VSS gf180mcu_fd_sc_mcu7t5v0__fill_2
XFILLER_70_224 VDD VDD VSS VSS gf180mcu_fd_sc_mcu7t5v0__fillcap_16
Xwave_controller_x_inst__3526_ max_cap464/I wave_controller_x_inst__3556_/A2 wave_controller_x_inst__3527_/A3
+ VDD VDD VSS VSS gf180mcu_fd_sc_mcu7t5v0__nor2_1
XFILLER_62_14 VDD VDD VSS VSS gf180mcu_fd_sc_mcu7t5v0__fillcap_8
XFILLER_71_769 VDD VDD VSS VSS gf180mcu_fd_sc_mcu7t5v0__fill_1
XFILLER_93_1154 VDD VDD VSS VSS gf180mcu_fd_sc_mcu7t5v0__fillcap_16
Xwave_controller_y_inst__3473_ wave_controller_y_inst__3698_/Q wave_controller_y_inst__3483_/A2
+ wave_controller_y_inst__3475_/A2 VDD VDD VSS VSS gf180mcu_fd_sc_mcu7t5v0__nor2_1
Xwave_controller_x_inst__3457_ wave_controller_x_inst__3447_/S wave_controller_x_inst__3461_/A2
+ wave_controller_x_inst__3460_/A1 VDD VDD VSS VSS gf180mcu_fd_sc_mcu7t5v0__nand2_1
Xsignal_processor_x_inst__201_ signal_processor_x_inst__108_/I spi_regs_inst__1050_/A1
+ signal_processor_x_inst__203_/A1 signal_processor_x_inst__202_/B VDD VDD VSS VSS
+ gf180mcu_fd_sc_mcu7t5v0__nand3_1
Xclkbuf_leaf_35_clk clkbuf_3_6__f_clk/Z clkbuf_leaf_35_clk/Z VDD VDD VSS VSS gf180mcu_fd_sc_mcu7t5v0__clkbuf_8
Xwave_controller_y_inst__2424_ wave_controller_y_inst__2430_/A1 wave_controller_y_inst__2417_/Z
+ wave_controller_y_inst__2431_/A1 VDD VDD VSS VSS gf180mcu_fd_sc_mcu7t5v0__nor2_1
Xwave_controller_x_inst__2408_ wave_controller_x_inst__2407_/B wave_controller_x_inst__2408_/A2
+ wave_controller_x_inst__2409_/I VDD VDD VSS VSS gf180mcu_fd_sc_mcu7t5v0__xor2_1
Xsignal_processor_x_inst__132_ signal_processor_x_inst__239_/Q signal_processor_x_inst__203_/A1
+ signal_processor_x_inst__132_/A3 signal_processor_x_inst__195_/B VDD VDD VSS VSS
+ gf180mcu_fd_sc_mcu7t5v0__or3_1
Xwave_controller_y_inst__2355_ fanout516/Z wave_controller_y_inst__2356_/A3 wave_controller_y_inst__2355_/Z
+ VDD VDD VSS VSS gf180mcu_fd_sc_mcu7t5v0__and2_1
Xwave_controller_x_inst__3388_ fanout542/Z wave_controller_x_inst__3364_/Z wave_controller_x_inst__3388_/B
+ wave_controller_x_inst__3390_/B2 VDD VDD VSS VSS gf180mcu_fd_sc_mcu7t5v0__aoi21_1
XFILLER_11_368 VDD VDD VSS VSS gf180mcu_fd_sc_mcu7t5v0__fillcap_4
Xwave_controller_x_inst__2339_ wave_controller_x_inst__2616_/A1 wave_controller_x_inst__2325_/Z
+ wave_controller_x_inst__2339_/B wave_controller_x_inst__2341_/A2 VDD VDD VSS VSS
+ gf180mcu_fd_sc_mcu7t5v0__oai21_1
Xwave_controller_y_inst__2286_ wave_controller_y_inst__2786_/A1 wave_controller_y_inst__2286_/A2
+ wave_controller_y_inst__2286_/Z VDD VDD VSS VSS gf180mcu_fd_sc_mcu7t5v0__and2_1
XFILLER_109_278 VDD VDD VSS VSS gf180mcu_fd_sc_mcu7t5v0__fill_2
Xwave_controller_y_inst_fanout420 wave_controller_y_inst__3714_/Q wave_controller_y_inst__1785_/I
+ VDD VDD VSS VSS gf180mcu_fd_sc_mcu7t5v0__dlyb_1
XFILLER_2_2 VDD VDD VSS VSS gf180mcu_fd_sc_mcu7t5v0__fillcap_32
XTAP_TAPCELL_ROW_111_1705 VDD VSS gf180mcu_fd_sc_mcu7t5v0__filltie
XTAP_TAPCELL_ROW_111_1716 VDD VSS gf180mcu_fd_sc_mcu7t5v0__filltie
XFILLER_133_782 VDD VDD VSS VSS gf180mcu_fd_sc_mcu7t5v0__fill_1
XFILLER_78_313 VDD VDD VSS VSS gf180mcu_fd_sc_mcu7t5v0__fill_2
XFILLER_79_858 VDD VDD VSS VSS gf180mcu_fd_sc_mcu7t5v0__fillcap_4
XFILLER_87_55 VDD VDD VSS VSS gf180mcu_fd_sc_mcu7t5v0__fillcap_8
XFILLER_120_454 VDD VDD VSS VSS gf180mcu_fd_sc_mcu7t5v0__fill_1
Xfanout392 fanout393/Z fanout392/Z VDD VDD VSS VSS gf180mcu_fd_sc_mcu7t5v0__dlyb_1
XFILLER_46_221 VDD VDD VSS VSS gf180mcu_fd_sc_mcu7t5v0__fillcap_8
XTAP_TAPCELL_ROW_144_2248 VDD VSS gf180mcu_fd_sc_mcu7t5v0__filltie
XTAP_TAPCELL_ROW_144_2259 VDD VSS gf180mcu_fd_sc_mcu7t5v0__filltie
XTAP_TAPCELL_ROW_161_2540 VDD VSS gf180mcu_fd_sc_mcu7t5v0__filltie
Xspi_regs_inst__0800_ spi_regs_inst__1439_/I1 spi_regs_inst__1550_/Q spi_regs_inst__0803_/S
+ spi_regs_inst__1550_/D VDD VDD VSS VSS gf180mcu_fd_sc_mcu7t5v0__mux2_2
XFILLER_74_563 VDD VDD VSS VSS gf180mcu_fd_sc_mcu7t5v0__fill_1
XFILLER_98_1087 VDD VDD VSS VSS gf180mcu_fd_sc_mcu7t5v0__fillcap_64
XTAP_TAPCELL_ROW_109_1678 VDD VSS gf180mcu_fd_sc_mcu7t5v0__filltie
Xspi_regs_inst__0731_ spi_regs_inst__1459_/Q spi_regs_inst__0940_/A1 VDD VDD VSS VSS
+ gf180mcu_fd_sc_mcu7t5v0__clkinv_1
Xspi_regs_inst_max_cap230 spi_regs_inst_wire231/Z spi_regs_inst__1345_/A2 VDD VDD
+ VSS VSS gf180mcu_fd_sc_mcu7t5v0__buf_2
Xclkbuf_leaf_26_clk clkbuf_3_4__f_clk/Z clkbuf_leaf_26_clk/Z VDD VDD VSS VSS gf180mcu_fd_sc_mcu7t5v0__clkbuf_8
XFILLER_14_151 VDD VDD VSS VSS gf180mcu_fd_sc_mcu7t5v0__fillcap_4
XTAP_TAPCELL_ROW_122_1889 VDD VSS gf180mcu_fd_sc_mcu7t5v0__filltie
Xspi_regs_inst_max_cap285 spi_regs_inst_wire284/I spi_regs_inst__1190_/A2 VDD VDD
+ VSS VSS gf180mcu_fd_sc_mcu7t5v0__buf_2
Xspi_regs_inst_max_cap274 spi_regs_inst__1207_/A2 spi_regs_inst__1339_/A2 VDD VDD
+ VSS VSS gf180mcu_fd_sc_mcu7t5v0__buf_2
XFILLER_116_705 VDD VDD VSS VSS gf180mcu_fd_sc_mcu7t5v0__fillcap_8
Xspi_regs_inst__1214_ spi_regs_inst__1214_/A1 spi_regs_inst__1214_/A2 spi_regs_inst__1214_/A3
+ spi_regs_inst__1214_/A4 spi_regs_inst__1220_/A3 VDD VDD VSS VSS gf180mcu_fd_sc_mcu7t5v0__nand4_1
XFILLER_6_394 VDD VDD VSS VSS gf180mcu_fd_sc_mcu7t5v0__fillcap_16
Xspi_regs_inst__1145_ spi_regs_inst__1145_/A1 spi_regs_inst__1251_/B1 spi_regs_inst_wire218/I
+ spi_regs_inst__1145_/B2 spi_regs_inst__1147_/A3 VDD VDD VSS VSS gf180mcu_fd_sc_mcu7t5v0__aoi22_1
XFILLER_112_911 VDD VDD VSS VSS gf180mcu_fd_sc_mcu7t5v0__fillcap_32
XPHY_EDGE_ROW_31_1_Right_30 VDD VSS gf180mcu_fd_sc_mcu7t5v0__endcap
Xspi_regs_inst__1076_ spi_regs_inst__1266_/S spi_regs_inst__1076_/A2 spi_regs_inst__1357_/B
+ spi_regs_inst__1076_/B spi_regs_inst__1642_/D VDD VDD VSS VSS gf180mcu_fd_sc_mcu7t5v0__oai31_1
XFILLER_35_2 VDD VDD VSS VSS gf180mcu_fd_sc_mcu7t5v0__fillcap_4
XFILLER_97_644 VDD VDD VSS VSS gf180mcu_fd_sc_mcu7t5v0__fill_1
XFILLER_97_699 VDD VDD VSS VSS gf180mcu_fd_sc_mcu7t5v0__fill_1
XFILLER_133_1170 VDD VDD VSS VSS gf180mcu_fd_sc_mcu7t5v0__fillcap_4
XFILLER_37_232 VDD VDD VSS VSS gf180mcu_fd_sc_mcu7t5v0__fill_2
XFILLER_65_541 VDD VDD VSS VSS gf180mcu_fd_sc_mcu7t5v0__fill_1
XFILLER_93_850 VDD VDD VSS VSS gf180mcu_fd_sc_mcu7t5v0__fillcap_16
Xwave_controller_x_inst__2690_ wave_controller_x_inst__3245_/A1 wave_controller_x_inst__2689_/Z
+ wave_controller_x_inst__2705_/A2 VDD VDD VSS VSS gf180mcu_fd_sc_mcu7t5v0__nor2_1
XFILLER_77_1116 VDD VDD VSS VSS gf180mcu_fd_sc_mcu7t5v0__fillcap_4
Xspi_regs_inst__0929_ spi_regs_inst__1633_/Q spi_regs_inst__1632_/Q spi_regs_inst__1376_/A1
+ spi_regs_inst__0929_/ZN VDD VDD VSS VSS gf180mcu_fd_sc_mcu7t5v0__nand3_1
XFILLER_52_224 VDD VDD VSS VSS gf180mcu_fd_sc_mcu7t5v0__fill_1
Xwave_controller_x_inst__3311_ wave_controller_x_inst__3712_/Q wave_controller_x_inst__3311_/A2
+ wave_controller_x_inst__3311_/B wave_controller_x_inst__3312_/B1 VDD VDD VSS VSS
+ gf180mcu_fd_sc_mcu7t5v0__aoi21_1
Xclkbuf_leaf_17_clk clkbuf_3_4__f_clk/Z clkload24/I VDD VDD VSS VSS gf180mcu_fd_sc_mcu7t5v0__clkbuf_8
Xwave_controller_x_inst__3242_ wave_controller_x_inst__3244_/B2 wave_controller_x_inst__3202_/Z
+ wave_controller_x_inst__3242_/A3 wave_controller_x_inst__3242_/B1 fanout539/I wave_controller_x_inst__3243_/A2
+ VDD VDD VSS VSS gf180mcu_fd_sc_mcu7t5v0__oai32_1
XFILLER_20_165 VDD VDD VSS VSS gf180mcu_fd_sc_mcu7t5v0__fillcap_4
Xwave_controller_x_inst__3173_ wave_controller_x_inst__3107_/Z wave_controller_x_inst__3171_/Z
+ wave_controller_x_inst__3173_/Z VDD VDD VSS VSS gf180mcu_fd_sc_mcu7t5v0__or2_1
Xwave_controller_y_inst__2140_ wave_controller_y_inst__2754_/A2 wave_controller_y_inst__2139_/Z
+ wave_controller_y_inst__2143_/A3 VDD VDD VSS VSS gf180mcu_fd_sc_mcu7t5v0__nand2_1
Xwave_controller_x_inst__2124_ wave_controller_x_inst__2124_/A1 wave_controller_x_inst__2124_/A2
+ wave_controller_x_inst__2124_/B wave_controller_x_inst__2145_/I1 VDD VDD VSS VSS
+ gf180mcu_fd_sc_mcu7t5v0__oai21_1
XFILLER_146_373 VDD VDD VSS VSS gf180mcu_fd_sc_mcu7t5v0__fillcap_8
Xwave_controller_y_inst__2071_ wave_controller_y_inst__2092_/A1 wave_controller_y_inst_wire358/Z
+ wave_controller_y_inst_wire356/Z wave_controller_y_inst__2072_/A2 VDD VDD VSS VSS
+ gf180mcu_fd_sc_mcu7t5v0__nand3_1
Xwave_controller_x_inst__2055_ wave_controller_x_inst_wire377/Z wave_controller_x_inst__2125_/C
+ wave_controller_x_inst__2079_/A1 VDD VDD VSS VSS gf180mcu_fd_sc_mcu7t5v0__nand2_1
XTAP_TAPCELL_ROW_95_1446 VDD VSS gf180mcu_fd_sc_mcu7t5v0__filltie
XFILLER_134_535 VDD VDD VSS VSS gf180mcu_fd_sc_mcu7t5v0__fillcap_4
XFILLER_146_395 VDD VDD VSS VSS gf180mcu_fd_sc_mcu7t5v0__fillcap_32
XFILLER_162_877 VDD VDD VSS VSS gf180mcu_fd_sc_mcu7t5v0__fillcap_64
XFILLER_115_782 VDD VDD VSS VSS gf180mcu_fd_sc_mcu7t5v0__fill_1
XFILLER_138_1081 VDD VDD VSS VSS gf180mcu_fd_sc_mcu7t5v0__fillcap_4
XFILLER_88_644 VDD VDD VSS VSS gf180mcu_fd_sc_mcu7t5v0__fillcap_16
XFILLER_130_741 VDD VDD VSS VSS gf180mcu_fd_sc_mcu7t5v0__fill_2
XFILLER_48_508 VDD VDD VSS VSS gf180mcu_fd_sc_mcu7t5v0__fill_2
Xwave_controller_y_inst__2973_ wave_controller_y_inst__2951_/I wave_controller_y_inst__3055_/A2
+ wave_controller_y_inst__3055_/B wave_controller_y_inst__3056_/A2 VDD VDD VSS VSS
+ gf180mcu_fd_sc_mcu7t5v0__nand3_1
XFILLER_88_699 VDD VDD VSS VSS gf180mcu_fd_sc_mcu7t5v0__fillcap_4
Xwave_controller_y_inst__1924_ spi_regs_inst__1568_/Q wave_controller_y_inst__3570_/A1
+ spi_regs_inst__1567_/Q wave_controller_y_inst__3568_/A1 wave_controller_y_inst__1924_/C
+ wave_controller_y_inst__1926_/A1 VDD VDD VSS VSS gf180mcu_fd_sc_mcu7t5v0__aoi221_1
Xwave_controller_x_inst__2957_ wave_controller_x_inst__3705_/Q fanout527/Z wave_controller_x_inst__2957_/Z
+ VDD VDD VSS VSS gf180mcu_fd_sc_mcu7t5v0__or2_1
Xwave_controller_x_inst__2888_ wave_controller_x_inst__2856_/Z wave_controller_x_inst__2889_/B
+ wave_controller_x_inst__3419_/B VDD VDD VSS VSS gf180mcu_fd_sc_mcu7t5v0__and2_1
Xwave_controller_x_inst__1908_ spi_regs_inst__1274_/A1 wave_controller_x_inst__3472_/A1
+ VDD VDD VSS VSS gf180mcu_fd_sc_mcu7t5v0__clkinv_1
XFILLER_113_64 VDD VDD VSS VSS gf180mcu_fd_sc_mcu7t5v0__fill_1
Xwave_controller_y_inst__1855_ max_cap427/Z wave_controller_y_inst__2229_/A1 VDD VDD
+ VSS VSS gf180mcu_fd_sc_mcu7t5v0__clkinv_1
Xwave_controller_x_inst__1839_ spi_regs_inst__1343_/B2 wave_controller_x_inst__2236_/A1
+ VDD VDD VSS VSS gf180mcu_fd_sc_mcu7t5v0__clkinv_1
Xwave_controller_y_inst__1786_ wave_controller_y_inst__3713_/Q wave_controller_y_inst__3266_/A1
+ VDD VDD VSS VSS gf180mcu_fd_sc_mcu7t5v0__clkinv_1
XTAP_TAPCELL_ROW_54_764 VDD VSS gf180mcu_fd_sc_mcu7t5v0__filltie
Xwave_controller_y_inst__3525_ wave_controller_y_inst__3711_/Q wave_controller_y_inst__3528_/A2
+ wave_controller_y_inst__3527_/A2 VDD VDD VSS VSS gf180mcu_fd_sc_mcu7t5v0__nor2_1
Xwave_controller_x_inst__3509_ wave_controller_x_inst__3539_/A1 wave_controller_x_inst__3509_/A2
+ wave_controller_x_inst__3509_/A3 wave_controller_x_inst__3530_/B1 wave_controller_x_inst__3509_/B2
+ wave_controller_x_inst__3632_/D VDD VDD VSS VSS gf180mcu_fd_sc_mcu7t5v0__oai32_1
XFILLER_31_419 VDD VDD VSS VSS gf180mcu_fd_sc_mcu7t5v0__fill_1
XTAP_TAPCELL_ROW_54_775 VDD VSS gf180mcu_fd_sc_mcu7t5v0__filltie
Xwave_controller_y_inst__3456_ wave_controller_y_inst__3696_/Q wave_controller_y_inst__3493_/A1
+ wave_controller_y_inst__3456_/B wave_controller_y_inst__3461_/A2 VDD VDD VSS VSS
+ gf180mcu_fd_sc_mcu7t5v0__oai21_1
XFILLER_11_132 VDD VDD VSS VSS gf180mcu_fd_sc_mcu7t5v0__fill_2
XFILLER_145_1052 VDD VDD VSS VSS gf180mcu_fd_sc_mcu7t5v0__fillcap_64
XTAP_TAPCELL_ROW_104_1586 VDD VSS gf180mcu_fd_sc_mcu7t5v0__filltie
XTAP_TAPCELL_ROW_104_1597 VDD VSS gf180mcu_fd_sc_mcu7t5v0__filltie
Xwave_controller_y_inst__2407_ wave_controller_y_inst__2407_/A1 wave_controller_y_inst__2407_/A2
+ wave_controller_y_inst__2407_/B wave_controller_y_inst__2434_/B VDD VDD VSS VSS
+ gf180mcu_fd_sc_mcu7t5v0__aoi21_1
XFILLER_11_154 VDD VDD VSS VSS gf180mcu_fd_sc_mcu7t5v0__fill_2
XFILLER_11_165 VDD VDD VSS VSS gf180mcu_fd_sc_mcu7t5v0__fill_1
XFILLER_156_104 VDD VDD VSS VSS gf180mcu_fd_sc_mcu7t5v0__fill_1
Xwave_controller_y_inst__3387_ wave_controller_y_inst__3387_/A1 wave_controller_y_inst__3365_/Z
+ wave_controller_y_inst__3388_/B VDD VDD VSS VSS gf180mcu_fd_sc_mcu7t5v0__nor2_1
Xsignal_processor_x_inst__115_ signal_processor_x_inst__252_/Q signal_processor_x_inst__108_/I
+ signal_processor_x_inst__243_/D VDD VDD VSS VSS gf180mcu_fd_sc_mcu7t5v0__and2_1
XFILLER_138_841 VDD VDD VSS VSS gf180mcu_fd_sc_mcu7t5v0__fillcap_8
XFILLER_7_136 VDD VDD VSS VSS gf180mcu_fd_sc_mcu7t5v0__fillcap_4
Xwave_controller_y_inst__2338_ max_cap426/Z wave_controller_y_inst__2336_/Z wave_controller_y_inst__2338_/Z
+ VDD VDD VSS VSS gf180mcu_fd_sc_mcu7t5v0__xor2_1
XFILLER_138_874 VDD VDD VSS VSS gf180mcu_fd_sc_mcu7t5v0__fill_1
XFILLER_98_10 VDD VDD VSS VSS gf180mcu_fd_sc_mcu7t5v0__fillcap_4
Xwave_controller_y_inst__2269_ wave_controller_y_inst__2270_/A2 wave_controller_y_inst__2268_/Z
+ spi_regs_inst__1340_/A1 VDD VDD VSS VSS gf180mcu_fd_sc_mcu7t5v0__and2_1
XFILLER_137_395 VDD VDD VSS VSS gf180mcu_fd_sc_mcu7t5v0__fillcap_16
XFILLER_98_32 VDD VDD VSS VSS gf180mcu_fd_sc_mcu7t5v0__fill_2
XFILLER_152_376 VDD VDD VSS VSS gf180mcu_fd_sc_mcu7t5v0__fillcap_8
XPHY_EDGE_ROW_60_Left_227 VDD VSS gf180mcu_fd_sc_mcu7t5v0__endcap
XFILLER_106_771 VDD VDD VSS VSS gf180mcu_fd_sc_mcu7t5v0__fill_1
XFILLER_121_730 VDD VDD VSS VSS gf180mcu_fd_sc_mcu7t5v0__fill_2
XFILLER_140_527 VDD VDD VSS VSS gf180mcu_fd_sc_mcu7t5v0__fillcap_4
XFILLER_152_387 VDD VDD VSS VSS gf180mcu_fd_sc_mcu7t5v0__fillcap_4
XFILLER_117_1154 VDD VDD VSS VSS gf180mcu_fd_sc_mcu7t5v0__fillcap_16
XFILLER_79_699 VDD VDD VSS VSS gf180mcu_fd_sc_mcu7t5v0__fill_1
XFILLER_94_647 VDD VDD VSS VSS gf180mcu_fd_sc_mcu7t5v0__fill_2
XFILLER_94_669 VDD VDD VSS VSS gf180mcu_fd_sc_mcu7t5v0__fill_1
XTAP_TAPCELL_ROW_124_1918 VDD VSS gf180mcu_fd_sc_mcu7t5v0__filltie
XFILLER_62_533 VDD VDD VSS VSS gf180mcu_fd_sc_mcu7t5v0__fill_1
XTAP_TAPCELL_ROW_124_1929 VDD VSS gf180mcu_fd_sc_mcu7t5v0__filltie
XFILLER_62_566 VDD VDD VSS VSS gf180mcu_fd_sc_mcu7t5v0__fill_2
XFILLER_144_811 VDD VDD VSS VSS gf180mcu_fd_sc_mcu7t5v0__fill_2
XFILLER_162_107 VDD VDD VSS VSS gf180mcu_fd_sc_mcu7t5v0__fillcap_64
XFILLER_144_855 VDD VDD VSS VSS gf180mcu_fd_sc_mcu7t5v0__fillcap_16
XTAP_TAPCELL_ROW_77_1143 VDD VSS gf180mcu_fd_sc_mcu7t5v0__filltie
XTAP_TAPCELL_ROW_77_1154 VDD VSS gf180mcu_fd_sc_mcu7t5v0__filltie
XFILLER_143_365 VDD VDD VSS VSS gf180mcu_fd_sc_mcu7t5v0__fill_2
XFILLER_144_877 VDD VDD VSS VSS gf180mcu_fd_sc_mcu7t5v0__fillcap_64
Xspi_regs_inst__1128_ max_cap464/Z spi_regs_inst__1337_/A2 spi_regs_inst_wire227/Z
+ spi_regs_inst__1128_/B2 spi_regs_inst__1157_/A1 VDD VDD VSS VSS gf180mcu_fd_sc_mcu7t5v0__aoi22_1
Xclkbuf_leaf_6_clk clkbuf_leaf_8_clk/I clkbuf_leaf_6_clk/Z VDD VDD VSS VSS gf180mcu_fd_sc_mcu7t5v0__clkbuf_8
XFILLER_98_931 VDD VDD VSS VSS gf180mcu_fd_sc_mcu7t5v0__fillcap_8
XTAP_TAPCELL_ROW_90_1354 VDD VSS gf180mcu_fd_sc_mcu7t5v0__filltie
XTAP_TAPCELL_ROW_90_1365 VDD VSS gf180mcu_fd_sc_mcu7t5v0__filltie
Xwave_controller_x_inst__2811_ wave_controller_x_inst__3570_/A1 wave_controller_x_inst__2806_/I
+ wave_controller_x_inst__2812_/B2 VDD VDD VSS VSS gf180mcu_fd_sc_mcu7t5v0__nand2_1
Xspi_regs_inst__1059_ spi_regs_inst__1059_/A1 spi_regs_inst_wire263/Z spi_regs_inst_wire251/Z
+ spi_regs_inst__1607_/Q spi_regs_inst__1062_/A2 VDD VDD VSS VSS gf180mcu_fd_sc_mcu7t5v0__aoi22_1
XFILLER_111_251 VDD VDD VSS VSS gf180mcu_fd_sc_mcu7t5v0__fillcap_16
XFILLER_85_636 VDD VDD VSS VSS gf180mcu_fd_sc_mcu7t5v0__fill_2
XFILLER_97_474 VDD VDD VSS VSS gf180mcu_fd_sc_mcu7t5v0__fillcap_8
XFILLER_100_947 VDD VDD VSS VSS gf180mcu_fd_sc_mcu7t5v0__fillcap_64
XFILLER_73_809 VDD VDD VSS VSS gf180mcu_fd_sc_mcu7t5v0__fill_1
XFILLER_97_496 VDD VDD VSS VSS gf180mcu_fd_sc_mcu7t5v0__fill_1
Xwave_controller_x_inst__2742_ wave_controller_x_inst__2774_/A1 spi_regs_inst__1188_/C1
+ wave_controller_x_inst__2742_/B wave_controller_x_inst__2743_/A3 VDD VDD VSS VSS
+ gf180mcu_fd_sc_mcu7t5v0__aoi21_1
XPHY_EDGE_ROW_108_Left_275 VDD VSS gf180mcu_fd_sc_mcu7t5v0__endcap
Xwave_controller_x_inst__2673_ spi_regs_inst__1301_/A1 wave_controller_x_inst__2672_/Z
+ wave_controller_x_inst__2694_/A2 VDD VDD VSS VSS gf180mcu_fd_sc_mcu7t5v0__nand2_1
XFILLER_13_408 VDD VDD VSS VSS gf180mcu_fd_sc_mcu7t5v0__fillcap_8
XFILLER_25_279 VDD VDD VSS VSS gf180mcu_fd_sc_mcu7t5v0__fill_1
XFILLER_53_588 VDD VDD VSS VSS gf180mcu_fd_sc_mcu7t5v0__fill_2
XFILLER_81_897 VDD VDD VSS VSS gf180mcu_fd_sc_mcu7t5v0__fill_2
Xwave_controller_y_inst__3310_ wave_controller_y_inst__3310_/A1 wave_controller_y_inst__3310_/A2
+ wave_controller_y_inst__3310_/B wave_controller_y_inst__3310_/C wave_controller_y_inst__3358_/A2
+ VDD VDD VSS VSS gf180mcu_fd_sc_mcu7t5v0__aoi211_1
XFILLER_40_238 VDD VDD VSS VSS gf180mcu_fd_sc_mcu7t5v0__fill_1
XFILLER_139_638 VDD VDD VSS VSS gf180mcu_fd_sc_mcu7t5v0__fill_1
XFILLER_166_413 VDD VDD VSS VSS gf180mcu_fd_sc_mcu7t5v0__fill_1
XFILLER_90_1157 VDD VDD VSS VSS gf180mcu_fd_sc_mcu7t5v0__fillcap_8
Xwave_controller_y_inst__3241_ fanout517/Z wave_controller_y_inst__3242_/B1 wave_controller_y_inst__3241_/B1
+ wave_controller_y_inst__3241_/B2 wave_controller_y_inst__3241_/C wave_controller_y_inst__3243_/A1
+ VDD VDD VSS VSS gf180mcu_fd_sc_mcu7t5v0__aoi221_1
Xwave_controller_x_inst__3225_ wave_controller_x_inst__3225_/A1 wave_controller_x_inst__3225_/A2
+ wave_controller_x_inst__3234_/A2 VDD VDD VSS VSS gf180mcu_fd_sc_mcu7t5v0__nor2_1
XFILLER_166_457 VDD VDD VSS VSS gf180mcu_fd_sc_mcu7t5v0__fillcap_32
XFILLER_21_496 VDD VDD VSS VSS gf180mcu_fd_sc_mcu7t5v0__fill_2
Xwave_controller_y_inst__3172_ wave_controller_y_inst__3170_/B wave_controller_y_inst__3171_/Z
+ wave_controller_y_inst__3252_/A1 VDD VDD VSS VSS gf180mcu_fd_sc_mcu7t5v0__nor2_1
Xwave_controller_x_inst__3156_ wave_controller_x_inst__3709_/Q wave_controller_x_inst__3156_/A2
+ wave_controller_x_inst__3156_/B wave_controller_x_inst__3205_/A2 VDD VDD VSS VSS
+ gf180mcu_fd_sc_mcu7t5v0__oai21_1
XFILLER_119_362 VDD VDD VSS VSS gf180mcu_fd_sc_mcu7t5v0__fillcap_4
XFILLER_135_800 VDD VDD VSS VSS gf180mcu_fd_sc_mcu7t5v0__fill_2
XFILLER_153_107 VDD VDD VSS VSS gf180mcu_fd_sc_mcu7t5v0__fillcap_4
XFILLER_153_118 VDD VDD VSS VSS gf180mcu_fd_sc_mcu7t5v0__fillcap_16
XPHY_EDGE_ROW_117_Left_284 VDD VSS gf180mcu_fd_sc_mcu7t5v0__endcap
Xwave_controller_y_inst__2123_ wave_controller_y_inst__2123_/A1 wave_controller_y_inst__2123_/A2
+ wave_controller_y_inst__2123_/B wave_controller_y_inst__2136_/A1 VDD VDD VSS VSS
+ gf180mcu_fd_sc_mcu7t5v0__oai21_1
Xwave_controller_x_inst__2107_ wave_controller_x_inst__2037_/Z wave_controller_x_inst__2109_/A2
+ wave_controller_x_inst__2107_/B wave_controller_x_inst__2114_/B wave_controller_x_inst__2108_/C
+ VDD VDD VSS VSS gf180mcu_fd_sc_mcu7t5v0__aoi211_1
XFILLER_147_693 VDD VDD VSS VSS gf180mcu_fd_sc_mcu7t5v0__fillcap_4
Xwave_controller_x_inst__3087_ wave_controller_x_inst__3189_/C wave_controller_x_inst__3084_/Z
+ wave_controller_x_inst__3087_/Z VDD VDD VSS VSS gf180mcu_fd_sc_mcu7t5v0__xor2_1
XFILLER_108_42 VDD VDD VSS VSS gf180mcu_fd_sc_mcu7t5v0__fillcap_8
XFILLER_150_803 VDD VDD VSS VSS gf180mcu_fd_sc_mcu7t5v0__fill_2
Xwave_controller_y_inst__2054_ wave_controller_y_inst_wire358/Z wave_controller_y_inst__2125_/B
+ wave_controller_y_inst__2128_/A2 VDD VDD VSS VSS gf180mcu_fd_sc_mcu7t5v0__nand2_1
Xwave_controller_x_inst__2038_ wave_controller_x_inst__1781_/I wave_controller_x_inst__3089_/B
+ wave_controller_x_inst__2077_/A1 VDD VDD VSS VSS gf180mcu_fd_sc_mcu7t5v0__xnor2_1
XFILLER_122_527 VDD VDD VSS VSS gf180mcu_fd_sc_mcu7t5v0__fillcap_16
XFILLER_134_398 VDD VDD VSS VSS gf180mcu_fd_sc_mcu7t5v0__fillcap_4
XFILLER_89_920 VDD VDD VSS VSS gf180mcu_fd_sc_mcu7t5v0__fillcap_4
Xspi_regs_inst_wire193 spi_regs_inst_wire193/I spi_regs_inst__0870_/S VDD VDD VSS
+ VSS gf180mcu_fd_sc_mcu7t5v0__buf_4
Xspi_regs_inst_fanout614 fanout615/Z spi_regs_inst__1601_/RN VDD VDD VSS VSS gf180mcu_fd_sc_mcu7t5v0__dlyb_1
XFILLER_103_796 VDD VDD VSS VSS gf180mcu_fd_sc_mcu7t5v0__fill_1
XFILLER_48_305 VDD VDD VSS VSS gf180mcu_fd_sc_mcu7t5v0__fill_1
Xwave_controller_x_inst_fanout157 wave_controller_x_inst__3545_/B1 wave_controller_x_inst__3557_/B1
+ VDD VDD VSS VSS gf180mcu_fd_sc_mcu7t5v0__dlyb_1
XFILLER_75_135 VDD VDD VSS VSS gf180mcu_fd_sc_mcu7t5v0__fillcap_4
XFILLER_84_12 VDD VDD VSS VSS gf180mcu_fd_sc_mcu7t5v0__fill_2
XPHY_EDGE_ROW_126_Left_293 VDD VSS gf180mcu_fd_sc_mcu7t5v0__endcap
XTAP_TAPCELL_ROW_59_845 VDD VSS gf180mcu_fd_sc_mcu7t5v0__filltie
XTAP_TAPCELL_ROW_59_856 VDD VSS gf180mcu_fd_sc_mcu7t5v0__filltie
Xwave_controller_y_inst__2956_ wave_controller_y_inst__2956_/I wave_controller_y_inst__2971_/B
+ VDD VDD VSS VSS gf180mcu_fd_sc_mcu7t5v0__clkinv_1
XFILLER_84_34 VDD VDD VSS VSS gf180mcu_fd_sc_mcu7t5v0__fill_1
XTAP_TAPCELL_ROW_141_2207 VDD VSS gf180mcu_fd_sc_mcu7t5v0__filltie
Xwave_controller_y_inst__2887_ wave_controller_y_inst__2887_/A1 wave_controller_y_inst__2887_/A2
+ wave_controller_y_inst__2887_/A3 wave_controller_y_inst__2889_/B VDD VDD VSS VSS
+ gf180mcu_fd_sc_mcu7t5v0__and3_1
Xwave_controller_y_inst__1907_ spi_regs_inst__1262_/A1 wave_controller_y_inst__3462_/B2
+ VDD VDD VSS VSS gf180mcu_fd_sc_mcu7t5v0__clkinv_1
XFILLER_16_202 VDD VDD VSS VSS gf180mcu_fd_sc_mcu7t5v0__fill_2
XTAP_TAPCELL_ROW_106_1626 VDD VSS gf180mcu_fd_sc_mcu7t5v0__filltie
Xwave_controller_y_inst__1838_ spi_regs_inst__1315_/A1 wave_controller_y_inst__2226_/A1
+ VDD VDD VSS VSS gf180mcu_fd_sc_mcu7t5v0__clkinv_1
XFILLER_17_72 VDD VDD VSS VSS gf180mcu_fd_sc_mcu7t5v0__fillcap_64
XFILLER_71_330 VDD VDD VSS VSS gf180mcu_fd_sc_mcu7t5v0__fillcap_4
XFILLER_71_352 VDD VDD VSS VSS gf180mcu_fd_sc_mcu7t5v0__fillcap_4
XFILLER_95_1046 VDD VDD VSS VSS gf180mcu_fd_sc_mcu7t5v0__fillcap_4
XFILLER_72_897 VDD VDD VSS VSS gf180mcu_fd_sc_mcu7t5v0__fill_2
Xwave_controller_y_inst__3508_ max_cap433/Z wave_controller_y_inst__3529_/A2 wave_controller_y_inst__3509_/A3
+ VDD VDD VSS VSS gf180mcu_fd_sc_mcu7t5v0__nor2_1
Xwave_controller_x_inst_max_cap130 wave_controller_x_inst__3215_/A3 wave_controller_x_inst__3149_/B2
+ VDD VDD VSS VSS gf180mcu_fd_sc_mcu7t5v0__clkbuf_1
XFILLER_158_947 VDD VDD VSS VSS gf180mcu_fd_sc_mcu7t5v0__fillcap_64
XTAP_TAPCELL_ROW_139_2169 VDD VSS gf180mcu_fd_sc_mcu7t5v0__filltie
Xwave_controller_y_inst__3439_ wave_controller_y_inst__3439_/I wave_controller_y_inst__3440_/B2
+ VDD VDD VSS VSS gf180mcu_fd_sc_mcu7t5v0__clkinv_1
XTAP_TAPCELL_ROW_156_2450 VDD VSS gf180mcu_fd_sc_mcu7t5v0__filltie
XFILLER_144_107 VDD VDD VSS VSS gf180mcu_fd_sc_mcu7t5v0__fillcap_8
XFILLER_145_619 VDD VDD VSS VSS gf180mcu_fd_sc_mcu7t5v0__fill_1
XTAP_TAPCELL_ROW_48_1_691 VDD VSS gf180mcu_fd_sc_mcu7t5v0__filltie
XFILLER_137_181 VDD VDD VSS VSS gf180mcu_fd_sc_mcu7t5v0__fillcap_4
XFILLER_126_877 VDD VDD VSS VSS gf180mcu_fd_sc_mcu7t5v0__fillcap_16
XFILLER_137_192 VDD VDD VSS VSS gf180mcu_fd_sc_mcu7t5v0__fill_2
XFILLER_140_313 VDD VDD VSS VSS gf180mcu_fd_sc_mcu7t5v0__fill_2
XFILLER_152_173 VDD VDD VSS VSS gf180mcu_fd_sc_mcu7t5v0__fill_2
XFILLER_98_216 VDD VDD VSS VSS gf180mcu_fd_sc_mcu7t5v0__fillcap_4
XTAP_TAPCELL_ROW_14_1_436 VDD VSS gf180mcu_fd_sc_mcu7t5v0__filltie
XFILLER_67_603 VDD VDD VSS VSS gf180mcu_fd_sc_mcu7t5v0__fill_1
XTAP_TAPCELL_ROW_22_1_493 VDD VSS gf180mcu_fd_sc_mcu7t5v0__filltie
XTAP_TAPCELL_ROW_72_1062 VDD VSS gf180mcu_fd_sc_mcu7t5v0__filltie
XTAP_TAPCELL_ROW_72_1073 VDD VSS gf180mcu_fd_sc_mcu7t5v0__filltie
XFILLER_121_593 VDD VDD VSS VSS gf180mcu_fd_sc_mcu7t5v0__fill_1
XFILLER_95_956 VDD VDD VSS VSS gf180mcu_fd_sc_mcu7t5v0__fillcap_16
XFILLER_130_1151 VDD VDD VSS VSS gf180mcu_fd_sc_mcu7t5v0__fillcap_4
XFILLER_130_1173 VDD VDD VSS VSS gf180mcu_fd_sc_mcu7t5v0__fill_1
XFILLER_35_533 VDD VDD VSS VSS gf180mcu_fd_sc_mcu7t5v0__fill_1
XFILLER_63_842 VDD VDD VSS VSS gf180mcu_fd_sc_mcu7t5v0__fillcap_32
XPHY_EDGE_ROW_18_1_Left_185 VDD VSS gf180mcu_fd_sc_mcu7t5v0__endcap
Xspi_regs_inst_load_slew194 spi_regs_inst__0861_/S spi_regs_inst__0857_/S VDD VDD
+ VSS VSS gf180mcu_fd_sc_mcu7t5v0__clkbuf_3
XFILLER_148_457 VDD VDD VSS VSS gf180mcu_fd_sc_mcu7t5v0__fillcap_16
Xwave_controller_x_inst__3010_ wave_controller_x_inst__2117_/B wave_controller_x_inst__2764_/Z
+ wave_controller_x_inst__3094_/A2 fanout400/Z wave_controller_x_inst__3036_/A2 VDD
+ VDD VSS VSS gf180mcu_fd_sc_mcu7t5v0__oai31_2
XFILLER_163_416 VDD VDD VSS VSS gf180mcu_fd_sc_mcu7t5v0__fillcap_4
XFILLER_116_321 VDD VDD VSS VSS gf180mcu_fd_sc_mcu7t5v0__fillcap_16
XFILLER_117_833 VDD VDD VSS VSS gf180mcu_fd_sc_mcu7t5v0__fill_1
XFILLER_144_630 VDD VDD VSS VSS gf180mcu_fd_sc_mcu7t5v0__fillcap_16
XFILLER_144_652 VDD VDD VSS VSS gf180mcu_fd_sc_mcu7t5v0__fill_1
XFILLER_104_527 VDD VDD VSS VSS gf180mcu_fd_sc_mcu7t5v0__fillcap_8
XFILLER_116_387 VDD VDD VSS VSS gf180mcu_fd_sc_mcu7t5v0__fillcap_16
XFILLER_143_184 VDD VDD VSS VSS gf180mcu_fd_sc_mcu7t5v0__fillcap_8
Xwave_controller_y_inst__2810_ wave_controller_y_inst__2810_/A1 wave_controller_y_inst__2810_/A2
+ wave_controller_y_inst__2810_/B wave_controller_y_inst__2810_/C wave_controller_y_inst__2812_/B1
+ VDD VDD VSS VSS gf180mcu_fd_sc_mcu7t5v0__oai211_1
XFILLER_85_422 VDD VDD VSS VSS gf180mcu_fd_sc_mcu7t5v0__fillcap_4
XFILLER_97_282 VDD VDD VSS VSS gf180mcu_fd_sc_mcu7t5v0__fill_2
XFILLER_45_308 VDD VDD VSS VSS gf180mcu_fd_sc_mcu7t5v0__fill_1
XTAP_TAPCELL_ROW_56_804 VDD VSS gf180mcu_fd_sc_mcu7t5v0__filltie
Xwave_controller_y_inst__2741_ spi_regs_inst__1204_/B2 wave_controller_y_inst__3554_/B2
+ wave_controller_y_inst__2741_/B wave_controller_y_inst__2742_/B VDD VDD VSS VSS
+ gf180mcu_fd_sc_mcu7t5v0__aoi21_1
Xwave_controller_x_inst__2725_ wave_controller_x_inst__2722_/Z wave_controller_x_inst__2739_/A2
+ wave_controller_x_inst__2737_/A2 VDD VDD VSS VSS gf180mcu_fd_sc_mcu7t5v0__xnor2_1
XFILLER_66_680 VDD VDD VSS VSS gf180mcu_fd_sc_mcu7t5v0__fillcap_4
Xwave_controller_y_inst__2672_ wave_controller_y_inst__1818_/I wave_controller_y_inst__2668_/Z
+ wave_controller_y_inst__2672_/A3 wave_controller_y_inst__2672_/Z VDD VDD VSS VSS
+ gf180mcu_fd_sc_mcu7t5v0__xor3_1
XFILLER_54_26 VDD VDD VSS VSS gf180mcu_fd_sc_mcu7t5v0__fillcap_8
XTAP_TAPCELL_ROW_0_1_2669 VDD VSS gf180mcu_fd_sc_mcu7t5v0__filltie
Xwave_controller_x_inst__2656_ wave_controller_x_inst__2656_/A1 wave_controller_x_inst__2669_/B
+ wave_controller_x_inst__2686_/A1 VDD VDD VSS VSS gf180mcu_fd_sc_mcu7t5v0__nand2_1
Xwave_controller_x_inst__2587_ fanout521/Z wave_controller_x_inst__2589_/A3 wave_controller_x_inst__2602_/B
+ VDD VDD VSS VSS gf180mcu_fd_sc_mcu7t5v0__or2_1
XFILLER_110_43 VDD VDD VSS VSS gf180mcu_fd_sc_mcu7t5v0__fillcap_4
XFILLER_142_1011 VDD VDD VSS VSS gf180mcu_fd_sc_mcu7t5v0__fillcap_4
XFILLER_55_1052 VDD VDD VSS VSS gf180mcu_fd_sc_mcu7t5v0__fillcap_64
XFILLER_70_14 VDD VDD VSS VSS gf180mcu_fd_sc_mcu7t5v0__fill_2
XTAP_TAPCELL_ROW_101_1545 VDD VSS gf180mcu_fd_sc_mcu7t5v0__filltie
XFILLER_155_906 VDD VDD VSS VSS gf180mcu_fd_sc_mcu7t5v0__fillcap_4
Xwave_controller_y_inst__3224_ wave_controller_y_inst__3224_/A1 wave_controller_y_inst__3224_/A2
+ wave_controller_y_inst__3142_/B wave_controller_y_inst__3225_/A2 VDD VDD VSS VSS
+ gf180mcu_fd_sc_mcu7t5v0__nor3_1
XFILLER_108_811 VDD VDD VSS VSS gf180mcu_fd_sc_mcu7t5v0__fill_1
XFILLER_126_107 VDD VDD VSS VSS gf180mcu_fd_sc_mcu7t5v0__fillcap_16
XFILLER_154_416 VDD VDD VSS VSS gf180mcu_fd_sc_mcu7t5v0__fill_2
Xwave_controller_x_inst__3208_ wave_controller_x_inst__3115_/Z wave_controller_x_inst__3151_/Z
+ wave_controller_x_inst__3208_/B wave_controller_x_inst__3210_/A3 VDD VDD VSS VSS
+ gf180mcu_fd_sc_mcu7t5v0__oai21_1
XFILLER_119_52 VDD VDD VSS VSS gf180mcu_fd_sc_mcu7t5v0__fill_2
Xwave_controller_y_inst__3155_ wave_controller_y_inst__3305_/A1 spi_regs_inst__1592_/Q
+ spi_regs_inst__1591_/Q wave_controller_y_inst__3156_/A2 VDD VDD VSS VSS gf180mcu_fd_sc_mcu7t5v0__oai21_1
Xwave_controller_x_inst__3139_ wave_controller_x_inst__3564_/A1 spi_regs_inst__1523_/Q
+ wave_controller_x_inst__3142_/B VDD VDD VSS VSS gf180mcu_fd_sc_mcu7t5v0__xor2_1
XFILLER_102_2 VDD VDD VSS VSS gf180mcu_fd_sc_mcu7t5v0__fill_2
XFILLER_107_332 VDD VDD VSS VSS gf180mcu_fd_sc_mcu7t5v0__fill_2
XFILLER_108_877 VDD VDD VSS VSS gf180mcu_fd_sc_mcu7t5v0__fill_2
XFILLER_79_12 VDD VDD VSS VSS gf180mcu_fd_sc_mcu7t5v0__fill_1
XTAP_TAPCELL_ROW_134_2088 VDD VSS gf180mcu_fd_sc_mcu7t5v0__filltie
Xwave_controller_y_inst__3086_ wave_controller_y_inst__3084_/Z wave_controller_y_inst__3086_/A2
+ wave_controller_y_inst__3718_/D VDD VDD VSS VSS gf180mcu_fd_sc_mcu7t5v0__nor2_1
Xwave_controller_y_inst__2106_ wave_controller_y_inst__3728_/Q wave_controller_y_inst__2106_/A2
+ wave_controller_y_inst__2106_/B wave_controller_y_inst__2123_/A1 VDD VDD VSS VSS
+ gf180mcu_fd_sc_mcu7t5v0__aoi21_1
XFILLER_123_825 VDD VDD VSS VSS gf180mcu_fd_sc_mcu7t5v0__fillcap_4
XPHY_EDGE_ROW_57_Right_57 VDD VSS gf180mcu_fd_sc_mcu7t5v0__endcap
Xwave_controller_y_inst__2037_ wave_controller_y_inst__1781_/I wave_controller_y_inst__2038_/A2
+ wave_controller_y_inst__2037_/Z VDD VDD VSS VSS gf180mcu_fd_sc_mcu7t5v0__xor2_1
XFILLER_0_120 VDD VDD VSS VSS gf180mcu_fd_sc_mcu7t5v0__fill_1
XFILLER_95_219 VDD VDD VSS VSS gf180mcu_fd_sc_mcu7t5v0__fill_1
XPHY_EDGE_ROW_134_Left_301 VDD VSS gf180mcu_fd_sc_mcu7t5v0__endcap
XFILLER_103_593 VDD VDD VSS VSS gf180mcu_fd_sc_mcu7t5v0__fillcap_8
XFILLER_76_444 VDD VDD VSS VSS gf180mcu_fd_sc_mcu7t5v0__fillcap_8
XFILLER_77_945 VDD VDD VSS VSS gf180mcu_fd_sc_mcu7t5v0__fillcap_32
Xspi_regs_inst_fanout488 spi_regs_inst__1430_/I1 spi_regs_inst__1406_/I1 VDD VDD VSS
+ VSS gf180mcu_fd_sc_mcu7t5v0__dlyb_1
Xspi_regs_inst_fanout477 spi_regs_inst_wire480/I spi_regs_inst__1380_/I1 VDD VDD VSS
+ VSS gf180mcu_fd_sc_mcu7t5v0__dlyb_1
XFILLER_114_1157 VDD VDD VSS VSS gf180mcu_fd_sc_mcu7t5v0__fillcap_8
XFILLER_95_88 VDD VDD VSS VSS gf180mcu_fd_sc_mcu7t5v0__fillcap_8
Xwave_controller_y_inst__2939_ wave_controller_y_inst__1781_/I wave_controller_y_inst__3400_/A1
+ wave_controller_y_inst__2998_/A2 VDD VDD VSS VSS gf180mcu_fd_sc_mcu7t5v0__nand2_1
XFILLER_63_138 VDD VDD VSS VSS gf180mcu_fd_sc_mcu7t5v0__fill_2
Xspi_regs_inst__1600_ spi_regs_inst__1600_/D spi_regs_inst__1601_/RN clkbuf_leaf_36_clk/Z
+ spi_regs_inst__1600_/Q VDD VDD VSS VSS gf180mcu_fd_sc_mcu7t5v0__dffrnq_1
XFILLER_44_352 VDD VDD VSS VSS gf180mcu_fd_sc_mcu7t5v0__fill_1
XFILLER_72_683 VDD VDD VSS VSS gf180mcu_fd_sc_mcu7t5v0__fillcap_4
XPHY_EDGE_ROW_66_Right_66 VDD VSS gf180mcu_fd_sc_mcu7t5v0__endcap
Xspi_regs_inst__1531_ spi_regs_inst__1531_/D wire594/Z clkbuf_leaf_11_clk/Z spi_regs_inst__1531_/Q
+ VDD VDD VSS VSS gf180mcu_fd_sc_mcu7t5v0__dffrnq_1
XPHY_EDGE_ROW_143_Left_310 VDD VSS gf180mcu_fd_sc_mcu7t5v0__endcap
Xspi_regs_inst__1462_ spi_regs_inst__1462_/D spi_regs_inst__1605_/RN clkload18/I fanout542/I
+ VDD VDD VSS VSS gf180mcu_fd_sc_mcu7t5v0__dffrnq_1
XFILLER_12_271 VDD VDD VSS VSS gf180mcu_fd_sc_mcu7t5v0__fillcap_8
Xspi_regs_inst__1393_ fanout534/Z spi_regs_inst__1411_/I1 spi_regs_inst__1394_/S spi_regs_inst__1468_/D
+ VDD VDD VSS VSS gf180mcu_fd_sc_mcu7t5v0__mux2_2
XTAP_TAPCELL_ROW_119_1839 VDD VSS gf180mcu_fd_sc_mcu7t5v0__filltie
XFILLER_157_298 VDD VDD VSS VSS gf180mcu_fd_sc_mcu7t5v0__fillcap_4
XFILLER_126_641 VDD VDD VSS VSS gf180mcu_fd_sc_mcu7t5v0__fill_2
XPHY_EDGE_ROW_75_Right_75 VDD VSS gf180mcu_fd_sc_mcu7t5v0__endcap
XTAP_TAPCELL_ROW_74_1102 VDD VSS gf180mcu_fd_sc_mcu7t5v0__filltie
XFILLER_125_173 VDD VDD VSS VSS gf180mcu_fd_sc_mcu7t5v0__fillcap_4
XFILLER_113_346 VDD VDD VSS VSS gf180mcu_fd_sc_mcu7t5v0__fillcap_4
XFILLER_119_1046 VDD VDD VSS VSS gf180mcu_fd_sc_mcu7t5v0__fillcap_4
XFILLER_99_558 VDD VDD VSS VSS gf180mcu_fd_sc_mcu7t5v0__fill_2
XFILLER_141_677 VDD VDD VSS VSS gf180mcu_fd_sc_mcu7t5v0__fillcap_8
XFILLER_79_271 VDD VDD VSS VSS gf180mcu_fd_sc_mcu7t5v0__fillcap_8
XFILLER_79_282 VDD VDD VSS VSS gf180mcu_fd_sc_mcu7t5v0__fillcap_4
XFILLER_67_466 VDD VDD VSS VSS gf180mcu_fd_sc_mcu7t5v0__fillcap_8
XFILLER_94_230 VDD VDD VSS VSS gf180mcu_fd_sc_mcu7t5v0__fill_2
XFILLER_55_628 VDD VDD VSS VSS gf180mcu_fd_sc_mcu7t5v0__fill_2
XFILLER_83_948 VDD VDD VSS VSS gf180mcu_fd_sc_mcu7t5v0__fillcap_32
XFILLER_94_274 VDD VDD VSS VSS gf180mcu_fd_sc_mcu7t5v0__fillcap_4
XFILLER_94_296 VDD VDD VSS VSS gf180mcu_fd_sc_mcu7t5v0__fill_2
XPHY_EDGE_ROW_84_Right_84 VDD VSS gf180mcu_fd_sc_mcu7t5v0__endcap
Xwave_controller_x_inst__2510_ wave_controller_x_inst__2505_/Z wave_controller_x_inst__2510_/A2
+ wave_controller_x_inst_wire115/Z spi_regs_inst_wire105/I VDD VDD VSS VSS gf180mcu_fd_sc_mcu7t5v0__xnor3_1
Xwave_controller_x_inst__3490_ wave_controller_x_inst__3490_/A1 wave_controller_x_inst__3488_/I
+ wave_controller_x_inst__3490_/B wave_controller_x_inst__3490_/C wave_controller_x_inst__3492_/B1
+ VDD VDD VSS VSS gf180mcu_fd_sc_mcu7t5v0__aoi211_1
XFILLER_35_352 VDD VDD VSS VSS gf180mcu_fd_sc_mcu7t5v0__fillcap_4
XTAP_TAPCELL_ROW_85_1275 VDD VSS gf180mcu_fd_sc_mcu7t5v0__filltie
Xwave_controller_y_inst_wire128 wave_controller_y_inst_wire128/I wave_controller_y_inst_wire128/Z
+ VDD VDD VSS VSS gf180mcu_fd_sc_mcu7t5v0__clkbuf_1
Xwave_controller_y_inst_wire139 wave_controller_y_inst_wire139/I wave_controller_y_inst_wire139/Z
+ VDD VDD VSS VSS gf180mcu_fd_sc_mcu7t5v0__buf_4
Xwave_controller_x_inst__2441_ spi_regs_inst__1185_/B2 wave_controller_x_inst__2445_/A3
+ wave_controller_x_inst__2450_/A2 VDD VDD VSS VSS gf180mcu_fd_sc_mcu7t5v0__nor2_1
XFILLER_126_1017 VDD VDD VSS VSS gf180mcu_fd_sc_mcu7t5v0__fillcap_64
XFILLER_35_385 VDD VDD VSS VSS gf180mcu_fd_sc_mcu7t5v0__fill_2
XFILLER_50_333 VDD VDD VSS VSS gf180mcu_fd_sc_mcu7t5v0__fill_1
XFILLER_62_193 VDD VDD VSS VSS gf180mcu_fd_sc_mcu7t5v0__fill_1
XTAP_TAPCELL_ROW_85_1286 VDD VSS gf180mcu_fd_sc_mcu7t5v0__filltie
Xwave_controller_x_inst__2372_ wave_controller_x_inst__2369_/Z wave_controller_x_inst__2372_/A2
+ wave_controller_x_inst__2394_/A1 VDD VDD VSS VSS gf180mcu_fd_sc_mcu7t5v0__xnor2_1
XFILLER_137_906 VDD VDD VSS VSS gf180mcu_fd_sc_mcu7t5v0__fillcap_4
XTAP_TAPCELL_ROW_61_884 VDD VSS gf180mcu_fd_sc_mcu7t5v0__filltie
XFILLER_108_107 VDD VDD VSS VSS gf180mcu_fd_sc_mcu7t5v0__fill_2
XFILLER_148_243 VDD VDD VSS VSS gf180mcu_fd_sc_mcu7t5v0__fill_2
Xchip_core_629 bidir_cs[4] VDD VDD VSS VSS gf180mcu_fd_sc_mcu7t5v0__tiel
XFILLER_163_224 VDD VDD VSS VSS gf180mcu_fd_sc_mcu7t5v0__fill_1
XFILLER_163_235 VDD VDD VSS VSS gf180mcu_fd_sc_mcu7t5v0__fill_1
XPHY_EDGE_ROW_93_Right_93 VDD VSS gf180mcu_fd_sc_mcu7t5v0__endcap
XFILLER_89_1170 VDD VDD VSS VSS gf180mcu_fd_sc_mcu7t5v0__fillcap_4
XFILLER_116_173 VDD VDD VSS VSS gf180mcu_fd_sc_mcu7t5v0__fill_2
XFILLER_151_419 VDD VDD VSS VSS gf180mcu_fd_sc_mcu7t5v0__fill_1
XFILLER_163_279 VDD VDD VSS VSS gf180mcu_fd_sc_mcu7t5v0__fill_1
XFILLER_104_346 VDD VDD VSS VSS gf180mcu_fd_sc_mcu7t5v0__fillcap_16
XFILLER_105_858 VDD VDD VSS VSS gf180mcu_fd_sc_mcu7t5v0__fillcap_4
XFILLER_132_677 VDD VDD VSS VSS gf180mcu_fd_sc_mcu7t5v0__fill_1
XFILLER_59_912 VDD VDD VSS VSS gf180mcu_fd_sc_mcu7t5v0__fill_2
XFILLER_77_208 VDD VDD VSS VSS gf180mcu_fd_sc_mcu7t5v0__fill_2
XFILLER_105_10 VDD VDD VSS VSS gf180mcu_fd_sc_mcu7t5v0__fill_2
XTAP_TAPCELL_ROW_39_1_622 VDD VSS gf180mcu_fd_sc_mcu7t5v0__filltie
XFILLER_74_926 VDD VDD VSS VSS gf180mcu_fd_sc_mcu7t5v0__fillcap_4
XFILLER_86_764 VDD VDD VSS VSS gf180mcu_fd_sc_mcu7t5v0__fill_2
XFILLER_105_98 VDD VDD VSS VSS gf180mcu_fd_sc_mcu7t5v0__fillcap_4
Xwave_controller_y_inst__2724_ wave_controller_y_inst__2722_/Z wave_controller_y_inst__2739_/A2
+ wave_controller_y_inst__2738_/A2 VDD VDD VSS VSS gf180mcu_fd_sc_mcu7t5v0__nor2_1
Xwave_controller_x_inst__3688_ wave_controller_x_inst__3688_/D fanout589/Z clkload22/I
+ spi_regs_inst__1148_/B2 VDD VDD VSS VSS gf180mcu_fd_sc_mcu7t5v0__dffrnq_1
Xwave_controller_x_inst__2708_ wave_controller_x_inst__2676_/Z wave_controller_x_inst__2694_/Z
+ wave_controller_x_inst__2712_/B VDD VDD VSS VSS gf180mcu_fd_sc_mcu7t5v0__nor2_1
XFILLER_54_650 VDD VDD VSS VSS gf180mcu_fd_sc_mcu7t5v0__fill_2
Xwave_controller_y_inst__2655_ wave_controller_y_inst__2687_/B wave_controller_y_inst__2669_/B
+ VDD VDD VSS VSS gf180mcu_fd_sc_mcu7t5v0__clkinv_1
Xwave_controller_x_inst__2639_ wave_controller_x_inst__3391_/A1 wave_controller_x_inst__2638_/Z
+ wave_controller_x_inst__2664_/A1 VDD VDD VSS VSS gf180mcu_fd_sc_mcu7t5v0__nand2_1
XFILLER_159_508 VDD VDD VSS VSS gf180mcu_fd_sc_mcu7t5v0__fill_2
XFILLER_41_300 VDD VDD VSS VSS gf180mcu_fd_sc_mcu7t5v0__fill_1
XFILLER_81_480 VDD VDD VSS VSS gf180mcu_fd_sc_mcu7t5v0__fillcap_8
Xwave_controller_y_inst__2586_ wave_controller_y_inst__2580_/Z wave_controller_y_inst__2596_/A2
+ wave_controller_y_inst__2589_/A3 VDD VDD VSS VSS gf180mcu_fd_sc_mcu7t5v0__xnor2_1
XTAP_TAPCELL_ROW_136_2117 VDD VSS gf180mcu_fd_sc_mcu7t5v0__filltie
XTAP_TAPCELL_ROW_21_1_492 VDD VSS gf180mcu_fd_sc_mcu7t5v0__filltie
XFILLER_127_416 VDD VDD VSS VSS gf180mcu_fd_sc_mcu7t5v0__fillcap_4
XTAP_TAPCELL_ROW_136_2128 VDD VSS gf180mcu_fd_sc_mcu7t5v0__filltie
XFILLER_127_438 VDD VDD VSS VSS gf180mcu_fd_sc_mcu7t5v0__fillcap_4
XFILLER_5_212 VDD VDD VSS VSS gf180mcu_fd_sc_mcu7t5v0__fillcap_64
Xwave_controller_y_inst__3207_ wave_controller_y_inst__3115_/Z wave_controller_y_inst__3151_/Z
+ wave_controller_y_inst__3208_/B wave_controller_y_inst__3207_/Z VDD VDD VSS VSS
+ gf180mcu_fd_sc_mcu7t5v0__or3_1
XFILLER_154_257 VDD VDD VSS VSS gf180mcu_fd_sc_mcu7t5v0__fill_1
XFILLER_155_769 VDD VDD VSS VSS gf180mcu_fd_sc_mcu7t5v0__fill_1
Xwave_controller_y_inst__3138_ wave_controller_y_inst__3129_/Z wave_controller_y_inst__3233_/A2
+ wave_controller_y_inst__3138_/B wave_controller_y_inst__3228_/A1 VDD VDD VSS VSS
+ gf180mcu_fd_sc_mcu7t5v0__oai21_1
XTAP_TAPCELL_ROW_114_1758 VDD VSS gf180mcu_fd_sc_mcu7t5v0__filltie
Xwave_controller_y_inst__3069_ wave_controller_y_inst__2762_/I wave_controller_y_inst__2983_/B
+ wave_controller_y_inst__3068_/Z wave_controller_y_inst__3090_/B1 wave_controller_y_inst__3163_/C
+ wave_controller_y_inst__3711_/D VDD VDD VSS VSS gf180mcu_fd_sc_mcu7t5v0__oai32_1
XFILLER_111_839 VDD VDD VSS VSS gf180mcu_fd_sc_mcu7t5v0__fill_1
XFILLER_123_699 VDD VDD VSS VSS gf180mcu_fd_sc_mcu7t5v0__fill_1
XFILLER_150_496 VDD VDD VSS VSS gf180mcu_fd_sc_mcu7t5v0__fillcap_8
XFILLER_49_455 VDD VDD VSS VSS gf180mcu_fd_sc_mcu7t5v0__fillcap_8
Xspi_regs_inst__0962_ spi_regs_inst__1002_/A2 spi_regs_inst__1031_/A1 spi_regs_inst__1167_/A2
+ VDD VDD VSS VSS gf180mcu_fd_sc_mcu7t5v0__nor2_1
XFILLER_36_116 VDD VDD VSS VSS gf180mcu_fd_sc_mcu7t5v0__fillcap_8
XTAP_TAPCELL_ROW_164_2582 VDD VSS gf180mcu_fd_sc_mcu7t5v0__filltie
XFILLER_64_447 VDD VDD VSS VSS gf180mcu_fd_sc_mcu7t5v0__fillcap_8
XFILLER_80_918 VDD VDD VSS VSS gf180mcu_fd_sc_mcu7t5v0__fillcap_8
Xspi_regs_inst__0893_ spi_regs_inst__1624_/Q spi_regs_inst__0891_/I spi_regs_inst__0893_/B
+ spi_regs_inst__1624_/D VDD VDD VSS VSS gf180mcu_fd_sc_mcu7t5v0__aoi21_1
XFILLER_17_352 VDD VDD VSS VSS gf180mcu_fd_sc_mcu7t5v0__fillcap_8
XFILLER_44_193 VDD VDD VSS VSS gf180mcu_fd_sc_mcu7t5v0__fill_2
Xspi_regs_inst__1514_ spi_regs_inst__1514_/D fanout592/Z clkload29/I spi_regs_inst__1514_/Q
+ VDD VDD VSS VSS gf180mcu_fd_sc_mcu7t5v0__dffrnq_1
XFILLER_20_539 VDD VDD VSS VSS gf180mcu_fd_sc_mcu7t5v0__fillcap_16
Xspi_regs_inst__1445_ spi_regs_inst__1514_/Q spi_regs_inst__1445_/I1 spi_regs_inst__1445_/S
+ spi_regs_inst__1514_/D VDD VDD VSS VSS gf180mcu_fd_sc_mcu7t5v0__mux2_2
XFILLER_118_405 VDD VDD VSS VSS gf180mcu_fd_sc_mcu7t5v0__fill_1
XTAP_TAPCELL_ROW_80_1194 VDD VSS gf180mcu_fd_sc_mcu7t5v0__filltie
XFILLER_145_224 VDD VDD VSS VSS gf180mcu_fd_sc_mcu7t5v0__fillcap_8
Xspi_regs_inst__1376_ spi_regs_inst__1376_/A1 spi_regs_inst__1376_/A2 spi_regs_inst__1376_/B
+ spi_regs_inst__1656_/D VDD VDD VSS VSS gf180mcu_fd_sc_mcu7t5v0__oai21_1
XFILLER_133_419 VDD VDD VSS VSS gf180mcu_fd_sc_mcu7t5v0__fill_1
XFILLER_145_279 VDD VDD VSS VSS gf180mcu_fd_sc_mcu7t5v0__fill_1
Xwave_controller_x_inst__2990_ wave_controller_x_inst__3265_/A1 fanout535/Z wave_controller_x_inst__2990_/Z
+ VDD VDD VSS VSS gf180mcu_fd_sc_mcu7t5v0__xor2_1
Xwave_controller_x_inst__1941_ wave_controller_x_inst__1941_/A1 wave_controller_x_inst__1941_/A2
+ wave_controller_x_inst__1941_/B wave_controller_x_inst__1942_/B VDD VDD VSS VSS
+ gf180mcu_fd_sc_mcu7t5v0__oai21_1
XFILLER_101_327 VDD VDD VSS VSS gf180mcu_fd_sc_mcu7t5v0__fillcap_16
XFILLER_101_349 VDD VDD VSS VSS gf180mcu_fd_sc_mcu7t5v0__fill_1
Xwave_controller_x_inst__1872_ spi_regs_inst__1212_/B2 wave_controller_x_inst__3506_/B2
+ VDD VDD VSS VSS gf180mcu_fd_sc_mcu7t5v0__clkinv_1
XFILLER_132_1087 VDD VDD VSS VSS gf180mcu_fd_sc_mcu7t5v0__fillcap_64
XTAP_TAPCELL_ROW_87_1315 VDD VSS gf180mcu_fd_sc_mcu7t5v0__filltie
Xwave_controller_x_inst__3611_ wave_controller_x_inst__3611_/D fanout597/Z clkbuf_leaf_20_clk/Z
+ wave_controller_x_inst__3611_/Q VDD VDD VSS VSS gf180mcu_fd_sc_mcu7t5v0__dffsnq_1
Xsignal_processor_y_inst__188_ fanout393/Z signal_processor_y_inst__239_/Q signal_processor_y_inst__240_/Q
+ signal_processor_y_inst__129_/Z signal_processor_y_inst__189_/B1 VDD VDD VSS VSS
+ gf180mcu_fd_sc_mcu7t5v0__nand4_1
XFILLER_55_458 VDD VDD VSS VSS gf180mcu_fd_sc_mcu7t5v0__fill_1
Xwave_controller_x_inst__3542_ wave_controller_x_inst__3542_/A1 wave_controller_x_inst__3542_/A2
+ wave_controller_x_inst__3542_/A3 wave_controller_x_inst__3545_/B1 wave_controller_x_inst__3542_/B2
+ wave_controller_x_inst__3643_/D VDD VDD VSS VSS gf180mcu_fd_sc_mcu7t5v0__oai32_1
XFILLER_83_789 VDD VDD VSS VSS gf180mcu_fd_sc_mcu7t5v0__fill_1
XTAP_TAPCELL_ROW_66_965 VDD VSS gf180mcu_fd_sc_mcu7t5v0__filltie
Xwave_controller_y_inst__2440_ spi_regs_inst__1254_/A1 spi_regs_inst__1234_/A1 wave_controller_y_inst__2440_/A3
+ wave_controller_y_inst__2445_/A3 VDD VDD VSS VSS gf180mcu_fd_sc_mcu7t5v0__xnor3_1
Xwave_controller_x_inst__3473_ wave_controller_x_inst__3698_/Q wave_controller_x_inst__3483_/A2
+ wave_controller_x_inst__3475_/A2 VDD VDD VSS VSS gf180mcu_fd_sc_mcu7t5v0__nor2_1
Xwave_controller_x_inst__2424_ wave_controller_x_inst__2430_/A1 wave_controller_x_inst__2417_/Z
+ wave_controller_x_inst__2431_/A1 VDD VDD VSS VSS gf180mcu_fd_sc_mcu7t5v0__nor2_1
XFILLER_50_185 VDD VDD VSS VSS gf180mcu_fd_sc_mcu7t5v0__fill_2
Xwave_controller_y_inst__2371_ wave_controller_y_inst__2369_/Z wave_controller_y_inst__2372_/A2
+ wave_controller_y_inst__2391_/B VDD VDD VSS VSS gf180mcu_fd_sc_mcu7t5v0__nand2_1
Xwave_controller_x_inst__2355_ fanout537/Z wave_controller_x_inst__2356_/A3 wave_controller_x_inst__2355_/Z
+ VDD VDD VSS VSS gf180mcu_fd_sc_mcu7t5v0__and2_1
XFILLER_136_8 VDD VDD VSS VSS gf180mcu_fd_sc_mcu7t5v0__fill_1
XFILLER_137_714 VDD VDD VSS VSS gf180mcu_fd_sc_mcu7t5v0__fill_2
XFILLER_51_38 VDD VDD VSS VSS gf180mcu_fd_sc_mcu7t5v0__fillcap_8
Xwave_controller_x_inst__2286_ wave_controller_x_inst__2786_/A1 wave_controller_x_inst__2286_/A2
+ wave_controller_x_inst__2286_/Z VDD VDD VSS VSS gf180mcu_fd_sc_mcu7t5v0__and2_1
XFILLER_136_213 VDD VDD VSS VSS gf180mcu_fd_sc_mcu7t5v0__fillcap_4
XFILLER_149_585 VDD VDD VSS VSS gf180mcu_fd_sc_mcu7t5v0__fillcap_4
XFILLER_167_49 VDD VDD VSS VSS gf180mcu_fd_sc_mcu7t5v0__fillcap_16
XFILLER_125_909 VDD VDD VSS VSS gf180mcu_fd_sc_mcu7t5v0__fill_1
XFILLER_137_769 VDD VDD VSS VSS gf180mcu_fd_sc_mcu7t5v0__fill_1
XTAP_TAPCELL_ROW_98_1488 VDD VSS gf180mcu_fd_sc_mcu7t5v0__filltie
XFILLER_124_419 VDD VDD VSS VSS gf180mcu_fd_sc_mcu7t5v0__fill_1
XFILLER_136_268 VDD VDD VSS VSS gf180mcu_fd_sc_mcu7t5v0__fill_2
XFILLER_145_780 VDD VDD VSS VSS gf180mcu_fd_sc_mcu7t5v0__fill_1
XTAP_TAPCELL_ROW_131_2036 VDD VSS gf180mcu_fd_sc_mcu7t5v0__filltie
XTAP_TAPCELL_ROW_98_1499 VDD VSS gf180mcu_fd_sc_mcu7t5v0__filltie
XFILLER_116_20 VDD VDD VSS VSS gf180mcu_fd_sc_mcu7t5v0__fill_1
XFILLER_132_452 VDD VDD VSS VSS gf180mcu_fd_sc_mcu7t5v0__fill_2
XFILLER_78_506 VDD VDD VSS VSS gf180mcu_fd_sc_mcu7t5v0__fill_2
Xfanout530 fanout530/I fanout530/Z VDD VDD VSS VSS gf180mcu_fd_sc_mcu7t5v0__dlyb_1
XFILLER_101_850 VDD VDD VSS VSS gf180mcu_fd_sc_mcu7t5v0__fillcap_4
XFILLER_59_753 VDD VDD VSS VSS gf180mcu_fd_sc_mcu7t5v0__fillcap_4
Xfanout563 fanout569/Z fanout563/Z VDD VDD VSS VSS gf180mcu_fd_sc_mcu7t5v0__dlyb_1
XFILLER_100_371 VDD VDD VSS VSS gf180mcu_fd_sc_mcu7t5v0__fillcap_8
XFILLER_101_872 VDD VDD VSS VSS gf180mcu_fd_sc_mcu7t5v0__fillcap_4
XFILLER_111_1116 VDD VDD VSS VSS gf180mcu_fd_sc_mcu7t5v0__fillcap_4
XFILLER_74_701 VDD VDD VSS VSS gf180mcu_fd_sc_mcu7t5v0__fillcap_8
Xfanout596 fanout597/Z fanout596/Z VDD VDD VSS VSS gf180mcu_fd_sc_mcu7t5v0__dlyb_1
Xfanout585 fanout590/Z fanout585/Z VDD VDD VSS VSS gf180mcu_fd_sc_mcu7t5v0__dlyb_1
XFILLER_100_393 VDD VDD VSS VSS gf180mcu_fd_sc_mcu7t5v0__fill_1
XFILLER_92_12 VDD VDD VSS VSS gf180mcu_fd_sc_mcu7t5v0__fill_2
XTAP_TAPCELL_ROW_146_2290 VDD VSS gf180mcu_fd_sc_mcu7t5v0__filltie
XFILLER_61_406 VDD VDD VSS VSS gf180mcu_fd_sc_mcu7t5v0__fill_2
XFILLER_73_277 VDD VDD VSS VSS gf180mcu_fd_sc_mcu7t5v0__fill_2
Xwave_controller_y_inst__2707_ wave_controller_y_inst__2704_/Z wave_controller_y_inst__2707_/A2
+ wave_controller_y_inst__2737_/A1 VDD VDD VSS VSS gf180mcu_fd_sc_mcu7t5v0__xnor2_1
Xwave_controller_y_inst__3687_ wave_controller_y_inst__3687_/D wave_controller_y_inst__3689_/RN
+ clkload9/I spi_regs_inst__1099_/A1 VDD VDD VSS VSS gf180mcu_fd_sc_mcu7t5v0__dffrnq_1
XFILLER_54_480 VDD VDD VSS VSS gf180mcu_fd_sc_mcu7t5v0__fill_2
Xwave_controller_y_inst__2638_ wave_controller_y_inst__2636_/Z wave_controller_y_inst__2640_/A3
+ wave_controller_y_inst__2638_/Z VDD VDD VSS VSS gf180mcu_fd_sc_mcu7t5v0__xor2_1
XFILLER_14_355 VDD VDD VSS VSS gf180mcu_fd_sc_mcu7t5v0__fill_1
XFILLER_14_366 VDD VDD VSS VSS gf180mcu_fd_sc_mcu7t5v0__fillcap_16
XFILLER_159_349 VDD VDD VSS VSS gf180mcu_fd_sc_mcu7t5v0__fill_1
Xwave_controller_y_inst__2569_ wave_controller_y_inst__2952_/A2 wave_controller_y_inst__2569_/A2
+ wave_controller_y_inst__2591_/A1 VDD VDD VSS VSS gf180mcu_fd_sc_mcu7t5v0__nand2_1
XFILLER_155_522 VDD VDD VSS VSS gf180mcu_fd_sc_mcu7t5v0__fillcap_8
XFILLER_6_510 VDD VDD VSS VSS gf180mcu_fd_sc_mcu7t5v0__fill_2
Xspi_regs_inst__1230_ fanout536/Z spi_regs_inst_wire249/Z spi_regs_inst_wire247/Z
+ spi_regs_inst__1230_/B2 spi_regs_inst__1233_/A2 VDD VDD VSS VSS gf180mcu_fd_sc_mcu7t5v0__aoi22_1
XFILLER_6_554 VDD VDD VSS VSS gf180mcu_fd_sc_mcu7t5v0__fill_1
XTAP_TAPCELL_ROW_52_1_720 VDD VSS gf180mcu_fd_sc_mcu7t5v0__filltie
Xspi_regs_inst__1161_ spi_regs_inst__1161_/A1 spi_regs_inst__1161_/A2 spi_regs_inst__1161_/A3
+ spi_regs_inst__1171_/A2 VDD VDD VSS VSS gf180mcu_fd_sc_mcu7t5v0__nand3_1
XFILLER_127_279 VDD VDD VSS VSS gf180mcu_fd_sc_mcu7t5v0__fill_1
XFILLER_143_739 VDD VDD VSS VSS gf180mcu_fd_sc_mcu7t5v0__fill_1
XFILLER_51_8 VDD VDD VSS VSS gf180mcu_fd_sc_mcu7t5v0__fill_1
XFILLER_124_942 VDD VDD VSS VSS gf180mcu_fd_sc_mcu7t5v0__fill_2
XPHY_EDGE_ROW_27_1_Left_194 VDD VSS gf180mcu_fd_sc_mcu7t5v0__endcap
Xspi_regs_inst__1092_ spi_regs_inst__1092_/A1 spi_regs_inst__1176_/A2 spi_regs_inst__1315_/B1
+ spi_regs_inst__1521_/Q spi_regs_inst__1122_/A2 VDD VDD VSS VSS gf180mcu_fd_sc_mcu7t5v0__aoi22_1
XFILLER_111_603 VDD VDD VSS VSS gf180mcu_fd_sc_mcu7t5v0__fill_2
XFILLER_123_452 VDD VDD VSS VSS gf180mcu_fd_sc_mcu7t5v0__fill_1
XFILLER_151_772 VDD VDD VSS VSS gf180mcu_fd_sc_mcu7t5v0__fillcap_4
XFILLER_96_303 VDD VDD VSS VSS gf180mcu_fd_sc_mcu7t5v0__fillcap_4
XFILLER_97_815 VDD VDD VSS VSS gf180mcu_fd_sc_mcu7t5v0__fillcap_8
XTAP_TAPCELL_ROW_166_2611 VDD VSS gf180mcu_fd_sc_mcu7t5v0__filltie
XFILLER_97_837 VDD VDD VSS VSS gf180mcu_fd_sc_mcu7t5v0__fill_2
XFILLER_97_848 VDD VDD VSS VSS gf180mcu_fd_sc_mcu7t5v0__fill_1
XTAP_TAPCELL_ROW_166_2622 VDD VSS gf180mcu_fd_sc_mcu7t5v0__filltie
Xsignal_processor_y_inst__111_ signal_processor_y_inst__240_/Q signal_processor_y_inst__183_/A1
+ VDD VDD VSS VSS gf180mcu_fd_sc_mcu7t5v0__clkinv_1
XFILLER_77_550 VDD VDD VSS VSS gf180mcu_fd_sc_mcu7t5v0__fill_1
XTAP_TAPCELL_ROW_69_1012 VDD VSS gf180mcu_fd_sc_mcu7t5v0__filltie
XFILLER_65_745 VDD VDD VSS VSS gf180mcu_fd_sc_mcu7t5v0__fillcap_16
XTAP_TAPCELL_ROW_69_1023 VDD VSS gf180mcu_fd_sc_mcu7t5v0__filltie
Xspi_regs_inst__0945_ spi_regs_inst__1032_/A1 spi_regs_inst__0992_/A1 spi_regs_inst_wire299/I
+ VDD VDD VSS VSS gf180mcu_fd_sc_mcu7t5v0__nor2_1
XFILLER_52_417 VDD VDD VSS VSS gf180mcu_fd_sc_mcu7t5v0__fillcap_8
XFILLER_92_564 VDD VDD VSS VSS gf180mcu_fd_sc_mcu7t5v0__fill_1
XTAP_TAPCELL_ROW_63_913 VDD VSS gf180mcu_fd_sc_mcu7t5v0__filltie
Xspi_regs_inst__0876_ spi_regs_inst__1611_/Q spi_regs_inst__1391_/I1 spi_regs_inst__0877_/S
+ spi_regs_inst__1611_/D VDD VDD VSS VSS gf180mcu_fd_sc_mcu7t5v0__mux2_2
XFILLER_80_737 VDD VDD VSS VSS gf180mcu_fd_sc_mcu7t5v0__fillcap_16
XFILLER_80_759 VDD VDD VSS VSS gf180mcu_fd_sc_mcu7t5v0__fill_1
XFILLER_92_597 VDD VDD VSS VSS gf180mcu_fd_sc_mcu7t5v0__fillcap_4
XTAP_TAPCELL_ROW_63_924 VDD VSS gf180mcu_fd_sc_mcu7t5v0__filltie
XTAP_TAPCELL_ROW_82_1223 VDD VSS gf180mcu_fd_sc_mcu7t5v0__filltie
XFILLER_166_1161 VDD VDD VSS VSS gf180mcu_fd_sc_mcu7t5v0__fill_1
XFILLER_17_193 VDD VDD VSS VSS gf180mcu_fd_sc_mcu7t5v0__fill_2
XTAP_TAPCELL_ROW_82_1234 VDD VSS gf180mcu_fd_sc_mcu7t5v0__filltie
XFILLER_20_314 VDD VDD VSS VSS gf180mcu_fd_sc_mcu7t5v0__fill_1
XFILLER_32_152 VDD VDD VSS VSS gf180mcu_fd_sc_mcu7t5v0__fillcap_8
XFILLER_119_714 VDD VDD VSS VSS gf180mcu_fd_sc_mcu7t5v0__fillcap_8
XFILLER_20_325 VDD VDD VSS VSS gf180mcu_fd_sc_mcu7t5v0__fillcap_8
Xwave_controller_x_inst__2140_ wave_controller_x_inst__2153_/A2 wave_controller_x_inst__2139_/Z
+ wave_controller_x_inst__2143_/A3 VDD VDD VSS VSS gf180mcu_fd_sc_mcu7t5v0__nand2_1
Xspi_regs_inst__1428_ spi_regs_inst__1437_/A1 spi_regs_inst__1428_/A2 spi_regs_inst__1437_/A3
+ spi_regs_inst__1435_/S VDD VDD VSS VSS gf180mcu_fd_sc_mcu7t5v0__nor3_2
XFILLER_119_769 VDD VDD VSS VSS gf180mcu_fd_sc_mcu7t5v0__fill_1
Xwave_controller_x_inst__2071_ wave_controller_x_inst__2071_/A1 wave_controller_x_inst__2035_/Z
+ wave_controller_x_inst__2073_/A2 wave_controller_x_inst__2072_/A2 VDD VDD VSS VSS
+ gf180mcu_fd_sc_mcu7t5v0__nand3_1
Xspi_regs_inst__1359_ spi_regs_inst__1359_/A1 spi_regs_inst__1359_/A2 spi_regs_inst__1359_/A3
+ spi_regs_inst__1359_/A4 spi_regs_inst__1360_/A4 VDD VDD VSS VSS gf180mcu_fd_sc_mcu7t5v0__nor4_1
XFILLER_118_279 VDD VDD VSS VSS gf180mcu_fd_sc_mcu7t5v0__fill_2
XFILLER_133_216 VDD VDD VSS VSS gf180mcu_fd_sc_mcu7t5v0__fill_1
XFILLER_134_717 VDD VDD VSS VSS gf180mcu_fd_sc_mcu7t5v0__fill_1
XFILLER_86_1151 VDD VDD VSS VSS gf180mcu_fd_sc_mcu7t5v0__fillcap_4
XFILLER_114_441 VDD VDD VSS VSS gf180mcu_fd_sc_mcu7t5v0__fillcap_8
XFILLER_86_1173 VDD VDD VSS VSS gf180mcu_fd_sc_mcu7t5v0__fill_1
XTAP_TAPCELL_ROW_12_1_423 VDD VSS gf180mcu_fd_sc_mcu7t5v0__filltie
XFILLER_130_934 VDD VDD VSS VSS gf180mcu_fd_sc_mcu7t5v0__fillcap_8
XFILLER_141_282 VDD VDD VSS VSS gf180mcu_fd_sc_mcu7t5v0__fill_2
XFILLER_88_837 VDD VDD VSS VSS gf180mcu_fd_sc_mcu7t5v0__fill_2
Xwave_controller_y_inst__1940_ wave_controller_y_inst__1940_/A1 wave_controller_y_inst__1781_/I
+ wave_controller_y_inst__1940_/B wave_controller_y_inst__1941_/B VDD VDD VSS VSS
+ gf180mcu_fd_sc_mcu7t5v0__oai21_1
Xwave_controller_x_inst__2973_ wave_controller_x_inst__2951_/I wave_controller_x_inst__3055_/A2
+ wave_controller_x_inst__3055_/B wave_controller_x_inst__3056_/A2 VDD VDD VSS VSS
+ gf180mcu_fd_sc_mcu7t5v0__nand3_1
XTAP_TAPCELL_ROW_20_1_480 VDD VSS gf180mcu_fd_sc_mcu7t5v0__filltie
Xwave_controller_x_inst__1924_ spi_regs_inst__1505_/Q wave_controller_x_inst__3570_/A1
+ spi_regs_inst__1504_/Q wave_controller_x_inst__3568_/A1 wave_controller_x_inst__1924_/C
+ wave_controller_x_inst__1926_/A1 VDD VDD VSS VSS gf180mcu_fd_sc_mcu7t5v0__aoi221_1
XFILLER_28_414 VDD VDD VSS VSS gf180mcu_fd_sc_mcu7t5v0__fillcap_8
XFILLER_56_701 VDD VDD VSS VSS gf180mcu_fd_sc_mcu7t5v0__fill_1
Xwave_controller_y_inst__1871_ spi_regs_inst__1063_/B2 wave_controller_y_inst__3497_/A1
+ VDD VDD VSS VSS gf180mcu_fd_sc_mcu7t5v0__clkinv_1
Xwave_controller_x_inst__1855_ max_cap458/Z wave_controller_x_inst__2229_/A1 VDD VDD
+ VSS VSS gf180mcu_fd_sc_mcu7t5v0__clkinv_1
XFILLER_28_447 VDD VDD VSS VSS gf180mcu_fd_sc_mcu7t5v0__fillcap_4
XFILLER_56_734 VDD VDD VSS VSS gf180mcu_fd_sc_mcu7t5v0__fill_1
Xwave_controller_y_inst__3610_ wave_controller_y_inst__2929_/S wave_controller_y_inst__3610_/A2
+ wave_controller_y_inst__3610_/B wave_controller_y_inst__3681_/D VDD VDD VSS VSS
+ gf180mcu_fd_sc_mcu7t5v0__oai21_1
XFILLER_55_277 VDD VDD VSS VSS gf180mcu_fd_sc_mcu7t5v0__fill_2
Xwave_controller_y_inst__3541_ max_cap431/I wave_controller_y_inst__3556_/A2 wave_controller_y_inst__3542_/A3
+ VDD VDD VSS VSS gf180mcu_fd_sc_mcu7t5v0__nor2_1
Xwave_controller_x_inst__1786_ wave_controller_x_inst__3713_/Q wave_controller_x_inst__3266_/A1
+ VDD VDD VSS VSS gf180mcu_fd_sc_mcu7t5v0__clkinv_1
XFILLER_93_1122 VDD VDD VSS VSS gf180mcu_fd_sc_mcu7t5v0__fillcap_32
Xwave_controller_x_inst__3525_ wave_controller_x_inst__3711_/Q wave_controller_x_inst__3555_/A2
+ wave_controller_x_inst__3527_/A2 VDD VDD VSS VSS gf180mcu_fd_sc_mcu7t5v0__nor2_1
XFILLER_36_491 VDD VDD VSS VSS gf180mcu_fd_sc_mcu7t5v0__fill_2
XFILLER_62_37 VDD VDD VSS VSS gf180mcu_fd_sc_mcu7t5v0__fillcap_16
XFILLER_70_247 VDD VDD VSS VSS gf180mcu_fd_sc_mcu7t5v0__fill_2
Xwave_controller_y_inst__3472_ wave_controller_y_inst__3472_/A1 wave_controller_y_inst__3524_/B1
+ wave_controller_y_inst__3472_/B1 wave_controller_y_inst__3472_/B2 wave_controller_y_inst__3625_/D
+ VDD VDD VSS VSS gf180mcu_fd_sc_mcu7t5v0__oai22_1
Xwave_controller_x_inst__3456_ wave_controller_x_inst__3696_/Q wave_controller_x_inst__3487_/A2
+ wave_controller_x_inst__3456_/B wave_controller_x_inst__3461_/A2 VDD VDD VSS VSS
+ gf180mcu_fd_sc_mcu7t5v0__oai21_1
Xsignal_processor_x_inst__200_ signal_processor_x_inst__202_/A1 signal_processor_x_inst__200_/A2
+ signal_processor_x_inst__200_/A3 signal_processor_x_inst__218_/D VDD VDD VSS VSS
+ gf180mcu_fd_sc_mcu7t5v0__nor3_1
Xwave_controller_y_inst__2423_ wave_controller_y_inst__2433_/A2 wave_controller_y_inst__2423_/A2
+ spi_regs_inst__1111_/A1 VDD VDD VSS VSS gf180mcu_fd_sc_mcu7t5v0__xor2_1
Xwave_controller_x_inst__2407_ wave_controller_x_inst__2407_/A1 wave_controller_x_inst__2407_/A2
+ wave_controller_x_inst__2407_/B wave_controller_x_inst__2434_/B VDD VDD VSS VSS
+ gf180mcu_fd_sc_mcu7t5v0__aoi21_1
Xsignal_processor_x_inst__131_ signal_processor_x_inst__240_/Q signal_processor_x_inst__241_/Q
+ signal_processor_x_inst__242_/Q signal_processor_x_inst__132_/A3 VDD VDD VSS VSS
+ gf180mcu_fd_sc_mcu7t5v0__nand3_1
Xwave_controller_y_inst__2354_ fanout516/Z wave_controller_y_inst__2356_/A3 wave_controller_y_inst__2370_/B
+ VDD VDD VSS VSS gf180mcu_fd_sc_mcu7t5v0__or2_1
Xwave_controller_x_inst__3387_ wave_controller_x_inst__3387_/A1 wave_controller_x_inst__3365_/Z
+ wave_controller_x_inst__3388_/B VDD VDD VSS VSS gf180mcu_fd_sc_mcu7t5v0__nor2_1
Xwave_controller_x_inst__2338_ max_cap453/Z wave_controller_x_inst__2336_/Z wave_controller_x_inst__2338_/Z
+ VDD VDD VSS VSS gf180mcu_fd_sc_mcu7t5v0__xor2_1
XFILLER_165_842 VDD VDD VSS VSS gf180mcu_fd_sc_mcu7t5v0__fillcap_64
Xwave_controller_y_inst__2285_ wave_controller_y_inst__2254_/Z wave_controller_y_inst__2286_/A2
+ wave_controller_y_inst__2320_/A2 VDD VDD VSS VSS gf180mcu_fd_sc_mcu7t5v0__nand2_1
Xwave_controller_x_inst__2269_ wave_controller_x_inst__2270_/A2 wave_controller_x_inst__2268_/Z
+ spi_regs_inst__1334_/B2 VDD VDD VSS VSS gf180mcu_fd_sc_mcu7t5v0__and2_1
XFILLER_125_739 VDD VDD VSS VSS gf180mcu_fd_sc_mcu7t5v0__fillcap_16
XFILLER_118_780 VDD VDD VSS VSS gf180mcu_fd_sc_mcu7t5v0__fill_1
XFILLER_117_290 VDD VDD VSS VSS gf180mcu_fd_sc_mcu7t5v0__fillcap_8
XFILLER_121_912 VDD VDD VSS VSS gf180mcu_fd_sc_mcu7t5v0__fillcap_64
XTAP_TAPCELL_ROW_111_1706 VDD VSS gf180mcu_fd_sc_mcu7t5v0__filltie
Xwave_controller_y_inst_fanout421 wave_controller_y_inst__3710_/Q wave_controller_y_inst__1790_/I
+ VDD VDD VSS VSS gf180mcu_fd_sc_mcu7t5v0__dlyb_1
XFILLER_105_474 VDD VDD VSS VSS gf180mcu_fd_sc_mcu7t5v0__fill_1
XFILLER_133_794 VDD VDD VSS VSS gf180mcu_fd_sc_mcu7t5v0__fillcap_4
XFILLER_160_580 VDD VDD VSS VSS gf180mcu_fd_sc_mcu7t5v0__fillcap_8
XFILLER_78_325 VDD VDD VSS VSS gf180mcu_fd_sc_mcu7t5v0__fill_2
XFILLER_87_67 VDD VDD VSS VSS gf180mcu_fd_sc_mcu7t5v0__fill_2
XFILLER_59_550 VDD VDD VSS VSS gf180mcu_fd_sc_mcu7t5v0__fill_2
XFILLER_78_369 VDD VDD VSS VSS gf180mcu_fd_sc_mcu7t5v0__fill_1
XFILLER_94_807 VDD VDD VSS VSS gf180mcu_fd_sc_mcu7t5v0__fillcap_16
XFILLER_120_477 VDD VDD VSS VSS gf180mcu_fd_sc_mcu7t5v0__fillcap_4
XFILLER_19_414 VDD VDD VSS VSS gf180mcu_fd_sc_mcu7t5v0__fillcap_4
XFILLER_93_328 VDD VDD VSS VSS gf180mcu_fd_sc_mcu7t5v0__fillcap_8
XFILLER_94_829 VDD VDD VSS VSS gf180mcu_fd_sc_mcu7t5v0__fill_1
Xfanout393 fanout402/I fanout393/Z VDD VDD VSS VSS gf180mcu_fd_sc_mcu7t5v0__dlyb_1
XFILLER_59_594 VDD VDD VSS VSS gf180mcu_fd_sc_mcu7t5v0__fillcap_8
XFILLER_74_520 VDD VDD VSS VSS gf180mcu_fd_sc_mcu7t5v0__fillcap_4
XFILLER_98_1011 VDD VDD VSS VSS gf180mcu_fd_sc_mcu7t5v0__fillcap_4
XTAP_TAPCELL_ROW_144_2249 VDD VSS gf180mcu_fd_sc_mcu7t5v0__filltie
XTAP_TAPCELL_ROW_161_2530 VDD VSS gf180mcu_fd_sc_mcu7t5v0__filltie
XTAP_TAPCELL_ROW_161_2541 VDD VSS gf180mcu_fd_sc_mcu7t5v0__filltie
XFILLER_46_244 VDD VDD VSS VSS gf180mcu_fd_sc_mcu7t5v0__fill_1
XFILLER_46_255 VDD VDD VSS VSS gf180mcu_fd_sc_mcu7t5v0__fillcap_4
XFILLER_62_715 VDD VDD VSS VSS gf180mcu_fd_sc_mcu7t5v0__fillcap_4
XTAP_TAPCELL_ROW_109_1668 VDD VSS gf180mcu_fd_sc_mcu7t5v0__filltie
XTAP_TAPCELL_ROW_109_1679 VDD VSS gf180mcu_fd_sc_mcu7t5v0__filltie
Xwave_controller_y_inst_max_cap360 wave_controller_y_inst__2033_/Z wave_controller_y_inst__2073_/A1
+ VDD VDD VSS VSS gf180mcu_fd_sc_mcu7t5v0__buf_2
Xspi_regs_inst__0730_ spi_regs_inst__1454_/Q spi_regs_inst__0827_/A3 VDD VDD VSS VSS
+ gf180mcu_fd_sc_mcu7t5v0__clkinv_1
XFILLER_62_737 VDD VDD VSS VSS gf180mcu_fd_sc_mcu7t5v0__fillcap_16
XFILLER_74_597 VDD VDD VSS VSS gf180mcu_fd_sc_mcu7t5v0__fillcap_16
XTAP_TAPCELL_ROW_126_1960 VDD VSS gf180mcu_fd_sc_mcu7t5v0__filltie
Xwave_controller_y_inst__3739_ wave_controller_y_inst__3739_/D wave_controller_y_inst__3739_/RN
+ clkload4/I wave_controller_y_inst__3739_/Q VDD VDD VSS VSS gf180mcu_fd_sc_mcu7t5v0__dffrnq_1
Xspi_regs_inst_max_cap220 spi_regs_inst__1141_/B1 spi_regs_inst__1257_/B1 VDD VDD
+ VSS VSS gf180mcu_fd_sc_mcu7t5v0__buf_2
XFILLER_61_236 VDD VDD VSS VSS gf180mcu_fd_sc_mcu7t5v0__fill_2
Xspi_regs_inst_max_cap264 spi_regs_inst_wire263/I spi_regs_inst__1290_/A2 VDD VDD
+ VSS VSS gf180mcu_fd_sc_mcu7t5v0__buf_2
Xspi_regs_inst_max_cap253 spi_regs_inst_wire252/I spi_regs_inst__1316_/B1 VDD VDD
+ VSS VSS gf180mcu_fd_sc_mcu7t5v0__buf_2
Xspi_regs_inst_max_cap275 spi_regs_inst__1135_/A2 spi_regs_inst__1207_/A2 VDD VDD
+ VSS VSS gf180mcu_fd_sc_mcu7t5v0__buf_2
XFILLER_42_483 VDD VDD VSS VSS gf180mcu_fd_sc_mcu7t5v0__fillcap_8
XFILLER_128_522 VDD VDD VSS VSS gf180mcu_fd_sc_mcu7t5v0__fill_2
XFILLER_52_81 VDD VDD VSS VSS gf180mcu_fd_sc_mcu7t5v0__fill_1
XFILLER_52_92 VDD VDD VSS VSS gf180mcu_fd_sc_mcu7t5v0__fill_1
Xspi_regs_inst__1213_ spi_regs_inst__1213_/A1 spi_regs_inst__1334_/B1 spi_regs_inst_wire218/Z
+ spi_regs_inst__1213_/B2 spi_regs_inst__1214_/A4 VDD VDD VSS VSS gf180mcu_fd_sc_mcu7t5v0__aoi22_1
XFILLER_155_352 VDD VDD VSS VSS gf180mcu_fd_sc_mcu7t5v0__fill_2
XFILLER_115_227 VDD VDD VSS VSS gf180mcu_fd_sc_mcu7t5v0__fill_2
XFILLER_143_536 VDD VDD VSS VSS gf180mcu_fd_sc_mcu7t5v0__fill_1
XFILLER_143_558 VDD VDD VSS VSS gf180mcu_fd_sc_mcu7t5v0__fill_2
XFILLER_157_1116 VDD VDD VSS VSS gf180mcu_fd_sc_mcu7t5v0__fillcap_4
Xspi_regs_inst__1144_ spi_regs_inst__1144_/A1 spi_regs_inst__1336_/B1 spi_regs_inst__1176_/B1
+ spi_regs_inst__1144_/B2 spi_regs_inst__1147_/A2 VDD VDD VSS VSS gf180mcu_fd_sc_mcu7t5v0__aoi22_1
Xspi_regs_inst__1075_ spi_regs_inst__1623_/Q spi_regs_inst__1075_/A2 spi_regs_inst__1184_/B
+ VDD VDD VSS VSS gf180mcu_fd_sc_mcu7t5v0__nand2_1
XFILLER_111_422 VDD VDD VSS VSS gf180mcu_fd_sc_mcu7t5v0__fillcap_4
XFILLER_124_772 VDD VDD VSS VSS gf180mcu_fd_sc_mcu7t5v0__fill_1
XFILLER_69_314 VDD VDD VSS VSS gf180mcu_fd_sc_mcu7t5v0__fillcap_16
XFILLER_97_612 VDD VDD VSS VSS gf180mcu_fd_sc_mcu7t5v0__fillcap_4
XFILLER_28_2 VDD VDD VSS VSS gf180mcu_fd_sc_mcu7t5v0__fill_2
XFILLER_96_122 VDD VDD VSS VSS gf180mcu_fd_sc_mcu7t5v0__fill_2
XFILLER_78_892 VDD VDD VSS VSS gf180mcu_fd_sc_mcu7t5v0__fillcap_4
XFILLER_84_317 VDD VDD VSS VSS gf180mcu_fd_sc_mcu7t5v0__fillcap_4
XFILLER_96_177 VDD VDD VSS VSS gf180mcu_fd_sc_mcu7t5v0__fillcap_4
XFILLER_65_531 VDD VDD VSS VSS gf180mcu_fd_sc_mcu7t5v0__fillcap_8
XFILLER_96_199 VDD VDD VSS VSS gf180mcu_fd_sc_mcu7t5v0__fill_1
Xspi_regs_inst__0928_ spi_regs_inst__1374_/A1 spi_regs_inst__0928_/A2 spi_regs_inst__0928_/B
+ spi_regs_inst__1634_/Q spi_regs_inst__0932_/A1 VDD VDD VSS VSS gf180mcu_fd_sc_mcu7t5v0__oai211_1
XFILLER_25_428 VDD VDD VSS VSS gf180mcu_fd_sc_mcu7t5v0__fillcap_16
Xwave_controller_y_inst_load_slew554 wave_controller_y_inst__3717_/RN wave_controller_y_inst__3711_/RN
+ VDD VDD VSS VSS gf180mcu_fd_sc_mcu7t5v0__buf_4
XFILLER_52_247 VDD VDD VSS VSS gf180mcu_fd_sc_mcu7t5v0__fillcap_16
XFILLER_80_567 VDD VDD VSS VSS gf180mcu_fd_sc_mcu7t5v0__fill_2
Xwave_controller_x_inst__3310_ wave_controller_x_inst__3310_/A1 wave_controller_x_inst__3310_/A2
+ wave_controller_x_inst__3310_/B wave_controller_x_inst__3310_/C wave_controller_x_inst__3358_/A2
+ VDD VDD VSS VSS gf180mcu_fd_sc_mcu7t5v0__aoi211_1
Xspi_regs_inst__0859_ spi_regs_inst__1596_/Q spi_regs_inst__1410_/I1 spi_regs_inst__0861_/S
+ spi_regs_inst__1596_/D VDD VDD VSS VSS gf180mcu_fd_sc_mcu7t5v0__mux2_2
XFILLER_33_472 VDD VDD VSS VSS gf180mcu_fd_sc_mcu7t5v0__fill_1
XFILLER_80_589 VDD VDD VSS VSS gf180mcu_fd_sc_mcu7t5v0__fillcap_4
Xwave_controller_x_inst__3241_ fanout539/Z wave_controller_x_inst__3242_/B1 wave_controller_x_inst__3241_/B1
+ wave_controller_x_inst__3241_/B2 wave_controller_x_inst__3241_/C wave_controller_x_inst__3243_/A1
+ VDD VDD VSS VSS gf180mcu_fd_sc_mcu7t5v0__aoi221_1
XFILLER_20_111 VDD VDD VSS VSS gf180mcu_fd_sc_mcu7t5v0__fill_1
XFILLER_119_500 VDD VDD VSS VSS gf180mcu_fd_sc_mcu7t5v0__fillcap_16
XFILLER_148_18 VDD VDD VSS VSS gf180mcu_fd_sc_mcu7t5v0__fill_2
Xwave_controller_x_inst__3172_ wave_controller_x_inst__3170_/B wave_controller_x_inst__3171_/Z
+ wave_controller_x_inst__3252_/A1 VDD VDD VSS VSS gf180mcu_fd_sc_mcu7t5v0__nor2_1
XFILLER_147_842 VDD VDD VSS VSS gf180mcu_fd_sc_mcu7t5v0__fillcap_64
XFILLER_20_177 VDD VDD VSS VSS gf180mcu_fd_sc_mcu7t5v0__fill_1
Xwave_controller_x_inst__2123_ wave_controller_x_inst__2123_/A1 wave_controller_x_inst__2123_/A2
+ wave_controller_x_inst__2123_/B wave_controller_x_inst__2136_/A1 VDD VDD VSS VSS
+ gf180mcu_fd_sc_mcu7t5v0__oai21_1
XFILLER_107_706 VDD VDD VSS VSS gf180mcu_fd_sc_mcu7t5v0__fill_2
XFILLER_162_801 VDD VDD VSS VSS gf180mcu_fd_sc_mcu7t5v0__fillcap_4
Xwave_controller_y_inst__2070_ wave_controller_y_inst_wire356/Z wave_controller_y_inst__2069_/Z
+ wave_controller_y_inst__2070_/Z VDD VDD VSS VSS gf180mcu_fd_sc_mcu7t5v0__or2_1
Xwave_controller_x_inst__2054_ wave_controller_x_inst__2035_/Z wave_controller_x_inst__2039_/B
+ wave_controller_x_inst__2128_/A2 VDD VDD VSS VSS gf180mcu_fd_sc_mcu7t5v0__nand2_1
XFILLER_161_322 VDD VDD VSS VSS gf180mcu_fd_sc_mcu7t5v0__fillcap_16
XTAP_TAPCELL_ROW_95_1447 VDD VSS gf180mcu_fd_sc_mcu7t5v0__filltie
XFILLER_103_912 VDD VDD VSS VSS gf180mcu_fd_sc_mcu7t5v0__fillcap_64
XFILLER_142_591 VDD VDD VSS VSS gf180mcu_fd_sc_mcu7t5v0__fillcap_4
XFILLER_76_807 VDD VDD VSS VSS gf180mcu_fd_sc_mcu7t5v0__fillcap_16
XFILLER_87_144 VDD VDD VSS VSS gf180mcu_fd_sc_mcu7t5v0__fill_1
XFILLER_88_667 VDD VDD VSS VSS gf180mcu_fd_sc_mcu7t5v0__fillcap_16
Xwave_controller_y_inst__2972_ wave_controller_y_inst__2972_/A1 wave_controller_y_inst__3053_/A3
+ wave_controller_y_inst__2972_/B wave_controller_y_inst__3055_/B VDD VDD VSS VSS
+ gf180mcu_fd_sc_mcu7t5v0__oai21_1
Xwave_controller_x_inst__2956_ wave_controller_x_inst__2956_/I wave_controller_x_inst__2971_/B
+ VDD VDD VSS VSS gf180mcu_fd_sc_mcu7t5v0__clkinv_1
XFILLER_130_775 VDD VDD VSS VSS gf180mcu_fd_sc_mcu7t5v0__fillcap_16
XFILLER_57_48 VDD VDD VSS VSS gf180mcu_fd_sc_mcu7t5v0__fillcap_16
Xwave_controller_y_inst__1923_ wave_controller_y_inst__1923_/A1 wave_controller_y_inst__1923_/A2
+ wave_controller_y_inst__1923_/B wave_controller_y_inst__1924_/C VDD VDD VSS VSS
+ gf180mcu_fd_sc_mcu7t5v0__aoi21_1
Xwave_controller_x_inst__1907_ spi_regs_inst__1239_/A1 wave_controller_x_inst__3462_/B2
+ VDD VDD VSS VSS gf180mcu_fd_sc_mcu7t5v0__clkinv_1
XFILLER_102_499 VDD VDD VSS VSS gf180mcu_fd_sc_mcu7t5v0__fillcap_8
XFILLER_28_200 VDD VDD VSS VSS gf180mcu_fd_sc_mcu7t5v0__fill_2
Xwave_controller_y_inst__1854_ spi_regs_inst__1218_/A1 wave_controller_y_inst__2516_/A1
+ VDD VDD VSS VSS gf180mcu_fd_sc_mcu7t5v0__clkinv_1
Xwave_controller_x_inst__2887_ wave_controller_x_inst__2887_/A1 wave_controller_x_inst__2887_/A2
+ wave_controller_x_inst__2887_/A3 wave_controller_x_inst__2889_/B VDD VDD VSS VSS
+ gf180mcu_fd_sc_mcu7t5v0__and3_1
XFILLER_56_575 VDD VDD VSS VSS gf180mcu_fd_sc_mcu7t5v0__fillcap_4
Xwave_controller_x_inst__1838_ spi_regs_inst__1320_/B2 wave_controller_x_inst__2226_/A1
+ VDD VDD VSS VSS gf180mcu_fd_sc_mcu7t5v0__clkinv_1
XFILLER_73_36 VDD VDD VSS VSS gf180mcu_fd_sc_mcu7t5v0__fill_1
XFILLER_73_47 VDD VDD VSS VSS gf180mcu_fd_sc_mcu7t5v0__fill_1
Xwave_controller_y_inst__1785_ wave_controller_y_inst__1785_/I wave_controller_y_inst__2915_/A1
+ VDD VDD VSS VSS gf180mcu_fd_sc_mcu7t5v0__inv_1
Xwave_controller_y_inst__3524_ wave_controller_y_inst__3554_/A1 wave_controller_y_inst__3524_/A2
+ wave_controller_y_inst__3524_/A3 wave_controller_y_inst__3524_/B1 wave_controller_y_inst__3524_/B2
+ wave_controller_y_inst__3637_/D VDD VDD VSS VSS gf180mcu_fd_sc_mcu7t5v0__oai32_1
Xwave_controller_x_inst__3508_ spi_regs_inst__1259_/B2 wave_controller_x_inst__3538_/A2
+ wave_controller_x_inst__3509_/A3 VDD VDD VSS VSS gf180mcu_fd_sc_mcu7t5v0__nor2_1
XFILLER_71_589 VDD VDD VSS VSS gf180mcu_fd_sc_mcu7t5v0__fill_1
XTAP_TAPCELL_ROW_54_765 VDD VSS gf180mcu_fd_sc_mcu7t5v0__filltie
XTAP_TAPCELL_ROW_54_776 VDD VSS gf180mcu_fd_sc_mcu7t5v0__filltie
Xwave_controller_y_inst__3455_ wave_controller_y_inst__3462_/B2 wave_controller_y_inst__3493_/A1
+ wave_controller_y_inst__3456_/B VDD VDD VSS VSS gf180mcu_fd_sc_mcu7t5v0__nand2_1
XTAP_TAPCELL_ROW_104_1587 VDD VSS gf180mcu_fd_sc_mcu7t5v0__filltie
XTAP_TAPCELL_ROW_104_1598 VDD VSS gf180mcu_fd_sc_mcu7t5v0__filltie
Xwave_controller_y_inst__2406_ wave_controller_y_inst__2407_/A1 wave_controller_y_inst__2407_/A2
+ wave_controller_y_inst__2408_/A2 VDD VDD VSS VSS gf180mcu_fd_sc_mcu7t5v0__nand2_1
Xwave_controller_x_inst__3439_ wave_controller_x_inst__3439_/I wave_controller_x_inst__3440_/B2
+ VDD VDD VSS VSS gf180mcu_fd_sc_mcu7t5v0__clkinv_1
XFILLER_129_319 VDD VDD VSS VSS gf180mcu_fd_sc_mcu7t5v0__fillcap_4
XFILLER_132_2 VDD VDD VSS VSS gf180mcu_fd_sc_mcu7t5v0__fillcap_32
XFILLER_156_127 VDD VDD VSS VSS gf180mcu_fd_sc_mcu7t5v0__fill_1
XPHY_EDGE_ROW_9_1_Right_8 VDD VSS gf180mcu_fd_sc_mcu7t5v0__endcap
Xwave_controller_y_inst__3386_ fanout502/Z wave_controller_y_inst__3386_/A2 wave_controller_y_inst__3386_/B
+ wave_controller_y_inst__3386_/C wave_controller_y_inst__3390_/B1 VDD VDD VSS VSS
+ gf180mcu_fd_sc_mcu7t5v0__oai211_1
Xsignal_processor_x_inst__114_ spi_regs_inst__1098_/A1 signal_processor_x_inst__203_/B2
+ VDD VDD VSS VSS gf180mcu_fd_sc_mcu7t5v0__clkinv_1
Xwave_controller_y_inst__2337_ max_cap426/Z wave_controller_y_inst__2336_/Z wave_controller_y_inst__2337_/Z
+ VDD VDD VSS VSS gf180mcu_fd_sc_mcu7t5v0__and2_1
XFILLER_137_352 VDD VDD VSS VSS gf180mcu_fd_sc_mcu7t5v0__fillcap_4
XFILLER_152_300 VDD VDD VSS VSS gf180mcu_fd_sc_mcu7t5v0__fillcap_8
Xwave_controller_y_inst__2268_ wave_controller_y_inst__2268_/A1 wave_controller_y_inst__2249_/Z
+ wave_controller_y_inst__2267_/B wave_controller_y_inst__2268_/Z VDD VDD VSS VSS
+ gf180mcu_fd_sc_mcu7t5v0__or3_1
XFILLER_152_333 VDD VDD VSS VSS gf180mcu_fd_sc_mcu7t5v0__fill_2
XFILLER_164_171 VDD VDD VSS VSS gf180mcu_fd_sc_mcu7t5v0__fillcap_4
Xwave_controller_y_inst__2199_ spi_regs_inst__1218_/A1 wave_controller_y_inst__2197_/Z
+ wave_controller_y_inst__2201_/B VDD VDD VSS VSS gf180mcu_fd_sc_mcu7t5v0__xor2_1
XFILLER_117_1122 VDD VDD VSS VSS gf180mcu_fd_sc_mcu7t5v0__fillcap_32
XFILLER_105_282 VDD VDD VSS VSS gf180mcu_fd_sc_mcu7t5v0__fillcap_16
XFILLER_78_144 VDD VDD VSS VSS gf180mcu_fd_sc_mcu7t5v0__fill_1
XFILLER_94_626 VDD VDD VSS VSS gf180mcu_fd_sc_mcu7t5v0__fillcap_8
XFILLER_120_296 VDD VDD VSS VSS gf180mcu_fd_sc_mcu7t5v0__fillcap_4
XFILLER_93_125 VDD VDD VSS VSS gf180mcu_fd_sc_mcu7t5v0__fillcap_8
XFILLER_93_147 VDD VDD VSS VSS gf180mcu_fd_sc_mcu7t5v0__fillcap_4
XFILLER_19_277 VDD VDD VSS VSS gf180mcu_fd_sc_mcu7t5v0__fill_2
XFILLER_62_501 VDD VDD VSS VSS gf180mcu_fd_sc_mcu7t5v0__fill_1
XTAP_TAPCELL_ROW_124_1919 VDD VSS gf180mcu_fd_sc_mcu7t5v0__filltie
XFILLER_34_247 VDD VDD VSS VSS gf180mcu_fd_sc_mcu7t5v0__fillcap_4
XTAP_TAPCELL_ROW_11_1_411 VDD VSS gf180mcu_fd_sc_mcu7t5v0__filltie
XFILLER_15_483 VDD VDD VSS VSS gf180mcu_fd_sc_mcu7t5v0__fillcap_4
XFILLER_147_105 VDD VDD VSS VSS gf180mcu_fd_sc_mcu7t5v0__fill_1
XFILLER_30_453 VDD VDD VSS VSS gf180mcu_fd_sc_mcu7t5v0__fill_2
XTAP_TAPCELL_ROW_77_1144 VDD VSS gf180mcu_fd_sc_mcu7t5v0__filltie
XTAP_TAPCELL_ROW_77_1155 VDD VSS gf180mcu_fd_sc_mcu7t5v0__filltie
Xspi_regs_inst__1127_ spi_regs_inst__1644_/Q spi_regs_inst__1266_/S spi_regs_inst__1174_/B
+ VDD VDD VSS VSS gf180mcu_fd_sc_mcu7t5v0__nand2_1
XFILLER_143_399 VDD VDD VSS VSS gf180mcu_fd_sc_mcu7t5v0__fillcap_8
XFILLER_98_943 VDD VDD VSS VSS gf180mcu_fd_sc_mcu7t5v0__fill_2
XFILLER_112_742 VDD VDD VSS VSS gf180mcu_fd_sc_mcu7t5v0__fillcap_8
XFILLER_83_1154 VDD VDD VSS VSS gf180mcu_fd_sc_mcu7t5v0__fillcap_16
XTAP_TAPCELL_ROW_90_1355 VDD VSS gf180mcu_fd_sc_mcu7t5v0__filltie
XTAP_TAPCELL_ROW_90_1366 VDD VSS gf180mcu_fd_sc_mcu7t5v0__filltie
Xwave_controller_x_inst__2810_ wave_controller_x_inst__2810_/A1 wave_controller_x_inst__2810_/A2
+ wave_controller_x_inst__2810_/B wave_controller_x_inst__2810_/C wave_controller_x_inst__2812_/B1
+ VDD VDD VSS VSS gf180mcu_fd_sc_mcu7t5v0__oai211_1
Xspi_regs_inst__1058_ spi_regs_inst__1541_/Q spi_regs_inst_wire252/Z spi_regs_inst__1146_/A2
+ spi_regs_inst__1058_/B2 spi_regs_inst__1062_/A1 VDD VDD VSS VSS gf180mcu_fd_sc_mcu7t5v0__aoi22_1
XFILLER_57_306 VDD VDD VSS VSS gf180mcu_fd_sc_mcu7t5v0__fillcap_4
Xwave_controller_x_inst__2741_ spi_regs_inst__1185_/B2 wave_controller_x_inst__3554_/B2
+ wave_controller_x_inst_wire95/Z wave_controller_x_inst__2742_/B VDD VDD VSS VSS
+ gf180mcu_fd_sc_mcu7t5v0__aoi21_1
Xwave_controller_x_inst__2672_ fanout536/Z wave_controller_x_inst__2668_/Z wave_controller_x_inst__2672_/A3
+ wave_controller_x_inst__2672_/Z VDD VDD VSS VSS gf180mcu_fd_sc_mcu7t5v0__xor3_1
XFILLER_53_512 VDD VDD VSS VSS gf180mcu_fd_sc_mcu7t5v0__fillcap_8
XFILLER_53_534 VDD VDD VSS VSS gf180mcu_fd_sc_mcu7t5v0__fill_2
XFILLER_65_394 VDD VDD VSS VSS gf180mcu_fd_sc_mcu7t5v0__fillcap_4
XFILLER_81_876 VDD VDD VSS VSS gf180mcu_fd_sc_mcu7t5v0__fill_1
XFILLER_25_269 VDD VDD VSS VSS gf180mcu_fd_sc_mcu7t5v0__fillcap_8
Xwave_controller_y_inst_load_slew395 wave_controller_y_inst__1829_/I wave_controller_y_inst__3408_/A1
+ VDD VDD VSS VSS gf180mcu_fd_sc_mcu7t5v0__buf_4
XFILLER_139_606 VDD VDD VSS VSS gf180mcu_fd_sc_mcu7t5v0__fill_1
XFILLER_167_904 VDD VDD VSS VSS gf180mcu_fd_sc_mcu7t5v0__fill_1
Xwave_controller_y_inst__3240_ wave_controller_y_inst__3240_/A1 wave_controller_y_inst__3240_/A2
+ wave_controller_y_inst__3240_/A3 wave_controller_y_inst__3240_/B wave_controller_y_inst__3241_/B2
+ VDD VDD VSS VSS gf180mcu_fd_sc_mcu7t5v0__oai31_1
XFILLER_139_628 VDD VDD VSS VSS gf180mcu_fd_sc_mcu7t5v0__fill_2
Xwave_controller_x_inst__3224_ wave_controller_x_inst__3224_/A1 wave_controller_x_inst__3224_/A2
+ wave_controller_x_inst__3142_/B wave_controller_x_inst__3225_/A2 VDD VDD VSS VSS
+ gf180mcu_fd_sc_mcu7t5v0__nor3_1
Xwave_controller_y_inst__3171_ wave_controller_y_inst__1781_/I spi_regs_inst__1598_/Q
+ wave_controller_y_inst__3171_/Z VDD VDD VSS VSS gf180mcu_fd_sc_mcu7t5v0__xor2_1
Xwave_controller_x_inst__3155_ wave_controller_x_inst__3305_/A1 spi_regs_inst__1529_/Q
+ spi_regs_inst__1528_/Q wave_controller_x_inst__3156_/A2 VDD VDD VSS VSS gf180mcu_fd_sc_mcu7t5v0__oai21_1
Xwave_controller_y_inst__2122_ wave_controller_y_inst__3729_/Q wave_controller_y_inst__2123_/A1
+ wave_controller_y_inst__2122_/A3 wave_controller_y_inst__3729_/D VDD VDD VSS VSS
+ gf180mcu_fd_sc_mcu7t5v0__xor3_1
Xwave_controller_x_inst__2106_ wave_controller_x_inst__3728_/Q wave_controller_x_inst__2106_/A2
+ wave_controller_x_inst__2106_/B wave_controller_x_inst__2123_/A1 VDD VDD VSS VSS
+ gf180mcu_fd_sc_mcu7t5v0__aoi21_1
XFILLER_119_385 VDD VDD VSS VSS gf180mcu_fd_sc_mcu7t5v0__fillcap_16
XFILLER_4_107 VDD VDD VSS VSS gf180mcu_fd_sc_mcu7t5v0__fillcap_64
Xwave_controller_y_inst__2053_ wave_controller_y_inst__2079_/B wave_controller_y_inst__2073_/A1
+ wave_controller_y_inst__2144_/B wave_controller_y_inst__2062_/B1 VDD VDD VSS VSS
+ gf180mcu_fd_sc_mcu7t5v0__oai21_1
Xwave_controller_x_inst__3086_ wave_controller_x_inst__3084_/Z wave_controller_x_inst__3086_/A2
+ wave_controller_x_inst__3718_/D VDD VDD VSS VSS gf180mcu_fd_sc_mcu7t5v0__nor2_1
XFILLER_108_32 VDD VDD VSS VSS gf180mcu_fd_sc_mcu7t5v0__fill_2
XFILLER_162_664 VDD VDD VSS VSS gf180mcu_fd_sc_mcu7t5v0__fill_1
XFILLER_88_1087 VDD VDD VSS VSS gf180mcu_fd_sc_mcu7t5v0__fillcap_64
Xwave_controller_x_inst__2037_ wave_controller_x_inst__1781_/I wave_controller_x_inst__3089_/B
+ wave_controller_x_inst__2037_/Z VDD VDD VSS VSS gf180mcu_fd_sc_mcu7t5v0__xor2_1
XFILLER_161_174 VDD VDD VSS VSS gf180mcu_fd_sc_mcu7t5v0__fillcap_16
XFILLER_68_14 VDD VDD VSS VSS gf180mcu_fd_sc_mcu7t5v0__fillcap_16
XFILLER_88_431 VDD VDD VSS VSS gf180mcu_fd_sc_mcu7t5v0__fillcap_4
XFILLER_130_561 VDD VDD VSS VSS gf180mcu_fd_sc_mcu7t5v0__fillcap_16
XFILLER_48_317 VDD VDD VSS VSS gf180mcu_fd_sc_mcu7t5v0__fillcap_4
XFILLER_88_453 VDD VDD VSS VSS gf180mcu_fd_sc_mcu7t5v0__fill_2
Xwave_controller_x_inst_fanout158 wave_controller_x_inst__3518_/B1 wave_controller_x_inst__3545_/B1
+ VDD VDD VSS VSS gf180mcu_fd_sc_mcu7t5v0__dlyb_1
XFILLER_130_594 VDD VDD VSS VSS gf180mcu_fd_sc_mcu7t5v0__fill_1
XTAP_TAPCELL_ROW_59_846 VDD VSS gf180mcu_fd_sc_mcu7t5v0__filltie
Xwave_controller_y_inst__2955_ wave_controller_y_inst__3705_/Q fanout505/I wave_controller_y_inst__2956_/I
+ VDD VDD VSS VSS gf180mcu_fd_sc_mcu7t5v0__nand2_1
Xwave_controller_x_inst__2939_ wave_controller_x_inst__3716_/Q wave_controller_x_inst__2939_/A2
+ wave_controller_x_inst__2998_/A2 VDD VDD VSS VSS gf180mcu_fd_sc_mcu7t5v0__nand2_1
XTAP_TAPCELL_ROW_141_2208 VDD VSS gf180mcu_fd_sc_mcu7t5v0__filltie
XTAP_TAPCELL_ROW_59_857 VDD VSS gf180mcu_fd_sc_mcu7t5v0__filltie
Xwave_controller_y_inst__2886_ wave_controller_y_inst__2869_/B wave_controller_y_inst__2886_/A2
+ wave_controller_y_inst__2886_/B wave_controller_y_inst__2886_/C wave_controller_y_inst__2887_/A3
+ VDD VDD VSS VSS gf180mcu_fd_sc_mcu7t5v0__aoi211_1
Xwave_controller_y_inst__1906_ spi_regs_inst__1190_/A1 wave_controller_y_inst__3452_/A1
+ VDD VDD VSS VSS gf180mcu_fd_sc_mcu7t5v0__clkinv_1
XFILLER_16_214 VDD VDD VSS VSS gf180mcu_fd_sc_mcu7t5v0__fill_2
XFILLER_44_523 VDD VDD VSS VSS gf180mcu_fd_sc_mcu7t5v0__fill_2
XFILLER_56_372 VDD VDD VSS VSS gf180mcu_fd_sc_mcu7t5v0__fill_2
XTAP_TAPCELL_ROW_106_1627 VDD VSS gf180mcu_fd_sc_mcu7t5v0__filltie
Xwave_controller_y_inst__1837_ spi_regs_inst__1281_/A1 wave_controller_y_inst__2223_/B2
+ VDD VDD VSS VSS gf180mcu_fd_sc_mcu7t5v0__clkinv_1
XFILLER_16_247 VDD VDD VSS VSS gf180mcu_fd_sc_mcu7t5v0__fillcap_16
XFILLER_71_375 VDD VDD VSS VSS gf180mcu_fd_sc_mcu7t5v0__fill_1
Xwave_controller_y_inst__3507_ wave_controller_y_inst__3705_/Q wave_controller_y_inst__3528_/A2
+ wave_controller_y_inst__3509_/A2 VDD VDD VSS VSS gf180mcu_fd_sc_mcu7t5v0__nor2_1
Xwave_controller_x_inst_max_cap131 wave_controller_x_inst__2621_/A2 wave_controller_x_inst__2652_/A1
+ VDD VDD VSS VSS gf180mcu_fd_sc_mcu7t5v0__clkbuf_1
XFILLER_157_414 VDD VDD VSS VSS gf180mcu_fd_sc_mcu7t5v0__fillcap_4
Xwave_controller_y_inst__3438_ wave_controller_y_inst__3440_/A1 wave_controller_y_inst__3494_/A1
+ wave_controller_y_inst__3438_/B wave_controller_y_inst__3439_/I VDD VDD VSS VSS
+ gf180mcu_fd_sc_mcu7t5v0__oai21_1
XFILLER_8_446 VDD VDD VSS VSS gf180mcu_fd_sc_mcu7t5v0__fill_1
XTAP_TAPCELL_ROW_156_2451 VDD VSS gf180mcu_fd_sc_mcu7t5v0__filltie
Xwave_controller_y_inst__3369_ wave_controller_y_inst__3568_/A1 spi_regs_inst__1604_/Q
+ wave_controller_y_inst__3369_/A3 wave_controller_y_inst__3369_/Z VDD VDD VSS VSS
+ gf180mcu_fd_sc_mcu7t5v0__xor3_1
XFILLER_123_1170 VDD VDD VSS VSS gf180mcu_fd_sc_mcu7t5v0__fillcap_4
XTAP_TAPCELL_ROW_48_1_692 VDD VSS gf180mcu_fd_sc_mcu7t5v0__filltie
XFILLER_144_119 VDD VDD VSS VSS gf180mcu_fd_sc_mcu7t5v0__fill_2
XFILLER_126_867 VDD VDD VSS VSS gf180mcu_fd_sc_mcu7t5v0__fillcap_8
XFILLER_67_1116 VDD VDD VSS VSS gf180mcu_fd_sc_mcu7t5v0__fillcap_4
XFILLER_99_718 VDD VDD VSS VSS gf180mcu_fd_sc_mcu7t5v0__fill_2
XTAP_TAPCELL_ROW_14_1_437 VDD VSS gf180mcu_fd_sc_mcu7t5v0__filltie
XFILLER_94_401 VDD VDD VSS VSS gf180mcu_fd_sc_mcu7t5v0__fillcap_4
XFILLER_95_924 VDD VDD VSS VSS gf180mcu_fd_sc_mcu7t5v0__fillcap_32
XTAP_TAPCELL_ROW_22_1_494 VDD VSS gf180mcu_fd_sc_mcu7t5v0__filltie
XTAP_TAPCELL_ROW_72_1063 VDD VSS gf180mcu_fd_sc_mcu7t5v0__filltie
XFILLER_94_434 VDD VDD VSS VSS gf180mcu_fd_sc_mcu7t5v0__fillcap_16
XFILLER_82_618 VDD VDD VSS VSS gf180mcu_fd_sc_mcu7t5v0__fill_2
XFILLER_63_821 VDD VDD VSS VSS gf180mcu_fd_sc_mcu7t5v0__fill_1
XFILLER_94_489 VDD VDD VSS VSS gf180mcu_fd_sc_mcu7t5v0__fill_1
XPHY_EDGE_ROW_12_1_Right_11 VDD VSS gf180mcu_fd_sc_mcu7t5v0__endcap
XFILLER_81_139 VDD VDD VSS VSS gf180mcu_fd_sc_mcu7t5v0__fill_1
XFILLER_50_515 VDD VDD VSS VSS gf180mcu_fd_sc_mcu7t5v0__fill_2
XFILLER_50_548 VDD VDD VSS VSS gf180mcu_fd_sc_mcu7t5v0__fillcap_4
XFILLER_128_1081 VDD VDD VSS VSS gf180mcu_fd_sc_mcu7t5v0__fillcap_4
XFILLER_116_300 VDD VDD VSS VSS gf180mcu_fd_sc_mcu7t5v0__fill_1
XFILLER_143_152 VDD VDD VSS VSS gf180mcu_fd_sc_mcu7t5v0__fillcap_4
XFILLER_132_859 VDD VDD VSS VSS gf180mcu_fd_sc_mcu7t5v0__fill_1
XFILLER_143_196 VDD VDD VSS VSS gf180mcu_fd_sc_mcu7t5v0__fill_2
XFILLER_135_1052 VDD VDD VSS VSS gf180mcu_fd_sc_mcu7t5v0__fillcap_64
XFILLER_97_261 VDD VDD VSS VSS gf180mcu_fd_sc_mcu7t5v0__fill_1
XFILLER_112_594 VDD VDD VSS VSS gf180mcu_fd_sc_mcu7t5v0__fill_1
XFILLER_57_125 VDD VDD VSS VSS gf180mcu_fd_sc_mcu7t5v0__fillcap_8
XFILLER_98_795 VDD VDD VSS VSS gf180mcu_fd_sc_mcu7t5v0__fillcap_8
XFILLER_85_478 VDD VDD VSS VSS gf180mcu_fd_sc_mcu7t5v0__fill_2
XTAP_TAPCELL_ROW_56_805 VDD VSS gf180mcu_fd_sc_mcu7t5v0__filltie
Xwave_controller_y_inst__2740_ wave_controller_y_inst__2749_/A1 wave_controller_y_inst__2740_/A2
+ spi_regs_inst__1141_/B2 VDD VDD VSS VSS gf180mcu_fd_sc_mcu7t5v0__xor2_1
Xwave_controller_x_inst__2724_ wave_controller_x_inst__2722_/Z wave_controller_x_inst__2739_/A2
+ wave_controller_x_inst__2738_/A2 VDD VDD VSS VSS gf180mcu_fd_sc_mcu7t5v0__nor2_1
Xwave_controller_y_inst__2671_ wave_controller_y_inst__2671_/A1 wave_controller_y_inst__2671_/A2
+ wave_controller_y_inst__2694_/A1 VDD VDD VSS VSS gf180mcu_fd_sc_mcu7t5v0__nand2_1
XTAP_TAPCELL_ROW_0_1_2659 VDD VSS gf180mcu_fd_sc_mcu7t5v0__filltie
Xwave_controller_x_inst__2655_ wave_controller_x_inst__2687_/B wave_controller_x_inst__2669_/B
+ VDD VDD VSS VSS gf180mcu_fd_sc_mcu7t5v0__clkinv_1
Xwave_controller_x_inst__2586_ wave_controller_x_inst__2580_/Z wave_controller_x_inst__2596_/A2
+ wave_controller_x_inst__2589_/A3 VDD VDD VSS VSS gf180mcu_fd_sc_mcu7t5v0__xnor2_1
XFILLER_110_22 VDD VDD VSS VSS gf180mcu_fd_sc_mcu7t5v0__fill_2
XFILLER_41_526 VDD VDD VSS VSS gf180mcu_fd_sc_mcu7t5v0__fill_1
XTAP_TAPCELL_ROW_101_1546 VDD VSS gf180mcu_fd_sc_mcu7t5v0__filltie
XFILLER_107_1154 VDD VDD VSS VSS gf180mcu_fd_sc_mcu7t5v0__fillcap_16
XFILLER_70_37 VDD VDD VSS VSS gf180mcu_fd_sc_mcu7t5v0__fill_2
XFILLER_70_59 VDD VDD VSS VSS gf180mcu_fd_sc_mcu7t5v0__fill_1
Xwave_controller_y_inst__3223_ fanout505/I wave_controller_y_inst__3235_/A2 wave_controller_y_inst__3237_/A2
+ VDD VDD VSS VSS gf180mcu_fd_sc_mcu7t5v0__nor2_1
Xwave_controller_x_inst__3207_ wave_controller_x_inst__3115_/Z wave_controller_x_inst__3151_/Z
+ wave_controller_x_inst__3208_/B wave_controller_x_inst__3207_/Z VDD VDD VSS VSS
+ gf180mcu_fd_sc_mcu7t5v0__or3_1
XFILLER_108_801 VDD VDD VSS VSS gf180mcu_fd_sc_mcu7t5v0__fillcap_4
Xwave_controller_y_inst__3154_ wave_controller_y_inst__3211_/A1 wave_controller_y_inst__3211_/A2
+ wave_controller_y_inst__3211_/B wave_controller_y_inst__3208_/B wave_controller_y_inst__3154_/Z
+ VDD VDD VSS VSS gf180mcu_fd_sc_mcu7t5v0__and4_1
Xwave_controller_y_inst__2105_ wave_controller_y_inst__2105_/A1 wave_controller_y_inst__2104_/B
+ wave_controller_y_inst__3728_/D VDD VDD VSS VSS gf180mcu_fd_sc_mcu7t5v0__xnor2_1
Xwave_controller_x_inst__3138_ wave_controller_x_inst__3129_/Z wave_controller_x_inst__3233_/A2
+ wave_controller_x_inst__3138_/B wave_controller_x_inst__3228_/A1 VDD VDD VSS VSS
+ gf180mcu_fd_sc_mcu7t5v0__oai21_1
XTAP_TAPCELL_ROW_134_2089 VDD VSS gf180mcu_fd_sc_mcu7t5v0__filltie
XTAP_TAPCELL_ROW_151_2370 VDD VSS gf180mcu_fd_sc_mcu7t5v0__filltie
Xwave_controller_y_inst__3085_ wave_controller_y_inst__3718_/Q wave_controller_y_inst__3085_/A2
+ fanout389/Z wave_controller_y_inst__3086_/A2 VDD VDD VSS VSS gf180mcu_fd_sc_mcu7t5v0__oai21_1
Xwave_controller_x_inst__3069_ wave_controller_x_inst_wire166/Z wave_controller_x_inst__2983_/B
+ wave_controller_x_inst__3068_/Z wave_controller_x_inst__3069_/B1 wave_controller_x_inst__3163_/C
+ wave_controller_x_inst__3711_/D VDD VDD VSS VSS gf180mcu_fd_sc_mcu7t5v0__oai32_1
XFILLER_150_601 VDD VDD VSS VSS gf180mcu_fd_sc_mcu7t5v0__fill_2
XFILLER_150_623 VDD VDD VSS VSS gf180mcu_fd_sc_mcu7t5v0__fillcap_16
Xwave_controller_y_inst__2036_ wave_controller_y_inst__1783_/I wave_controller_y_inst__3089_/B
+ wave_controller_y_inst__2125_/A2 VDD VDD VSS VSS gf180mcu_fd_sc_mcu7t5v0__xnor2_1
XFILLER_135_74 VDD VDD VSS VSS gf180mcu_fd_sc_mcu7t5v0__fill_1
XFILLER_150_667 VDD VDD VSS VSS gf180mcu_fd_sc_mcu7t5v0__fill_2
XFILLER_77_902 VDD VDD VSS VSS gf180mcu_fd_sc_mcu7t5v0__fill_2
XFILLER_95_209 VDD VDD VSS VSS gf180mcu_fd_sc_mcu7t5v0__fill_1
XTAP_TAPCELL_ROW_10_1_410 VDD VSS gf180mcu_fd_sc_mcu7t5v0__filltie
XFILLER_114_1169 VDD VDD VSS VSS gf180mcu_fd_sc_mcu7t5v0__fill_1
XFILLER_64_618 VDD VDD VSS VSS gf180mcu_fd_sc_mcu7t5v0__fillcap_16
XFILLER_77_979 VDD VDD VSS VSS gf180mcu_fd_sc_mcu7t5v0__fill_1
Xwave_controller_y_inst__2938_ wave_controller_y_inst__1781_/I wave_controller_y_inst__3400_/A1
+ wave_controller_y_inst__2938_/Z VDD VDD VSS VSS gf180mcu_fd_sc_mcu7t5v0__or2_1
XFILLER_63_106 VDD VDD VSS VSS gf180mcu_fd_sc_mcu7t5v0__fillcap_32
XFILLER_91_437 VDD VDD VSS VSS gf180mcu_fd_sc_mcu7t5v0__fill_1
XFILLER_17_523 VDD VDD VSS VSS gf180mcu_fd_sc_mcu7t5v0__fill_1
XFILLER_72_640 VDD VDD VSS VSS gf180mcu_fd_sc_mcu7t5v0__fill_2
Xwave_controller_y_inst__2869_ wave_controller_y_inst__3449_/A1 spi_regs_inst__1190_/A1
+ wave_controller_y_inst__2869_/B wave_controller_y_inst__2884_/B wave_controller_y_inst__2881_/A1
+ VDD VDD VSS VSS gf180mcu_fd_sc_mcu7t5v0__oai211_1
XFILLER_44_375 VDD VDD VSS VSS gf180mcu_fd_sc_mcu7t5v0__fill_1
XFILLER_60_824 VDD VDD VSS VSS gf180mcu_fd_sc_mcu7t5v0__fill_2
Xspi_regs_inst__1530_ spi_regs_inst__1530_/D wire594/Z clkbuf_leaf_11_clk/Z spi_regs_inst__1530_/Q
+ VDD VDD VSS VSS gf180mcu_fd_sc_mcu7t5v0__dffrnq_1
XFILLER_60_868 VDD VDD VSS VSS gf180mcu_fd_sc_mcu7t5v0__fillcap_4
Xspi_regs_inst__1461_ spi_regs_inst__1461_/D fanout582/Z clkload10/I spi_regs_inst__1461_/Q
+ VDD VDD VSS VSS gf180mcu_fd_sc_mcu7t5v0__dffrnq_1
XFILLER_158_734 VDD VDD VSS VSS gf180mcu_fd_sc_mcu7t5v0__fill_1
Xspi_regs_inst__1392_ fanout535/Z spi_regs_inst__1410_/I1 spi_regs_inst__1394_/S spi_regs_inst__1467_/D
+ VDD VDD VSS VSS gf180mcu_fd_sc_mcu7t5v0__mux2_2
XFILLER_118_609 VDD VDD VSS VSS gf180mcu_fd_sc_mcu7t5v0__fillcap_4
XTAP_TAPCELL_ROW_74_1103 VDD VSS gf180mcu_fd_sc_mcu7t5v0__filltie
XFILLER_114_815 VDD VDD VSS VSS gf180mcu_fd_sc_mcu7t5v0__fill_2
XFILLER_114_848 VDD VDD VSS VSS gf180mcu_fd_sc_mcu7t5v0__fill_1
XFILLER_141_645 VDD VDD VSS VSS gf180mcu_fd_sc_mcu7t5v0__fillcap_32
XFILLER_95_710 VDD VDD VSS VSS gf180mcu_fd_sc_mcu7t5v0__fill_2
XFILLER_140_177 VDD VDD VSS VSS gf180mcu_fd_sc_mcu7t5v0__fill_2
XFILLER_80_1157 VDD VDD VSS VSS gf180mcu_fd_sc_mcu7t5v0__fillcap_8
XFILLER_95_721 VDD VDD VSS VSS gf180mcu_fd_sc_mcu7t5v0__fill_2
XFILLER_10_2 VDD VDD VSS VSS gf180mcu_fd_sc_mcu7t5v0__fillcap_32
XFILLER_39_158 VDD VDD VSS VSS gf180mcu_fd_sc_mcu7t5v0__fill_1
XFILLER_95_754 VDD VDD VSS VSS gf180mcu_fd_sc_mcu7t5v0__fillcap_4
XFILLER_35_320 VDD VDD VSS VSS gf180mcu_fd_sc_mcu7t5v0__fill_1
XFILLER_63_640 VDD VDD VSS VSS gf180mcu_fd_sc_mcu7t5v0__fill_2
XFILLER_63_673 VDD VDD VSS VSS gf180mcu_fd_sc_mcu7t5v0__fill_2
XFILLER_91_982 VDD VDD VSS VSS gf180mcu_fd_sc_mcu7t5v0__fillcap_64
Xwave_controller_x_inst__2440_ spi_regs_inst__1252_/B2 spi_regs_inst__1225_/A1 wave_controller_x_inst__2440_/A3
+ wave_controller_x_inst__2445_/A3 VDD VDD VSS VSS gf180mcu_fd_sc_mcu7t5v0__xnor3_1
XFILLER_62_172 VDD VDD VSS VSS gf180mcu_fd_sc_mcu7t5v0__fill_2
XTAP_TAPCELL_ROW_85_1276 VDD VSS gf180mcu_fd_sc_mcu7t5v0__filltie
XTAP_TAPCELL_ROW_85_1287 VDD VSS gf180mcu_fd_sc_mcu7t5v0__filltie
Xwave_controller_x_inst__2371_ wave_controller_x_inst__2369_/Z wave_controller_x_inst__2372_/A2
+ wave_controller_x_inst__2391_/B VDD VDD VSS VSS gf180mcu_fd_sc_mcu7t5v0__nand2_1
Xspi_regs_inst__1659_ spi_regs_inst__1659_/D spi_regs_inst__1659_/RN clkbuf_leaf_6_clk/Z
+ spi_regs_inst__1659_/Q VDD VDD VSS VSS gf180mcu_fd_sc_mcu7t5v0__dffrnq_1
XTAP_TAPCELL_ROW_61_885 VDD VSS gf180mcu_fd_sc_mcu7t5v0__filltie
XFILLER_148_255 VDD VDD VSS VSS gf180mcu_fd_sc_mcu7t5v0__fill_1
XFILLER_164_737 VDD VDD VSS VSS gf180mcu_fd_sc_mcu7t5v0__fillcap_64
XFILLER_116_130 VDD VDD VSS VSS gf180mcu_fd_sc_mcu7t5v0__fill_1
XFILLER_117_653 VDD VDD VSS VSS gf180mcu_fd_sc_mcu7t5v0__fillcap_4
XFILLER_105_826 VDD VDD VSS VSS gf180mcu_fd_sc_mcu7t5v0__fillcap_8
XFILLER_85_1046 VDD VDD VSS VSS gf180mcu_fd_sc_mcu7t5v0__fillcap_4
XFILLER_120_807 VDD VDD VSS VSS gf180mcu_fd_sc_mcu7t5v0__fill_1
XFILLER_131_133 VDD VDD VSS VSS gf180mcu_fd_sc_mcu7t5v0__fillcap_4
XFILLER_49_49 VDD VDD VSS VSS gf180mcu_fd_sc_mcu7t5v0__fillcap_16
XFILLER_105_33 VDD VDD VSS VSS gf180mcu_fd_sc_mcu7t5v0__fill_2
XFILLER_98_592 VDD VDD VSS VSS gf180mcu_fd_sc_mcu7t5v0__fill_2
XTAP_TAPCELL_ROW_39_1_623 VDD VSS gf180mcu_fd_sc_mcu7t5v0__filltie
XFILLER_100_542 VDD VDD VSS VSS gf180mcu_fd_sc_mcu7t5v0__fillcap_16
XFILLER_59_979 VDD VDD VSS VSS gf180mcu_fd_sc_mcu7t5v0__fill_1
XFILLER_100_575 VDD VDD VSS VSS gf180mcu_fd_sc_mcu7t5v0__fill_1
XFILLER_73_404 VDD VDD VSS VSS gf180mcu_fd_sc_mcu7t5v0__fill_1
XFILLER_85_275 VDD VDD VSS VSS gf180mcu_fd_sc_mcu7t5v0__fillcap_4
Xwave_controller_y_inst__2723_ wave_controller_y_inst__1816_/I wave_controller_y_inst__2723_/A2
+ wave_controller_y_inst__2723_/B wave_controller_y_inst__2739_/A2 VDD VDD VSS VSS
+ gf180mcu_fd_sc_mcu7t5v0__oai21_1
XFILLER_45_128 VDD VDD VSS VSS gf180mcu_fd_sc_mcu7t5v0__fillcap_4
Xwave_controller_x_inst__3687_ wave_controller_x_inst__3687_/D fanout591/Z clkload22/I
+ spi_regs_inst__1108_/B2 VDD VDD VSS VSS gf180mcu_fd_sc_mcu7t5v0__dffrnq_1
Xwave_controller_x_inst__2707_ wave_controller_x_inst__2704_/Z wave_controller_x_inst__2707_/A2
+ wave_controller_x_inst__2737_/A1 VDD VDD VSS VSS gf180mcu_fd_sc_mcu7t5v0__xnor2_1
Xwave_controller_y_inst__2654_ wave_controller_y_inst__2822_/A1 spi_regs_inst__1303_/A1
+ wave_controller_y_inst__2687_/B VDD VDD VSS VSS gf180mcu_fd_sc_mcu7t5v0__nor2_1
Xwave_controller_x_inst__2638_ wave_controller_x_inst__2636_/Z wave_controller_x_inst__2640_/A3
+ wave_controller_x_inst__2638_/Z VDD VDD VSS VSS gf180mcu_fd_sc_mcu7t5v0__xor2_1
XFILLER_121_65 VDD VDD VSS VSS gf180mcu_fd_sc_mcu7t5v0__fillcap_4
XFILLER_53_172 VDD VDD VSS VSS gf180mcu_fd_sc_mcu7t5v0__fillcap_16
XFILLER_81_36 VDD VDD VSS VSS gf180mcu_fd_sc_mcu7t5v0__fill_2
XFILLER_81_492 VDD VDD VSS VSS gf180mcu_fd_sc_mcu7t5v0__fill_2
XFILLER_92_1017 VDD VDD VSS VSS gf180mcu_fd_sc_mcu7t5v0__fillcap_64
Xwave_controller_y_inst__2585_ wave_controller_y_inst_wire150/Z wave_controller_y_inst__2620_/A2
+ wave_controller_y_inst__2585_/B wave_controller_y_inst__2596_/A2 VDD VDD VSS VSS
+ gf180mcu_fd_sc_mcu7t5v0__oai21_1
Xwave_controller_x_inst__2569_ wave_controller_x_inst__2952_/A2 wave_controller_x_inst__2569_/A2
+ wave_controller_x_inst__2591_/A1 VDD VDD VSS VSS gf180mcu_fd_sc_mcu7t5v0__nand2_1
XTAP_TAPCELL_ROW_136_2118 VDD VSS gf180mcu_fd_sc_mcu7t5v0__filltie
XFILLER_155_704 VDD VDD VSS VSS gf180mcu_fd_sc_mcu7t5v0__fill_1
XFILLER_167_564 VDD VDD VSS VSS gf180mcu_fd_sc_mcu7t5v0__fillcap_8
XTAP_TAPCELL_ROW_136_2129 VDD VSS gf180mcu_fd_sc_mcu7t5v0__filltie
Xwave_controller_y_inst__3206_ wave_controller_y_inst__3206_/A1 wave_controller_y_inst__3205_/Z
+ wave_controller_y_inst__3242_/B1 VDD VDD VSS VSS gf180mcu_fd_sc_mcu7t5v0__nand2_1
XFILLER_120_1151 VDD VDD VSS VSS gf180mcu_fd_sc_mcu7t5v0__fillcap_4
XFILLER_154_247 VDD VDD VSS VSS gf180mcu_fd_sc_mcu7t5v0__fillcap_8
Xwave_controller_y_inst__3137_ wave_controller_y_inst__3227_/A1 wave_controller_y_inst__3232_/B1
+ wave_controller_y_inst__3137_/B wave_controller_y_inst__3224_/A2 VDD VDD VSS VSS
+ gf180mcu_fd_sc_mcu7t5v0__aoi21_1
XFILLER_108_664 VDD VDD VSS VSS gf180mcu_fd_sc_mcu7t5v0__fill_1
XFILLER_120_1173 VDD VDD VSS VSS gf180mcu_fd_sc_mcu7t5v0__fill_1
XFILLER_135_472 VDD VDD VSS VSS gf180mcu_fd_sc_mcu7t5v0__fillcap_8
Xwave_controller_y_inst__3068_ wave_controller_y_inst__2945_/Z wave_controller_y_inst__3068_/A2
+ wave_controller_y_inst__3068_/A3 wave_controller_y_inst__3068_/Z VDD VDD VSS VSS
+ gf180mcu_fd_sc_mcu7t5v0__and3_1
XFILLER_123_634 VDD VDD VSS VSS gf180mcu_fd_sc_mcu7t5v0__fill_1
XTAP_TAPCELL_ROW_114_1759 VDD VSS gf180mcu_fd_sc_mcu7t5v0__filltie
Xwave_controller_y_inst__2019_ wave_controller_y_inst__2017_/Z wave_controller_y_inst__2019_/A2
+ spi_regs_inst__1037_/A1 VDD VDD VSS VSS gf180mcu_fd_sc_mcu7t5v0__nor2_1
XFILLER_122_144 VDD VDD VSS VSS gf180mcu_fd_sc_mcu7t5v0__fillcap_16
XFILLER_151_976 VDD VDD VSS VSS gf180mcu_fd_sc_mcu7t5v0__fillcap_4
XFILLER_96_507 VDD VDD VSS VSS gf180mcu_fd_sc_mcu7t5v0__fillcap_16
XFILLER_122_177 VDD VDD VSS VSS gf180mcu_fd_sc_mcu7t5v0__fillcap_16
XFILLER_77_710 VDD VDD VSS VSS gf180mcu_fd_sc_mcu7t5v0__fill_2
XFILLER_77_732 VDD VDD VSS VSS gf180mcu_fd_sc_mcu7t5v0__fillcap_16
XFILLER_103_391 VDD VDD VSS VSS gf180mcu_fd_sc_mcu7t5v0__fillcap_16
XFILLER_49_434 VDD VDD VSS VSS gf180mcu_fd_sc_mcu7t5v0__fillcap_16
XFILLER_65_916 VDD VDD VSS VSS gf180mcu_fd_sc_mcu7t5v0__fill_2
XFILLER_77_765 VDD VDD VSS VSS gf180mcu_fd_sc_mcu7t5v0__fillcap_4
Xspi_regs_inst__0961_ spi_regs_inst__1030_/A2 spi_regs_inst__1019_/A2 spi_regs_inst_wire288/I
+ VDD VDD VSS VSS gf180mcu_fd_sc_mcu7t5v0__nor2_1
XFILLER_76_286 VDD VDD VSS VSS gf180mcu_fd_sc_mcu7t5v0__fill_2
XTAP_TAPCELL_ROW_164_2583 VDD VSS gf180mcu_fd_sc_mcu7t5v0__filltie
Xspi_regs_inst__0892_ spi_regs_inst__1624_/Q spi_regs_inst__0939_/S spi_regs_inst__0893_/B
+ VDD VDD VSS VSS gf180mcu_fd_sc_mcu7t5v0__nor2_1
XFILLER_76_297 VDD VDD VSS VSS gf180mcu_fd_sc_mcu7t5v0__fillcap_16
XFILLER_91_212 VDD VDD VSS VSS gf180mcu_fd_sc_mcu7t5v0__fillcap_4
XFILLER_73_982 VDD VDD VSS VSS gf180mcu_fd_sc_mcu7t5v0__fillcap_64
XFILLER_91_256 VDD VDD VSS VSS gf180mcu_fd_sc_mcu7t5v0__fillcap_8
XFILLER_17_375 VDD VDD VSS VSS gf180mcu_fd_sc_mcu7t5v0__fill_1
Xspi_regs_inst__1513_ spi_regs_inst__1513_/D spi_regs_inst__1551_/RN clkload29/I spi_regs_inst__1513_/Q
+ VDD VDD VSS VSS gf180mcu_fd_sc_mcu7t5v0__dffrnq_1
XFILLER_20_507 VDD VDD VSS VSS gf180mcu_fd_sc_mcu7t5v0__fillcap_8
XFILLER_60_687 VDD VDD VSS VSS gf180mcu_fd_sc_mcu7t5v0__fillcap_4
Xspi_regs_inst__1444_ spi_regs_inst__1513_/Q spi_regs_inst__1444_/I1 spi_regs_inst__1445_/S
+ spi_regs_inst__1513_/D VDD VDD VSS VSS gf180mcu_fd_sc_mcu7t5v0__mux2_2
XFILLER_9_541 VDD VDD VSS VSS gf180mcu_fd_sc_mcu7t5v0__fillcap_8
XTAP_TAPCELL_ROW_80_1195 VDD VSS gf180mcu_fd_sc_mcu7t5v0__filltie
Xspi_regs_inst__1375_ spi_regs_inst__1656_/Q spi_regs_inst__1376_/A2 spi_regs_inst__1376_/B
+ VDD VDD VSS VSS gf180mcu_fd_sc_mcu7t5v0__nand2_1
XFILLER_126_450 VDD VDD VSS VSS gf180mcu_fd_sc_mcu7t5v0__fillcap_4
XFILLER_58_2 VDD VDD VSS VSS gf180mcu_fd_sc_mcu7t5v0__fillcap_8
Xchip_core bidir_cs[3] VDD VDD VSS VSS gf180mcu_fd_sc_mcu7t5v0__tiel
XFILLER_113_133 VDD VDD VSS VSS gf180mcu_fd_sc_mcu7t5v0__fillcap_4
XFILLER_114_667 VDD VDD VSS VSS gf180mcu_fd_sc_mcu7t5v0__fill_2
Xwave_controller_x_inst__1940_ wave_controller_x_inst__1940_/A1 wave_controller_x_inst__1781_/I
+ wave_controller_x_inst__1940_/B wave_controller_x_inst__1941_/B VDD VDD VSS VSS
+ gf180mcu_fd_sc_mcu7t5v0__oai21_1
XFILLER_101_317 VDD VDD VSS VSS gf180mcu_fd_sc_mcu7t5v0__fill_2
Xsignal_processor_y_inst__256_ signal_processor_y_inst__256_/D fanout544/Z clkload1/I
+ signal_processor_y_inst__256_/Q VDD VDD VSS VSS gf180mcu_fd_sc_mcu7t5v0__dffrnq_1
XFILLER_132_1011 VDD VDD VSS VSS gf180mcu_fd_sc_mcu7t5v0__fillcap_4
XFILLER_67_220 VDD VDD VSS VSS gf180mcu_fd_sc_mcu7t5v0__fillcap_4
Xwave_controller_x_inst__3610_ wave_controller_x_inst__3610_/A1 wave_controller_x_inst__3610_/A2
+ wave_controller_x_inst__3610_/B wave_controller_x_inst__3681_/D VDD VDD VSS VSS
+ gf180mcu_fd_sc_mcu7t5v0__oai21_1
Xwave_controller_x_inst__1871_ spi_regs_inst__1064_/B2 wave_controller_x_inst__3497_/A1
+ VDD VDD VSS VSS gf180mcu_fd_sc_mcu7t5v0__clkinv_1
XFILLER_27_117 VDD VDD VSS VSS gf180mcu_fd_sc_mcu7t5v0__fillcap_16
XFILLER_56_927 VDD VDD VSS VSS gf180mcu_fd_sc_mcu7t5v0__fillcap_16
XFILLER_83_702 VDD VDD VSS VSS gf180mcu_fd_sc_mcu7t5v0__fill_2
XTAP_TAPCELL_ROW_87_1305 VDD VSS gf180mcu_fd_sc_mcu7t5v0__filltie
XTAP_TAPCELL_ROW_87_1316 VDD VSS gf180mcu_fd_sc_mcu7t5v0__filltie
Xsignal_processor_y_inst__187_ signal_processor_y_inst__187_/A1 signal_processor_y_inst__187_/A2
+ signal_processor_y_inst__187_/B signal_processor_y_inst__190_/A2 VDD VDD VSS VSS
+ gf180mcu_fd_sc_mcu7t5v0__oai21_1
XFILLER_27_139 VDD VDD VSS VSS gf180mcu_fd_sc_mcu7t5v0__fill_1
XFILLER_55_426 VDD VDD VSS VSS gf180mcu_fd_sc_mcu7t5v0__fill_2
Xwave_controller_x_inst__3541_ spi_regs_inst__1337_/A1 wave_controller_x_inst__3556_/A2
+ wave_controller_x_inst__3542_/A3 VDD VDD VSS VSS gf180mcu_fd_sc_mcu7t5v0__nor2_1
XFILLER_83_779 VDD VDD VSS VSS gf180mcu_fd_sc_mcu7t5v0__fillcap_8
XTAP_TAPCELL_ROW_66_966 VDD VSS gf180mcu_fd_sc_mcu7t5v0__filltie
Xwave_controller_x_inst__3472_ wave_controller_x_inst__3472_/A1 wave_controller_x_inst__3545_/B1
+ wave_controller_x_inst__3472_/B1 wave_controller_x_inst__3472_/B2 wave_controller_x_inst__3625_/D
+ VDD VDD VSS VSS gf180mcu_fd_sc_mcu7t5v0__oai22_1
XFILLER_63_470 VDD VDD VSS VSS gf180mcu_fd_sc_mcu7t5v0__fillcap_8
XFILLER_63_492 VDD VDD VSS VSS gf180mcu_fd_sc_mcu7t5v0__fill_2
Xwave_controller_x_inst__2423_ wave_controller_x_inst__2433_/A2 wave_controller_x_inst__2423_/A2
+ spi_regs_inst__1083_/A1 VDD VDD VSS VSS gf180mcu_fd_sc_mcu7t5v0__xor2_1
Xwave_controller_y_inst__2370_ wave_controller_y_inst__2831_/A1 wave_controller_y_inst__2355_/Z
+ wave_controller_y_inst__2370_/B wave_controller_y_inst__2372_/A2 VDD VDD VSS VSS
+ gf180mcu_fd_sc_mcu7t5v0__oai21_1
XFILLER_50_164 VDD VDD VSS VSS gf180mcu_fd_sc_mcu7t5v0__fillcap_4
Xwave_controller_x_inst__2354_ fanout537/Z wave_controller_x_inst__2356_/A3 wave_controller_x_inst__2370_/B
+ VDD VDD VSS VSS gf180mcu_fd_sc_mcu7t5v0__or2_1
Xwave_controller_x_inst__2285_ wave_controller_x_inst__2254_/Z wave_controller_x_inst__2286_/A2
+ wave_controller_x_inst__2320_/A2 VDD VDD VSS VSS gf180mcu_fd_sc_mcu7t5v0__nand2_1
XFILLER_104_1157 VDD VDD VSS VSS gf180mcu_fd_sc_mcu7t5v0__fillcap_16
XFILLER_136_247 VDD VDD VSS VSS gf180mcu_fd_sc_mcu7t5v0__fillcap_8
XFILLER_152_707 VDD VDD VSS VSS gf180mcu_fd_sc_mcu7t5v0__fillcap_16
XPHY_EDGE_ROW_162_Left_329 VDD VSS gf180mcu_fd_sc_mcu7t5v0__endcap
XTAP_TAPCELL_ROW_98_1489 VDD VSS gf180mcu_fd_sc_mcu7t5v0__filltie
XTAP_TAPCELL_ROW_131_2037 VDD VSS gf180mcu_fd_sc_mcu7t5v0__filltie
XFILLER_133_976 VDD VDD VSS VSS gf180mcu_fd_sc_mcu7t5v0__fillcap_4
XFILLER_104_177 VDD VDD VSS VSS gf180mcu_fd_sc_mcu7t5v0__fillcap_32
Xfanout542 fanout542/I fanout542/Z VDD VDD VSS VSS gf180mcu_fd_sc_mcu7t5v0__dlyb_1
XFILLER_116_98 VDD VDD VSS VSS gf180mcu_fd_sc_mcu7t5v0__fillcap_4
XFILLER_58_220 VDD VDD VSS VSS gf180mcu_fd_sc_mcu7t5v0__fill_1
Xfanout575 fanout581/Z fanout575/Z VDD VDD VSS VSS gf180mcu_fd_sc_mcu7t5v0__dlyb_1
Xfanout564 fanout566/Z fanout564/Z VDD VDD VSS VSS gf180mcu_fd_sc_mcu7t5v0__dlyb_1
XFILLER_58_264 VDD VDD VSS VSS gf180mcu_fd_sc_mcu7t5v0__fill_1
Xfanout597 fanout598/Z fanout597/Z VDD VDD VSS VSS gf180mcu_fd_sc_mcu7t5v0__dlyb_1
XFILLER_100_383 VDD VDD VSS VSS gf180mcu_fd_sc_mcu7t5v0__fill_2
XFILLER_73_212 VDD VDD VSS VSS gf180mcu_fd_sc_mcu7t5v0__fill_1
XTAP_TAPCELL_ROW_146_2280 VDD VSS gf180mcu_fd_sc_mcu7t5v0__filltie
XTAP_TAPCELL_ROW_146_2291 VDD VSS gf180mcu_fd_sc_mcu7t5v0__filltie
Xwave_controller_x_inst__3739_ wave_controller_x_inst__3739_/D fanout601/Z clkload26/I
+ wave_controller_x_inst__3739_/Q VDD VDD VSS VSS gf180mcu_fd_sc_mcu7t5v0__dffrnq_1
XFILLER_61_418 VDD VDD VSS VSS gf180mcu_fd_sc_mcu7t5v0__fill_2
Xwave_controller_y_inst__2706_ wave_controller_y_inst__2704_/Z wave_controller_y_inst__2707_/A2
+ wave_controller_y_inst__2726_/B VDD VDD VSS VSS gf180mcu_fd_sc_mcu7t5v0__nand2_1
Xwave_controller_y_inst__3686_ wave_controller_y_inst__3686_/D wave_controller_y_inst__3716_/RN
+ clkload14/I spi_regs_inst__0974_/B2 VDD VDD VSS VSS gf180mcu_fd_sc_mcu7t5v0__dffrnq_1
XFILLER_162_2 VDD VDD VSS VSS gf180mcu_fd_sc_mcu7t5v0__fillcap_32
XFILLER_55_982 VDD VDD VSS VSS gf180mcu_fd_sc_mcu7t5v0__fillcap_64
XFILLER_92_57 VDD VDD VSS VSS gf180mcu_fd_sc_mcu7t5v0__fillcap_4
Xwave_controller_y_inst__2637_ wave_controller_y_inst__2637_/A1 wave_controller_y_inst__2652_/A1
+ wave_controller_y_inst__2650_/B wave_controller_y_inst__2640_/A3 VDD VDD VSS VSS
+ gf180mcu_fd_sc_mcu7t5v0__aoi21_1
XFILLER_109_1046 VDD VDD VSS VSS gf180mcu_fd_sc_mcu7t5v0__fillcap_4
XPHY_EDGE_ROW_153_Right_153 VDD VSS gf180mcu_fd_sc_mcu7t5v0__endcap
Xwave_controller_y_inst__2568_ wave_controller_y_inst__2566_/Z wave_controller_y_inst__2570_/A3
+ wave_controller_y_inst__2569_/A2 VDD VDD VSS VSS gf180mcu_fd_sc_mcu7t5v0__xnor2_1
Xwave_controller_y_inst__2499_ max_cap427/Z wave_controller_y_inst__3512_/B2 wave_controller_y_inst__2519_/A1
+ VDD VDD VSS VSS gf180mcu_fd_sc_mcu7t5v0__nand2_1
XFILLER_128_737 VDD VDD VSS VSS gf180mcu_fd_sc_mcu7t5v0__fillcap_16
XFILLER_127_236 VDD VDD VSS VSS gf180mcu_fd_sc_mcu7t5v0__fillcap_4
XFILLER_155_534 VDD VDD VSS VSS gf180mcu_fd_sc_mcu7t5v0__fill_2
XFILLER_155_545 VDD VDD VSS VSS gf180mcu_fd_sc_mcu7t5v0__fill_1
XFILLER_157_50 VDD VDD VSS VSS gf180mcu_fd_sc_mcu7t5v0__fillcap_4
XTAP_TAPCELL_ROW_52_1_721 VDD VSS gf180mcu_fd_sc_mcu7t5v0__filltie
Xspi_regs_inst__1160_ spi_regs_inst__1160_/A1 spi_regs_inst_wire284/Z spi_regs_inst__1224_/A2
+ spi_regs_inst__1160_/B2 spi_regs_inst__1161_/A3 VDD VDD VSS VSS gf180mcu_fd_sc_mcu7t5v0__aoi22_1
XFILLER_157_72 VDD VDD VSS VSS gf180mcu_fd_sc_mcu7t5v0__fillcap_16
Xspi_regs_inst__1091_ spi_regs_inst__1091_/A1 spi_regs_inst__1190_/A2 spi_regs_inst__1290_/A2
+ spi_regs_inst__1091_/B2 spi_regs_inst__1120_/A3 VDD VDD VSS VSS gf180mcu_fd_sc_mcu7t5v0__aoi22_1
XFILLER_108_472 VDD VDD VSS VSS gf180mcu_fd_sc_mcu7t5v0__fillcap_16
XFILLER_157_94 VDD VDD VSS VSS gf180mcu_fd_sc_mcu7t5v0__fill_1
XPHY_EDGE_ROW_21_1_Right_20 VDD VSS gf180mcu_fd_sc_mcu7t5v0__endcap
XFILLER_151_751 VDD VDD VSS VSS gf180mcu_fd_sc_mcu7t5v0__fill_1
XFILLER_97_827 VDD VDD VSS VSS gf180mcu_fd_sc_mcu7t5v0__fill_2
XFILLER_116_1017 VDD VDD VSS VSS gf180mcu_fd_sc_mcu7t5v0__fillcap_64
XFILLER_151_795 VDD VDD VSS VSS gf180mcu_fd_sc_mcu7t5v0__fillcap_32
XFILLER_69_529 VDD VDD VSS VSS gf180mcu_fd_sc_mcu7t5v0__fill_1
XFILLER_96_326 VDD VDD VSS VSS gf180mcu_fd_sc_mcu7t5v0__fillcap_4
XTAP_TAPCELL_ROW_166_2612 VDD VSS gf180mcu_fd_sc_mcu7t5v0__filltie
XTAP_TAPCELL_ROW_166_2623 VDD VSS gf180mcu_fd_sc_mcu7t5v0__filltie
Xsignal_processor_y_inst__110_ signal_processor_y_inst__229_/Q signal_processor_y_inst__161_/A2
+ VDD VDD VSS VSS gf180mcu_fd_sc_mcu7t5v0__clkinv_1
XFILLER_1_282 VDD VDD VSS VSS gf180mcu_fd_sc_mcu7t5v0__fillcap_64
XFILLER_96_359 VDD VDD VSS VSS gf180mcu_fd_sc_mcu7t5v0__fill_2
XFILLER_37_415 VDD VDD VSS VSS gf180mcu_fd_sc_mcu7t5v0__fillcap_4
XFILLER_49_264 VDD VDD VSS VSS gf180mcu_fd_sc_mcu7t5v0__fillcap_4
XTAP_TAPCELL_ROW_8_1_390 VDD VSS gf180mcu_fd_sc_mcu7t5v0__filltie
XFILLER_37_426 VDD VDD VSS VSS gf180mcu_fd_sc_mcu7t5v0__fill_1
XFILLER_37_437 VDD VDD VSS VSS gf180mcu_fd_sc_mcu7t5v0__fill_1
XFILLER_64_223 VDD VDD VSS VSS gf180mcu_fd_sc_mcu7t5v0__fillcap_16
XTAP_TAPCELL_ROW_69_1013 VDD VSS gf180mcu_fd_sc_mcu7t5v0__filltie
Xspi_regs_inst__0944_ spi_regs_inst__0909_/Z spi_regs_inst__0995_/A3 spi_regs_inst__0992_/A1
+ VDD VDD VSS VSS gf180mcu_fd_sc_mcu7t5v0__nand2_1
XFILLER_80_716 VDD VDD VSS VSS gf180mcu_fd_sc_mcu7t5v0__fill_2
XTAP_TAPCELL_ROW_63_914 VDD VSS gf180mcu_fd_sc_mcu7t5v0__filltie
Xspi_regs_inst__0875_ spi_regs_inst__1610_/Q spi_regs_inst__1408_/I1 spi_regs_inst__0875_/S
+ spi_regs_inst__1610_/D VDD VDD VSS VSS gf180mcu_fd_sc_mcu7t5v0__mux2_2
XFILLER_79_1170 VDD VDD VSS VSS gf180mcu_fd_sc_mcu7t5v0__fillcap_4
XFILLER_166_1151 VDD VDD VSS VSS gf180mcu_fd_sc_mcu7t5v0__fillcap_4
XFILLER_45_492 VDD VDD VSS VSS gf180mcu_fd_sc_mcu7t5v0__fillcap_8
XTAP_TAPCELL_ROW_82_1224 VDD VSS gf180mcu_fd_sc_mcu7t5v0__filltie
XTAP_TAPCELL_ROW_82_1235 VDD VSS gf180mcu_fd_sc_mcu7t5v0__filltie
XFILLER_32_142 VDD VDD VSS VSS gf180mcu_fd_sc_mcu7t5v0__fillcap_4
XFILLER_60_473 VDD VDD VSS VSS gf180mcu_fd_sc_mcu7t5v0__fill_2
XPHY_EDGE_ROW_120_Right_120 VDD VSS gf180mcu_fd_sc_mcu7t5v0__endcap
XFILLER_146_501 VDD VDD VSS VSS gf180mcu_fd_sc_mcu7t5v0__fillcap_4
XFILLER_146_512 VDD VDD VSS VSS gf180mcu_fd_sc_mcu7t5v0__fillcap_8
XFILLER_9_360 VDD VDD VSS VSS gf180mcu_fd_sc_mcu7t5v0__fillcap_4
Xspi_regs_inst__1427_ spi_regs_inst__1451_/I1 spi_regs_inst__1498_/Q spi_regs_inst__1427_/S
+ spi_regs_inst__1498_/D VDD VDD VSS VSS gf180mcu_fd_sc_mcu7t5v0__mux2_2
Xwave_controller_x_inst__2070_ wave_controller_x_inst__2073_/A2 wave_controller_x_inst__2069_/Z
+ wave_controller_x_inst__2070_/Z VDD VDD VSS VSS gf180mcu_fd_sc_mcu7t5v0__or2_1
Xspi_regs_inst__1358_ spi_regs_inst__1358_/A1 spi_regs_inst__1358_/A2 spi_regs_inst__1358_/A3
+ spi_regs_inst__1358_/A4 spi_regs_inst__1359_/A4 VDD VDD VSS VSS gf180mcu_fd_sc_mcu7t5v0__nand4_1
Xspi_regs_inst__1289_ spi_regs_inst__1512_/Q spi_regs_inst_wire242/Z spi_regs_inst__1301_/B1
+ spi_regs_inst__1289_/B2 spi_regs_inst__1291_/A3 VDD VDD VSS VSS gf180mcu_fd_sc_mcu7t5v0__aoi22_1
XFILLER_114_453 VDD VDD VSS VSS gf180mcu_fd_sc_mcu7t5v0__fill_2
XFILLER_115_976 VDD VDD VSS VSS gf180mcu_fd_sc_mcu7t5v0__fillcap_4
XFILLER_99_142 VDD VDD VSS VSS gf180mcu_fd_sc_mcu7t5v0__fill_2
XTAP_TAPCELL_ROW_12_1_424 VDD VSS gf180mcu_fd_sc_mcu7t5v0__filltie
Xwave_controller_x_inst__2972_ wave_controller_x_inst__2972_/A1 wave_controller_x_inst__3053_/A3
+ wave_controller_x_inst__2972_/B wave_controller_x_inst__3055_/B VDD VDD VSS VSS
+ gf180mcu_fd_sc_mcu7t5v0__oai21_1
Xwave_controller_x_inst__1923_ wave_controller_x_inst__1923_/A1 wave_controller_x_inst__1923_/A2
+ wave_controller_x_inst__1923_/B wave_controller_x_inst__1924_/C VDD VDD VSS VSS
+ gf180mcu_fd_sc_mcu7t5v0__aoi21_1
XTAP_TAPCELL_ROW_20_1_481 VDD VSS gf180mcu_fd_sc_mcu7t5v0__filltie
Xwave_controller_y_inst__1870_ spi_regs_inst__1139_/A1 wave_controller_y_inst__3503_/B2
+ VDD VDD VSS VSS gf180mcu_fd_sc_mcu7t5v0__clkinv_1
Xwave_controller_x_inst__1854_ max_cap460/I wave_controller_x_inst__2516_/A1 VDD VDD
+ VSS VSS gf180mcu_fd_sc_mcu7t5v0__clkinv_1
Xsignal_processor_y_inst__239_ signal_processor_y_inst__239_/D signal_processor_y_inst__253_/RN
+ clkbuf_leaf_0_clk/Z signal_processor_y_inst__239_/Q VDD VDD VSS VSS gf180mcu_fd_sc_mcu7t5v0__dffrnq_1
XFILLER_55_212 VDD VDD VSS VSS gf180mcu_fd_sc_mcu7t5v0__fillcap_16
XFILLER_56_757 VDD VDD VSS VSS gf180mcu_fd_sc_mcu7t5v0__fill_2
XFILLER_95_370 VDD VDD VSS VSS gf180mcu_fd_sc_mcu7t5v0__fill_1
XFILLER_55_245 VDD VDD VSS VSS gf180mcu_fd_sc_mcu7t5v0__fillcap_32
Xwave_controller_y_inst__3540_ wave_controller_y_inst__1781_/I wave_controller_y_inst__3555_/A2
+ wave_controller_y_inst__3542_/A2 VDD VDD VSS VSS gf180mcu_fd_sc_mcu7t5v0__nor2_1
Xwave_controller_x_inst__3524_ wave_controller_x_inst__3530_/A1 wave_controller_x_inst__3524_/A2
+ wave_controller_x_inst__3524_/A3 wave_controller_x_inst__3530_/B1 wave_controller_x_inst__3524_/B2
+ wave_controller_x_inst__3637_/D VDD VDD VSS VSS gf180mcu_fd_sc_mcu7t5v0__oai32_1
Xwave_controller_x_inst__1785_ wave_controller_x_inst__1785_/I wave_controller_x_inst__3265_/A1
+ VDD VDD VSS VSS gf180mcu_fd_sc_mcu7t5v0__inv_1
XFILLER_102_34 VDD VDD VSS VSS gf180mcu_fd_sc_mcu7t5v0__fill_1
XFILLER_102_78 VDD VDD VSS VSS gf180mcu_fd_sc_mcu7t5v0__fill_1
XFILLER_23_120 VDD VDD VSS VSS gf180mcu_fd_sc_mcu7t5v0__fillcap_4
Xwave_controller_y_inst__3471_ wave_controller_y_inst__3485_/B wave_controller_y_inst__3468_/I
+ wave_controller_y_inst__3491_/B wave_controller_y_inst__3472_/B2 VDD VDD VSS VSS
+ gf180mcu_fd_sc_mcu7t5v0__oai21_1
Xwave_controller_x_inst__3455_ wave_controller_x_inst__3462_/B2 wave_controller_x_inst__3487_/A2
+ wave_controller_x_inst__3456_/B VDD VDD VSS VSS gf180mcu_fd_sc_mcu7t5v0__nand2_1
XFILLER_23_142 VDD VDD VSS VSS gf180mcu_fd_sc_mcu7t5v0__fillcap_4
Xwave_controller_y_inst__2422_ wave_controller_y_inst__2436_/A1 wave_controller_y_inst__2422_/A2
+ wave_controller_y_inst__2434_/B wave_controller_y_inst__2423_/A2 VDD VDD VSS VSS
+ gf180mcu_fd_sc_mcu7t5v0__aoi21_1
Xwave_controller_x_inst__3386_ fanout523/Z wave_controller_x_inst__3386_/A2 wave_controller_x_inst__3386_/B
+ wave_controller_x_inst__3386_/C wave_controller_x_inst__3390_/B1 VDD VDD VSS VSS
+ gf180mcu_fd_sc_mcu7t5v0__oai211_1
Xwave_controller_x_inst__2406_ wave_controller_x_inst__2407_/A1 wave_controller_x_inst__2407_/A2
+ wave_controller_x_inst__2408_/A2 VDD VDD VSS VSS gf180mcu_fd_sc_mcu7t5v0__nand2_1
Xsignal_processor_x_inst__130_ signal_processor_x_inst__230_/Q signal_processor_x_inst__256_/Q
+ signal_processor_x_inst__203_/A1 VDD VDD VSS VSS gf180mcu_fd_sc_mcu7t5v0__nand2_1
Xwave_controller_y_inst__2353_ wave_controller_y_inst_wire120/Z wave_controller_y_inst__2352_/Z
+ wave_controller_y_inst__2356_/A3 VDD VDD VSS VSS gf180mcu_fd_sc_mcu7t5v0__xnor2_1
Xwave_controller_x_inst__2337_ max_cap453/Z wave_controller_x_inst__2336_/Z wave_controller_x_inst__2337_/Z
+ VDD VDD VSS VSS gf180mcu_fd_sc_mcu7t5v0__and2_1
XFILLER_137_512 VDD VDD VSS VSS gf180mcu_fd_sc_mcu7t5v0__fill_2
Xwave_controller_y_inst__2284_ wave_controller_y_inst__2284_/A1 spi_regs_inst__1139_/B2
+ wave_controller_y_inst__2284_/Z VDD VDD VSS VSS gf180mcu_fd_sc_mcu7t5v0__xor2_1
Xwave_controller_x_inst__2268_ wave_controller_x_inst__2268_/A1 wave_controller_x_inst__2249_/Z
+ wave_controller_x_inst__2267_/B wave_controller_x_inst__2268_/Z VDD VDD VSS VSS
+ gf180mcu_fd_sc_mcu7t5v0__or3_1
XFILLER_137_578 VDD VDD VSS VSS gf180mcu_fd_sc_mcu7t5v0__fill_2
Xwave_controller_x_inst__2199_ max_cap460/Z wave_controller_x_inst__2197_/Z wave_controller_x_inst__2201_/B
+ VDD VDD VSS VSS gf180mcu_fd_sc_mcu7t5v0__xor2_1
XFILLER_106_932 VDD VDD VSS VSS gf180mcu_fd_sc_mcu7t5v0__fillcap_8
Xwave_controller_y_inst_fanout411 wave_controller_y_inst__3722_/Q wave_controller_y_inst_wire412/I
+ VDD VDD VSS VSS gf180mcu_fd_sc_mcu7t5v0__dlyb_1
XFILLER_133_740 VDD VDD VSS VSS gf180mcu_fd_sc_mcu7t5v0__fillcap_8
XTAP_TAPCELL_ROW_111_1707 VDD VSS gf180mcu_fd_sc_mcu7t5v0__filltie
Xwave_controller_y_inst_fanout422 wave_controller_y_inst__3708_/Q wave_controller_y_inst__1792_/I
+ VDD VDD VSS VSS gf180mcu_fd_sc_mcu7t5v0__dlyb_1
XTAP_TAPCELL_ROW_148_2320 VDD VSS gf180mcu_fd_sc_mcu7t5v0__filltie
XFILLER_160_592 VDD VDD VSS VSS gf180mcu_fd_sc_mcu7t5v0__fill_2
XFILLER_59_573 VDD VDD VSS VSS gf180mcu_fd_sc_mcu7t5v0__fillcap_16
XFILLER_143_85 VDD VDD VSS VSS gf180mcu_fd_sc_mcu7t5v0__fill_1
XFILLER_46_212 VDD VDD VSS VSS gf180mcu_fd_sc_mcu7t5v0__fill_1
XFILLER_86_381 VDD VDD VSS VSS gf180mcu_fd_sc_mcu7t5v0__fillcap_4
XTAP_TAPCELL_ROW_161_2531 VDD VSS gf180mcu_fd_sc_mcu7t5v0__filltie
XTAP_TAPCELL_ROW_109_1669 VDD VSS gf180mcu_fd_sc_mcu7t5v0__filltie
XTAP_TAPCELL_ROW_126_1950 VDD VSS gf180mcu_fd_sc_mcu7t5v0__filltie
Xwave_controller_y_inst__3738_ wave_controller_y_inst__3738_/D wave_controller_y_inst__3739_/RN
+ clkload4/I wave_controller_y_inst__3738_/Q VDD VDD VSS VSS gf180mcu_fd_sc_mcu7t5v0__dffrnq_1
Xwave_controller_y_inst__1999_ fanout519/Z wave_controller_y_inst__2318_/A1 wave_controller_y_inst__1999_/B1
+ wave_controller_y_inst__1999_/B2 wave_controller_y_inst__1999_/C wave_controller_y_inst__2001_/A2
+ VDD VDD VSS VSS gf180mcu_fd_sc_mcu7t5v0__oai221_1
XTAP_TAPCELL_ROW_126_1961 VDD VSS gf180mcu_fd_sc_mcu7t5v0__filltie
XFILLER_27_492 VDD VDD VSS VSS gf180mcu_fd_sc_mcu7t5v0__fillcap_8
XFILLER_36_83 VDD VDD VSS VSS gf180mcu_fd_sc_mcu7t5v0__fill_2
XFILLER_36_94 VDD VDD VSS VSS gf180mcu_fd_sc_mcu7t5v0__fillcap_8
Xwave_controller_y_inst__3669_ wave_controller_y_inst__3669_/D wave_controller_y_inst__3721_/RN
+ clkload4/I spi_regs_inst__1234_/A1 VDD VDD VSS VSS gf180mcu_fd_sc_mcu7t5v0__dffrnq_1
Xspi_regs_inst_max_cap232 spi_regs_inst_wire233/Z spi_regs_inst__1334_/B1 VDD VDD
+ VSS VSS gf180mcu_fd_sc_mcu7t5v0__buf_2
Xspi_regs_inst_max_cap298 spi_regs_inst_wire299/Z spi_regs_inst__1231_/A2 VDD VDD
+ VSS VSS gf180mcu_fd_sc_mcu7t5v0__buf_2
Xspi_regs_inst_max_cap287 spi_regs_inst__1167_/A2 spi_regs_inst_wire286/I VDD VDD
+ VSS VSS gf180mcu_fd_sc_mcu7t5v0__buf_2
Xspi_regs_inst_max_cap276 spi_regs_inst__1202_/A2 spi_regs_inst__1254_/A2 VDD VDD
+ VSS VSS gf180mcu_fd_sc_mcu7t5v0__buf_2
Xspi_regs_inst_max_cap265 spi_regs_inst__1085_/C1 spi_regs_inst__1337_/A2 VDD VDD
+ VSS VSS gf180mcu_fd_sc_mcu7t5v0__buf_2
XFILLER_159_136 VDD VDD VSS VSS gf180mcu_fd_sc_mcu7t5v0__fillcap_4
XFILLER_42_495 VDD VDD VSS VSS gf180mcu_fd_sc_mcu7t5v0__fill_2
XTAP_TAPCELL_ROW_159_2493 VDD VSS gf180mcu_fd_sc_mcu7t5v0__filltie
XFILLER_128_556 VDD VDD VSS VSS gf180mcu_fd_sc_mcu7t5v0__fill_2
Xspi_regs_inst__1212_ spi_regs_inst_wire19/Z spi_regs_inst__1257_/B1 spi_regs_inst_wire214/I
+ spi_regs_inst__1212_/B2 spi_regs_inst__1214_/A3 VDD VDD VSS VSS gf180mcu_fd_sc_mcu7t5v0__aoi22_1
XFILLER_116_729 VDD VDD VSS VSS gf180mcu_fd_sc_mcu7t5v0__fillcap_4
XFILLER_122_1087 VDD VDD VSS VSS gf180mcu_fd_sc_mcu7t5v0__fillcap_64
Xspi_regs_inst__1143_ spi_regs_inst__1572_/Q spi_regs_inst__1347_/A2 spi_regs_inst_wire207/I
+ fanout529/Z spi_regs_inst__1147_/A1 VDD VDD VSS VSS gf180mcu_fd_sc_mcu7t5v0__aoi22_1
XFILLER_109_792 VDD VDD VSS VSS gf180mcu_fd_sc_mcu7t5v0__fillcap_16
XFILLER_6_363 VDD VDD VSS VSS gf180mcu_fd_sc_mcu7t5v0__fill_2
Xspi_regs_inst__1074_ spi_regs_inst__1623_/Q spi_regs_inst__1075_/A2 spi_regs_inst__1074_/Z
+ VDD VDD VSS VSS gf180mcu_fd_sc_mcu7t5v0__and2_1
XFILLER_123_261 VDD VDD VSS VSS gf180mcu_fd_sc_mcu7t5v0__fill_1
XFILLER_151_592 VDD VDD VSS VSS gf180mcu_fd_sc_mcu7t5v0__fillcap_8
XFILLER_37_212 VDD VDD VSS VSS gf180mcu_fd_sc_mcu7t5v0__fill_1
XFILLER_25_407 VDD VDD VSS VSS gf180mcu_fd_sc_mcu7t5v0__fillcap_8
XFILLER_37_234 VDD VDD VSS VSS gf180mcu_fd_sc_mcu7t5v0__fill_1
XFILLER_53_716 VDD VDD VSS VSS gf180mcu_fd_sc_mcu7t5v0__fillcap_4
Xspi_regs_inst__0927_ spi_regs_inst__0927_/I spi_regs_inst__1633_/D VDD VDD VSS VSS
+ gf180mcu_fd_sc_mcu7t5v0__clkinv_1
XFILLER_93_896 VDD VDD VSS VSS gf180mcu_fd_sc_mcu7t5v0__fillcap_8
Xspi_regs_inst__0858_ spi_regs_inst__1595_/Q spi_regs_inst__1391_/I1 spi_regs_inst__0861_/S
+ spi_regs_inst__1595_/D VDD VDD VSS VSS gf180mcu_fd_sc_mcu7t5v0__mux2_2
XFILLER_33_462 VDD VDD VSS VSS gf180mcu_fd_sc_mcu7t5v0__fill_1
Xwave_controller_x_inst__3240_ wave_controller_x_inst__3240_/A1 wave_controller_x_inst__3240_/A2
+ wave_controller_x_inst__3240_/A3 wave_controller_x_inst__3240_/B wave_controller_x_inst__3241_/B2
+ VDD VDD VSS VSS gf180mcu_fd_sc_mcu7t5v0__oai31_1
Xspi_regs_inst__0789_ spi_regs_inst__1446_/A1 spi_regs_inst__0827_/A4 spi_regs_inst__0797_/S
+ VDD VDD VSS VSS gf180mcu_fd_sc_mcu7t5v0__nor2_2
Xwave_controller_x_inst__3171_ wave_controller_x_inst__1781_/I spi_regs_inst__1535_/Q
+ wave_controller_x_inst__3171_/Z VDD VDD VSS VSS gf180mcu_fd_sc_mcu7t5v0__xor2_1
XFILLER_119_556 VDD VDD VSS VSS gf180mcu_fd_sc_mcu7t5v0__fillcap_4
XFILLER_147_832 VDD VDD VSS VSS gf180mcu_fd_sc_mcu7t5v0__fillcap_8
XFILLER_159_692 VDD VDD VSS VSS gf180mcu_fd_sc_mcu7t5v0__fillcap_8
Xwave_controller_x_inst__2122_ wave_controller_x_inst__3729_/Q wave_controller_x_inst__2123_/A1
+ wave_controller_x_inst__2122_/A3 wave_controller_x_inst__3729_/D VDD VDD VSS VSS
+ gf180mcu_fd_sc_mcu7t5v0__xor3_1
XFILLER_101_1116 VDD VDD VSS VSS gf180mcu_fd_sc_mcu7t5v0__fillcap_4
Xwave_controller_x_inst__2053_ wave_controller_x_inst__2114_/B wave_controller_x_inst_wire377/Z
+ wave_controller_x_inst__2098_/C wave_controller_x_inst__2062_/B1 VDD VDD VSS VSS
+ gf180mcu_fd_sc_mcu7t5v0__oai21_1
XTAP_TAPCELL_ROW_95_1437 VDD VSS gf180mcu_fd_sc_mcu7t5v0__filltie
XFILLER_106_228 VDD VDD VSS VSS gf180mcu_fd_sc_mcu7t5v0__fillcap_16
XTAP_TAPCELL_ROW_95_1448 VDD VSS gf180mcu_fd_sc_mcu7t5v0__filltie
XFILLER_103_902 VDD VDD VSS VSS gf180mcu_fd_sc_mcu7t5v0__fill_2
XFILLER_130_732 VDD VDD VSS VSS gf180mcu_fd_sc_mcu7t5v0__fill_2
Xwave_controller_y_inst__2971_ wave_controller_y_inst__2957_/Z wave_controller_y_inst__3050_/B
+ wave_controller_y_inst__2971_/B wave_controller_y_inst__3053_/A3 VDD VDD VSS VSS
+ gf180mcu_fd_sc_mcu7t5v0__aoi21_1
Xwave_controller_x_inst__2955_ wave_controller_x_inst__3705_/Q fanout526/Z wave_controller_x_inst__2956_/I
+ VDD VDD VSS VSS gf180mcu_fd_sc_mcu7t5v0__nand2_1
Xwave_controller_y_inst__1922_ spi_regs_inst__1567_/Q wave_controller_y_inst__3568_/A1
+ wave_controller_y_inst__3290_/A1 spi_regs_inst__1566_/Q wave_controller_y_inst__1923_/B
+ VDD VDD VSS VSS gf180mcu_fd_sc_mcu7t5v0__oai22_1
Xwave_controller_x_inst__1906_ spi_regs_inst__1197_/B2 wave_controller_x_inst__3452_/A1
+ VDD VDD VSS VSS gf180mcu_fd_sc_mcu7t5v0__clkinv_1
XFILLER_68_381 VDD VDD VSS VSS gf180mcu_fd_sc_mcu7t5v0__fillcap_4
XFILLER_87_189 VDD VDD VSS VSS gf180mcu_fd_sc_mcu7t5v0__fillcap_16
Xwave_controller_y_inst__1853_ spi_regs_inst__1065_/B2 wave_controller_y_inst__2162_/A2
+ VDD VDD VSS VSS gf180mcu_fd_sc_mcu7t5v0__clkinv_1
Xwave_controller_x_inst__2886_ wave_controller_x_inst__2869_/B wave_controller_x_inst__2886_/A2
+ wave_controller_x_inst__2886_/B wave_controller_x_inst__2886_/C wave_controller_x_inst__2887_/A3
+ VDD VDD VSS VSS gf180mcu_fd_sc_mcu7t5v0__aoi211_1
XFILLER_28_256 VDD VDD VSS VSS gf180mcu_fd_sc_mcu7t5v0__fillcap_16
XFILLER_83_340 VDD VDD VSS VSS gf180mcu_fd_sc_mcu7t5v0__fill_2
Xwave_controller_x_inst__1837_ spi_regs_inst__1284_/B2 wave_controller_x_inst__2223_/B2
+ VDD VDD VSS VSS gf180mcu_fd_sc_mcu7t5v0__clkinv_1
XFILLER_113_88 VDD VDD VSS VSS gf180mcu_fd_sc_mcu7t5v0__fill_2
Xwave_controller_y_inst__1784_ spi_regs_inst__1575_/Q wave_controller_y_inst__1937_/B1
+ VDD VDD VSS VSS gf180mcu_fd_sc_mcu7t5v0__clkinv_1
Xwave_controller_y_inst__3523_ spi_regs_inst__1099_/B2 wave_controller_y_inst__3556_/A2
+ wave_controller_y_inst__3524_/A3 VDD VDD VSS VSS gf180mcu_fd_sc_mcu7t5v0__nor2_1
Xwave_controller_x_inst__3507_ wave_controller_x_inst__3705_/Q wave_controller_x_inst__3537_/A2
+ wave_controller_x_inst__3509_/A2 VDD VDD VSS VSS gf180mcu_fd_sc_mcu7t5v0__nor2_1
XTAP_TAPCELL_ROW_54_766 VDD VSS gf180mcu_fd_sc_mcu7t5v0__filltie
Xwave_controller_y_inst__3454_ wave_controller_y_inst__3458_/A1 wave_controller_y_inst__3454_/A2
+ wave_controller_y_inst__3454_/B wave_controller_y_inst__3454_/C wave_controller_y_inst__3460_/C
+ VDD VDD VSS VSS gf180mcu_fd_sc_mcu7t5v0__aoi211_1
Xwave_controller_x_inst__3438_ wave_controller_x_inst__3440_/A1 wave_controller_x_inst__3494_/A1
+ wave_controller_x_inst__3438_/B wave_controller_x_inst__3439_/I VDD VDD VSS VSS
+ gf180mcu_fd_sc_mcu7t5v0__oai21_1
XFILLER_11_112 VDD VDD VSS VSS gf180mcu_fd_sc_mcu7t5v0__fill_2
XTAP_TAPCELL_ROW_104_1588 VDD VSS gf180mcu_fd_sc_mcu7t5v0__filltie
XTAP_TAPCELL_ROW_104_1599 VDD VSS gf180mcu_fd_sc_mcu7t5v0__filltie
XTAP_TAPCELL_ROW_121_1880 VDD VSS gf180mcu_fd_sc_mcu7t5v0__filltie
Xwave_controller_y_inst__2405_ wave_controller_y_inst__2841_/A1 wave_controller_y_inst__2403_/Z
+ wave_controller_y_inst__2407_/B VDD VDD VSS VSS gf180mcu_fd_sc_mcu7t5v0__xor2_1
Xsignal_processor_x_inst__113_ _90_/I signal_processor_x_inst__196_/A2 VDD VDD VSS
+ VSS gf180mcu_fd_sc_mcu7t5v0__clkinv_1
XFILLER_11_156 VDD VDD VSS VSS gf180mcu_fd_sc_mcu7t5v0__fill_1
Xwave_controller_y_inst__3385_ wave_controller_y_inst__3385_/A1 wave_controller_y_inst__3385_/A2
+ wave_controller_y_inst__3385_/B wave_controller_y_inst__3385_/C wave_controller_y_inst__3386_/B
+ VDD VDD VSS VSS gf180mcu_fd_sc_mcu7t5v0__oai211_1
Xwave_controller_x_inst__3369_ wave_controller_x_inst__3568_/A1 spi_regs_inst__1546_/Q
+ wave_controller_x_inst__3369_/A3 wave_controller_x_inst__3369_/Z VDD VDD VSS VSS
+ gf180mcu_fd_sc_mcu7t5v0__xor3_1
Xwave_controller_y_inst__2336_ fanout517/Z wave_controller_y_inst__2332_/Z wave_controller_y_inst__2336_/A3
+ wave_controller_y_inst__2336_/Z VDD VDD VSS VSS gf180mcu_fd_sc_mcu7t5v0__xor3_1
XFILLER_22_85 VDD VDD VSS VSS gf180mcu_fd_sc_mcu7t5v0__fillcap_8
Xwave_controller_y_inst__2267_ wave_controller_y_inst__2268_/A1 wave_controller_y_inst__2249_/Z
+ wave_controller_y_inst__2267_/B wave_controller_y_inst__2270_/A2 VDD VDD VSS VSS
+ gf180mcu_fd_sc_mcu7t5v0__oai21_1
XFILLER_152_312 VDD VDD VSS VSS gf180mcu_fd_sc_mcu7t5v0__fill_2
XFILLER_98_34 VDD VDD VSS VSS gf180mcu_fd_sc_mcu7t5v0__fill_1
Xwave_controller_y_inst__2198_ wave_controller_y_inst__2516_/A1 wave_controller_y_inst__2197_/Z
+ wave_controller_y_inst__2210_/B VDD VDD VSS VSS gf180mcu_fd_sc_mcu7t5v0__nor2_1
XFILLER_125_559 VDD VDD VSS VSS gf180mcu_fd_sc_mcu7t5v0__fill_1
XFILLER_140_507 VDD VDD VSS VSS gf180mcu_fd_sc_mcu7t5v0__fillcap_4
XFILLER_98_45 VDD VDD VSS VSS gf180mcu_fd_sc_mcu7t5v0__fill_2
XFILLER_79_624 VDD VDD VSS VSS gf180mcu_fd_sc_mcu7t5v0__fillcap_4
XFILLER_121_732 VDD VDD VSS VSS gf180mcu_fd_sc_mcu7t5v0__fill_1
XFILLER_133_592 VDD VDD VSS VSS gf180mcu_fd_sc_mcu7t5v0__fill_2
XFILLER_120_253 VDD VDD VSS VSS gf180mcu_fd_sc_mcu7t5v0__fillcap_4
XFILLER_154_95 VDD VDD VSS VSS gf180mcu_fd_sc_mcu7t5v0__fillcap_8
XFILLER_67_819 VDD VDD VSS VSS gf180mcu_fd_sc_mcu7t5v0__fill_2
XFILLER_94_605 VDD VDD VSS VSS gf180mcu_fd_sc_mcu7t5v0__fillcap_4
XFILLER_121_798 VDD VDD VSS VSS gf180mcu_fd_sc_mcu7t5v0__fillcap_8
XFILLER_93_137 VDD VDD VSS VSS gf180mcu_fd_sc_mcu7t5v0__fill_2
XTAP_TAPCELL_ROW_37_1_610 VDD VSS gf180mcu_fd_sc_mcu7t5v0__filltie
XFILLER_19_234 VDD VDD VSS VSS gf180mcu_fd_sc_mcu7t5v0__fillcap_16
XFILLER_93_159 VDD VDD VSS VSS gf180mcu_fd_sc_mcu7t5v0__fillcap_8
XFILLER_34_215 VDD VDD VSS VSS gf180mcu_fd_sc_mcu7t5v0__fill_2
XFILLER_62_524 VDD VDD VSS VSS gf180mcu_fd_sc_mcu7t5v0__fill_1
XFILLER_74_384 VDD VDD VSS VSS gf180mcu_fd_sc_mcu7t5v0__fill_1
XFILLER_62_568 VDD VDD VSS VSS gf180mcu_fd_sc_mcu7t5v0__fill_1
XFILLER_76_1151 VDD VDD VSS VSS gf180mcu_fd_sc_mcu7t5v0__fillcap_4
XFILLER_76_1173 VDD VDD VSS VSS gf180mcu_fd_sc_mcu7t5v0__fill_1
XFILLER_90_877 VDD VDD VSS VSS gf180mcu_fd_sc_mcu7t5v0__fillcap_8
XFILLER_163_1154 VDD VDD VSS VSS gf180mcu_fd_sc_mcu7t5v0__fillcap_16
XFILLER_70_590 VDD VDD VSS VSS gf180mcu_fd_sc_mcu7t5v0__fill_1
XTAP_TAPCELL_ROW_11_1_412 VDD VSS gf180mcu_fd_sc_mcu7t5v0__filltie
XFILLER_128_364 VDD VDD VSS VSS gf180mcu_fd_sc_mcu7t5v0__fill_2
XFILLER_129_887 VDD VDD VSS VSS gf180mcu_fd_sc_mcu7t5v0__fill_2
XFILLER_129_898 VDD VDD VSS VSS gf180mcu_fd_sc_mcu7t5v0__fill_2
XFILLER_6_171 VDD VDD VSS VSS gf180mcu_fd_sc_mcu7t5v0__fillcap_4
XTAP_TAPCELL_ROW_77_1145 VDD VSS gf180mcu_fd_sc_mcu7t5v0__filltie
Xspi_regs_inst__1126_ spi_regs_inst__1266_/S spi_regs_inst__1124_/Z spi_regs_inst__1126_/A3
+ spi_regs_inst__1126_/B spi_regs_inst__1643_/D VDD VDD VSS VSS gf180mcu_fd_sc_mcu7t5v0__oai31_1
XFILLER_143_367 VDD VDD VSS VSS gf180mcu_fd_sc_mcu7t5v0__fill_1
XFILLER_83_1122 VDD VDD VSS VSS gf180mcu_fd_sc_mcu7t5v0__fillcap_32
Xspi_regs_inst__1057_ spi_regs_inst__1057_/A1 spi_regs_inst__1057_/A2 spi_regs_inst__1057_/A3
+ spi_regs_inst__1057_/A4 spi_regs_inst__1071_/A1 VDD VDD VSS VSS gf180mcu_fd_sc_mcu7t5v0__nand4_1
XFILLER_112_732 VDD VDD VSS VSS gf180mcu_fd_sc_mcu7t5v0__fill_2
XFILLER_97_432 VDD VDD VSS VSS gf180mcu_fd_sc_mcu7t5v0__fillcap_8
XTAP_TAPCELL_ROW_90_1356 VDD VSS gf180mcu_fd_sc_mcu7t5v0__filltie
XTAP_TAPCELL_ROW_90_1367 VDD VSS gf180mcu_fd_sc_mcu7t5v0__filltie
XFILLER_57_318 VDD VDD VSS VSS gf180mcu_fd_sc_mcu7t5v0__fillcap_32
XFILLER_69_167 VDD VDD VSS VSS gf180mcu_fd_sc_mcu7t5v0__fill_1
Xwave_controller_x_inst__2740_ wave_controller_x_inst__2749_/A1 wave_controller_x_inst_wire36/Z
+ spi_regs_inst__1160_/B2 VDD VDD VSS VSS gf180mcu_fd_sc_mcu7t5v0__xor2_1
XFILLER_111_275 VDD VDD VSS VSS gf180mcu_fd_sc_mcu7t5v0__fillcap_4
XFILLER_38_554 VDD VDD VSS VSS gf180mcu_fd_sc_mcu7t5v0__fill_1
XFILLER_66_874 VDD VDD VSS VSS gf180mcu_fd_sc_mcu7t5v0__fill_1
Xwave_controller_x_inst__2671_ wave_controller_x_inst__2671_/A1 wave_controller_x_inst__2671_/A2
+ wave_controller_x_inst__2694_/A1 VDD VDD VSS VSS gf180mcu_fd_sc_mcu7t5v0__nand2_1
XFILLER_93_682 VDD VDD VSS VSS gf180mcu_fd_sc_mcu7t5v0__fill_2
X_19_ _19_/D _21_/CLK _19_/Q VDD VDD VSS VSS gf180mcu_fd_sc_mcu7t5v0__dffq_1
XFILLER_25_237 VDD VDD VSS VSS gf180mcu_fd_sc_mcu7t5v0__fill_2
XFILLER_80_376 VDD VDD VSS VSS gf180mcu_fd_sc_mcu7t5v0__fill_1
XFILLER_80_387 VDD VDD VSS VSS gf180mcu_fd_sc_mcu7t5v0__fillcap_16
XFILLER_21_454 VDD VDD VSS VSS gf180mcu_fd_sc_mcu7t5v0__fillcap_4
Xwave_controller_x_inst__3223_ fanout527/Z wave_controller_x_inst__3235_/A2 wave_controller_x_inst__3237_/A2
+ VDD VDD VSS VSS gf180mcu_fd_sc_mcu7t5v0__nor2_1
Xwave_controller_y_inst__3170_ wave_controller_y_inst__3107_/Z wave_controller_y_inst__3197_/A1
+ wave_controller_y_inst__3174_/A2 wave_controller_y_inst__3170_/B wave_controller_y_inst__3195_/A1
+ VDD VDD VSS VSS gf180mcu_fd_sc_mcu7t5v0__oai31_1
Xwave_controller_x_inst__3154_ wave_controller_x_inst__3211_/A1 wave_controller_x_inst__3211_/A2
+ wave_controller_x_inst__3211_/B wave_controller_x_inst__3208_/B wave_controller_x_inst__3154_/Z
+ VDD VDD VSS VSS gf180mcu_fd_sc_mcu7t5v0__and4_1
XFILLER_135_802 VDD VDD VSS VSS gf180mcu_fd_sc_mcu7t5v0__fill_1
XFILLER_147_651 VDD VDD VSS VSS gf180mcu_fd_sc_mcu7t5v0__fillcap_8
XFILLER_88_1011 VDD VDD VSS VSS gf180mcu_fd_sc_mcu7t5v0__fillcap_4
Xwave_controller_y_inst_hold690 wave_controller_y_inst__3734_/Q wave_controller_y_inst__3724_/D
+ VDD VDD VSS VSS gf180mcu_fd_sc_mcu7t5v0__dlyc_1
Xwave_controller_y_inst__2121_ wave_controller_y_inst__2754_/A2 wave_controller_y_inst__2118_/Z
+ wave_controller_y_inst__3729_/Q wave_controller_y_inst__2123_/A2 VDD VDD VSS VSS
+ gf180mcu_fd_sc_mcu7t5v0__aoi21_1
Xwave_controller_x_inst__2105_ wave_controller_x_inst__2105_/A1 wave_controller_x_inst__2104_/B
+ wave_controller_x_inst__3728_/D VDD VDD VSS VSS gf180mcu_fd_sc_mcu7t5v0__xnor2_1
XFILLER_146_150 VDD VDD VSS VSS gf180mcu_fd_sc_mcu7t5v0__fill_2
Xwave_controller_y_inst__2052_ wave_controller_y_inst__3189_/C wave_controller_y_inst__3089_/B
+ wave_controller_y_inst__2114_/C VDD VDD VSS VSS gf180mcu_fd_sc_mcu7t5v0__xor2_1
Xwave_controller_x_inst__3085_ wave_controller_x_inst__3718_/Q wave_controller_x_inst__3085_/A2
+ fanout399/Z wave_controller_x_inst__3086_/A2 VDD VDD VSS VSS gf180mcu_fd_sc_mcu7t5v0__oai21_1
XFILLER_107_559 VDD VDD VSS VSS gf180mcu_fd_sc_mcu7t5v0__fill_1
XFILLER_161_142 VDD VDD VSS VSS gf180mcu_fd_sc_mcu7t5v0__fillcap_32
Xwave_controller_x_inst__2036_ wave_controller_x_inst__1783_/I wave_controller_x_inst__3089_/B
+ wave_controller_x_inst__2068_/A2 VDD VDD VSS VSS gf180mcu_fd_sc_mcu7t5v0__xnor2_1
XFILLER_0_303 VDD VDD VSS VSS gf180mcu_fd_sc_mcu7t5v0__fill_2
XFILLER_115_570 VDD VDD VSS VSS gf180mcu_fd_sc_mcu7t5v0__fillcap_4
XFILLER_143_890 VDD VDD VSS VSS gf180mcu_fd_sc_mcu7t5v0__fillcap_16
XFILLER_88_421 VDD VDD VSS VSS gf180mcu_fd_sc_mcu7t5v0__fill_1
XFILLER_124_10 VDD VDD VSS VSS gf180mcu_fd_sc_mcu7t5v0__fillcap_4
XFILLER_130_540 VDD VDD VSS VSS gf180mcu_fd_sc_mcu7t5v0__fill_1
Xwave_controller_y_inst__2954_ wave_controller_y_inst__3706_/Q wave_controller_y_inst__1825_/I
+ wave_controller_y_inst__2972_/A1 VDD VDD VSS VSS gf180mcu_fd_sc_mcu7t5v0__nor2_1
Xspi_regs_inst_wire195 spi_regs_inst__0851_/S spi_regs_inst__0849_/S VDD VDD VSS VSS
+ gf180mcu_fd_sc_mcu7t5v0__buf_3
XFILLER_102_264 VDD VDD VSS VSS gf180mcu_fd_sc_mcu7t5v0__fillcap_8
XFILLER_88_487 VDD VDD VSS VSS gf180mcu_fd_sc_mcu7t5v0__fillcap_4
XTAP_TAPCELL_ROW_59_847 VDD VSS gf180mcu_fd_sc_mcu7t5v0__filltie
Xwave_controller_y_inst__1905_ spi_regs_inst__1160_/A1 wave_controller_y_inst__3443_/A1
+ VDD VDD VSS VSS gf180mcu_fd_sc_mcu7t5v0__clkinv_1
Xwave_controller_x_inst_fanout159 wave_controller_x_inst__3518_/B1 wave_controller_x_inst__3530_/B1
+ VDD VDD VSS VSS gf180mcu_fd_sc_mcu7t5v0__dlyb_1
Xwave_controller_x_inst__2938_ wave_controller_x_inst__3716_/Q wave_controller_x_inst__2939_/A2
+ wave_controller_x_inst__2938_/Z VDD VDD VSS VSS gf180mcu_fd_sc_mcu7t5v0__or2_1
XFILLER_124_87 VDD VDD VSS VSS gf180mcu_fd_sc_mcu7t5v0__fillcap_4
XFILLER_29_554 VDD VDD VSS VSS gf180mcu_fd_sc_mcu7t5v0__fill_1
XFILLER_84_14 VDD VDD VSS VSS gf180mcu_fd_sc_mcu7t5v0__fill_1
XTAP_TAPCELL_ROW_141_2209 VDD VSS gf180mcu_fd_sc_mcu7t5v0__filltie
XTAP_TAPCELL_ROW_59_858 VDD VSS gf180mcu_fd_sc_mcu7t5v0__filltie
Xwave_controller_y_inst__2885_ wave_controller_y_inst__2885_/A1 wave_controller_y_inst__2885_/A2
+ wave_controller_y_inst__2885_/A3 wave_controller_y_inst__2886_/A2 VDD VDD VSS VSS
+ gf180mcu_fd_sc_mcu7t5v0__nand3_1
Xwave_controller_x_inst__2869_ wave_controller_x_inst__3449_/A1 spi_regs_inst__1197_/B2
+ wave_controller_x_inst__2869_/B wave_controller_x_inst__2884_/B wave_controller_x_inst__2881_/A1
+ VDD VDD VSS VSS gf180mcu_fd_sc_mcu7t5v0__oai211_1
XFILLER_16_204 VDD VDD VSS VSS gf180mcu_fd_sc_mcu7t5v0__fill_1
XFILLER_84_682 VDD VDD VSS VSS gf180mcu_fd_sc_mcu7t5v0__fillcap_32
Xwave_controller_y_inst__1836_ spi_regs_inst__1226_/A1 wave_controller_y_inst__2223_/A1
+ VDD VDD VSS VSS gf180mcu_fd_sc_mcu7t5v0__clkinv_1
XFILLER_147_1116 VDD VDD VSS VSS gf180mcu_fd_sc_mcu7t5v0__fillcap_4
XFILLER_16_226 VDD VDD VSS VSS gf180mcu_fd_sc_mcu7t5v0__fill_2
XFILLER_16_237 VDD VDD VSS VSS gf180mcu_fd_sc_mcu7t5v0__fillcap_8
XFILLER_72_855 VDD VDD VSS VSS gf180mcu_fd_sc_mcu7t5v0__fillcap_4
XTAP_TAPCELL_ROW_106_1628 VDD VSS gf180mcu_fd_sc_mcu7t5v0__filltie
XFILLER_72_877 VDD VDD VSS VSS gf180mcu_fd_sc_mcu7t5v0__fillcap_16
Xwave_controller_y_inst__3506_ wave_controller_y_inst_wire144/Z wave_controller_y_inst__3506_/A2
+ wave_controller_y_inst__3506_/A3 wave_controller_y_inst_wire139/Z wave_controller_y_inst__3506_/B2
+ wave_controller_y_inst__3631_/D VDD VDD VSS VSS gf180mcu_fd_sc_mcu7t5v0__oai32_1
XFILLER_129_106 VDD VDD VSS VSS gf180mcu_fd_sc_mcu7t5v0__fillcap_8
XFILLER_12_443 VDD VDD VSS VSS gf180mcu_fd_sc_mcu7t5v0__fillcap_8
Xwave_controller_y_inst__3437_ spi_regs_inst__1160_/A1 wave_controller_y_inst__3494_/A1
+ wave_controller_y_inst__3438_/B VDD VDD VSS VSS gf180mcu_fd_sc_mcu7t5v0__nand2_1
XFILLER_129_128 VDD VDD VSS VSS gf180mcu_fd_sc_mcu7t5v0__fill_2
XTAP_TAPCELL_ROW_156_2452 VDD VSS gf180mcu_fd_sc_mcu7t5v0__filltie
Xwave_controller_y_inst__3368_ fanout502/Z wave_controller_y_inst__3386_/A2 wave_controller_y_inst__3385_/B
+ VDD VDD VSS VSS gf180mcu_fd_sc_mcu7t5v0__nand2_1
XTAP_TAPCELL_ROW_48_1_693 VDD VSS gf180mcu_fd_sc_mcu7t5v0__filltie
Xwave_controller_y_inst__2319_ spi_regs_inst__1179_/A1 wave_controller_y_inst__2616_/A1
+ wave_controller_y_inst__2319_/B1 spi_regs_inst__1159_/C2 wave_controller_y_inst__2319_/C
+ wave_controller_y_inst__2320_/B VDD VDD VSS VSS gf180mcu_fd_sc_mcu7t5v0__aoi221_1
XFILLER_153_632 VDD VDD VSS VSS gf180mcu_fd_sc_mcu7t5v0__fillcap_8
Xwave_controller_y_inst__3299_ wave_controller_y_inst__3299_/I wave_controller_y_inst__3364_/A2
+ VDD VDD VSS VSS gf180mcu_fd_sc_mcu7t5v0__clkinv_1
XFILLER_113_507 VDD VDD VSS VSS gf180mcu_fd_sc_mcu7t5v0__fill_2
XFILLER_153_698 VDD VDD VSS VSS gf180mcu_fd_sc_mcu7t5v0__fill_2
XFILLER_165_72 VDD VDD VSS VSS gf180mcu_fd_sc_mcu7t5v0__fillcap_64
XTAP_TAPCELL_ROW_14_1_438 VDD VSS gf180mcu_fd_sc_mcu7t5v0__filltie
XFILLER_106_592 VDD VDD VSS VSS gf180mcu_fd_sc_mcu7t5v0__fill_2
XFILLER_152_197 VDD VDD VSS VSS gf180mcu_fd_sc_mcu7t5v0__fill_1
XFILLER_121_562 VDD VDD VSS VSS gf180mcu_fd_sc_mcu7t5v0__fillcap_16
XTAP_TAPCELL_ROW_22_1_495 VDD VSS gf180mcu_fd_sc_mcu7t5v0__filltie
XTAP_TAPCELL_ROW_72_1064 VDD VSS gf180mcu_fd_sc_mcu7t5v0__filltie
XFILLER_66_115 VDD VDD VSS VSS gf180mcu_fd_sc_mcu7t5v0__fill_2
XFILLER_66_159 VDD VDD VSS VSS gf180mcu_fd_sc_mcu7t5v0__fill_1
XFILLER_94_457 VDD VDD VSS VSS gf180mcu_fd_sc_mcu7t5v0__fillcap_32
XFILLER_75_660 VDD VDD VSS VSS gf180mcu_fd_sc_mcu7t5v0__fill_2
XFILLER_47_384 VDD VDD VSS VSS gf180mcu_fd_sc_mcu7t5v0__fill_1
XFILLER_47_395 VDD VDD VSS VSS gf180mcu_fd_sc_mcu7t5v0__fillcap_16
XFILLER_90_652 VDD VDD VSS VSS gf180mcu_fd_sc_mcu7t5v0__fillcap_4
XFILLER_90_663 VDD VDD VSS VSS gf180mcu_fd_sc_mcu7t5v0__fill_2
XFILLER_50_527 VDD VDD VSS VSS gf180mcu_fd_sc_mcu7t5v0__fill_1
Xspi_regs_inst_load_slew196 spi_regs_inst__0814_/S spi_regs_inst__0813_/S VDD VDD
+ VSS VSS gf180mcu_fd_sc_mcu7t5v0__buf_2
XFILLER_30_240 VDD VDD VSS VSS gf180mcu_fd_sc_mcu7t5v0__fillcap_4
XFILLER_88_2 VDD VDD VSS VSS gf180mcu_fd_sc_mcu7t5v0__fillcap_16
XFILLER_163_407 VDD VDD VSS VSS gf180mcu_fd_sc_mcu7t5v0__fill_1
XFILLER_117_813 VDD VDD VSS VSS gf180mcu_fd_sc_mcu7t5v0__fillcap_16
XFILLER_128_161 VDD VDD VSS VSS gf180mcu_fd_sc_mcu7t5v0__fill_2
XFILLER_129_673 VDD VDD VSS VSS gf180mcu_fd_sc_mcu7t5v0__fillcap_8
XFILLER_144_621 VDD VDD VSS VSS gf180mcu_fd_sc_mcu7t5v0__fill_1
XFILLER_157_982 VDD VDD VSS VSS gf180mcu_fd_sc_mcu7t5v0__fillcap_64
XFILLER_104_518 VDD VDD VSS VSS gf180mcu_fd_sc_mcu7t5v0__fillcap_4
Xspi_regs_inst__1109_ spi_regs_inst__1109_/A1 spi_regs_inst__1278_/A2 spi_regs_inst__1345_/A2
+ spi_regs_inst__1109_/B2 spi_regs_inst__1118_/A4 VDD VDD VSS VSS gf180mcu_fd_sc_mcu7t5v0__aoi22_1
XFILLER_112_540 VDD VDD VSS VSS gf180mcu_fd_sc_mcu7t5v0__fill_2
XFILLER_38_18 VDD VDD VSS VSS gf180mcu_fd_sc_mcu7t5v0__fill_1
XFILLER_85_435 VDD VDD VSS VSS gf180mcu_fd_sc_mcu7t5v0__fillcap_4
XFILLER_86_947 VDD VDD VSS VSS gf180mcu_fd_sc_mcu7t5v0__fillcap_64
XFILLER_97_284 VDD VDD VSS VSS gf180mcu_fd_sc_mcu7t5v0__fill_1
XFILLER_57_137 VDD VDD VSS VSS gf180mcu_fd_sc_mcu7t5v0__fill_2
Xwave_controller_x_inst__2723_ fanout534/Z wave_controller_x_inst__2723_/A2 wave_controller_x_inst__2723_/B
+ wave_controller_x_inst__2739_/A2 VDD VDD VSS VSS gf180mcu_fd_sc_mcu7t5v0__oai21_1
XFILLER_72_107 VDD VDD VSS VSS gf180mcu_fd_sc_mcu7t5v0__fill_1
XTAP_TAPCELL_ROW_56_806 VDD VSS gf180mcu_fd_sc_mcu7t5v0__filltie
Xwave_controller_y_inst__2670_ wave_controller_y_inst__2668_/Z wave_controller_y_inst__2672_/A3
+ wave_controller_y_inst__2671_/A2 VDD VDD VSS VSS gf180mcu_fd_sc_mcu7t5v0__xnor2_1
Xwave_controller_x_inst__2654_ wave_controller_x_inst__2822_/A1 spi_regs_inst__1301_/A1
+ wave_controller_x_inst__2687_/B VDD VDD VSS VSS gf180mcu_fd_sc_mcu7t5v0__nor2_1
XFILLER_53_354 VDD VDD VSS VSS gf180mcu_fd_sc_mcu7t5v0__fillcap_16
XFILLER_54_877 VDD VDD VSS VSS gf180mcu_fd_sc_mcu7t5v0__fillcap_64
Xwave_controller_x_inst__2585_ wave_controller_x_inst__2620_/A1 wave_controller_x_inst__2620_/A2
+ wave_controller_x_inst__2585_/B wave_controller_x_inst__2596_/A2 VDD VDD VSS VSS
+ gf180mcu_fd_sc_mcu7t5v0__oai21_1
XFILLER_41_549 VDD VDD VSS VSS gf180mcu_fd_sc_mcu7t5v0__fillcap_4
XFILLER_53_376 VDD VDD VSS VSS gf180mcu_fd_sc_mcu7t5v0__fillcap_4
XFILLER_94_1081 VDD VDD VSS VSS gf180mcu_fd_sc_mcu7t5v0__fillcap_4
XFILLER_107_1122 VDD VDD VSS VSS gf180mcu_fd_sc_mcu7t5v0__fillcap_32
XTAP_TAPCELL_ROW_101_1536 VDD VSS gf180mcu_fd_sc_mcu7t5v0__filltie
XTAP_TAPCELL_ROW_101_1547 VDD VSS gf180mcu_fd_sc_mcu7t5v0__filltie
XFILLER_139_426 VDD VDD VSS VSS gf180mcu_fd_sc_mcu7t5v0__fillcap_4
Xwave_controller_y_inst__3222_ wave_controller_y_inst__3222_/A1 wave_controller_y_inst__3222_/A2
+ wave_controller_y_inst__3235_/A2 VDD VDD VSS VSS gf180mcu_fd_sc_mcu7t5v0__nand2_1
Xwave_controller_x_inst__3206_ wave_controller_x_inst__3206_/A1 wave_controller_x_inst__3205_/Z
+ wave_controller_x_inst__3242_/B1 VDD VDD VSS VSS gf180mcu_fd_sc_mcu7t5v0__nand2_1
XTAP_TAPCELL_ROW_138_2160 VDD VSS gf180mcu_fd_sc_mcu7t5v0__filltie
Xwave_controller_y_inst__3153_ wave_controller_y_inst__3153_/I wave_controller_y_inst__3208_/B
+ VDD VDD VSS VSS gf180mcu_fd_sc_mcu7t5v0__clkinv_1
XFILLER_166_289 VDD VDD VSS VSS gf180mcu_fd_sc_mcu7t5v0__fillcap_4
Xwave_controller_y_inst__2104_ wave_controller_y_inst__2104_/A1 wave_controller_y_inst__2104_/A2
+ wave_controller_y_inst__2104_/B wave_controller_y_inst__2106_/B VDD VDD VSS VSS
+ gf180mcu_fd_sc_mcu7t5v0__aoi21_1
Xwave_controller_x_inst__3137_ wave_controller_x_inst__3227_/A1 wave_controller_x_inst__3232_/B1
+ wave_controller_x_inst__3137_/B wave_controller_x_inst__3224_/A2 VDD VDD VSS VSS
+ gf180mcu_fd_sc_mcu7t5v0__aoi21_1
XFILLER_107_334 VDD VDD VSS VSS gf180mcu_fd_sc_mcu7t5v0__fill_1
Xwave_controller_y_inst__3084_ wave_controller_y_inst__3092_/A1 wave_controller_y_inst__3089_/A2
+ wave_controller_y_inst__3084_/Z VDD VDD VSS VSS gf180mcu_fd_sc_mcu7t5v0__and2_1
Xwave_controller_x_inst__3068_ wave_controller_x_inst__2945_/Z wave_controller_x_inst__3068_/A2
+ wave_controller_x_inst__3068_/A3 wave_controller_x_inst__3068_/Z VDD VDD VSS VSS
+ gf180mcu_fd_sc_mcu7t5v0__and3_1
XFILLER_162_473 VDD VDD VSS VSS gf180mcu_fd_sc_mcu7t5v0__fillcap_8
XTAP_TAPCELL_ROW_151_2371 VDD VSS gf180mcu_fd_sc_mcu7t5v0__filltie
Xwave_controller_y_inst__2035_ wave_controller_y_inst__1783_/I wave_controller_y_inst__2038_/A2
+ wave_controller_y_inst__2035_/Z VDD VDD VSS VSS gf180mcu_fd_sc_mcu7t5v0__xor2_1
Xwave_controller_x_inst__2019_ wave_controller_x_inst__2017_/Z wave_controller_x_inst__2019_/A2
+ spi_regs_inst__1056_/A1 VDD VDD VSS VSS gf180mcu_fd_sc_mcu7t5v0__nor2_1
XTAP_TAPCELL_ROW_116_1790 VDD VSS gf180mcu_fd_sc_mcu7t5v0__filltie
XFILLER_0_133 VDD VDD VSS VSS gf180mcu_fd_sc_mcu7t5v0__fill_2
XFILLER_131_893 VDD VDD VSS VSS gf180mcu_fd_sc_mcu7t5v0__fill_2
XFILLER_77_936 VDD VDD VSS VSS gf180mcu_fd_sc_mcu7t5v0__fill_2
Xspi_regs_inst_fanout479 spi_regs_inst__1660_/Q spi_regs_inst_wire480/I VDD VDD VSS
+ VSS gf180mcu_fd_sc_mcu7t5v0__dlyb_1
Xspi_regs_inst_fanout468 spi_regs_inst__1664_/Q spi_regs_inst__1412_/I1 VDD VDD VSS
+ VSS gf180mcu_fd_sc_mcu7t5v0__dlyb_1
XFILLER_76_457 VDD VDD VSS VSS gf180mcu_fd_sc_mcu7t5v0__fillcap_4
Xwave_controller_y_inst__2937_ wave_controller_y_inst__2937_/I wave_controller_y_inst__3691_/D
+ VDD VDD VSS VSS gf180mcu_fd_sc_mcu7t5v0__clkinv_1
XFILLER_28_73 VDD VDD VSS VSS gf180mcu_fd_sc_mcu7t5v0__fillcap_32
Xwave_controller_y_inst__2868_ wave_controller_y_inst__3694_/Q wave_controller_y_inst__3443_/A1
+ wave_controller_y_inst__2864_/Z wave_controller_y_inst__2884_/B VDD VDD VSS VSS
+ gf180mcu_fd_sc_mcu7t5v0__nand3_1
Xwave_controller_y_inst__1819_ wave_controller_y_inst__1819_/I wave_controller_y_inst__2944_/A2
+ VDD VDD VSS VSS gf180mcu_fd_sc_mcu7t5v0__clkinv_1
Xwave_controller_y_inst__2799_ wave_controller_y_inst__3279_/A1 wave_controller_y_inst__2795_/Z
+ wave_controller_y_inst__2798_/Z wave_controller_y_inst__3562_/A1 wave_controller_y_inst__2802_/A2
+ VDD VDD VSS VSS gf180mcu_fd_sc_mcu7t5v0__aoi22_1
XFILLER_32_527 VDD VDD VSS VSS gf180mcu_fd_sc_mcu7t5v0__fillcap_4
XFILLER_44_387 VDD VDD VSS VSS gf180mcu_fd_sc_mcu7t5v0__fillcap_8
XFILLER_158_724 VDD VDD VSS VSS gf180mcu_fd_sc_mcu7t5v0__fillcap_8
XFILLER_73_1154 VDD VDD VSS VSS gf180mcu_fd_sc_mcu7t5v0__fillcap_16
Xspi_regs_inst__1460_ input3/Z fanout582/Z clkload8/I spi_regs_inst__1460_/Q VDD VDD
+ VSS VSS gf180mcu_fd_sc_mcu7t5v0__dffrnq_1
Xspi_regs_inst__1391_ fanout536/Z spi_regs_inst__1391_/I1 spi_regs_inst__1391_/S spi_regs_inst__1466_/D
+ VDD VDD VSS VSS gf180mcu_fd_sc_mcu7t5v0__mux2_2
XFILLER_160_1157 VDD VDD VSS VSS gf180mcu_fd_sc_mcu7t5v0__fillcap_16
XPHY_EDGE_ROW_57_Left_224 VDD VSS gf180mcu_fd_sc_mcu7t5v0__endcap
XFILLER_138_470 VDD VDD VSS VSS gf180mcu_fd_sc_mcu7t5v0__fillcap_8
XFILLER_139_982 VDD VDD VSS VSS gf180mcu_fd_sc_mcu7t5v0__fillcap_64
XFILLER_125_131 VDD VDD VSS VSS gf180mcu_fd_sc_mcu7t5v0__fill_1
XFILLER_126_632 VDD VDD VSS VSS gf180mcu_fd_sc_mcu7t5v0__fill_1
XFILLER_154_941 VDD VDD VSS VSS gf180mcu_fd_sc_mcu7t5v0__fillcap_4
XFILLER_99_527 VDD VDD VSS VSS gf180mcu_fd_sc_mcu7t5v0__fillcap_8
XTAP_TAPCELL_ROW_74_1104 VDD VSS gf180mcu_fd_sc_mcu7t5v0__filltie
XFILLER_140_123 VDD VDD VSS VSS gf180mcu_fd_sc_mcu7t5v0__fill_1
XFILLER_4_483 VDD VDD VSS VSS gf180mcu_fd_sc_mcu7t5v0__fillcap_8
XFILLER_5_66 VDD VDD VSS VSS gf180mcu_fd_sc_mcu7t5v0__fillcap_4
XFILLER_39_104 VDD VDD VSS VSS gf180mcu_fd_sc_mcu7t5v0__fillcap_4
XFILLER_68_925 VDD VDD VSS VSS gf180mcu_fd_sc_mcu7t5v0__fillcap_16
XFILLER_68_947 VDD VDD VSS VSS gf180mcu_fd_sc_mcu7t5v0__fillcap_64
XPHY_EDGE_ROW_66_Left_233 VDD VSS gf180mcu_fd_sc_mcu7t5v0__endcap
XFILLER_121_381 VDD VDD VSS VSS gf180mcu_fd_sc_mcu7t5v0__fillcap_32
XFILLER_83_917 VDD VDD VSS VSS gf180mcu_fd_sc_mcu7t5v0__fill_2
XFILLER_94_232 VDD VDD VSS VSS gf180mcu_fd_sc_mcu7t5v0__fill_1
XFILLER_54_107 VDD VDD VSS VSS gf180mcu_fd_sc_mcu7t5v0__fillcap_8
XFILLER_95_788 VDD VDD VSS VSS gf180mcu_fd_sc_mcu7t5v0__fillcap_8
XPHY_EDGE_ROW_167_Right_167 VDD VSS gf180mcu_fd_sc_mcu7t5v0__endcap
Xwave_controller_y_inst_wire108 wave_controller_y_inst_wire108/I wave_controller_y_inst_wire108/Z
+ VDD VDD VSS VSS gf180mcu_fd_sc_mcu7t5v0__clkbuf_1
Xwave_controller_y_inst_wire119 wave_controller_y_inst_wire119/I wave_controller_y_inst_wire119/Z
+ VDD VDD VSS VSS gf180mcu_fd_sc_mcu7t5v0__buf_1
XFILLER_165_1046 VDD VDD VSS VSS gf180mcu_fd_sc_mcu7t5v0__fillcap_4
XFILLER_50_302 VDD VDD VSS VSS gf180mcu_fd_sc_mcu7t5v0__fill_1
XFILLER_78_1087 VDD VDD VSS VSS gf180mcu_fd_sc_mcu7t5v0__fillcap_64
XFILLER_90_482 VDD VDD VSS VSS gf180mcu_fd_sc_mcu7t5v0__fillcap_16
XTAP_TAPCELL_ROW_85_1277 VDD VSS gf180mcu_fd_sc_mcu7t5v0__filltie
Xwave_controller_x_inst__2370_ wave_controller_x_inst__2831_/A1 wave_controller_x_inst__2355_/Z
+ wave_controller_x_inst__2370_/B wave_controller_x_inst__2372_/A2 VDD VDD VSS VSS
+ gf180mcu_fd_sc_mcu7t5v0__oai21_1
XFILLER_149_702 VDD VDD VSS VSS gf180mcu_fd_sc_mcu7t5v0__fillcap_8
Xspi_regs_inst__1658_ spi_regs_inst__1658_/D spi_regs_inst__1659_/RN clkbuf_leaf_6_clk/Z
+ spi_regs_inst__1658_/Q VDD VDD VSS VSS gf180mcu_fd_sc_mcu7t5v0__dffrnq_1
XFILLER_149_724 VDD VDD VSS VSS gf180mcu_fd_sc_mcu7t5v0__fill_1
XFILLER_149_735 VDD VDD VSS VSS gf180mcu_fd_sc_mcu7t5v0__fill_2
XFILLER_50_368 VDD VDD VSS VSS gf180mcu_fd_sc_mcu7t5v0__fillcap_4
XPHY_EDGE_ROW_75_Left_242 VDD VSS gf180mcu_fd_sc_mcu7t5v0__endcap
XTAP_TAPCELL_ROW_61_886 VDD VSS gf180mcu_fd_sc_mcu7t5v0__filltie
Xspi_regs_inst__1589_ spi_regs_inst__1589_/D spi_regs_inst__1649_/RN clkload18/I spi_regs_inst__1589_/Q
+ VDD VDD VSS VSS gf180mcu_fd_sc_mcu7t5v0__dffrnq_1
XFILLER_148_289 VDD VDD VSS VSS gf180mcu_fd_sc_mcu7t5v0__fill_1
XFILLER_129_481 VDD VDD VSS VSS gf180mcu_fd_sc_mcu7t5v0__fill_1
XFILLER_129_492 VDD VDD VSS VSS gf180mcu_fd_sc_mcu7t5v0__fillcap_8
XFILLER_163_248 VDD VDD VSS VSS gf180mcu_fd_sc_mcu7t5v0__fillcap_8
XFILLER_117_676 VDD VDD VSS VSS gf180mcu_fd_sc_mcu7t5v0__fill_2
XFILLER_105_838 VDD VDD VSS VSS gf180mcu_fd_sc_mcu7t5v0__fill_2
XFILLER_116_197 VDD VDD VSS VSS gf180mcu_fd_sc_mcu7t5v0__fill_2
XFILLER_49_28 VDD VDD VSS VSS gf180mcu_fd_sc_mcu7t5v0__fillcap_16
XPHY_EDGE_ROW_84_Left_251 VDD VSS gf180mcu_fd_sc_mcu7t5v0__endcap
XFILLER_105_12 VDD VDD VSS VSS gf180mcu_fd_sc_mcu7t5v0__fill_1
XFILLER_86_733 VDD VDD VSS VSS gf180mcu_fd_sc_mcu7t5v0__fill_2
XTAP_TAPCELL_ROW_39_1_624 VDD VSS gf180mcu_fd_sc_mcu7t5v0__filltie
XFILLER_58_446 VDD VDD VSS VSS gf180mcu_fd_sc_mcu7t5v0__fill_2
XFILLER_58_457 VDD VDD VSS VSS gf180mcu_fd_sc_mcu7t5v0__fillcap_16
XFILLER_65_38 VDD VDD VSS VSS gf180mcu_fd_sc_mcu7t5v0__fill_1
XFILLER_86_788 VDD VDD VSS VSS gf180mcu_fd_sc_mcu7t5v0__fillcap_4
XTAP_TAPCELL_ROW_47_1_681 VDD VSS gf180mcu_fd_sc_mcu7t5v0__filltie
Xwave_controller_y_inst__2722_ fanout511/Z spi_regs_inst__1121_/A1 wave_controller_y_inst__2719_/Z
+ wave_controller_y_inst__2722_/Z VDD VDD VSS VSS gf180mcu_fd_sc_mcu7t5v0__xor3_1
XPHY_EDGE_ROW_134_Right_134 VDD VSS gf180mcu_fd_sc_mcu7t5v0__endcap
Xwave_controller_x_inst__3686_ wave_controller_x_inst__3686_/D wave_controller_x_inst__3686_/RN
+ clkload27/I spi_regs_inst__1052_/B2 VDD VDD VSS VSS gf180mcu_fd_sc_mcu7t5v0__dffrnq_1
Xwave_controller_x_inst__2706_ wave_controller_x_inst__2704_/Z wave_controller_x_inst__2707_/A2
+ wave_controller_x_inst__2726_/B VDD VDD VSS VSS gf180mcu_fd_sc_mcu7t5v0__nand2_1
XFILLER_54_652 VDD VDD VSS VSS gf180mcu_fd_sc_mcu7t5v0__fill_1
XFILLER_57_1116 VDD VDD VSS VSS gf180mcu_fd_sc_mcu7t5v0__fillcap_4
XFILLER_96_1165 VDD VDD VSS VSS gf180mcu_fd_sc_mcu7t5v0__fillcap_4
Xwave_controller_y_inst__2653_ wave_controller_y_inst__2822_/A1 spi_regs_inst__1303_/A1
+ wave_controller_y_inst__2656_/A1 VDD VDD VSS VSS gf180mcu_fd_sc_mcu7t5v0__nand2_1
Xwave_controller_x_inst__2637_ wave_controller_x_inst__2637_/A1 wave_controller_x_inst__2652_/A1
+ wave_controller_x_inst__2650_/B wave_controller_x_inst__2640_/A3 VDD VDD VSS VSS
+ gf180mcu_fd_sc_mcu7t5v0__aoi21_1
XFILLER_14_527 VDD VDD VSS VSS gf180mcu_fd_sc_mcu7t5v0__fillcap_16
XFILLER_26_387 VDD VDD VSS VSS gf180mcu_fd_sc_mcu7t5v0__fillcap_8
XTAP_TAPCELL_ROW_13_1_426 VDD VSS gf180mcu_fd_sc_mcu7t5v0__filltie
Xwave_controller_y_inst__2584_ wave_controller_y_inst__2584_/I wave_controller_y_inst__2585_/B
+ VDD VDD VSS VSS gf180mcu_fd_sc_mcu7t5v0__clkinv_1
Xwave_controller_x_inst__2568_ wave_controller_x_inst__2566_/Z wave_controller_x_inst__2570_/A3
+ wave_controller_x_inst__2569_/A2 VDD VDD VSS VSS gf180mcu_fd_sc_mcu7t5v0__xnor2_1
XFILLER_121_88 VDD VDD VSS VSS gf180mcu_fd_sc_mcu7t5v0__fill_2
XPHY_EDGE_ROW_93_Left_260 VDD VSS gf180mcu_fd_sc_mcu7t5v0__endcap
XFILLER_139_212 VDD VDD VSS VSS gf180mcu_fd_sc_mcu7t5v0__fill_2
Xwave_controller_x_inst__2499_ max_cap458/I wave_controller_x_inst__3512_/B2 wave_controller_x_inst__2519_/A1
+ VDD VDD VSS VSS gf180mcu_fd_sc_mcu7t5v0__nand2_1
XFILLER_167_554 VDD VDD VSS VSS gf180mcu_fd_sc_mcu7t5v0__fill_2
XTAP_TAPCELL_ROW_136_2119 VDD VSS gf180mcu_fd_sc_mcu7t5v0__filltie
XTAP_TAPCELL_ROW_153_2400 VDD VSS gf180mcu_fd_sc_mcu7t5v0__filltie
Xwave_controller_y_inst__3205_ wave_controller_y_inst__3154_/Z wave_controller_y_inst__3205_/A2
+ wave_controller_y_inst__3159_/B wave_controller_y_inst__3205_/Z VDD VDD VSS VSS
+ gf180mcu_fd_sc_mcu7t5v0__or3_1
XFILLER_167_576 VDD VDD VSS VSS gf180mcu_fd_sc_mcu7t5v0__fill_2
XTAP_TAPCELL_ROW_118_1830 VDD VSS gf180mcu_fd_sc_mcu7t5v0__filltie
XFILLER_136_941 VDD VDD VSS VSS gf180mcu_fd_sc_mcu7t5v0__fillcap_4
XFILLER_154_237 VDD VDD VSS VSS gf180mcu_fd_sc_mcu7t5v0__fillcap_8
Xwave_controller_y_inst__3136_ wave_controller_y_inst__3137_/B wave_controller_y_inst__3138_/B
+ VDD VDD VSS VSS gf180mcu_fd_sc_mcu7t5v0__clkinv_1
XFILLER_107_131 VDD VDD VSS VSS gf180mcu_fd_sc_mcu7t5v0__fill_1
XFILLER_107_142 VDD VDD VSS VSS gf180mcu_fd_sc_mcu7t5v0__fillcap_4
XPHY_EDGE_ROW_17_1_Left_184 VDD VSS gf180mcu_fd_sc_mcu7t5v0__endcap
Xwave_controller_y_inst__3067_ wave_controller_y_inst__3711_/Q wave_controller_y_inst__3408_/A1
+ wave_controller_y_inst__3608_/A2 VDD VDD VSS VSS gf180mcu_fd_sc_mcu7t5v0__nand2_1
XFILLER_122_123 VDD VDD VSS VSS gf180mcu_fd_sc_mcu7t5v0__fillcap_8
Xwave_controller_y_inst__2018_ wave_controller_y_inst__2018_/A1 wave_controller_y_inst__2018_/A2
+ wave_controller_y_inst__2018_/B wave_controller_y_inst__2019_/A2 VDD VDD VSS VSS
+ gf180mcu_fd_sc_mcu7t5v0__aoi21_1
XFILLER_146_96 VDD VDD VSS VSS gf180mcu_fd_sc_mcu7t5v0__fillcap_8
XFILLER_104_893 VDD VDD VSS VSS gf180mcu_fd_sc_mcu7t5v0__fillcap_8
XFILLER_118_1081 VDD VDD VSS VSS gf180mcu_fd_sc_mcu7t5v0__fillcap_4
XFILLER_39_72 VDD VDD VSS VSS gf180mcu_fd_sc_mcu7t5v0__fillcap_32
XFILLER_65_906 VDD VDD VSS VSS gf180mcu_fd_sc_mcu7t5v0__fillcap_4
XFILLER_76_243 VDD VDD VSS VSS gf180mcu_fd_sc_mcu7t5v0__fill_2
Xspi_regs_inst__0960_ spi_regs_inst__1633_/Q spi_regs_inst__1372_/A1 spi_regs_inst__1376_/A1
+ spi_regs_inst__0960_/ZN VDD VDD VSS VSS gf180mcu_fd_sc_mcu7t5v0__nand3_1
XFILLER_36_107 VDD VDD VSS VSS gf180mcu_fd_sc_mcu7t5v0__fill_1
XFILLER_91_202 VDD VDD VSS VSS gf180mcu_fd_sc_mcu7t5v0__fillcap_8
XFILLER_92_725 VDD VDD VSS VSS gf180mcu_fd_sc_mcu7t5v0__fillcap_8
XTAP_TAPCELL_ROW_164_2584 VDD VSS gf180mcu_fd_sc_mcu7t5v0__filltie
Xspi_regs_inst__0891_ spi_regs_inst__0891_/I spi_regs_inst__0897_/A2 VDD VDD VSS VSS
+ gf180mcu_fd_sc_mcu7t5v0__clkinv_1
XFILLER_64_438 VDD VDD VSS VSS gf180mcu_fd_sc_mcu7t5v0__fill_1
XFILLER_91_224 VDD VDD VSS VSS gf180mcu_fd_sc_mcu7t5v0__fillcap_32
XPHY_EDGE_ROW_101_Right_101 VDD VSS gf180mcu_fd_sc_mcu7t5v0__endcap
XFILLER_91_279 VDD VDD VSS VSS gf180mcu_fd_sc_mcu7t5v0__fill_1
XFILLER_32_302 VDD VDD VSS VSS gf180mcu_fd_sc_mcu7t5v0__fillcap_8
XFILLER_44_195 VDD VDD VSS VSS gf180mcu_fd_sc_mcu7t5v0__fill_1
Xspi_regs_inst__1512_ spi_regs_inst__1512_/D spi_regs_inst__1551_/RN clkload29/I spi_regs_inst__1512_/Q
+ VDD VDD VSS VSS gf180mcu_fd_sc_mcu7t5v0__dffrnq_1
XFILLER_158_521 VDD VDD VSS VSS gf180mcu_fd_sc_mcu7t5v0__fillcap_4
XFILLER_32_379 VDD VDD VSS VSS gf180mcu_fd_sc_mcu7t5v0__fillcap_4
Xspi_regs_inst__1443_ spi_regs_inst__1512_/Q spi_regs_inst__1443_/I1 spi_regs_inst__1445_/S
+ spi_regs_inst__1512_/D VDD VDD VSS VSS gf180mcu_fd_sc_mcu7t5v0__mux2_2
XFILLER_125_1052 VDD VDD VSS VSS gf180mcu_fd_sc_mcu7t5v0__fillcap_64
XFILLER_71_92 VDD VDD VSS VSS gf180mcu_fd_sc_mcu7t5v0__fillcap_8
XFILLER_9_553 VDD VDD VSS VSS gf180mcu_fd_sc_mcu7t5v0__fill_2
XTAP_TAPCELL_ROW_80_1196 VDD VSS gf180mcu_fd_sc_mcu7t5v0__filltie
Xspi_regs_inst__1374_ spi_regs_inst__1374_/A1 spi_regs_inst__1379_/S spi_regs_inst__1374_/B
+ spi_regs_inst__1655_/D VDD VDD VSS VSS gf180mcu_fd_sc_mcu7t5v0__oai21_1
XFILLER_114_613 VDD VDD VSS VSS gf180mcu_fd_sc_mcu7t5v0__fill_2
XFILLER_126_473 VDD VDD VSS VSS gf180mcu_fd_sc_mcu7t5v0__fillcap_8
XFILLER_99_324 VDD VDD VSS VSS gf180mcu_fd_sc_mcu7t5v0__fillcap_8
XFILLER_141_454 VDD VDD VSS VSS gf180mcu_fd_sc_mcu7t5v0__fill_2
XFILLER_87_508 VDD VDD VSS VSS gf180mcu_fd_sc_mcu7t5v0__fillcap_8
XFILLER_99_368 VDD VDD VSS VSS gf180mcu_fd_sc_mcu7t5v0__fill_1
Xwave_controller_x_inst__1870_ max_cap466/Z wave_controller_x_inst__3503_/B2 VDD VDD
+ VSS VSS gf180mcu_fd_sc_mcu7t5v0__clkinv_1
Xsignal_processor_y_inst__255_ signal_processor_y_inst__255_/D fanout544/Z clkbuf_leaf_0_clk/Z
+ signal_processor_y_inst__255_/Q VDD VDD VSS VSS gf180mcu_fd_sc_mcu7t5v0__dffrnq_1
XFILLER_110_841 VDD VDD VSS VSS gf180mcu_fd_sc_mcu7t5v0__fill_1
XFILLER_122_690 VDD VDD VSS VSS gf180mcu_fd_sc_mcu7t5v0__fillcap_32
XFILLER_95_530 VDD VDD VSS VSS gf180mcu_fd_sc_mcu7t5v0__fillcap_4
XFILLER_95_552 VDD VDD VSS VSS gf180mcu_fd_sc_mcu7t5v0__fillcap_8
Xsignal_processor_y_inst__186_ signal_processor_y_inst__212_/A2 signal_processor_y_inst__185_/I
+ signal_processor_y_inst__189_/A2 VDD VDD VSS VSS gf180mcu_fd_sc_mcu7t5v0__nand2_1
XFILLER_110_874 VDD VDD VSS VSS gf180mcu_fd_sc_mcu7t5v0__fill_1
XFILLER_27_107 VDD VDD VSS VSS gf180mcu_fd_sc_mcu7t5v0__fill_2
XFILLER_55_405 VDD VDD VSS VSS gf180mcu_fd_sc_mcu7t5v0__fillcap_8
XFILLER_68_788 VDD VDD VSS VSS gf180mcu_fd_sc_mcu7t5v0__fill_1
XFILLER_82_202 VDD VDD VSS VSS gf180mcu_fd_sc_mcu7t5v0__fill_1
XTAP_TAPCELL_ROW_87_1306 VDD VSS gf180mcu_fd_sc_mcu7t5v0__filltie
XTAP_TAPCELL_ROW_87_1317 VDD VSS gf180mcu_fd_sc_mcu7t5v0__filltie
Xwave_controller_x_inst__3540_ wave_controller_x_inst__3716_/Q wave_controller_x_inst__3555_/A2
+ wave_controller_x_inst__3542_/A2 VDD VDD VSS VSS gf180mcu_fd_sc_mcu7t5v0__nor2_1
XTAP_TAPCELL_ROW_66_967 VDD VSS gf180mcu_fd_sc_mcu7t5v0__filltie
Xwave_controller_x_inst__3471_ wave_controller_x_inst__3485_/B wave_controller_x_inst__3468_/I
+ wave_controller_x_inst__3471_/B wave_controller_x_inst__3472_/B2 VDD VDD VSS VSS
+ gf180mcu_fd_sc_mcu7t5v0__oai21_1
Xclkbuf_leaf_47_clk clkbuf_3_2__f_clk/Z clkload12/I VDD VDD VSS VSS gf180mcu_fd_sc_mcu7t5v0__clkbuf_8
Xwave_controller_x_inst__2422_ wave_controller_x_inst__2436_/A1 wave_controller_x_inst__2422_/A2
+ wave_controller_x_inst__2434_/B wave_controller_x_inst__2423_/A2 VDD VDD VSS VSS
+ gf180mcu_fd_sc_mcu7t5v0__aoi21_1
XFILLER_23_346 VDD VDD VSS VSS gf180mcu_fd_sc_mcu7t5v0__fillcap_4
XFILLER_35_195 VDD VDD VSS VSS gf180mcu_fd_sc_mcu7t5v0__fillcap_8
XFILLER_11_508 VDD VDD VSS VSS gf180mcu_fd_sc_mcu7t5v0__fill_2
Xwave_controller_x_inst__2353_ wave_controller_x_inst_wire121/Z wave_controller_x_inst__2352_/Z
+ wave_controller_x_inst__2356_/A3 VDD VDD VSS VSS gf180mcu_fd_sc_mcu7t5v0__xnor2_1
Xwave_controller_x_inst__2284_ wave_controller_x_inst__2284_/A1 max_cap455/Z wave_controller_x_inst__2284_/Z
+ VDD VDD VSS VSS gf180mcu_fd_sc_mcu7t5v0__xor2_1
XFILLER_109_407 VDD VDD VSS VSS gf180mcu_fd_sc_mcu7t5v0__fillcap_4
XFILLER_137_716 VDD VDD VSS VSS gf180mcu_fd_sc_mcu7t5v0__fill_1
XTAP_TAPCELL_ROW_131_2038 VDD VSS gf180mcu_fd_sc_mcu7t5v0__filltie
XFILLER_120_605 VDD VDD VSS VSS gf180mcu_fd_sc_mcu7t5v0__fill_2
XFILLER_132_432 VDD VDD VSS VSS gf180mcu_fd_sc_mcu7t5v0__fillcap_16
XFILLER_132_454 VDD VDD VSS VSS gf180mcu_fd_sc_mcu7t5v0__fill_1
XFILLER_78_508 VDD VDD VSS VSS gf180mcu_fd_sc_mcu7t5v0__fill_1
XFILLER_116_44 VDD VDD VSS VSS gf180mcu_fd_sc_mcu7t5v0__fillcap_8
Xfanout532 fanout532/I fanout532/Z VDD VDD VSS VSS gf180mcu_fd_sc_mcu7t5v0__dlyb_1
Xfanout521 fanout521/I fanout521/Z VDD VDD VSS VSS gf180mcu_fd_sc_mcu7t5v0__dlyb_1
XFILLER_120_649 VDD VDD VSS VSS gf180mcu_fd_sc_mcu7t5v0__fill_1
XFILLER_59_733 VDD VDD VSS VSS gf180mcu_fd_sc_mcu7t5v0__fill_1
XFILLER_59_777 VDD VDD VSS VSS gf180mcu_fd_sc_mcu7t5v0__fill_2
Xwave_controller_x_inst__1999_ fanout540/Z wave_controller_x_inst__2318_/A1 wave_controller_x_inst__1999_/B1
+ wave_controller_x_inst__1999_/B2 wave_controller_x_inst__1999_/C wave_controller_x_inst__2001_/A2
+ VDD VDD VSS VSS gf180mcu_fd_sc_mcu7t5v0__oai221_1
Xfanout598 fanout601/Z fanout598/Z VDD VDD VSS VSS gf180mcu_fd_sc_mcu7t5v0__dlyb_1
Xfanout587 fanout590/Z fanout587/Z VDD VDD VSS VSS gf180mcu_fd_sc_mcu7t5v0__dlyb_1
XFILLER_74_747 VDD VDD VSS VSS gf180mcu_fd_sc_mcu7t5v0__fillcap_4
XTAP_TAPCELL_ROW_146_2281 VDD VSS gf180mcu_fd_sc_mcu7t5v0__filltie
XTAP_TAPCELL_ROW_146_2292 VDD VSS gf180mcu_fd_sc_mcu7t5v0__filltie
Xwave_controller_x_inst__3738_ wave_controller_x_inst__3738_/D fanout601/Z clkload26/I
+ wave_controller_x_inst__3738_/Q VDD VDD VSS VSS gf180mcu_fd_sc_mcu7t5v0__dffrnq_1
Xwave_controller_y_inst__2705_ wave_controller_y_inst__3542_/B2 wave_controller_y_inst__2705_/A2
+ wave_controller_y_inst__2705_/B wave_controller_y_inst__2707_/A2 VDD VDD VSS VSS
+ gf180mcu_fd_sc_mcu7t5v0__oai21_1
Xwave_controller_y_inst__3685_ wave_controller_y_inst__3685_/D wave_controller_y_inst__3711_/RN
+ clkload15/I spi_regs_inst__1333_/B2 VDD VDD VSS VSS gf180mcu_fd_sc_mcu7t5v0__dffrnq_1
Xclkbuf_leaf_38_clk clkload0/I clkbuf_leaf_38_clk/Z VDD VDD VSS VSS gf180mcu_fd_sc_mcu7t5v0__clkbuf_8
XFILLER_132_98 VDD VDD VSS VSS gf180mcu_fd_sc_mcu7t5v0__fillcap_4
XFILLER_26_173 VDD VDD VSS VSS gf180mcu_fd_sc_mcu7t5v0__fill_2
XFILLER_73_279 VDD VDD VSS VSS gf180mcu_fd_sc_mcu7t5v0__fill_1
Xwave_controller_y_inst__2636_ spi_regs_inst__1275_/B2 spi_regs_inst__1285_/B2 wave_controller_y_inst__2636_/Z
+ VDD VDD VSS VSS gf180mcu_fd_sc_mcu7t5v0__xor2_1
Xwave_controller_x_inst__3669_ wave_controller_x_inst__3669_/D fanout598/Z clkbuf_leaf_22_clk/Z
+ spi_regs_inst__1225_/A1 VDD VDD VSS VSS gf180mcu_fd_sc_mcu7t5v0__dffrnq_1
XFILLER_155_2 VDD VDD VSS VSS gf180mcu_fd_sc_mcu7t5v0__fillcap_16
Xwave_controller_y_inst__2567_ wave_controller_y_inst__2550_/Z wave_controller_y_inst_wire149/Z
+ wave_controller_y_inst__2567_/B wave_controller_y_inst__2570_/A3 VDD VDD VSS VSS
+ gf180mcu_fd_sc_mcu7t5v0__aoi21_1
Xwave_controller_y_inst__2498_ wave_controller_y_inst__2498_/A1 wave_controller_y_inst__2498_/A2
+ wave_controller_y_inst__2497_/B spi_regs_inst_wire101/I VDD VDD VSS VSS gf180mcu_fd_sc_mcu7t5v0__xor3_1
XFILLER_10_541 VDD VDD VSS VSS gf180mcu_fd_sc_mcu7t5v0__fillcap_8
XFILLER_70_1157 VDD VDD VSS VSS gf180mcu_fd_sc_mcu7t5v0__fillcap_16
XFILLER_41_62 VDD VDD VSS VSS gf180mcu_fd_sc_mcu7t5v0__fillcap_8
XFILLER_6_512 VDD VDD VSS VSS gf180mcu_fd_sc_mcu7t5v0__fill_1
XTAP_TAPCELL_ROW_52_1_722 VDD VSS gf180mcu_fd_sc_mcu7t5v0__filltie
Xwave_controller_y_inst__3119_ wave_controller_y_inst__3706_/Q wave_controller_y_inst__3122_/A2
+ wave_controller_y_inst__3219_/B VDD VDD VSS VSS gf180mcu_fd_sc_mcu7t5v0__nor2_1
Xspi_regs_inst__1090_ spi_regs_inst__1090_/A1 spi_regs_inst__1306_/A2 spi_regs_inst__1306_/B1
+ spi_regs_inst__1090_/B2 spi_regs_inst__1120_/A2 VDD VDD VSS VSS gf180mcu_fd_sc_mcu7t5v0__aoi22_1
XFILLER_124_944 VDD VDD VSS VSS gf180mcu_fd_sc_mcu7t5v0__fill_1
XFILLER_151_730 VDD VDD VSS VSS gf180mcu_fd_sc_mcu7t5v0__fill_1
XFILLER_159_1170 VDD VDD VSS VSS gf180mcu_fd_sc_mcu7t5v0__fillcap_4
XFILLER_135_292 VDD VDD VSS VSS gf180mcu_fd_sc_mcu7t5v0__fill_2
XFILLER_111_605 VDD VDD VSS VSS gf180mcu_fd_sc_mcu7t5v0__fill_1
XFILLER_69_519 VDD VDD VSS VSS gf180mcu_fd_sc_mcu7t5v0__fillcap_8
XFILLER_97_839 VDD VDD VSS VSS gf180mcu_fd_sc_mcu7t5v0__fill_1
XTAP_TAPCELL_ROW_166_2613 VDD VSS gf180mcu_fd_sc_mcu7t5v0__filltie
XTAP_TAPCELL_ROW_166_2624 VDD VSS gf180mcu_fd_sc_mcu7t5v0__filltie
XFILLER_2_34 VDD VDD VSS VSS gf180mcu_fd_sc_mcu7t5v0__fill_1
XTAP_TAPCELL_ROW_8_1_391 VDD VSS gf180mcu_fd_sc_mcu7t5v0__filltie
Xspi_regs_inst__0943_ spi_regs_inst__1630_/Q spi_regs_inst__1631_/Q spi_regs_inst__0995_/A3
+ VDD VDD VSS VSS gf180mcu_fd_sc_mcu7t5v0__nor2_1
XFILLER_65_736 VDD VDD VSS VSS gf180mcu_fd_sc_mcu7t5v0__fill_1
XFILLER_66_70 VDD VDD VSS VSS gf180mcu_fd_sc_mcu7t5v0__fill_1
XFILLER_92_511 VDD VDD VSS VSS gf180mcu_fd_sc_mcu7t5v0__fill_2
XFILLER_92_522 VDD VDD VSS VSS gf180mcu_fd_sc_mcu7t5v0__fill_2
XTAP_TAPCELL_ROW_69_1014 VDD VSS gf180mcu_fd_sc_mcu7t5v0__filltie
XFILLER_65_769 VDD VDD VSS VSS gf180mcu_fd_sc_mcu7t5v0__fill_1
XFILLER_92_544 VDD VDD VSS VSS gf180mcu_fd_sc_mcu7t5v0__fillcap_4
Xspi_regs_inst__0874_ spi_regs_inst__1609_/Q spi_regs_inst__0883_/I1 spi_regs_inst__0875_/S
+ spi_regs_inst__1609_/D VDD VDD VSS VSS gf180mcu_fd_sc_mcu7t5v0__mux2_2
Xclkbuf_leaf_29_clk clkload0/I clkload33/I VDD VDD VSS VSS gf180mcu_fd_sc_mcu7t5v0__clkbuf_8
XFILLER_73_780 VDD VDD VSS VSS gf180mcu_fd_sc_mcu7t5v0__fillcap_4
XFILLER_73_791 VDD VDD VSS VSS gf180mcu_fd_sc_mcu7t5v0__fillcap_16
XTAP_TAPCELL_ROW_63_915 VDD VSS gf180mcu_fd_sc_mcu7t5v0__filltie
XFILLER_32_121 VDD VDD VSS VSS gf180mcu_fd_sc_mcu7t5v0__fill_1
XFILLER_60_441 VDD VDD VSS VSS gf180mcu_fd_sc_mcu7t5v0__fillcap_8
XFILLER_75_1046 VDD VDD VSS VSS gf180mcu_fd_sc_mcu7t5v0__fillcap_4
XTAP_TAPCELL_ROW_82_1225 VDD VSS gf180mcu_fd_sc_mcu7t5v0__filltie
XTAP_TAPCELL_ROW_82_1236 VDD VSS gf180mcu_fd_sc_mcu7t5v0__filltie
XFILLER_61_975 VDD VDD VSS VSS gf180mcu_fd_sc_mcu7t5v0__fillcap_4
XFILLER_32_198 VDD VDD VSS VSS gf180mcu_fd_sc_mcu7t5v0__fillcap_4
XFILLER_70_2 VDD VDD VSS VSS gf180mcu_fd_sc_mcu7t5v0__fillcap_8
Xspi_regs_inst__1426_ spi_regs_inst_wire480/I spi_regs_inst__1497_/Q spi_regs_inst__1427_/S
+ spi_regs_inst__1497_/D VDD VDD VSS VSS gf180mcu_fd_sc_mcu7t5v0__mux2_2
XFILLER_146_524 VDD VDD VSS VSS gf180mcu_fd_sc_mcu7t5v0__fill_1
Xspi_regs_inst__1357_ spi_regs_inst__1527_/Q spi_regs_inst__1357_/A2 spi_regs_inst__1357_/B
+ spi_regs_inst__1358_/A4 VDD VDD VSS VSS gf180mcu_fd_sc_mcu7t5v0__aoi21_1
XTAP_TAPCELL_ROW_46_1_680 VDD VSS gf180mcu_fd_sc_mcu7t5v0__filltie
XFILLER_133_229 VDD VDD VSS VSS gf180mcu_fd_sc_mcu7t5v0__fill_2
Xspi_regs_inst__1288_ spi_regs_inst__1288_/A1 spi_regs_inst__1340_/A2 spi_regs_inst__1339_/B1
+ spi_regs_inst__1288_/B2 spi_regs_inst_wire88/I VDD VDD VSS VSS gf180mcu_fd_sc_mcu7t5v0__aoi22_1
XFILLER_82_1017 VDD VDD VSS VSS gf180mcu_fd_sc_mcu7t5v0__fillcap_64
XTAP_TAPCELL_ROW_12_1_425 VDD VSS gf180mcu_fd_sc_mcu7t5v0__filltie
Xwave_controller_x_inst__2971_ wave_controller_x_inst__2957_/Z wave_controller_x_inst__3050_/B
+ wave_controller_x_inst__2971_/B wave_controller_x_inst__3053_/A3 VDD VDD VSS VSS
+ gf180mcu_fd_sc_mcu7t5v0__aoi21_1
XFILLER_101_137 VDD VDD VSS VSS gf180mcu_fd_sc_mcu7t5v0__fill_2
XFILLER_130_947 VDD VDD VSS VSS gf180mcu_fd_sc_mcu7t5v0__fillcap_64
XFILLER_141_284 VDD VDD VSS VSS gf180mcu_fd_sc_mcu7t5v0__fill_1
Xwave_controller_x_inst__1922_ spi_regs_inst__1504_/Q wave_controller_x_inst__3568_/A1
+ wave_controller_x_inst__3290_/A1 spi_regs_inst__1503_/Q wave_controller_x_inst__1923_/B
+ VDD VDD VSS VSS gf180mcu_fd_sc_mcu7t5v0__oai22_1
Xsignal_processor_y_inst__238_ signal_processor_y_inst__238_/D fanout557/Z clkload2/I
+ signal_processor_y_inst__238_/Q VDD VDD VSS VSS gf180mcu_fd_sc_mcu7t5v0__dffrnq_1
XFILLER_68_552 VDD VDD VSS VSS gf180mcu_fd_sc_mcu7t5v0__fillcap_16
XFILLER_96_861 VDD VDD VSS VSS gf180mcu_fd_sc_mcu7t5v0__fillcap_8
XTAP_TAPCELL_ROW_20_1_482 VDD VSS gf180mcu_fd_sc_mcu7t5v0__filltie
Xwave_controller_x_inst__1853_ spi_regs_inst__1033_/B2 wave_controller_x_inst__2162_/A2
+ VDD VDD VSS VSS gf180mcu_fd_sc_mcu7t5v0__clkinv_1
XFILLER_46_18 VDD VDD VSS VSS gf180mcu_fd_sc_mcu7t5v0__fillcap_8
XFILLER_95_393 VDD VDD VSS VSS gf180mcu_fd_sc_mcu7t5v0__fill_1
Xwave_controller_x_inst__1784_ spi_regs_inst__1512_/Q wave_controller_x_inst__1937_/B1
+ VDD VDD VSS VSS gf180mcu_fd_sc_mcu7t5v0__clkinv_1
Xsignal_processor_y_inst__169_ signal_processor_y_inst__234_/Q signal_processor_y_inst__169_/A2
+ signal_processor_y_inst__169_/Z VDD VDD VSS VSS gf180mcu_fd_sc_mcu7t5v0__xor2_1
Xwave_controller_x_inst__3523_ spi_regs_inst__1085_/C2 wave_controller_x_inst__3523_/A2
+ wave_controller_x_inst__3524_/A3 VDD VDD VSS VSS gf180mcu_fd_sc_mcu7t5v0__nor2_1
XFILLER_110_1151 VDD VDD VSS VSS gf180mcu_fd_sc_mcu7t5v0__fillcap_4
XFILLER_110_1173 VDD VDD VSS VSS gf180mcu_fd_sc_mcu7t5v0__fill_1
XFILLER_36_471 VDD VDD VSS VSS gf180mcu_fd_sc_mcu7t5v0__fill_2
XFILLER_43_419 VDD VDD VSS VSS gf180mcu_fd_sc_mcu7t5v0__fill_1
XFILLER_55_279 VDD VDD VSS VSS gf180mcu_fd_sc_mcu7t5v0__fill_1
Xwave_controller_y_inst__3470_ wave_controller_y_inst__3490_/A1 wave_controller_y_inst__3468_/I
+ wave_controller_y_inst__3470_/B wave_controller_y_inst__3470_/C wave_controller_y_inst__3472_/B1
+ VDD VDD VSS VSS gf180mcu_fd_sc_mcu7t5v0__aoi211_1
XFILLER_36_493 VDD VDD VSS VSS gf180mcu_fd_sc_mcu7t5v0__fill_1
XFILLER_64_791 VDD VDD VSS VSS gf180mcu_fd_sc_mcu7t5v0__fillcap_4
XFILLER_70_249 VDD VDD VSS VSS gf180mcu_fd_sc_mcu7t5v0__fill_1
Xwave_controller_y_inst__2421_ wave_controller_y_inst__2418_/Z wave_controller_y_inst__2434_/A2
+ wave_controller_y_inst__2433_/A2 VDD VDD VSS VSS gf180mcu_fd_sc_mcu7t5v0__xnor2_1
Xwave_controller_x_inst__3454_ wave_controller_x_inst__3458_/A1 wave_controller_x_inst__3454_/A2
+ wave_controller_x_inst__3454_/B wave_controller_x_inst__3454_/C wave_controller_x_inst__3460_/C
+ VDD VDD VSS VSS gf180mcu_fd_sc_mcu7t5v0__aoi211_1
Xwave_controller_x_inst__3385_ wave_controller_x_inst__3385_/A1 wave_controller_x_inst__3385_/A2
+ wave_controller_x_inst__3385_/B wave_controller_x_inst__3385_/C wave_controller_x_inst__3386_/B
+ VDD VDD VSS VSS gf180mcu_fd_sc_mcu7t5v0__oai211_1
Xwave_controller_x_inst__2405_ wave_controller_x_inst__2841_/A1 wave_controller_x_inst__2403_/Z
+ wave_controller_x_inst__2407_/B VDD VDD VSS VSS gf180mcu_fd_sc_mcu7t5v0__xor2_1
XFILLER_149_340 VDD VDD VSS VSS gf180mcu_fd_sc_mcu7t5v0__fillcap_8
Xwave_controller_y_inst__2352_ spi_regs_inst__1318_/C2 spi_regs_inst__1321_/A1 wave_controller_y_inst__2352_/Z
+ VDD VDD VSS VSS gf180mcu_fd_sc_mcu7t5v0__xor2_1
Xwave_controller_x_inst__2336_ fanout539/Z wave_controller_x_inst__2332_/Z wave_controller_x_inst__2336_/A3
+ wave_controller_x_inst__2336_/Z VDD VDD VSS VSS gf180mcu_fd_sc_mcu7t5v0__xor3_1
Xwave_controller_y_inst__2283_ wave_controller_y_inst__2284_/A1 spi_regs_inst__1139_/B2
+ wave_controller_y_inst__2299_/B VDD VDD VSS VSS gf180mcu_fd_sc_mcu7t5v0__nor2_1
Xwave_controller_x_inst__2267_ wave_controller_x_inst__2268_/A1 wave_controller_x_inst__2249_/Z
+ wave_controller_x_inst__2267_/B wave_controller_x_inst__2270_/A2 VDD VDD VSS VSS
+ gf180mcu_fd_sc_mcu7t5v0__oai21_1
XFILLER_124_207 VDD VDD VSS VSS gf180mcu_fd_sc_mcu7t5v0__fill_1
XFILLER_152_505 VDD VDD VSS VSS gf180mcu_fd_sc_mcu7t5v0__fill_1
Xwave_controller_x_inst__2198_ wave_controller_x_inst__2516_/A1 wave_controller_x_inst__2197_/Z
+ wave_controller_x_inst__2210_/B VDD VDD VSS VSS gf180mcu_fd_sc_mcu7t5v0__nor2_1
XFILLER_105_410 VDD VDD VSS VSS gf180mcu_fd_sc_mcu7t5v0__fill_1
XFILLER_106_944 VDD VDD VSS VSS gf180mcu_fd_sc_mcu7t5v0__fill_1
XFILLER_152_527 VDD VDD VSS VSS gf180mcu_fd_sc_mcu7t5v0__fillcap_4
XFILLER_164_398 VDD VDD VSS VSS gf180mcu_fd_sc_mcu7t5v0__fillcap_4
XFILLER_133_752 VDD VDD VSS VSS gf180mcu_fd_sc_mcu7t5v0__fill_1
XTAP_TAPCELL_ROW_111_1708 VDD VSS gf180mcu_fd_sc_mcu7t5v0__filltie
XFILLER_127_98 VDD VDD VSS VSS gf180mcu_fd_sc_mcu7t5v0__fill_1
XTAP_TAPCELL_ROW_148_2321 VDD VSS gf180mcu_fd_sc_mcu7t5v0__filltie
XFILLER_87_69 VDD VDD VSS VSS gf180mcu_fd_sc_mcu7t5v0__fill_1
XTAP_TAPCELL_ROW_161_2532 VDD VSS gf180mcu_fd_sc_mcu7t5v0__filltie
Xwave_controller_y_inst__1998_ wave_controller_y_inst__3391_/A1 spi_regs_inst__1232_/B2
+ wave_controller_y_inst__2001_/B VDD VDD VSS VSS gf180mcu_fd_sc_mcu7t5v0__xor2_1
Xwave_controller_y_inst__3737_ wave_controller_y_inst__3737_/D fanout547/Z clkload5/I
+ wave_controller_y_inst__3737_/Q VDD VDD VSS VSS gf180mcu_fd_sc_mcu7t5v0__dffrnq_1
XFILLER_46_268 VDD VDD VSS VSS gf180mcu_fd_sc_mcu7t5v0__fillcap_32
XTAP_TAPCELL_ROW_126_1951 VDD VSS gf180mcu_fd_sc_mcu7t5v0__filltie
XTAP_TAPCELL_ROW_126_1962 VDD VSS gf180mcu_fd_sc_mcu7t5v0__filltie
Xspi_regs_inst_max_cap211 spi_regs_inst_wire210/I spi_regs_inst__1308_/B1 VDD VDD
+ VSS VSS gf180mcu_fd_sc_mcu7t5v0__buf_2
Xwave_controller_y_inst__3668_ wave_controller_y_inst__3668_/D wave_controller_y_inst__3716_/RN
+ clkbuf_leaf_9_clk/Z spi_regs_inst__1204_/B2 VDD VDD VSS VSS gf180mcu_fd_sc_mcu7t5v0__dffrnq_1
Xspi_regs_inst_max_cap255 spi_regs_inst__1148_/B1 spi_regs_inst__1252_/B1 VDD VDD
+ VSS VSS gf180mcu_fd_sc_mcu7t5v0__buf_2
Xwave_controller_y_inst__2619_ spi_regs_inst__1199_/A1 wave_controller_y_inst__3530_/B2
+ wave_controller_y_inst__2584_/I wave_controller_y_inst__2617_/Z wave_controller_y_inst__2619_/C
+ wave_controller_y_inst__2620_/B VDD VDD VSS VSS gf180mcu_fd_sc_mcu7t5v0__aoi221_1
Xwave_controller_y_inst__3599_ wave_controller_y_inst__3597_/S wave_controller_y_inst__3599_/A2
+ wave_controller_y_inst__3599_/B wave_controller_y_inst__3674_/D VDD VDD VSS VSS
+ gf180mcu_fd_sc_mcu7t5v0__oai21_1
Xspi_regs_inst_max_cap266 spi_regs_inst__1231_/B1 spi_regs_inst__1085_/C1 VDD VDD
+ VSS VSS gf180mcu_fd_sc_mcu7t5v0__buf_2
XFILLER_122_1011 VDD VDD VSS VSS gf180mcu_fd_sc_mcu7t5v0__fillcap_4
XFILLER_128_502 VDD VDD VSS VSS gf180mcu_fd_sc_mcu7t5v0__fill_2
XFILLER_156_800 VDD VDD VSS VSS gf180mcu_fd_sc_mcu7t5v0__fillcap_4
XTAP_TAPCELL_ROW_159_2494 VDD VSS gf180mcu_fd_sc_mcu7t5v0__filltie
XFILLER_128_524 VDD VDD VSS VSS gf180mcu_fd_sc_mcu7t5v0__fill_1
Xspi_regs_inst__1211_ spi_regs_inst__1211_/A1 spi_regs_inst_wire296/Z spi_regs_inst_wire228/Z
+ spi_regs_inst__1211_/B2 spi_regs_inst__1214_/A2 VDD VDD VSS VSS gf180mcu_fd_sc_mcu7t5v0__aoi22_1
Xsignal_processor_x_inst__189_ signal_processor_x_inst__187_/B signal_processor_x_inst__189_/A2
+ signal_processor_x_inst__189_/B1 signal_processor_x_inst__189_/B2 signal_processor_x_inst__241_/D
+ VDD VDD VSS VSS gf180mcu_fd_sc_mcu7t5v0__aoi22_1
XFILLER_156_877 VDD VDD VSS VSS gf180mcu_fd_sc_mcu7t5v0__fillcap_64
Xspi_regs_inst__1142_ spi_regs_inst__1142_/A1 spi_regs_inst__1142_/A2 spi_regs_inst__1142_/A3
+ spi_regs_inst__1142_/A4 spi_regs_inst__1153_/A1 VDD VDD VSS VSS gf180mcu_fd_sc_mcu7t5v0__nand4_1
XFILLER_115_229 VDD VDD VSS VSS gf180mcu_fd_sc_mcu7t5v0__fill_1
Xspi_regs_inst__1073_ spi_regs_inst__1626_/Q spi_regs_inst__1624_/Q spi_regs_inst__1625_/Q
+ spi_regs_inst__1075_/A2 VDD VDD VSS VSS gf180mcu_fd_sc_mcu7t5v0__nor3_1
XFILLER_111_402 VDD VDD VSS VSS gf180mcu_fd_sc_mcu7t5v0__fillcap_8
XFILLER_112_947 VDD VDD VSS VSS gf180mcu_fd_sc_mcu7t5v0__fillcap_64
XFILLER_123_295 VDD VDD VSS VSS gf180mcu_fd_sc_mcu7t5v0__fillcap_16
XFILLER_96_124 VDD VDD VSS VSS gf180mcu_fd_sc_mcu7t5v0__fill_1
XFILLER_28_4 VDD VDD VSS VSS gf180mcu_fd_sc_mcu7t5v0__fill_1
XFILLER_78_861 VDD VDD VSS VSS gf180mcu_fd_sc_mcu7t5v0__fill_2
XFILLER_84_308 VDD VDD VSS VSS gf180mcu_fd_sc_mcu7t5v0__fillcap_4
XFILLER_65_500 VDD VDD VSS VSS gf180mcu_fd_sc_mcu7t5v0__fillcap_4
Xspi_regs_inst__0926_ spi_regs_inst__1639_/Q spi_regs_inst__0928_/B spi_regs_inst__0926_/B1
+ spi_regs_inst__1633_/Q spi_regs_inst__0926_/C spi_regs_inst__0927_/I VDD VDD VSS
+ VSS gf180mcu_fd_sc_mcu7t5v0__oai221_1
XFILLER_25_419 VDD VDD VSS VSS gf180mcu_fd_sc_mcu7t5v0__fill_1
XFILLER_37_268 VDD VDD VSS VSS gf180mcu_fd_sc_mcu7t5v0__fillcap_8
XFILLER_92_374 VDD VDD VSS VSS gf180mcu_fd_sc_mcu7t5v0__fill_1
Xspi_regs_inst__0857_ spi_regs_inst__1594_/Q spi_regs_inst__1408_/I1 spi_regs_inst__0857_/S
+ spi_regs_inst__1594_/D VDD VDD VSS VSS gf180mcu_fd_sc_mcu7t5v0__mux2_2
XFILLER_80_569 VDD VDD VSS VSS gf180mcu_fd_sc_mcu7t5v0__fill_1
Xspi_regs_inst__0788_ spi_regs_inst__1650_/Q spi_regs_inst__1651_/Q spi_regs_inst__1385_/A2
+ spi_regs_inst__0827_/A4 VDD VDD VSS VSS gf180mcu_fd_sc_mcu7t5v0__nand3_1
XFILLER_33_485 VDD VDD VSS VSS gf180mcu_fd_sc_mcu7t5v0__fillcap_4
XFILLER_60_271 VDD VDD VSS VSS gf180mcu_fd_sc_mcu7t5v0__fillcap_4
Xwave_controller_x_inst__3170_ wave_controller_x_inst__3107_/Z wave_controller_x_inst__3197_/A1
+ wave_controller_x_inst__3174_/A2 wave_controller_x_inst__3170_/B wave_controller_x_inst__3195_/A1
+ VDD VDD VSS VSS gf180mcu_fd_sc_mcu7t5v0__oai31_1
XFILLER_20_157 VDD VDD VSS VSS gf180mcu_fd_sc_mcu7t5v0__fillcap_8
Xwave_controller_x_inst__2121_ wave_controller_x_inst__2153_/A2 wave_controller_x_inst__2118_/Z
+ wave_controller_x_inst__3729_/Q wave_controller_x_inst__2123_/A2 VDD VDD VSS VSS
+ gf180mcu_fd_sc_mcu7t5v0__aoi21_1
XFILLER_119_546 VDD VDD VSS VSS gf180mcu_fd_sc_mcu7t5v0__fillcap_4
Xspi_regs_inst__1409_ spi_regs_inst__1482_/Q spi_regs_inst__1451_/I1 spi_regs_inst__1412_/S
+ spi_regs_inst__1482_/D VDD VDD VSS VSS gf180mcu_fd_sc_mcu7t5v0__mux2_2
Xwave_controller_x_inst__2052_ wave_controller_x_inst__3189_/C wave_controller_x_inst__2052_/A2
+ wave_controller_x_inst__2052_/Z VDD VDD VSS VSS gf180mcu_fd_sc_mcu7t5v0__xor2_1
Xclkbuf_leaf_9_clk clkbuf_leaf_9_clk/I clkbuf_leaf_9_clk/Z VDD VDD VSS VSS gf180mcu_fd_sc_mcu7t5v0__clkbuf_8
XFILLER_134_527 VDD VDD VSS VSS gf180mcu_fd_sc_mcu7t5v0__fillcap_8
XFILLER_161_302 VDD VDD VSS VSS gf180mcu_fd_sc_mcu7t5v0__fillcap_4
XTAP_TAPCELL_ROW_95_1449 VDD VSS gf180mcu_fd_sc_mcu7t5v0__filltie
XTAP_TAPCELL_ROW_95_1438 VDD VSS gf180mcu_fd_sc_mcu7t5v0__filltie
XFILLER_115_730 VDD VDD VSS VSS gf180mcu_fd_sc_mcu7t5v0__fillcap_4
XFILLER_161_346 VDD VDD VSS VSS gf180mcu_fd_sc_mcu7t5v0__fillcap_4
Xspi_regs_inst_wire311 spi_regs_inst_wire311/I spi_regs_inst__0787_/S VDD VDD VSS
+ VSS gf180mcu_fd_sc_mcu7t5v0__buf_2
XFILLER_88_603 VDD VDD VSS VSS gf180mcu_fd_sc_mcu7t5v0__fill_1
XFILLER_130_755 VDD VDD VSS VSS gf180mcu_fd_sc_mcu7t5v0__fill_1
Xwave_controller_y_inst__2970_ wave_controller_y_inst__2956_/I wave_controller_y_inst__2957_/Z
+ wave_controller_y_inst__3050_/B wave_controller_y_inst__3051_/A2 VDD VDD VSS VSS
+ gf180mcu_fd_sc_mcu7t5v0__nand3_1
Xwave_controller_x_inst__2954_ wave_controller_x_inst__3706_/Q wave_controller_x_inst__3236_/B
+ wave_controller_x_inst__2972_/A1 VDD VDD VSS VSS gf180mcu_fd_sc_mcu7t5v0__nor2_1
XFILLER_102_457 VDD VDD VSS VSS gf180mcu_fd_sc_mcu7t5v0__fillcap_4
XFILLER_75_308 VDD VDD VSS VSS gf180mcu_fd_sc_mcu7t5v0__fill_1
Xwave_controller_y_inst__1921_ wave_controller_y_inst__3290_/A1 spi_regs_inst__1566_/Q
+ spi_regs_inst__1565_/Q wave_controller_y_inst__3564_/A1 wave_controller_y_inst__1923_/A2
+ VDD VDD VSS VSS gf180mcu_fd_sc_mcu7t5v0__aoi22_1
Xwave_controller_x_inst__1905_ spi_regs_inst__1134_/A1 wave_controller_x_inst__3443_/A1
+ VDD VDD VSS VSS gf180mcu_fd_sc_mcu7t5v0__clkinv_1
XFILLER_130_799 VDD VDD VSS VSS gf180mcu_fd_sc_mcu7t5v0__fillcap_4
XFILLER_28_202 VDD VDD VSS VSS gf180mcu_fd_sc_mcu7t5v0__fill_1
Xwave_controller_y_inst__1852_ spi_regs_inst__0967_/A1 wave_controller_y_inst__2757_/A1
+ VDD VDD VSS VSS gf180mcu_fd_sc_mcu7t5v0__clkinv_1
Xwave_controller_x_inst__2885_ wave_controller_x_inst__2885_/A1 wave_controller_x_inst__2885_/A2
+ wave_controller_x_inst__2885_/A3 wave_controller_x_inst__2886_/A2 VDD VDD VSS VSS
+ gf180mcu_fd_sc_mcu7t5v0__nand3_1
XTAP_TAPCELL_ROW_143_2240 VDD VSS gf180mcu_fd_sc_mcu7t5v0__filltie
Xwave_controller_x_inst__1836_ spi_regs_inst__1254_/B2 wave_controller_x_inst__2223_/A1
+ VDD VDD VSS VSS gf180mcu_fd_sc_mcu7t5v0__clkinv_1
XFILLER_16_419 VDD VDD VSS VSS gf180mcu_fd_sc_mcu7t5v0__fillcap_16
XFILLER_43_216 VDD VDD VSS VSS gf180mcu_fd_sc_mcu7t5v0__fill_2
XFILLER_83_352 VDD VDD VSS VSS gf180mcu_fd_sc_mcu7t5v0__fillcap_4
Xwave_controller_y_inst__3522_ wave_controller_y_inst__3710_/Q wave_controller_y_inst__3555_/A2
+ wave_controller_y_inst__3524_/A2 VDD VDD VSS VSS gf180mcu_fd_sc_mcu7t5v0__nor2_1
Xwave_controller_y_inst__1783_ wave_controller_y_inst__1783_/I wave_controller_y_inst__3320_/A1
+ VDD VDD VSS VSS gf180mcu_fd_sc_mcu7t5v0__inv_1
XFILLER_43_227 VDD VDD VSS VSS gf180mcu_fd_sc_mcu7t5v0__fill_1
XFILLER_71_558 VDD VDD VSS VSS gf180mcu_fd_sc_mcu7t5v0__fill_2
XPHY_EDGE_ROW_26_1_Left_193 VDD VSS gf180mcu_fd_sc_mcu7t5v0__endcap
Xwave_controller_x_inst__3506_ wave_controller_x_inst__3539_/A1 wave_controller_x_inst__3506_/A2
+ wave_controller_x_inst__3506_/A3 wave_controller_x_inst__3530_/B1 wave_controller_x_inst__3506_/B2
+ wave_controller_x_inst__3631_/D VDD VDD VSS VSS gf180mcu_fd_sc_mcu7t5v0__oai32_1
XTAP_TAPCELL_ROW_54_767 VDD VSS gf180mcu_fd_sc_mcu7t5v0__filltie
Xwave_controller_y_inst__3453_ spi_regs_inst__1262_/A1 wave_controller_y_inst__3454_/A2
+ wave_controller_y_inst__3454_/C VDD VDD VSS VSS gf180mcu_fd_sc_mcu7t5v0__nor2_1
Xwave_controller_x_inst__3437_ spi_regs_inst__1134_/A1 wave_controller_x_inst__3494_/A1
+ wave_controller_x_inst__3438_/B VDD VDD VSS VSS gf180mcu_fd_sc_mcu7t5v0__nand2_1
XFILLER_106_1017 VDD VDD VSS VSS gf180mcu_fd_sc_mcu7t5v0__fillcap_64
XFILLER_51_282 VDD VDD VSS VSS gf180mcu_fd_sc_mcu7t5v0__fillcap_64
XTAP_TAPCELL_ROW_104_1589 VDD VSS gf180mcu_fd_sc_mcu7t5v0__filltie
XTAP_TAPCELL_ROW_121_1870 VDD VSS gf180mcu_fd_sc_mcu7t5v0__filltie
Xwave_controller_y_inst__2404_ spi_regs_inst__1045_/A1 wave_controller_y_inst__2403_/Z
+ wave_controller_y_inst__2419_/B VDD VDD VSS VSS gf180mcu_fd_sc_mcu7t5v0__nand2_1
Xwave_controller_y_inst__3384_ fanout505/Z wave_controller_y_inst__3384_/A2 wave_controller_y_inst__3371_/Z
+ wave_controller_y_inst__3369_/Z wave_controller_y_inst__1825_/I wave_controller_y_inst__3385_/A2
+ VDD VDD VSS VSS gf180mcu_fd_sc_mcu7t5v0__oai32_1
Xsignal_processor_x_inst__112_ signal_processor_x_inst__241_/Q signal_processor_x_inst__189_/B2
+ VDD VDD VSS VSS gf180mcu_fd_sc_mcu7t5v0__clkinv_1
XFILLER_156_107 VDD VDD VSS VSS gf180mcu_fd_sc_mcu7t5v0__fillcap_16
XTAP_TAPCELL_ROW_121_1881 VDD VSS gf180mcu_fd_sc_mcu7t5v0__filltie
Xwave_controller_y_inst__2335_ fanout517/Z wave_controller_y_inst__2334_/Z wave_controller_y_inst__2358_/A1
+ VDD VDD VSS VSS gf180mcu_fd_sc_mcu7t5v0__nor2_1
Xwave_controller_x_inst__3368_ fanout523/Z wave_controller_x_inst__3386_/A2 wave_controller_x_inst__3385_/B
+ VDD VDD VSS VSS gf180mcu_fd_sc_mcu7t5v0__nand2_1
Xwave_controller_x_inst__3299_ wave_controller_x_inst__3299_/I wave_controller_x_inst__3364_/A2
+ VDD VDD VSS VSS gf180mcu_fd_sc_mcu7t5v0__clkinv_1
Xwave_controller_x_inst__2319_ spi_regs_inst__1211_/B2 wave_controller_x_inst__2616_/A1
+ wave_controller_x_inst__2319_/B1 spi_regs_inst__1140_/B2 wave_controller_x_inst__2319_/C
+ wave_controller_x_inst__2320_/B VDD VDD VSS VSS gf180mcu_fd_sc_mcu7t5v0__aoi221_1
XFILLER_138_877 VDD VDD VSS VSS gf180mcu_fd_sc_mcu7t5v0__fillcap_64
Xwave_controller_y_inst__2266_ wave_controller_y_inst__2266_/A1 wave_controller_y_inst__2265_/B
+ wave_controller_y_inst__2267_/B VDD VDD VSS VSS gf180mcu_fd_sc_mcu7t5v0__xnor2_1
XFILLER_118_2 VDD VDD VSS VSS gf180mcu_fd_sc_mcu7t5v0__fillcap_16
XFILLER_125_527 VDD VDD VSS VSS gf180mcu_fd_sc_mcu7t5v0__fillcap_16
XFILLER_165_696 VDD VDD VSS VSS gf180mcu_fd_sc_mcu7t5v0__fillcap_4
Xwave_controller_y_inst__2197_ fanout509/Z wave_controller_y_inst__2192_/Z wave_controller_y_inst__2204_/A2
+ wave_controller_y_inst__2197_/Z VDD VDD VSS VSS gf180mcu_fd_sc_mcu7t5v0__xor3_1
XFILLER_152_335 VDD VDD VSS VSS gf180mcu_fd_sc_mcu7t5v0__fill_1
XFILLER_69_1170 VDD VDD VSS VSS gf180mcu_fd_sc_mcu7t5v0__fillcap_4
XFILLER_156_1151 VDD VDD VSS VSS gf180mcu_fd_sc_mcu7t5v0__fillcap_4
XFILLER_78_102 VDD VDD VSS VSS gf180mcu_fd_sc_mcu7t5v0__fill_2
XFILLER_105_273 VDD VDD VSS VSS gf180mcu_fd_sc_mcu7t5v0__fillcap_4
XFILLER_156_1173 VDD VDD VSS VSS gf180mcu_fd_sc_mcu7t5v0__fill_1
XFILLER_47_500 VDD VDD VSS VSS gf180mcu_fd_sc_mcu7t5v0__fill_1
XTAP_TAPCELL_ROW_37_1_611 VDD VSS gf180mcu_fd_sc_mcu7t5v0__filltie
XFILLER_47_72 VDD VDD VSS VSS gf180mcu_fd_sc_mcu7t5v0__fillcap_16
Xspi_regs_inst_load_slew301 spi_regs_inst__0885_/S spi_regs_inst__0884_/S VDD VDD
+ VSS VSS gf180mcu_fd_sc_mcu7t5v0__buf_2
XFILLER_19_279 VDD VDD VSS VSS gf180mcu_fd_sc_mcu7t5v0__fill_1
XFILLER_15_452 VDD VDD VSS VSS gf180mcu_fd_sc_mcu7t5v0__fillcap_4
XFILLER_163_1122 VDD VDD VSS VSS gf180mcu_fd_sc_mcu7t5v0__fillcap_32
XFILLER_90_889 VDD VDD VSS VSS gf180mcu_fd_sc_mcu7t5v0__fill_2
XTAP_TAPCELL_ROW_11_1_413 VDD VSS gf180mcu_fd_sc_mcu7t5v0__filltie
Xclkbuf_3_4__f_clk clkbuf_0_clk/Z clkbuf_3_4__f_clk/Z VDD VDD VSS VSS gf180mcu_fd_sc_mcu7t5v0__clkbuf_16
XFILLER_129_833 VDD VDD VSS VSS gf180mcu_fd_sc_mcu7t5v0__fillcap_4
XFILLER_147_118 VDD VDD VSS VSS gf180mcu_fd_sc_mcu7t5v0__fillcap_4
XFILLER_30_488 VDD VDD VSS VSS gf180mcu_fd_sc_mcu7t5v0__fillcap_4
XFILLER_129_855 VDD VDD VSS VSS gf180mcu_fd_sc_mcu7t5v0__fillcap_32
XFILLER_144_803 VDD VDD VSS VSS gf180mcu_fd_sc_mcu7t5v0__fill_2
XFILLER_116_527 VDD VDD VSS VSS gf180mcu_fd_sc_mcu7t5v0__fill_2
XFILLER_128_376 VDD VDD VSS VSS gf180mcu_fd_sc_mcu7t5v0__fill_1
XFILLER_128_387 VDD VDD VSS VSS gf180mcu_fd_sc_mcu7t5v0__fillcap_4
XFILLER_155_162 VDD VDD VSS VSS gf180mcu_fd_sc_mcu7t5v0__fill_2
XFILLER_155_173 VDD VDD VSS VSS gf180mcu_fd_sc_mcu7t5v0__fill_2
XTAP_TAPCELL_ROW_77_1146 VDD VSS gf180mcu_fd_sc_mcu7t5v0__filltie
Xspi_regs_inst__1125_ spi_regs_inst__1642_/Q spi_regs_inst__1074_/Z spi_regs_inst__1126_/A3
+ VDD VDD VSS VSS gf180mcu_fd_sc_mcu7t5v0__nor2_1
Xspi_regs_inst__1056_ spi_regs_inst__1056_/A1 spi_regs_inst__1251_/B1 spi_regs_inst__1106_/B1
+ spi_regs_inst__1615_/Q spi_regs_inst__1057_/A4 VDD VDD VSS VSS gf180mcu_fd_sc_mcu7t5v0__aoi22_1
XFILLER_33_2 VDD VDD VSS VSS gf180mcu_fd_sc_mcu7t5v0__fillcap_16
XFILLER_97_422 VDD VDD VSS VSS gf180mcu_fd_sc_mcu7t5v0__fill_1
XTAP_TAPCELL_ROW_90_1357 VDD VSS gf180mcu_fd_sc_mcu7t5v0__filltie
XFILLER_69_146 VDD VDD VSS VSS gf180mcu_fd_sc_mcu7t5v0__fill_1
XTAP_TAPCELL_ROW_90_1368 VDD VSS gf180mcu_fd_sc_mcu7t5v0__filltie
XFILLER_85_628 VDD VDD VSS VSS gf180mcu_fd_sc_mcu7t5v0__fill_2
Xload_slew576 fanout575/Z load_slew576/Z VDD VDD VSS VSS gf180mcu_fd_sc_mcu7t5v0__buf_4
Xwave_controller_x_inst__2670_ wave_controller_x_inst__2668_/Z wave_controller_x_inst__2672_/A3
+ wave_controller_x_inst__2671_/A2 VDD VDD VSS VSS gf180mcu_fd_sc_mcu7t5v0__xnor2_1
XFILLER_53_503 VDD VDD VSS VSS gf180mcu_fd_sc_mcu7t5v0__fillcap_4
XFILLER_65_352 VDD VDD VSS VSS gf180mcu_fd_sc_mcu7t5v0__fillcap_4
Xspi_regs_inst__0909_ spi_regs_inst__1629_/Q spi_regs_inst__1628_/Q spi_regs_inst__0909_/Z
+ VDD VDD VSS VSS gf180mcu_fd_sc_mcu7t5v0__and2_1
X_18_ _19_/Q _18_/A2 _18_/B _19_/D VDD VDD VSS VSS gf180mcu_fd_sc_mcu7t5v0__aoi21_1
XFILLER_92_193 VDD VDD VSS VSS gf180mcu_fd_sc_mcu7t5v0__fill_2
XFILLER_80_355 VDD VDD VSS VSS gf180mcu_fd_sc_mcu7t5v0__fill_2
XFILLER_81_889 VDD VDD VSS VSS gf180mcu_fd_sc_mcu7t5v0__fillcap_8
XFILLER_21_422 VDD VDD VSS VSS gf180mcu_fd_sc_mcu7t5v0__fillcap_32
XFILLER_138_107 VDD VDD VSS VSS gf180mcu_fd_sc_mcu7t5v0__fillcap_16
XFILLER_167_917 VDD VDD VSS VSS gf180mcu_fd_sc_mcu7t5v0__fill_1
XFILLER_33_282 VDD VDD VSS VSS gf180mcu_fd_sc_mcu7t5v0__fillcap_4
Xwave_controller_x_inst__3222_ wave_controller_x_inst__3222_/A1 wave_controller_x_inst__3222_/A2
+ wave_controller_x_inst__3235_/A2 VDD VDD VSS VSS gf180mcu_fd_sc_mcu7t5v0__nand2_1
XFILLER_21_488 VDD VDD VSS VSS gf180mcu_fd_sc_mcu7t5v0__fill_2
Xwave_controller_x_inst__3153_ wave_controller_x_inst__3153_/I wave_controller_x_inst__3208_/B
+ VDD VDD VSS VSS gf180mcu_fd_sc_mcu7t5v0__clkinv_1
Xwave_controller_y_inst__2120_ wave_controller_y_inst__3729_/Q wave_controller_y_inst__2754_/A2
+ wave_controller_y_inst__2118_/Z wave_controller_y_inst__2123_/B VDD VDD VSS VSS
+ gf180mcu_fd_sc_mcu7t5v0__nand3_1
Xwave_controller_x_inst__3084_ wave_controller_x_inst__3092_/A1 wave_controller_x_inst__3089_/A2
+ wave_controller_x_inst__3084_/Z VDD VDD VSS VSS gf180mcu_fd_sc_mcu7t5v0__and2_1
Xwave_controller_x_inst__2104_ wave_controller_x_inst__2104_/A1 wave_controller_x_inst__2104_/A2
+ wave_controller_x_inst__2104_/B wave_controller_x_inst__2106_/B VDD VDD VSS VSS
+ gf180mcu_fd_sc_mcu7t5v0__aoi21_1
XFILLER_119_376 VDD VDD VSS VSS gf180mcu_fd_sc_mcu7t5v0__fill_2
Xwave_controller_y_inst__2051_ wave_controller_y_inst__3719_/Q wave_controller_y_inst__3089_/B
+ wave_controller_y_inst__2051_/Z VDD VDD VSS VSS gf180mcu_fd_sc_mcu7t5v0__xor2_1
Xwave_controller_x_inst__2035_ wave_controller_x_inst__1783_/I wave_controller_x_inst__3089_/B
+ wave_controller_x_inst__2035_/Z VDD VDD VSS VSS gf180mcu_fd_sc_mcu7t5v0__xor2_1
XFILLER_104_8 VDD VDD VSS VSS gf180mcu_fd_sc_mcu7t5v0__fill_2
XFILLER_108_34 VDD VDD VSS VSS gf180mcu_fd_sc_mcu7t5v0__fill_1
XFILLER_146_195 VDD VDD VSS VSS gf180mcu_fd_sc_mcu7t5v0__fill_2
XFILLER_89_912 VDD VDD VSS VSS gf180mcu_fd_sc_mcu7t5v0__fillcap_8
XFILLER_103_744 VDD VDD VSS VSS gf180mcu_fd_sc_mcu7t5v0__fill_2
XFILLER_161_198 VDD VDD VSS VSS gf180mcu_fd_sc_mcu7t5v0__fillcap_4
XFILLER_89_956 VDD VDD VSS VSS gf180mcu_fd_sc_mcu7t5v0__fillcap_16
Xspi_regs_inst_wire185 spi_regs_inst_wire185/I spi_regs_inst_wire185/Z VDD VDD VSS
+ VSS gf180mcu_fd_sc_mcu7t5v0__buf_2
XFILLER_124_22 VDD VDD VSS VSS gf180mcu_fd_sc_mcu7t5v0__fillcap_4
Xwave_controller_y_inst__2953_ wave_controller_y_inst__3706_/Q wave_controller_y_inst__1825_/I
+ wave_controller_y_inst__2972_/B VDD VDD VSS VSS gf180mcu_fd_sc_mcu7t5v0__nand2_1
XFILLER_69_680 VDD VDD VSS VSS gf180mcu_fd_sc_mcu7t5v0__fill_1
Xwave_controller_y_inst__1904_ spi_regs_inst__1091_/A1 wave_controller_y_inst__3433_/A1
+ VDD VDD VSS VSS gf180mcu_fd_sc_mcu7t5v0__clkinv_1
Xwave_controller_x_inst__2937_ wave_controller_x_inst__2937_/I wave_controller_x_inst__3691_/D
+ VDD VDD VSS VSS gf180mcu_fd_sc_mcu7t5v0__clkinv_1
XFILLER_57_842 VDD VDD VSS VSS gf180mcu_fd_sc_mcu7t5v0__fill_2
XFILLER_57_864 VDD VDD VSS VSS gf180mcu_fd_sc_mcu7t5v0__fillcap_4
XFILLER_84_37 VDD VDD VSS VSS gf180mcu_fd_sc_mcu7t5v0__fill_2
XTAP_TAPCELL_ROW_59_848 VDD VSS gf180mcu_fd_sc_mcu7t5v0__filltie
Xwave_controller_y_inst__2884_ wave_controller_y_inst__2864_/Z wave_controller_y_inst__2884_/A2
+ wave_controller_y_inst__2884_/B wave_controller_y_inst__2885_/A3 VDD VDD VSS VSS
+ gf180mcu_fd_sc_mcu7t5v0__oai21_1
Xwave_controller_x_inst__2868_ wave_controller_x_inst__3694_/Q wave_controller_x_inst__3443_/A1
+ wave_controller_x_inst__2864_/Z wave_controller_x_inst__2884_/B VDD VDD VSS VSS
+ gf180mcu_fd_sc_mcu7t5v0__nand3_1
XFILLER_56_374 VDD VDD VSS VSS gf180mcu_fd_sc_mcu7t5v0__fill_1
XFILLER_57_875 VDD VDD VSS VSS gf180mcu_fd_sc_mcu7t5v0__fill_1
XFILLER_72_823 VDD VDD VSS VSS gf180mcu_fd_sc_mcu7t5v0__fillcap_4
XFILLER_83_160 VDD VDD VSS VSS gf180mcu_fd_sc_mcu7t5v0__fill_2
XFILLER_90_119 VDD VDD VSS VSS gf180mcu_fd_sc_mcu7t5v0__fill_2
XTAP_TAPCELL_ROW_106_1618 VDD VSS gf180mcu_fd_sc_mcu7t5v0__filltie
Xwave_controller_y_inst__1835_ wave_controller_y_inst__3739_/Q wave_controller_y_inst__2935_/A2
+ VDD VDD VSS VSS gf180mcu_fd_sc_mcu7t5v0__clkinv_1
Xwave_controller_x_inst__1819_ fanout537/Z wave_controller_x_inst__2944_/A2 VDD VDD
+ VSS VSS gf180mcu_fd_sc_mcu7t5v0__clkinv_1
XFILLER_112_1087 VDD VDD VSS VSS gf180mcu_fd_sc_mcu7t5v0__fillcap_64
XFILLER_16_216 VDD VDD VSS VSS gf180mcu_fd_sc_mcu7t5v0__fill_1
XFILLER_44_547 VDD VDD VSS VSS gf180mcu_fd_sc_mcu7t5v0__fillcap_8
XFILLER_83_171 VDD VDD VSS VSS gf180mcu_fd_sc_mcu7t5v0__fillcap_4
XTAP_TAPCELL_ROW_106_1629 VDD VSS gf180mcu_fd_sc_mcu7t5v0__filltie
XTAP_TAPCELL_ROW_123_1910 VDD VSS gf180mcu_fd_sc_mcu7t5v0__filltie
Xwave_controller_x_inst__2799_ wave_controller_x_inst__3279_/A1 wave_controller_x_inst__2795_/Z
+ wave_controller_x_inst__2798_/Z wave_controller_x_inst__3562_/A1 wave_controller_x_inst__2802_/A2
+ VDD VDD VSS VSS gf180mcu_fd_sc_mcu7t5v0__aoi22_1
Xwave_controller_y_inst__3505_ spi_regs_inst__1183_/A1 wave_controller_y_inst__3529_/A2
+ wave_controller_y_inst__3506_/A3 VDD VDD VSS VSS gf180mcu_fd_sc_mcu7t5v0__nor2_1
Xwave_controller_x_inst_max_cap133 wave_controller_x_inst__2323_/A1 wave_controller_x_inst__2350_/B1
+ VDD VDD VSS VSS gf180mcu_fd_sc_mcu7t5v0__clkbuf_1
XFILLER_140_98 VDD VDD VSS VSS gf180mcu_fd_sc_mcu7t5v0__fillcap_4
Xwave_controller_y_inst__3436_ wave_controller_y_inst__3454_/B wave_controller_y_inst__3436_/A2
+ wave_controller_y_inst__3436_/A3 wave_controller_y_inst__3465_/B wave_controller_y_inst__3441_/C
+ VDD VDD VSS VSS gf180mcu_fd_sc_mcu7t5v0__oai31_1
XFILLER_12_477 VDD VDD VSS VSS gf180mcu_fd_sc_mcu7t5v0__fill_2
XFILLER_149_52 VDD VDD VSS VSS gf180mcu_fd_sc_mcu7t5v0__fillcap_16
XTAP_TAPCELL_ROW_156_2453 VDD VSS gf180mcu_fd_sc_mcu7t5v0__filltie
Xwave_controller_y_inst__3367_ wave_controller_y_inst__3271_/Z wave_controller_y_inst_wire122/Z
+ wave_controller_y_inst__3386_/A2 VDD VDD VSS VSS gf180mcu_fd_sc_mcu7t5v0__xnor2_1
XFILLER_12_499 VDD VDD VSS VSS gf180mcu_fd_sc_mcu7t5v0__fill_2
XFILLER_138_663 VDD VDD VSS VSS gf180mcu_fd_sc_mcu7t5v0__fill_2
XFILLER_33_96 VDD VDD VSS VSS gf180mcu_fd_sc_mcu7t5v0__fillcap_8
XTAP_TAPCELL_ROW_48_1_694 VDD VSS gf180mcu_fd_sc_mcu7t5v0__filltie
Xwave_controller_y_inst__3298_ wave_controller_y_inst__3305_/B2 spi_regs_inst__1607_/Q
+ wave_controller_y_inst__3299_/I VDD VDD VSS VSS gf180mcu_fd_sc_mcu7t5v0__xor2_1
Xwave_controller_y_inst__2318_ wave_controller_y_inst__2318_/A1 spi_regs_inst__1199_/A1
+ spi_regs_inst__1139_/B2 wave_controller_y_inst__2319_/B1 VDD VDD VSS VSS gf180mcu_fd_sc_mcu7t5v0__aoi21_1
XFILLER_137_173 VDD VDD VSS VSS gf180mcu_fd_sc_mcu7t5v0__fillcap_8
XFILLER_149_96 VDD VDD VSS VSS gf180mcu_fd_sc_mcu7t5v0__fillcap_8
Xwave_controller_y_inst__2249_ wave_controller_y_inst__2250_/A1 wave_controller_y_inst__2250_/B
+ wave_controller_y_inst__2250_/A2 wave_controller_y_inst__2249_/Z VDD VDD VSS VSS
+ gf180mcu_fd_sc_mcu7t5v0__and3_1
XFILLER_153_644 VDD VDD VSS VSS gf180mcu_fd_sc_mcu7t5v0__fill_2
XFILLER_165_40 VDD VDD VSS VSS gf180mcu_fd_sc_mcu7t5v0__fillcap_16
XPHY_EDGE_ROW_104_Left_271 VDD VSS gf180mcu_fd_sc_mcu7t5v0__endcap
XFILLER_125_368 VDD VDD VSS VSS gf180mcu_fd_sc_mcu7t5v0__fillcap_4
XFILLER_3_142 VDD VDD VSS VSS gf180mcu_fd_sc_mcu7t5v0__fillcap_64
XTAP_TAPCELL_ROW_14_1_439 VDD VSS gf180mcu_fd_sc_mcu7t5v0__filltie
XFILLER_79_422 VDD VDD VSS VSS gf180mcu_fd_sc_mcu7t5v0__fillcap_4
XPHY_EDGE_ROW_148_Right_148 VDD VSS gf180mcu_fd_sc_mcu7t5v0__endcap
XTAP_TAPCELL_ROW_22_1_496 VDD VSS gf180mcu_fd_sc_mcu7t5v0__filltie
XTAP_TAPCELL_ROW_72_1065 VDD VSS gf180mcu_fd_sc_mcu7t5v0__filltie
XFILLER_121_585 VDD VDD VSS VSS gf180mcu_fd_sc_mcu7t5v0__fillcap_8
XFILLER_58_71 VDD VDD VSS VSS gf180mcu_fd_sc_mcu7t5v0__fillcap_4
XFILLER_79_488 VDD VDD VSS VSS gf180mcu_fd_sc_mcu7t5v0__fill_2
XFILLER_47_352 VDD VDD VSS VSS gf180mcu_fd_sc_mcu7t5v0__fillcap_32
XFILLER_62_300 VDD VDD VSS VSS gf180mcu_fd_sc_mcu7t5v0__fillcap_4
XFILLER_63_801 VDD VDD VSS VSS gf180mcu_fd_sc_mcu7t5v0__fillcap_4
XPHY_EDGE_ROW_113_Left_280 VDD VSS gf180mcu_fd_sc_mcu7t5v0__endcap
XFILLER_62_333 VDD VDD VSS VSS gf180mcu_fd_sc_mcu7t5v0__fillcap_4
XFILLER_149_906 VDD VDD VSS VSS gf180mcu_fd_sc_mcu7t5v0__fillcap_4
XFILLER_15_271 VDD VDD VSS VSS gf180mcu_fd_sc_mcu7t5v0__fill_1
XFILLER_15_282 VDD VDD VSS VSS gf180mcu_fd_sc_mcu7t5v0__fillcap_16
XFILLER_148_449 VDD VDD VSS VSS gf180mcu_fd_sc_mcu7t5v0__fillcap_4
XFILLER_116_313 VDD VDD VSS VSS gf180mcu_fd_sc_mcu7t5v0__fill_2
XFILLER_143_132 VDD VDD VSS VSS gf180mcu_fd_sc_mcu7t5v0__fillcap_8
XFILLER_7_492 VDD VDD VSS VSS gf180mcu_fd_sc_mcu7t5v0__fillcap_16
Xspi_regs_inst__1108_ spi_regs_inst__1108_/A1 spi_regs_inst__1252_/A2 spi_regs_inst__1252_/B1
+ spi_regs_inst__1108_/B2 spi_regs_inst__1118_/A3 VDD VDD VSS VSS gf180mcu_fd_sc_mcu7t5v0__aoi22_1
XFILLER_131_349 VDD VDD VSS VSS gf180mcu_fd_sc_mcu7t5v0__fill_1
XPHY_EDGE_ROW_115_Right_115 VDD VSS gf180mcu_fd_sc_mcu7t5v0__endcap
XFILLER_140_861 VDD VDD VSS VSS gf180mcu_fd_sc_mcu7t5v0__fillcap_8
XFILLER_97_230 VDD VDD VSS VSS gf180mcu_fd_sc_mcu7t5v0__fillcap_16
Xspi_regs_inst__1039_ spi_regs_inst__1039_/A1 spi_regs_inst__1039_/A2 spi_regs_inst__1039_/A3
+ spi_regs_inst__1039_/A4 spi_regs_inst__1039_/Z VDD VDD VSS VSS gf180mcu_fd_sc_mcu7t5v0__and4_1
XFILLER_58_617 VDD VDD VSS VSS gf180mcu_fd_sc_mcu7t5v0__fill_1
Xwave_controller_x_inst__2722_ wave_controller_x_inst__2939_/A2 spi_regs_inst__1119_/A1
+ wave_controller_x_inst__2719_/Z wave_controller_x_inst__2722_/Z VDD VDD VSS VSS
+ gf180mcu_fd_sc_mcu7t5v0__xor3_1
XTAP_TAPCELL_ROW_56_807 VDD VSS gf180mcu_fd_sc_mcu7t5v0__filltie
Xwave_controller_x_inst__2653_ wave_controller_x_inst__2822_/A1 spi_regs_inst__1301_/A1
+ wave_controller_x_inst__2656_/A1 VDD VDD VSS VSS gf180mcu_fd_sc_mcu7t5v0__nand2_1
Xwave_controller_x_inst__2584_ wave_controller_x_inst__2584_/I wave_controller_x_inst__2585_/B
+ VDD VDD VSS VSS gf180mcu_fd_sc_mcu7t5v0__clkinv_1
XFILLER_13_208 VDD VDD VSS VSS gf180mcu_fd_sc_mcu7t5v0__fill_2
XFILLER_80_185 VDD VDD VSS VSS gf180mcu_fd_sc_mcu7t5v0__fill_2
XTAP_TAPCELL_ROW_101_1537 VDD VSS gf180mcu_fd_sc_mcu7t5v0__filltie
XTAP_TAPCELL_ROW_101_1548 VDD VSS gf180mcu_fd_sc_mcu7t5v0__filltie
XFILLER_166_213 VDD VDD VSS VSS gf180mcu_fd_sc_mcu7t5v0__fill_2
XFILLER_21_241 VDD VDD VSS VSS gf180mcu_fd_sc_mcu7t5v0__fillcap_16
XFILLER_70_28 VDD VDD VSS VSS gf180mcu_fd_sc_mcu7t5v0__fill_2
XTAP_TAPCELL_ROW_138_2150 VDD VSS gf180mcu_fd_sc_mcu7t5v0__filltie
Xwave_controller_y_inst__3221_ wave_controller_y_inst__3126_/I wave_controller_y_inst__3221_/A2
+ wave_controller_y_inst__3145_/B wave_controller_y_inst__3222_/A2 VDD VDD VSS VSS
+ gf180mcu_fd_sc_mcu7t5v0__nand3_1
Xwave_controller_x_inst__3205_ wave_controller_x_inst__3154_/Z wave_controller_x_inst__3205_/A2
+ wave_controller_x_inst__3159_/B wave_controller_x_inst__3205_/Z VDD VDD VSS VSS
+ gf180mcu_fd_sc_mcu7t5v0__or3_1
XFILLER_154_408 VDD VDD VSS VSS gf180mcu_fd_sc_mcu7t5v0__fillcap_8
XFILLER_21_274 VDD VDD VSS VSS gf180mcu_fd_sc_mcu7t5v0__fillcap_4
XTAP_TAPCELL_ROW_138_2161 VDD VSS gf180mcu_fd_sc_mcu7t5v0__filltie
Xwave_controller_y_inst__3152_ wave_controller_y_inst__1790_/I spi_regs_inst__1592_/Q
+ wave_controller_y_inst__3153_/I VDD VDD VSS VSS gf180mcu_fd_sc_mcu7t5v0__xor2_1
XFILLER_135_622 VDD VDD VSS VSS gf180mcu_fd_sc_mcu7t5v0__fillcap_8
Xwave_controller_y_inst__2103_ wave_controller_y_inst__3728_/Q wave_controller_y_inst__2102_/I
+ wave_controller_y_inst__2104_/B VDD VDD VSS VSS gf180mcu_fd_sc_mcu7t5v0__xor2_1
Xwave_controller_x_inst__3136_ wave_controller_x_inst__3137_/B wave_controller_x_inst__3138_/B
+ VDD VDD VSS VSS gf180mcu_fd_sc_mcu7t5v0__clkinv_1
XFILLER_107_324 VDD VDD VSS VSS gf180mcu_fd_sc_mcu7t5v0__fillcap_8
XTAP_TAPCELL_ROW_151_2361 VDD VSS gf180mcu_fd_sc_mcu7t5v0__filltie
Xwave_controller_y_inst__3083_ wave_controller_y_inst__3085_/A2 wave_controller_y_inst__3083_/A2
+ wave_controller_y_inst__3717_/D VDD VDD VSS VSS gf180mcu_fd_sc_mcu7t5v0__nor2_1
Xwave_controller_x_inst__3067_ wave_controller_x_inst__3711_/Q fanout404/Z wave_controller_x_inst__3608_/A2
+ VDD VDD VSS VSS gf180mcu_fd_sc_mcu7t5v0__nand2_1
XFILLER_107_368 VDD VDD VSS VSS gf180mcu_fd_sc_mcu7t5v0__fill_2
XFILLER_123_817 VDD VDD VSS VSS gf180mcu_fd_sc_mcu7t5v0__fillcap_8
XFILLER_135_677 VDD VDD VSS VSS gf180mcu_fd_sc_mcu7t5v0__fillcap_8
XTAP_TAPCELL_ROW_151_2372 VDD VSS gf180mcu_fd_sc_mcu7t5v0__filltie
Xwave_controller_y_inst__2034_ wave_controller_y_inst__1785_/I wave_controller_y_inst__2038_/A2
+ wave_controller_y_inst__2125_/A1 VDD VDD VSS VSS gf180mcu_fd_sc_mcu7t5v0__xnor2_1
Xwave_controller_x_inst__2018_ wave_controller_x_inst__2018_/A1 wave_controller_x_inst__2018_/A2
+ wave_controller_x_inst__2018_/B wave_controller_x_inst__2019_/A2 VDD VDD VSS VSS
+ gf180mcu_fd_sc_mcu7t5v0__aoi21_1
XFILLER_162_485 VDD VDD VSS VSS gf180mcu_fd_sc_mcu7t5v0__fill_2
XFILLER_66_1151 VDD VDD VSS VSS gf180mcu_fd_sc_mcu7t5v0__fillcap_4
XTAP_TAPCELL_ROW_116_1791 VDD VSS gf180mcu_fd_sc_mcu7t5v0__filltie
XFILLER_131_861 VDD VDD VSS VSS gf180mcu_fd_sc_mcu7t5v0__fill_1
XFILLER_150_669 VDD VDD VSS VSS gf180mcu_fd_sc_mcu7t5v0__fill_1
XFILLER_66_1173 VDD VDD VSS VSS gf180mcu_fd_sc_mcu7t5v0__fill_1
XFILLER_153_1154 VDD VDD VSS VSS gf180mcu_fd_sc_mcu7t5v0__fillcap_16
XFILLER_76_403 VDD VDD VSS VSS gf180mcu_fd_sc_mcu7t5v0__fillcap_4
XFILLER_88_263 VDD VDD VSS VSS gf180mcu_fd_sc_mcu7t5v0__fillcap_4
XFILLER_95_36 VDD VDD VSS VSS gf180mcu_fd_sc_mcu7t5v0__fill_1
Xspi_regs_inst_fanout469 spi_regs_inst__1664_/Q spi_regs_inst__1445_/I1 VDD VDD VSS
+ VSS gf180mcu_fd_sc_mcu7t5v0__dlyb_1
XFILLER_28_30 VDD VDD VSS VSS gf180mcu_fd_sc_mcu7t5v0__fillcap_4
Xwave_controller_y_inst__2936_ spi_regs_inst__1091_/B2 wave_controller_y_inst__3588_/S
+ wave_controller_y_inst__2936_/B1 wave_controller_y_inst__3010_/B wave_controller_y_inst__2937_/I
+ VDD VDD VSS VSS gf180mcu_fd_sc_mcu7t5v0__aoi22_1
XFILLER_29_352 VDD VDD VSS VSS gf180mcu_fd_sc_mcu7t5v0__fillcap_4
Xwave_controller_y_inst__2867_ wave_controller_y_inst__2867_/A1 wave_controller_y_inst__2864_/Z
+ wave_controller_y_inst__2867_/A3 wave_controller_y_inst__2884_/A2 wave_controller_y_inst__2869_/B
+ VDD VDD VSS VSS gf180mcu_fd_sc_mcu7t5v0__nand4_1
XFILLER_151_86 VDD VDD VSS VSS gf180mcu_fd_sc_mcu7t5v0__fillcap_4
XFILLER_44_300 VDD VDD VSS VSS gf180mcu_fd_sc_mcu7t5v0__fill_1
Xwave_controller_y_inst__1818_ wave_controller_y_inst__1818_/I wave_controller_y_inst__2671_/A1
+ VDD VDD VSS VSS gf180mcu_fd_sc_mcu7t5v0__clkinv_1
XFILLER_56_193 VDD VDD VSS VSS gf180mcu_fd_sc_mcu7t5v0__fill_2
XFILLER_60_804 VDD VDD VSS VSS gf180mcu_fd_sc_mcu7t5v0__fill_1
XFILLER_72_642 VDD VDD VSS VSS gf180mcu_fd_sc_mcu7t5v0__fill_1
XFILLER_72_664 VDD VDD VSS VSS gf180mcu_fd_sc_mcu7t5v0__fill_1
Xwave_controller_y_inst__2798_ max_cap429/Z spi_regs_inst__1139_/A1 wave_controller_y_inst__2800_/S
+ wave_controller_y_inst__2798_/Z VDD VDD VSS VSS gf180mcu_fd_sc_mcu7t5v0__mux2_2
XFILLER_73_1122 VDD VDD VSS VSS gf180mcu_fd_sc_mcu7t5v0__fillcap_32
XFILLER_71_196 VDD VDD VSS VSS gf180mcu_fd_sc_mcu7t5v0__fillcap_8
Xwave_controller_y_inst__3419_ wave_controller_y_inst__3723_/Q wave_controller_y_inst__1902_/I
+ wave_controller_y_inst__3419_/B wave_controller_y_inst__3419_/C wave_controller_y_inst__3494_/A2
+ VDD VDD VSS VSS gf180mcu_fd_sc_mcu7t5v0__oai211_1
Xspi_regs_inst__1390_ fanout537/Z spi_regs_inst__1441_/I1 spi_regs_inst__1391_/S spi_regs_inst__1465_/D
+ VDD VDD VSS VSS gf180mcu_fd_sc_mcu7t5v0__mux2_2
XFILLER_157_279 VDD VDD VSS VSS gf180mcu_fd_sc_mcu7t5v0__fill_1
XFILLER_60_61 VDD VDD VSS VSS gf180mcu_fd_sc_mcu7t5v0__fill_2
XFILLER_125_165 VDD VDD VSS VSS gf180mcu_fd_sc_mcu7t5v0__fillcap_8
XFILLER_126_677 VDD VDD VSS VSS gf180mcu_fd_sc_mcu7t5v0__fill_1
XTAP_TAPCELL_ROW_74_1105 VDD VSS gf180mcu_fd_sc_mcu7t5v0__filltie
XFILLER_113_338 VDD VDD VSS VSS gf180mcu_fd_sc_mcu7t5v0__fillcap_8
XFILLER_140_102 VDD VDD VSS VSS gf180mcu_fd_sc_mcu7t5v0__fill_2
XFILLER_141_636 VDD VDD VSS VSS gf180mcu_fd_sc_mcu7t5v0__fill_2
XFILLER_158_1087 VDD VDD VSS VSS gf180mcu_fd_sc_mcu7t5v0__fillcap_64
XFILLER_140_168 VDD VDD VSS VSS gf180mcu_fd_sc_mcu7t5v0__fill_2
XFILLER_67_414 VDD VDD VSS VSS gf180mcu_fd_sc_mcu7t5v0__fillcap_4
XFILLER_39_138 VDD VDD VSS VSS gf180mcu_fd_sc_mcu7t5v0__fill_2
XFILLER_94_266 VDD VDD VSS VSS gf180mcu_fd_sc_mcu7t5v0__fillcap_8
XFILLER_78_1011 VDD VDD VSS VSS gf180mcu_fd_sc_mcu7t5v0__fillcap_4
XFILLER_94_288 VDD VDD VSS VSS gf180mcu_fd_sc_mcu7t5v0__fillcap_8
XFILLER_63_653 VDD VDD VSS VSS gf180mcu_fd_sc_mcu7t5v0__fillcap_16
XFILLER_62_174 VDD VDD VSS VSS gf180mcu_fd_sc_mcu7t5v0__fill_1
XFILLER_63_675 VDD VDD VSS VSS gf180mcu_fd_sc_mcu7t5v0__fill_1
XFILLER_63_686 VDD VDD VSS VSS gf180mcu_fd_sc_mcu7t5v0__fill_2
XTAP_TAPCELL_ROW_85_1278 VDD VSS gf180mcu_fd_sc_mcu7t5v0__filltie
XPHY_EDGE_ROW_53_Right_53 VDD VSS gf180mcu_fd_sc_mcu7t5v0__endcap
Xspi_regs_inst__1657_ spi_regs_inst__1657_/D fanout583/Z clkload10/I spi_regs_inst__1657_/Q
+ VDD VDD VSS VSS gf180mcu_fd_sc_mcu7t5v0__dffrnq_1
XTAP_TAPCELL_ROW_61_876 VDD VSS gf180mcu_fd_sc_mcu7t5v0__filltie
XTAP_TAPCELL_ROW_61_887 VDD VSS gf180mcu_fd_sc_mcu7t5v0__filltie
Xspi_regs_inst__1588_ spi_regs_inst__1588_/D spi_regs_inst__1647_/RN clkbuf_leaf_39_clk/Z
+ spi_regs_inst__1588_/Q VDD VDD VSS VSS gf180mcu_fd_sc_mcu7t5v0__dffrnq_1
XFILLER_117_611 VDD VDD VSS VSS gf180mcu_fd_sc_mcu7t5v0__fillcap_8
XFILLER_117_644 VDD VDD VSS VSS gf180mcu_fd_sc_mcu7t5v0__fill_1
XFILLER_144_441 VDD VDD VSS VSS gf180mcu_fd_sc_mcu7t5v0__fillcap_8
XFILLER_116_165 VDD VDD VSS VSS gf180mcu_fd_sc_mcu7t5v0__fillcap_8
XFILLER_132_647 VDD VDD VSS VSS gf180mcu_fd_sc_mcu7t5v0__fillcap_4
XFILLER_137_1116 VDD VDD VSS VSS gf180mcu_fd_sc_mcu7t5v0__fillcap_4
XPHY_EDGE_ROW_62_Right_62 VDD VSS gf180mcu_fd_sc_mcu7t5v0__endcap
XFILLER_131_146 VDD VDD VSS VSS gf180mcu_fd_sc_mcu7t5v0__fill_1
XTAP_TAPCELL_ROW_39_1_625 VDD VSS gf180mcu_fd_sc_mcu7t5v0__filltie
XFILLER_100_522 VDD VDD VSS VSS gf180mcu_fd_sc_mcu7t5v0__fill_2
XFILLER_59_959 VDD VDD VSS VSS gf180mcu_fd_sc_mcu7t5v0__fillcap_16
XFILLER_86_756 VDD VDD VSS VSS gf180mcu_fd_sc_mcu7t5v0__fillcap_8
XFILLER_98_594 VDD VDD VSS VSS gf180mcu_fd_sc_mcu7t5v0__fill_1
XTAP_TAPCELL_ROW_47_1_682 VDD VSS gf180mcu_fd_sc_mcu7t5v0__filltie
Xwave_controller_y_inst__2721_ wave_controller_y_inst__3400_/A1 wave_controller_y_inst__2719_/Z
+ wave_controller_y_inst__2728_/A2 VDD VDD VSS VSS gf180mcu_fd_sc_mcu7t5v0__nand2_1
Xwave_controller_x_inst__2705_ wave_controller_x_inst__3542_/B2 wave_controller_x_inst__2705_/A2
+ wave_controller_x_inst__2705_/B wave_controller_x_inst__2707_/A2 VDD VDD VSS VSS
+ gf180mcu_fd_sc_mcu7t5v0__oai21_1
Xwave_controller_y_inst__2652_ wave_controller_y_inst__2652_/A1 wave_controller_y_inst__2652_/A2
+ wave_controller_y_inst__2652_/B wave_controller_y_inst__2688_/B1 VDD VDD VSS VSS
+ gf180mcu_fd_sc_mcu7t5v0__aoi21_1
Xwave_controller_x_inst__3685_ wave_controller_x_inst__3685_/D wave_controller_x_inst__3686_/RN
+ clkbuf_leaf_26_clk/Z spi_regs_inst__1349_/A1 VDD VDD VSS VSS gf180mcu_fd_sc_mcu7t5v0__dffrnq_1
XFILLER_38_193 VDD VDD VSS VSS gf180mcu_fd_sc_mcu7t5v0__fill_1
Xwave_controller_x_inst__2636_ max_cap452/Z spi_regs_inst__1284_/A1 wave_controller_x_inst__2636_/Z
+ VDD VDD VSS VSS gf180mcu_fd_sc_mcu7t5v0__xor2_1
XFILLER_14_506 VDD VDD VSS VSS gf180mcu_fd_sc_mcu7t5v0__fillcap_4
XFILLER_54_686 VDD VDD VSS VSS gf180mcu_fd_sc_mcu7t5v0__fill_1
XPHY_EDGE_ROW_71_Right_71 VDD VSS gf180mcu_fd_sc_mcu7t5v0__endcap
XTAP_TAPCELL_ROW_13_1_427 VDD VSS gf180mcu_fd_sc_mcu7t5v0__filltie
Xwave_controller_y_inst__2583_ wave_controller_y_inst__2815_/A1 spi_regs_inst__1099_/B2
+ wave_controller_y_inst__2583_/B wave_controller_y_inst__2584_/I VDD VDD VSS VSS
+ gf180mcu_fd_sc_mcu7t5v0__oai21_1
Xwave_controller_x_inst__2567_ wave_controller_x_inst__2550_/Z wave_controller_x_inst__2567_/A2
+ wave_controller_x_inst__2567_/B wave_controller_x_inst__2570_/A3 VDD VDD VSS VSS
+ gf180mcu_fd_sc_mcu7t5v0__aoi21_1
XFILLER_81_38 VDD VDD VSS VSS gf180mcu_fd_sc_mcu7t5v0__fill_1
XFILLER_81_494 VDD VDD VSS VSS gf180mcu_fd_sc_mcu7t5v0__fill_1
XFILLER_41_369 VDD VDD VSS VSS gf180mcu_fd_sc_mcu7t5v0__fillcap_4
Xwave_controller_x_inst__2498_ wave_controller_x_inst__2498_/A1 wave_controller_x_inst__2498_/A2
+ wave_controller_x_inst__2497_/B spi_regs_inst__1208_/A1 VDD VDD VSS VSS gf180mcu_fd_sc_mcu7t5v0__xor3_1
XFILLER_139_246 VDD VDD VSS VSS gf180mcu_fd_sc_mcu7t5v0__fill_1
XTAP_TAPCELL_ROW_153_2401 VDD VSS gf180mcu_fd_sc_mcu7t5v0__filltie
Xwave_controller_y_inst__3204_ wave_controller_y_inst__3202_/Z wave_controller_y_inst__3242_/A3
+ wave_controller_y_inst__3204_/Z VDD VDD VSS VSS gf180mcu_fd_sc_mcu7t5v0__or2_1
XFILLER_108_611 VDD VDD VSS VSS gf180mcu_fd_sc_mcu7t5v0__fillcap_4
XFILLER_127_408 VDD VDD VSS VSS gf180mcu_fd_sc_mcu7t5v0__fillcap_8
XFILLER_139_279 VDD VDD VSS VSS gf180mcu_fd_sc_mcu7t5v0__fill_1
XTAP_TAPCELL_ROW_118_1820 VDD VSS gf180mcu_fd_sc_mcu7t5v0__filltie
XPHY_EDGE_ROW_11_1_Right_10 VDD VSS gf180mcu_fd_sc_mcu7t5v0__endcap
XTAP_TAPCELL_ROW_118_1831 VDD VSS gf180mcu_fd_sc_mcu7t5v0__filltie
Xwave_controller_y_inst__3135_ wave_controller_y_inst__3703_/Q spi_regs_inst__1585_/Q
+ wave_controller_y_inst__3137_/B VDD VDD VSS VSS gf180mcu_fd_sc_mcu7t5v0__xor2_1
Xwave_controller_x_inst__3119_ wave_controller_x_inst__3706_/Q wave_controller_x_inst__3122_/A2
+ wave_controller_x_inst__3219_/B VDD VDD VSS VSS gf180mcu_fd_sc_mcu7t5v0__nor2_1
XFILLER_151_912 VDD VDD VSS VSS gf180mcu_fd_sc_mcu7t5v0__fillcap_64
XFILLER_163_772 VDD VDD VSS VSS gf180mcu_fd_sc_mcu7t5v0__fillcap_64
XFILLER_30_53 VDD VDD VSS VSS gf180mcu_fd_sc_mcu7t5v0__fillcap_4
XPHY_EDGE_ROW_80_Right_80 VDD VSS gf180mcu_fd_sc_mcu7t5v0__endcap
Xwave_controller_y_inst__3066_ wave_controller_y_inst__3305_/A1 wave_controller_y_inst__3090_/B1
+ wave_controller_y_inst__3065_/Z wave_controller_y_inst__2762_/I wave_controller_y_inst__3710_/D
+ VDD VDD VSS VSS gf180mcu_fd_sc_mcu7t5v0__oai22_1
XFILLER_100_2 VDD VDD VSS VSS gf180mcu_fd_sc_mcu7t5v0__fillcap_4
XFILLER_123_625 VDD VDD VSS VSS gf180mcu_fd_sc_mcu7t5v0__fillcap_4
XFILLER_162_260 VDD VDD VSS VSS gf180mcu_fd_sc_mcu7t5v0__fillcap_16
Xwave_controller_y_inst__2017_ wave_controller_y_inst__2018_/A1 wave_controller_y_inst__2018_/B
+ wave_controller_y_inst__2018_/A2 wave_controller_y_inst__2017_/Z VDD VDD VSS VSS
+ gf180mcu_fd_sc_mcu7t5v0__and3_1
XFILLER_122_168 VDD VDD VSS VSS gf180mcu_fd_sc_mcu7t5v0__fillcap_4
XFILLER_49_414 VDD VDD VSS VSS gf180mcu_fd_sc_mcu7t5v0__fill_2
XFILLER_103_371 VDD VDD VSS VSS gf180mcu_fd_sc_mcu7t5v0__fill_2
XFILLER_65_918 VDD VDD VSS VSS gf180mcu_fd_sc_mcu7t5v0__fill_1
Xwave_controller_y_inst__2919_ wave_controller_y_inst__1781_/I wave_controller_y_inst__3039_/A1
+ wave_controller_y_inst__3587_/A1 VDD VDD VSS VSS gf180mcu_fd_sc_mcu7t5v0__nand2_1
Xspi_regs_inst__0890_ spi_regs_inst__0940_/A1 spi_regs_inst__1455_/Q spi_regs_inst__1453_/D
+ spi_regs_inst__0891_/I VDD VDD VSS VSS gf180mcu_fd_sc_mcu7t5v0__oai21_1
XFILLER_76_288 VDD VDD VSS VSS gf180mcu_fd_sc_mcu7t5v0__fill_1
XTAP_TAPCELL_ROW_164_2585 VDD VSS gf180mcu_fd_sc_mcu7t5v0__filltie
XFILLER_32_314 VDD VDD VSS VSS gf180mcu_fd_sc_mcu7t5v0__fill_1
XFILLER_44_174 VDD VDD VSS VSS gf180mcu_fd_sc_mcu7t5v0__fill_1
XFILLER_72_461 VDD VDD VSS VSS gf180mcu_fd_sc_mcu7t5v0__fill_2
Xspi_regs_inst__1511_ spi_regs_inst__1511_/D fanout592/Z clkload29/I spi_regs_inst__1511_/Q
+ VDD VDD VSS VSS gf180mcu_fd_sc_mcu7t5v0__dffrnq_1
Xspi_regs_inst__1442_ spi_regs_inst__1511_/Q spi_regs_inst_wire476/Z spi_regs_inst__1445_/S
+ spi_regs_inst__1511_/D VDD VDD VSS VSS gf180mcu_fd_sc_mcu7t5v0__mux2_2
Xspi_regs_inst__1373_ spi_regs_inst__1655_/Q spi_regs_inst__1376_/A2 spi_regs_inst__1374_/B
+ VDD VDD VSS VSS gf180mcu_fd_sc_mcu7t5v0__nand2_1
XTAP_TAPCELL_ROW_80_1197 VDD VSS gf180mcu_fd_sc_mcu7t5v0__filltie
XFILLER_126_496 VDD VDD VSS VSS gf180mcu_fd_sc_mcu7t5v0__fillcap_4
XFILLER_141_422 VDD VDD VSS VSS gf180mcu_fd_sc_mcu7t5v0__fillcap_32
XFILLER_153_271 VDD VDD VSS VSS gf180mcu_fd_sc_mcu7t5v0__fillcap_8
XFILLER_99_314 VDD VDD VSS VSS gf180mcu_fd_sc_mcu7t5v0__fill_1
XFILLER_99_336 VDD VDD VSS VSS gf180mcu_fd_sc_mcu7t5v0__fill_2
XFILLER_101_308 VDD VDD VSS VSS gf180mcu_fd_sc_mcu7t5v0__fillcap_4
XFILLER_113_157 VDD VDD VSS VSS gf180mcu_fd_sc_mcu7t5v0__fillcap_16
XFILLER_141_466 VDD VDD VSS VSS gf180mcu_fd_sc_mcu7t5v0__fillcap_16
XFILLER_84_1081 VDD VDD VSS VSS gf180mcu_fd_sc_mcu7t5v0__fillcap_4
Xsignal_processor_y_inst__254_ signal_processor_y_inst__254_/D fanout546/Z clkbuf_leaf_0_clk/Z
+ signal_processor_y_inst__254_/Q VDD VDD VSS VSS gf180mcu_fd_sc_mcu7t5v0__dffrnq_1
Xsignal_processor_y_inst__185_ signal_processor_y_inst__185_/I signal_processor_y_inst__187_/A2
+ VDD VDD VSS VSS gf180mcu_fd_sc_mcu7t5v0__clkinv_1
XFILLER_83_704 VDD VDD VSS VSS gf180mcu_fd_sc_mcu7t5v0__fill_1
XTAP_TAPCELL_ROW_87_1307 VDD VSS gf180mcu_fd_sc_mcu7t5v0__filltie
XFILLER_55_417 VDD VDD VSS VSS gf180mcu_fd_sc_mcu7t5v0__fill_2
XTAP_TAPCELL_ROW_87_1318 VDD VSS gf180mcu_fd_sc_mcu7t5v0__filltie
XTAP_TAPCELL_ROW_66_968 VDD VSS gf180mcu_fd_sc_mcu7t5v0__filltie
Xwave_controller_x_inst__3470_ wave_controller_x_inst__3490_/A1 wave_controller_x_inst__3468_/I
+ wave_controller_x_inst__3470_/B wave_controller_x_inst__3470_/C wave_controller_x_inst__3472_/B1
+ VDD VDD VSS VSS gf180mcu_fd_sc_mcu7t5v0__aoi211_1
Xwave_controller_x_inst__2421_ wave_controller_x_inst__2418_/Z wave_controller_x_inst__2434_/A2
+ wave_controller_x_inst__2433_/A2 VDD VDD VSS VSS gf180mcu_fd_sc_mcu7t5v0__xnor2_1
XFILLER_149_500 VDD VDD VSS VSS gf180mcu_fd_sc_mcu7t5v0__fill_1
XFILLER_149_522 VDD VDD VSS VSS gf180mcu_fd_sc_mcu7t5v0__fill_1
XFILLER_91_1052 VDD VDD VSS VSS gf180mcu_fd_sc_mcu7t5v0__fillcap_64
Xwave_controller_x_inst__2352_ spi_regs_inst__1309_/C2 spi_regs_inst__1306_/A1 wave_controller_x_inst__2352_/Z
+ VDD VDD VSS VSS gf180mcu_fd_sc_mcu7t5v0__xor2_1
XFILLER_149_533 VDD VDD VSS VSS gf180mcu_fd_sc_mcu7t5v0__fillcap_16
XFILLER_50_199 VDD VDD VSS VSS gf180mcu_fd_sc_mcu7t5v0__fillcap_32
Xwave_controller_x_inst__2283_ wave_controller_x_inst__2284_/A1 max_cap455/Z wave_controller_x_inst__2299_/B
+ VDD VDD VSS VSS gf180mcu_fd_sc_mcu7t5v0__nor2_1
XFILLER_136_205 VDD VDD VSS VSS gf180mcu_fd_sc_mcu7t5v0__fillcap_8
XFILLER_149_566 VDD VDD VSS VSS gf180mcu_fd_sc_mcu7t5v0__fill_1
XFILLER_149_577 VDD VDD VSS VSS gf180mcu_fd_sc_mcu7t5v0__fillcap_8
XFILLER_118_942 VDD VDD VSS VSS gf180mcu_fd_sc_mcu7t5v0__fill_2
XFILLER_133_912 VDD VDD VSS VSS gf180mcu_fd_sc_mcu7t5v0__fillcap_64
XFILLER_145_750 VDD VDD VSS VSS gf180mcu_fd_sc_mcu7t5v0__fillcap_16
XFILLER_145_772 VDD VDD VSS VSS gf180mcu_fd_sc_mcu7t5v0__fillcap_8
XTAP_TAPCELL_ROW_131_2039 VDD VSS gf180mcu_fd_sc_mcu7t5v0__filltie
XFILLER_160_731 VDD VDD VSS VSS gf180mcu_fd_sc_mcu7t5v0__fillcap_4
XFILLER_120_617 VDD VDD VSS VSS gf180mcu_fd_sc_mcu7t5v0__fillcap_32
Xfanout511 fanout511/I fanout511/Z VDD VDD VSS VSS gf180mcu_fd_sc_mcu7t5v0__dlyb_1
XFILLER_101_842 VDD VDD VSS VSS gf180mcu_fd_sc_mcu7t5v0__fillcap_8
XFILLER_59_745 VDD VDD VSS VSS gf180mcu_fd_sc_mcu7t5v0__fillcap_4
XFILLER_63_1154 VDD VDD VSS VSS gf180mcu_fd_sc_mcu7t5v0__fillcap_16
Xfanout566 fanout569/Z fanout566/Z VDD VDD VSS VSS gf180mcu_fd_sc_mcu7t5v0__dlyb_1
Xfanout555 fanout557/Z _17_/B VDD VDD VSS VSS gf180mcu_fd_sc_mcu7t5v0__dlyb_1
Xfanout544 fanout546/Z fanout544/Z VDD VDD VSS VSS gf180mcu_fd_sc_mcu7t5v0__dlyb_1
XFILLER_101_886 VDD VDD VSS VSS gf180mcu_fd_sc_mcu7t5v0__fillcap_8
XFILLER_150_1157 VDD VDD VSS VSS gf180mcu_fd_sc_mcu7t5v0__fillcap_16
Xwave_controller_x_inst__1998_ wave_controller_x_inst__3391_/A1 spi_regs_inst__1250_/B2
+ wave_controller_x_inst__2001_/B VDD VDD VSS VSS gf180mcu_fd_sc_mcu7t5v0__xor2_1
Xfanout588 fanout589/Z fanout588/Z VDD VDD VSS VSS gf180mcu_fd_sc_mcu7t5v0__dlyb_1
XFILLER_58_288 VDD VDD VSS VSS gf180mcu_fd_sc_mcu7t5v0__fillcap_16
XTAP_TAPCELL_ROW_146_2282 VDD VSS gf180mcu_fd_sc_mcu7t5v0__filltie
XTAP_TAPCELL_ROW_146_2293 VDD VSS gf180mcu_fd_sc_mcu7t5v0__filltie
Xwave_controller_x_inst__3737_ wave_controller_x_inst__3737_/D fanout601/Z clkload26/I
+ wave_controller_x_inst__3737_/Q VDD VDD VSS VSS gf180mcu_fd_sc_mcu7t5v0__dffrnq_1
XFILLER_92_26 VDD VDD VSS VSS gf180mcu_fd_sc_mcu7t5v0__fillcap_4
Xwave_controller_y_inst__2704_ max_cap430/Z wave_controller_y_inst__2702_/Z wave_controller_y_inst__2704_/Z
+ VDD VDD VSS VSS gf180mcu_fd_sc_mcu7t5v0__xor2_1
Xwave_controller_y_inst__3684_ wave_controller_y_inst__3684_/D wave_controller_y_inst__3716_/RN
+ clkload14/I spi_regs_inst__1318_/C2 VDD VDD VSS VSS gf180mcu_fd_sc_mcu7t5v0__dffrnq_1
Xwave_controller_x_inst__3668_ wave_controller_x_inst__3668_/D fanout591/Z clkload22/I
+ spi_regs_inst__1185_/B2 VDD VDD VSS VSS gf180mcu_fd_sc_mcu7t5v0__dffrnq_1
XFILLER_26_141 VDD VDD VSS VSS gf180mcu_fd_sc_mcu7t5v0__fillcap_32
Xwave_controller_y_inst__2635_ wave_controller_y_inst__2646_/A1 wave_controller_y_inst__2646_/A2
+ wave_controller_y_inst__2713_/A1 VDD VDD VSS VSS gf180mcu_fd_sc_mcu7t5v0__nor2_1
Xwave_controller_x_inst__2619_ wire454/Z wave_controller_x_inst__3530_/B2 wave_controller_x_inst__2584_/I
+ wave_controller_x_inst__2617_/Z wave_controller_x_inst__2619_/C wave_controller_x_inst__2620_/B
+ VDD VDD VSS VSS gf180mcu_fd_sc_mcu7t5v0__aoi221_1
XFILLER_14_314 VDD VDD VSS VSS gf180mcu_fd_sc_mcu7t5v0__fill_1
XFILLER_14_325 VDD VDD VSS VSS gf180mcu_fd_sc_mcu7t5v0__fillcap_4
Xwave_controller_y_inst__2566_ wave_controller_y_inst__2815_/A1 spi_regs_inst__1099_/B2
+ wave_controller_y_inst__2566_/Z VDD VDD VSS VSS gf180mcu_fd_sc_mcu7t5v0__xor2_1
Xwave_controller_x_inst__3599_ wave_controller_x_inst__3602_/S wave_controller_x_inst__3599_/A2
+ wave_controller_x_inst__3599_/B wave_controller_x_inst__3674_/D VDD VDD VSS VSS
+ gf180mcu_fd_sc_mcu7t5v0__oai21_1
XFILLER_148_2 VDD VDD VSS VSS gf180mcu_fd_sc_mcu7t5v0__fillcap_16
XFILLER_159_319 VDD VDD VSS VSS gf180mcu_fd_sc_mcu7t5v0__fill_2
XFILLER_41_155 VDD VDD VSS VSS gf180mcu_fd_sc_mcu7t5v0__fillcap_4
Xwave_controller_y_inst__2497_ wave_controller_y_inst__2497_/A1 wave_controller_y_inst__2497_/A2
+ wave_controller_y_inst__2497_/B wave_controller_y_inst__2509_/A3 VDD VDD VSS VSS
+ gf180mcu_fd_sc_mcu7t5v0__aoi21_1
XFILLER_10_553 VDD VDD VSS VSS gf180mcu_fd_sc_mcu7t5v0__fill_2
XFILLER_127_205 VDD VDD VSS VSS gf180mcu_fd_sc_mcu7t5v0__fillcap_4
XFILLER_6_502 VDD VDD VSS VSS gf180mcu_fd_sc_mcu7t5v0__fillcap_8
XFILLER_155_536 VDD VDD VSS VSS gf180mcu_fd_sc_mcu7t5v0__fill_1
XFILLER_155_558 VDD VDD VSS VSS gf180mcu_fd_sc_mcu7t5v0__fill_2
XTAP_TAPCELL_ROW_52_1_723 VDD VSS gf180mcu_fd_sc_mcu7t5v0__filltie
XFILLER_108_441 VDD VDD VSS VSS gf180mcu_fd_sc_mcu7t5v0__fill_1
XFILLER_108_452 VDD VDD VSS VSS gf180mcu_fd_sc_mcu7t5v0__fill_2
Xwave_controller_y_inst__3118_ wave_controller_y_inst__3570_/A1 spi_regs_inst__1589_/Q
+ wave_controller_y_inst__3149_/B1 VDD VDD VSS VSS gf180mcu_fd_sc_mcu7t5v0__nor2_1
XFILLER_124_934 VDD VDD VSS VSS gf180mcu_fd_sc_mcu7t5v0__fillcap_8
XFILLER_151_764 VDD VDD VSS VSS gf180mcu_fd_sc_mcu7t5v0__fillcap_4
XFILLER_155_1046 VDD VDD VSS VSS gf180mcu_fd_sc_mcu7t5v0__fillcap_4
XFILLER_68_1087 VDD VDD VSS VSS gf180mcu_fd_sc_mcu7t5v0__fillcap_64
Xwave_controller_y_inst__3049_ wave_controller_y_inst__3705_/Q wave_controller_y_inst__1829_/I
+ wave_controller_y_inst__3599_/A2 VDD VDD VSS VSS gf180mcu_fd_sc_mcu7t5v0__nand2_1
XFILLER_150_241 VDD VDD VSS VSS gf180mcu_fd_sc_mcu7t5v0__fillcap_4
XTAP_TAPCELL_ROW_166_2614 VDD VSS gf180mcu_fd_sc_mcu7t5v0__filltie
XFILLER_110_127 VDD VDD VSS VSS gf180mcu_fd_sc_mcu7t5v0__fill_2
XFILLER_96_339 VDD VDD VSS VSS gf180mcu_fd_sc_mcu7t5v0__fillcap_16
XTAP_TAPCELL_ROW_8_1_392 VDD VSS gf180mcu_fd_sc_mcu7t5v0__filltie
Xspi_regs_inst__0942_ spi_regs_inst__1374_/A1 spi_regs_inst__1372_/A1 spi_regs_inst__1376_/A1
+ spi_regs_inst__0942_/ZN VDD VDD VSS VSS gf180mcu_fd_sc_mcu7t5v0__nand3_1
XFILLER_49_299 VDD VDD VSS VSS gf180mcu_fd_sc_mcu7t5v0__fill_2
XTAP_TAPCELL_ROW_69_1015 VDD VSS gf180mcu_fd_sc_mcu7t5v0__filltie
XFILLER_64_247 VDD VDD VSS VSS gf180mcu_fd_sc_mcu7t5v0__fillcap_16
Xspi_regs_inst__0873_ spi_regs_inst__1608_/Q spi_regs_inst__1406_/I1 spi_regs_inst__0875_/S
+ spi_regs_inst__1608_/D VDD VDD VSS VSS gf180mcu_fd_sc_mcu7t5v0__mux2_2
XFILLER_45_450 VDD VDD VSS VSS gf180mcu_fd_sc_mcu7t5v0__fillcap_8
XFILLER_80_718 VDD VDD VSS VSS gf180mcu_fd_sc_mcu7t5v0__fill_1
XFILLER_92_578 VDD VDD VSS VSS gf180mcu_fd_sc_mcu7t5v0__fill_2
XTAP_TAPCELL_ROW_63_916 VDD VSS gf180mcu_fd_sc_mcu7t5v0__filltie
XTAP_TAPCELL_ROW_82_1226 VDD VSS gf180mcu_fd_sc_mcu7t5v0__filltie
XTAP_TAPCELL_ROW_82_1237 VDD VSS gf180mcu_fd_sc_mcu7t5v0__filltie
XFILLER_162_1017 VDD VDD VSS VSS gf180mcu_fd_sc_mcu7t5v0__fillcap_64
XFILLER_60_453 VDD VDD VSS VSS gf180mcu_fd_sc_mcu7t5v0__fill_2
XFILLER_159_842 VDD VDD VSS VSS gf180mcu_fd_sc_mcu7t5v0__fillcap_64
XFILLER_32_177 VDD VDD VSS VSS gf180mcu_fd_sc_mcu7t5v0__fill_1
Xspi_regs_inst__1425_ spi_regs_inst_wire487/Z spi_regs_inst__1496_/Q spi_regs_inst__1427_/S
+ spi_regs_inst__1496_/D VDD VDD VSS VSS gf180mcu_fd_sc_mcu7t5v0__mux2_2
XPHY_EDGE_ROW_4_1_Right_3 VDD VSS gf180mcu_fd_sc_mcu7t5v0__endcap
XTAP_TAPCELL_ROW_38_1_613 VDD VSS gf180mcu_fd_sc_mcu7t5v0__filltie
Xspi_regs_inst__1356_ spi_regs_inst__1556_/Q spi_regs_inst__1356_/A2 spi_regs_inst_wire242/Z
+ spi_regs_inst__1514_/Q spi_regs_inst__1358_/A3 VDD VDD VSS VSS gf180mcu_fd_sc_mcu7t5v0__aoi22_1
XFILLER_103_1170 VDD VDD VSS VSS gf180mcu_fd_sc_mcu7t5v0__fillcap_4
XFILLER_127_750 VDD VDD VSS VSS gf180mcu_fd_sc_mcu7t5v0__fill_1
XFILLER_63_2 VDD VDD VSS VSS gf180mcu_fd_sc_mcu7t5v0__fillcap_4
Xspi_regs_inst__1287_ spi_regs_inst__1287_/A1 spi_regs_inst__1287_/A2 spi_regs_inst__1287_/A3
+ spi_regs_inst__1287_/A4 spi_regs_inst__1295_/A2 VDD VDD VSS VSS gf180mcu_fd_sc_mcu7t5v0__nand4_1
XFILLER_115_912 VDD VDD VSS VSS gf180mcu_fd_sc_mcu7t5v0__fillcap_64
XFILLER_126_271 VDD VDD VSS VSS gf180mcu_fd_sc_mcu7t5v0__fillcap_4
XFILLER_161_539 VDD VDD VSS VSS gf180mcu_fd_sc_mcu7t5v0__fill_1
XTAP_TAPCELL_ROW_97_1480 VDD VSS gf180mcu_fd_sc_mcu7t5v0__filltie
XFILLER_88_807 VDD VDD VSS VSS gf180mcu_fd_sc_mcu7t5v0__fillcap_16
Xwave_controller_x_inst__2970_ wave_controller_x_inst__2956_/I wave_controller_x_inst__2957_/Z
+ wave_controller_x_inst__3050_/B wave_controller_x_inst__3051_/A2 VDD VDD VSS VSS
+ gf180mcu_fd_sc_mcu7t5v0__nand3_1
Xwave_controller_x_inst__1921_ wave_controller_x_inst__3290_/A1 spi_regs_inst__1503_/Q
+ spi_regs_inst__1502_/Q wave_controller_x_inst__3564_/A1 wave_controller_x_inst__1923_/A2
+ VDD VDD VSS VSS gf180mcu_fd_sc_mcu7t5v0__aoi22_1
XFILLER_87_339 VDD VDD VSS VSS gf180mcu_fd_sc_mcu7t5v0__fill_2
Xsignal_processor_y_inst__237_ signal_processor_y_inst__237_/D fanout556/Z clkload2/I
+ signal_processor_y_inst__237_/Q VDD VDD VSS VSS gf180mcu_fd_sc_mcu7t5v0__dffrnq_1
XFILLER_110_650 VDD VDD VSS VSS gf180mcu_fd_sc_mcu7t5v0__fillcap_8
XTAP_TAPCELL_ROW_20_1_483 VDD VSS gf180mcu_fd_sc_mcu7t5v0__filltie
Xwave_controller_x_inst__1852_ spi_regs_inst__1064_/A1 wave_controller_x_inst__2757_/A1
+ VDD VDD VSS VSS gf180mcu_fd_sc_mcu7t5v0__clkinv_1
XFILLER_28_439 VDD VDD VSS VSS gf180mcu_fd_sc_mcu7t5v0__fillcap_8
XFILLER_55_203 VDD VDD VSS VSS gf180mcu_fd_sc_mcu7t5v0__fillcap_4
XFILLER_56_737 VDD VDD VSS VSS gf180mcu_fd_sc_mcu7t5v0__fillcap_16
XFILLER_68_597 VDD VDD VSS VSS gf180mcu_fd_sc_mcu7t5v0__fillcap_4
XFILLER_83_512 VDD VDD VSS VSS gf180mcu_fd_sc_mcu7t5v0__fill_2
Xwave_controller_x_inst__1783_ wave_controller_x_inst__1783_/I wave_controller_x_inst__3320_/A1
+ VDD VDD VSS VSS gf180mcu_fd_sc_mcu7t5v0__inv_1
Xsignal_processor_y_inst__168_ signal_processor_y_inst__187_/A1 signal_processor_y_inst__209_/A2
+ signal_processor_y_inst__233_/D VDD VDD VSS VSS gf180mcu_fd_sc_mcu7t5v0__nor2_1
XFILLER_56_759 VDD VDD VSS VSS gf180mcu_fd_sc_mcu7t5v0__fill_1
XFILLER_83_556 VDD VDD VSS VSS gf180mcu_fd_sc_mcu7t5v0__fillcap_4
XFILLER_83_567 VDD VDD VSS VSS gf180mcu_fd_sc_mcu7t5v0__fillcap_4
Xwave_controller_x_inst__3522_ wave_controller_x_inst__3710_/Q wave_controller_x_inst__3493_/Z
+ wave_controller_x_inst__3524_/A2 VDD VDD VSS VSS gf180mcu_fd_sc_mcu7t5v0__nor2_1
XFILLER_71_718 VDD VDD VSS VSS gf180mcu_fd_sc_mcu7t5v0__fillcap_4
Xwave_controller_y_inst__2420_ wave_controller_y_inst__2418_/Z wave_controller_y_inst__2434_/A2
+ wave_controller_y_inst__2435_/A1 VDD VDD VSS VSS gf180mcu_fd_sc_mcu7t5v0__nand2_1
Xwave_controller_x_inst__3453_ spi_regs_inst__1239_/A1 wave_controller_x_inst__3454_/A2
+ wave_controller_x_inst__3454_/C VDD VDD VSS VSS gf180mcu_fd_sc_mcu7t5v0__nor2_1
XFILLER_62_29 VDD VDD VSS VSS gf180mcu_fd_sc_mcu7t5v0__fillcap_4
Xwave_controller_x_inst__3384_ fanout526/Z wave_controller_x_inst__3384_/A2 wave_controller_x_inst__3371_/Z
+ wave_controller_x_inst__3369_/Z fanout524/Z wave_controller_x_inst__3385_/A2 VDD
+ VDD VSS VSS gf180mcu_fd_sc_mcu7t5v0__oai32_1
Xwave_controller_x_inst__2404_ spi_regs_inst__1060_/A1 wave_controller_x_inst__2403_/Z
+ wave_controller_x_inst__2419_/B VDD VDD VSS VSS gf180mcu_fd_sc_mcu7t5v0__nand2_1
XFILLER_11_306 VDD VDD VSS VSS gf180mcu_fd_sc_mcu7t5v0__fill_1
XFILLER_23_177 VDD VDD VSS VSS gf180mcu_fd_sc_mcu7t5v0__fillcap_4
Xwave_controller_y_inst__2351_ spi_regs_inst__1318_/C2 wave_controller_y_inst__2822_/A1
+ wave_controller_y_inst__2364_/B VDD VDD VSS VSS gf180mcu_fd_sc_mcu7t5v0__nand2_1
Xwave_controller_x_inst__2335_ fanout539/Z wave_controller_x_inst__2334_/Z wave_controller_x_inst__2358_/A1
+ VDD VDD VSS VSS gf180mcu_fd_sc_mcu7t5v0__nor2_1
XFILLER_108_1081 VDD VDD VSS VSS gf180mcu_fd_sc_mcu7t5v0__fillcap_4
XFILLER_149_352 VDD VDD VSS VSS gf180mcu_fd_sc_mcu7t5v0__fillcap_32
Xwave_controller_y_inst__2282_ wave_controller_y_inst__2346_/A1 wave_controller_y_inst__2280_/Z
+ spi_regs_inst__1068_/A1 VDD VDD VSS VSS gf180mcu_fd_sc_mcu7t5v0__xor2_1
Xwave_controller_x_inst__2266_ wave_controller_x_inst__2266_/A1 wave_controller_x_inst__2265_/B
+ wave_controller_x_inst__2267_/B VDD VDD VSS VSS gf180mcu_fd_sc_mcu7t5v0__xnor2_1
Xwave_controller_x_inst__2197_ fanout530/Z wave_controller_x_inst__2192_/Z wave_controller_x_inst__2204_/A2
+ wave_controller_x_inst__2197_/Z VDD VDD VSS VSS gf180mcu_fd_sc_mcu7t5v0__xor3_1
XFILLER_105_400 VDD VDD VSS VSS gf180mcu_fd_sc_mcu7t5v0__fillcap_8
XFILLER_11_66 VDD VDD VSS VSS gf180mcu_fd_sc_mcu7t5v0__fillcap_4
XFILLER_127_22 VDD VDD VSS VSS gf180mcu_fd_sc_mcu7t5v0__fill_1
XFILLER_105_422 VDD VDD VSS VSS gf180mcu_fd_sc_mcu7t5v0__fillcap_16
XFILLER_117_282 VDD VDD VSS VSS gf180mcu_fd_sc_mcu7t5v0__fill_2
XFILLER_3_538 VDD VDD VSS VSS gf180mcu_fd_sc_mcu7t5v0__fillcap_16
XTAP_TAPCELL_ROW_111_1709 VDD VSS gf180mcu_fd_sc_mcu7t5v0__filltie
Xwave_controller_y_inst_fanout413 wave_controller_y_inst__3721_/Q wave_controller_y_inst__2124_/B
+ VDD VDD VSS VSS gf180mcu_fd_sc_mcu7t5v0__dlyb_1
XFILLER_127_88 VDD VDD VSS VSS gf180mcu_fd_sc_mcu7t5v0__fillcap_4
XFILLER_132_263 VDD VDD VSS VSS gf180mcu_fd_sc_mcu7t5v0__fill_2
XFILLER_78_317 VDD VDD VSS VSS gf180mcu_fd_sc_mcu7t5v0__fillcap_8
XFILLER_79_829 VDD VDD VSS VSS gf180mcu_fd_sc_mcu7t5v0__fill_2
XTAP_TAPCELL_ROW_148_2311 VDD VSS gf180mcu_fd_sc_mcu7t5v0__filltie
XFILLER_132_296 VDD VDD VSS VSS gf180mcu_fd_sc_mcu7t5v0__fillcap_4
XFILLER_160_594 VDD VDD VSS VSS gf180mcu_fd_sc_mcu7t5v0__fill_1
XTAP_TAPCELL_ROW_148_2322 VDD VSS gf180mcu_fd_sc_mcu7t5v0__filltie
XFILLER_115_1052 VDD VDD VSS VSS gf180mcu_fd_sc_mcu7t5v0__fillcap_64
XFILLER_120_469 VDD VDD VSS VSS gf180mcu_fd_sc_mcu7t5v0__fillcap_8
XFILLER_74_512 VDD VDD VSS VSS gf180mcu_fd_sc_mcu7t5v0__fillcap_8
XFILLER_86_372 VDD VDD VSS VSS gf180mcu_fd_sc_mcu7t5v0__fill_1
Xwave_controller_y_inst__1997_ fanout517/I wave_controller_y_inst__2349_/C wave_controller_y_inst__2009_/A1
+ VDD VDD VSS VSS gf180mcu_fd_sc_mcu7t5v0__nor2_1
XFILLER_46_247 VDD VDD VSS VSS gf180mcu_fd_sc_mcu7t5v0__fillcap_8
XTAP_TAPCELL_ROW_161_2533 VDD VSS gf180mcu_fd_sc_mcu7t5v0__filltie
Xwave_controller_y_inst__3736_ wave_controller_y_inst__3736_/D fanout547/Z clkload5/I
+ wave_controller_y_inst__3736_/Q VDD VDD VSS VSS gf180mcu_fd_sc_mcu7t5v0__dffrnq_1
XTAP_TAPCELL_ROW_126_1952 VDD VSS gf180mcu_fd_sc_mcu7t5v0__filltie
XTAP_TAPCELL_ROW_126_1963 VDD VSS gf180mcu_fd_sc_mcu7t5v0__filltie
Xspi_regs_inst_max_cap212 spi_regs_inst__1306_/B1 spi_regs_inst__1345_/B1 VDD VDD
+ VSS VSS gf180mcu_fd_sc_mcu7t5v0__buf_2
XFILLER_27_483 VDD VDD VSS VSS gf180mcu_fd_sc_mcu7t5v0__fillcap_4
XFILLER_36_85 VDD VDD VSS VSS gf180mcu_fd_sc_mcu7t5v0__fill_1
XFILLER_61_228 VDD VDD VSS VSS gf180mcu_fd_sc_mcu7t5v0__fillcap_8
Xwave_controller_y_inst__3667_ wave_controller_y_inst__3667_/D fanout564/Z clkload9/I
+ spi_regs_inst__1150_/A1 VDD VDD VSS VSS gf180mcu_fd_sc_mcu7t5v0__dffrnq_1
Xspi_regs_inst_max_cap245 spi_regs_inst__1240_/A2 spi_regs_inst__1352_/A2 VDD VDD
+ VSS VSS gf180mcu_fd_sc_mcu7t5v0__buf_2
Xspi_regs_inst_max_cap234 spi_regs_inst__1232_/B1 spi_regs_inst__1278_/A2 VDD VDD
+ VSS VSS gf180mcu_fd_sc_mcu7t5v0__buf_2
Xspi_regs_inst_max_cap223 spi_regs_inst__1346_/B1 spi_regs_inst__1241_/B1 VDD VDD
+ VSS VSS gf180mcu_fd_sc_mcu7t5v0__buf_2
Xwave_controller_y_inst__2618_ wave_controller_y_inst__2580_/Z wave_controller_y_inst__2595_/Z
+ wave_controller_y_inst__2620_/A3 VDD VDD VSS VSS gf180mcu_fd_sc_mcu7t5v0__nand2_1
Xwave_controller_y_inst__3598_ spi_regs_inst__1226_/A1 wave_controller_y_inst__3597_/S
+ wave_controller_y_inst__3599_/B VDD VDD VSS VSS gf180mcu_fd_sc_mcu7t5v0__nand2_1
Xspi_regs_inst_max_cap289 spi_regs_inst_wire288/I spi_regs_inst__1333_/A2 VDD VDD
+ VSS VSS gf180mcu_fd_sc_mcu7t5v0__buf_2
Xspi_regs_inst_max_cap278 spi_regs_inst_wire277/I spi_regs_inst__1195_/B1 VDD VDD
+ VSS VSS gf180mcu_fd_sc_mcu7t5v0__buf_2
Xspi_regs_inst_max_cap267 spi_regs_inst__1176_/A2 spi_regs_inst__1340_/A2 VDD VDD
+ VSS VSS gf180mcu_fd_sc_mcu7t5v0__buf_4
Xspi_regs_inst_max_cap256 spi_regs_inst__1200_/A2 spi_regs_inst__1353_/B1 VDD VDD
+ VSS VSS gf180mcu_fd_sc_mcu7t5v0__buf_2
Xwave_controller_y_inst__2549_ wave_controller_y_inst__2786_/A1 spi_regs_inst__1045_/B2
+ wave_controller_y_inst__2567_/B VDD VDD VSS VSS gf180mcu_fd_sc_mcu7t5v0__nor2_1
XTAP_TAPCELL_ROW_159_2495 VDD VSS gf180mcu_fd_sc_mcu7t5v0__filltie
XFILLER_128_514 VDD VDD VSS VSS gf180mcu_fd_sc_mcu7t5v0__fillcap_8
Xspi_regs_inst__1210_ spi_regs_inst__1210_/A1 spi_regs_inst__1210_/A2 spi_regs_inst__1220_/A2
+ VDD VDD VSS VSS gf180mcu_fd_sc_mcu7t5v0__nand2_1
Xsignal_processor_x_inst__188_ fanout397/Z signal_processor_x_inst__239_/Q signal_processor_x_inst__240_/Q
+ signal_processor_x_inst__129_/Z signal_processor_x_inst__189_/B1 VDD VDD VSS VSS
+ gf180mcu_fd_sc_mcu7t5v0__nand4_1
XFILLER_109_761 VDD VDD VSS VSS gf180mcu_fd_sc_mcu7t5v0__fill_1
XFILLER_6_321 VDD VDD VSS VSS gf180mcu_fd_sc_mcu7t5v0__fill_2
Xspi_regs_inst__1141_ fanout517/Z spi_regs_inst__1341_/A2 spi_regs_inst__1141_/B1
+ spi_regs_inst__1141_/B2 spi_regs_inst__1142_/A4 VDD VDD VSS VSS gf180mcu_fd_sc_mcu7t5v0__aoi22_1
XFILLER_109_772 VDD VDD VSS VSS gf180mcu_fd_sc_mcu7t5v0__fillcap_4
XFILLER_143_528 VDD VDD VSS VSS gf180mcu_fd_sc_mcu7t5v0__fillcap_8
XFILLER_155_377 VDD VDD VSS VSS gf180mcu_fd_sc_mcu7t5v0__fill_1
XFILLER_6_387 VDD VDD VSS VSS gf180mcu_fd_sc_mcu7t5v0__fill_1
XFILLER_124_753 VDD VDD VSS VSS gf180mcu_fd_sc_mcu7t5v0__fillcap_4
Xspi_regs_inst__1072_ spi_regs_inst__1072_/A1 spi_regs_inst__1072_/A2 spi_regs_inst__1072_/A3
+ spi_regs_inst__1071_/Z spi_regs_inst__1076_/A2 VDD VDD VSS VSS gf180mcu_fd_sc_mcu7t5v0__nor4_1
XFILLER_124_764 VDD VDD VSS VSS gf180mcu_fd_sc_mcu7t5v0__fillcap_8
XFILLER_35_6 VDD VDD VSS VSS gf180mcu_fd_sc_mcu7t5v0__fill_2
XFILLER_37_203 VDD VDD VSS VSS gf180mcu_fd_sc_mcu7t5v0__fill_1
XFILLER_78_884 VDD VDD VSS VSS gf180mcu_fd_sc_mcu7t5v0__fillcap_8
XTAP_TAPCELL_ROW_49_1_696 VDD VSS gf180mcu_fd_sc_mcu7t5v0__filltie
XFILLER_65_556 VDD VDD VSS VSS gf180mcu_fd_sc_mcu7t5v0__fillcap_4
XFILLER_92_331 VDD VDD VSS VSS gf180mcu_fd_sc_mcu7t5v0__fillcap_4
Xspi_regs_inst__0925_ spi_regs_inst__1623_/Q spi_regs_inst__1633_/Q spi_regs_inst__1632_/Q
+ spi_regs_inst__0925_/A4 spi_regs_inst__0926_/C VDD VDD VSS VSS gf180mcu_fd_sc_mcu7t5v0__nand4_1
Xspi_regs_inst__0856_ spi_regs_inst__1593_/Q spi_regs_inst__0883_/I1 spi_regs_inst__0857_/S
+ spi_regs_inst__1593_/D VDD VDD VSS VSS gf180mcu_fd_sc_mcu7t5v0__mux2_2
XFILLER_80_559 VDD VDD VSS VSS gf180mcu_fd_sc_mcu7t5v0__fillcap_8
XFILLER_92_397 VDD VDD VSS VSS gf180mcu_fd_sc_mcu7t5v0__fill_2
Xwave_controller_y_inst_load_slew568 wave_controller_y_inst__3689_/RN wave_controller_y_inst__3716_/RN
+ VDD VDD VSS VSS gf180mcu_fd_sc_mcu7t5v0__buf_4
Xwave_controller_y_inst_load_slew579 fanout578/Z wave_controller_y_inst__3703_/RN
+ VDD VDD VSS VSS gf180mcu_fd_sc_mcu7t5v0__buf_4
Xspi_regs_inst__0787_ spi_regs_inst__1451_/I1 spi_regs_inst__1540_/Q spi_regs_inst__0787_/S
+ spi_regs_inst__1540_/D VDD VDD VSS VSS gf180mcu_fd_sc_mcu7t5v0__mux2_2
Xwave_controller_x_inst__2120_ wave_controller_x_inst__3729_/Q wave_controller_x_inst__2153_/A2
+ wave_controller_x_inst__2118_/Z wave_controller_x_inst__2123_/B VDD VDD VSS VSS
+ gf180mcu_fd_sc_mcu7t5v0__nand3_1
XFILLER_158_171 VDD VDD VSS VSS gf180mcu_fd_sc_mcu7t5v0__fillcap_4
XFILLER_20_169 VDD VDD VSS VSS gf180mcu_fd_sc_mcu7t5v0__fill_1
Xspi_regs_inst__1408_ fanout516/Z spi_regs_inst__1408_/I1 spi_regs_inst__1412_/S spi_regs_inst__1481_/D
+ VDD VDD VSS VSS gf180mcu_fd_sc_mcu7t5v0__mux2_2
XFILLER_146_333 VDD VDD VSS VSS gf180mcu_fd_sc_mcu7t5v0__fillcap_4
Xwave_controller_x_inst__2051_ wave_controller_x_inst__3719_/Q wave_controller_x_inst__2052_/A2
+ wave_controller_x_inst__2051_/Z VDD VDD VSS VSS gf180mcu_fd_sc_mcu7t5v0__xor2_1
XFILLER_134_539 VDD VDD VSS VSS gf180mcu_fd_sc_mcu7t5v0__fill_1
Xspi_regs_inst__1339_ spi_regs_inst__1569_/Q spi_regs_inst__1339_/A2 spi_regs_inst__1339_/B1
+ spi_regs_inst_wire81/Z spi_regs_inst__1355_/A1 VDD VDD VSS VSS gf180mcu_fd_sc_mcu7t5v0__aoi22_1
XTAP_TAPCELL_ROW_95_1439 VDD VSS gf180mcu_fd_sc_mcu7t5v0__filltie
XFILLER_102_403 VDD VDD VSS VSS gf180mcu_fd_sc_mcu7t5v0__fillcap_32
XFILLER_130_712 VDD VDD VSS VSS gf180mcu_fd_sc_mcu7t5v0__fillcap_4
XFILLER_130_734 VDD VDD VSS VSS gf180mcu_fd_sc_mcu7t5v0__fill_1
Xwave_controller_x_inst__2953_ wave_controller_x_inst__3706_/Q wave_controller_x_inst__3236_/B
+ wave_controller_x_inst__2972_/B VDD VDD VSS VSS gf180mcu_fd_sc_mcu7t5v0__nand2_1
Xwave_controller_y_inst__1920_ spi_regs_inst__1565_/Q wave_controller_y_inst__3564_/A1
+ wave_controller_y_inst__1920_/B wave_controller_y_inst__1923_/A1 VDD VDD VSS VSS
+ gf180mcu_fd_sc_mcu7t5v0__oai21_1
Xwave_controller_x_inst__2884_ wave_controller_x_inst__2864_/Z wave_controller_x_inst__2884_/A2
+ wave_controller_x_inst__2884_/B wave_controller_x_inst__2885_/A3 VDD VDD VSS VSS
+ gf180mcu_fd_sc_mcu7t5v0__oai21_1
Xwave_controller_x_inst__1904_ spi_regs_inst__1094_/A1 wave_controller_x_inst__3433_/A1
+ VDD VDD VSS VSS gf180mcu_fd_sc_mcu7t5v0__clkinv_1
XFILLER_60_1157 VDD VDD VSS VSS gf180mcu_fd_sc_mcu7t5v0__fillcap_16
Xwave_controller_y_inst__1851_ spi_regs_inst__1101_/A1 wave_controller_y_inst__2451_/A1
+ VDD VDD VSS VSS gf180mcu_fd_sc_mcu7t5v0__clkinv_1
Xwave_controller_x_inst__1835_ wave_controller_x_inst__3739_/Q wave_controller_x_inst__2935_/A2
+ VDD VDD VSS VSS gf180mcu_fd_sc_mcu7t5v0__clkinv_1
XTAP_TAPCELL_ROW_143_2230 VDD VSS gf180mcu_fd_sc_mcu7t5v0__filltie
XTAP_TAPCELL_ROW_143_2241 VDD VSS gf180mcu_fd_sc_mcu7t5v0__filltie
XTAP_TAPCELL_ROW_51_1_711 VDD VSS gf180mcu_fd_sc_mcu7t5v0__filltie
Xwave_controller_y_inst__1782_ spi_regs_inst__1576_/Q wave_controller_y_inst__1937_/A1
+ VDD VDD VSS VSS gf180mcu_fd_sc_mcu7t5v0__clkinv_1
XFILLER_16_409 VDD VDD VSS VSS gf180mcu_fd_sc_mcu7t5v0__fillcap_4
XTAP_TAPCELL_ROW_108_1660 VDD VSS gf180mcu_fd_sc_mcu7t5v0__filltie
Xwave_controller_y_inst__3521_ wave_controller_y_inst_wire144/Z wave_controller_y_inst__3521_/A2
+ wave_controller_y_inst__3521_/A3 wave_controller_y_inst__3521_/B1 wave_controller_y_inst__3521_/B2
+ wave_controller_y_inst__3636_/D VDD VDD VSS VSS gf180mcu_fd_sc_mcu7t5v0__oai32_1
Xwave_controller_x_inst_max_cap326 wave_controller_x_inst__2892_/Z wave_controller_x_inst__3483_/A2
+ VDD VDD VSS VSS gf180mcu_fd_sc_mcu7t5v0__clkbuf_2
Xwave_controller_x_inst__3505_ spi_regs_inst__1212_/B2 wave_controller_x_inst__3538_/A2
+ wave_controller_x_inst__3506_/A3 VDD VDD VSS VSS gf180mcu_fd_sc_mcu7t5v0__nor2_1
XFILLER_149_1170 VDD VDD VSS VSS gf180mcu_fd_sc_mcu7t5v0__fillcap_4
XFILLER_24_442 VDD VDD VSS VSS gf180mcu_fd_sc_mcu7t5v0__fillcap_4
XPHY_EDGE_ROW_159_Left_326 VDD VSS gf180mcu_fd_sc_mcu7t5v0__endcap
XTAP_TAPCELL_ROW_54_768 VDD VSS gf180mcu_fd_sc_mcu7t5v0__filltie
Xwave_controller_y_inst__3452_ wave_controller_y_inst__3452_/A1 wave_controller_y_inst__3557_/B1
+ wave_controller_y_inst__3452_/B1 wave_controller_y_inst__3452_/B2 wave_controller_y_inst__3623_/D
+ VDD VDD VSS VSS gf180mcu_fd_sc_mcu7t5v0__oai22_1
Xwave_controller_x_inst__3436_ wave_controller_x_inst__3454_/B wave_controller_x_inst__3436_/A2
+ wave_controller_x_inst__3436_/A3 wave_controller_x_inst__3465_/B wave_controller_x_inst__3441_/C
+ VDD VDD VSS VSS gf180mcu_fd_sc_mcu7t5v0__oai31_1
XFILLER_11_114 VDD VDD VSS VSS gf180mcu_fd_sc_mcu7t5v0__fill_1
XTAP_TAPCELL_ROW_121_1871 VDD VSS gf180mcu_fd_sc_mcu7t5v0__filltie
Xwave_controller_y_inst__2403_ wave_controller_y_inst__1816_/I wave_controller_y_inst__2403_/A2
+ wave_controller_y_inst__2403_/A3 wave_controller_y_inst__2403_/Z VDD VDD VSS VSS
+ gf180mcu_fd_sc_mcu7t5v0__xor3_1
Xwave_controller_y_inst__3383_ fanout505/Z wave_controller_y_inst__3372_/Z wave_controller_y_inst__3383_/B1
+ wave_controller_y_inst__3383_/B2 wave_controller_y_inst__3383_/C wave_controller_y_inst__3385_/A1
+ VDD VDD VSS VSS gf180mcu_fd_sc_mcu7t5v0__aoi221_1
Xsignal_processor_x_inst__111_ signal_processor_x_inst__240_/Q signal_processor_x_inst__183_/A1
+ VDD VDD VSS VSS gf180mcu_fd_sc_mcu7t5v0__clkinv_1
Xwave_controller_y_inst__2334_ wave_controller_y_inst__2332_/Z wave_controller_y_inst__2336_/A3
+ wave_controller_y_inst__2334_/Z VDD VDD VSS VSS gf180mcu_fd_sc_mcu7t5v0__xor2_1
Xwave_controller_x_inst__3367_ wave_controller_x_inst__3271_/Z wave_controller_x_inst__3367_/A2
+ wave_controller_x_inst__3386_/A2 VDD VDD VSS VSS gf180mcu_fd_sc_mcu7t5v0__xnor2_1
Xwave_controller_x_inst__3298_ wave_controller_x_inst__3305_/B2 spi_regs_inst__1549_/Q
+ wave_controller_x_inst__3299_/I VDD VDD VSS VSS gf180mcu_fd_sc_mcu7t5v0__xor2_1
Xwave_controller_x_inst__2318_ wave_controller_x_inst__2318_/A1 wire454/Z max_cap455/Z
+ wave_controller_x_inst__2319_/B1 VDD VDD VSS VSS gf180mcu_fd_sc_mcu7t5v0__aoi21_1
XPHY_EDGE_ROW_129_Right_129 VDD VSS gf180mcu_fd_sc_mcu7t5v0__endcap
Xwave_controller_y_inst__2265_ wave_controller_y_inst__2265_/A1 wave_controller_y_inst__2265_/A2
+ wave_controller_y_inst__2265_/B wave_controller_y_inst__2270_/A1 VDD VDD VSS VSS
+ gf180mcu_fd_sc_mcu7t5v0__oai21_1
Xwave_controller_x_inst__2249_ wave_controller_x_inst__2250_/A1 wave_controller_x_inst__2250_/B
+ wave_controller_x_inst__2250_/A2 wave_controller_x_inst__2249_/Z VDD VDD VSS VSS
+ gf180mcu_fd_sc_mcu7t5v0__and3_1
XFILLER_152_314 VDD VDD VSS VSS gf180mcu_fd_sc_mcu7t5v0__fill_1
Xwave_controller_y_inst__2196_ wave_controller_y_inst__2192_/Z wave_controller_y_inst__2204_/A2
+ wave_controller_y_inst__2196_/Z VDD VDD VSS VSS gf180mcu_fd_sc_mcu7t5v0__xor2_1
XFILLER_118_591 VDD VDD VSS VSS gf180mcu_fd_sc_mcu7t5v0__fillcap_4
XFILLER_164_185 VDD VDD VSS VSS gf180mcu_fd_sc_mcu7t5v0__fillcap_4
XFILLER_98_47 VDD VDD VSS VSS gf180mcu_fd_sc_mcu7t5v0__fill_1
XFILLER_105_230 VDD VDD VSS VSS gf180mcu_fd_sc_mcu7t5v0__fill_1
XFILLER_3_346 VDD VDD VSS VSS gf180mcu_fd_sc_mcu7t5v0__fillcap_4
XFILLER_3_368 VDD VDD VSS VSS gf180mcu_fd_sc_mcu7t5v0__fillcap_4
XFILLER_106_797 VDD VDD VSS VSS gf180mcu_fd_sc_mcu7t5v0__fillcap_8
XFILLER_120_211 VDD VDD VSS VSS gf180mcu_fd_sc_mcu7t5v0__fillcap_4
XFILLER_133_594 VDD VDD VSS VSS gf180mcu_fd_sc_mcu7t5v0__fill_1
XFILLER_65_1046 VDD VDD VSS VSS gf180mcu_fd_sc_mcu7t5v0__fillcap_4
XFILLER_79_648 VDD VDD VSS VSS gf180mcu_fd_sc_mcu7t5v0__fillcap_4
XFILLER_78_169 VDD VDD VSS VSS gf180mcu_fd_sc_mcu7t5v0__fillcap_4
XTAP_TAPCELL_ROW_37_1_612 VDD VSS gf180mcu_fd_sc_mcu7t5v0__filltie
XFILLER_75_854 VDD VDD VSS VSS gf180mcu_fd_sc_mcu7t5v0__fill_2
XFILLER_75_865 VDD VDD VSS VSS gf180mcu_fd_sc_mcu7t5v0__fill_2
XFILLER_93_139 VDD VDD VSS VSS gf180mcu_fd_sc_mcu7t5v0__fill_1
XFILLER_34_217 VDD VDD VSS VSS gf180mcu_fd_sc_mcu7t5v0__fill_1
XFILLER_34_239 VDD VDD VSS VSS gf180mcu_fd_sc_mcu7t5v0__fillcap_4
Xwave_controller_y_inst__3719_ wave_controller_y_inst__3719_/D fanout545/Z clkload1/I
+ wave_controller_y_inst__3719_/Q VDD VDD VSS VSS gf180mcu_fd_sc_mcu7t5v0__dffrnq_1
XFILLER_72_1017 VDD VDD VSS VSS gf180mcu_fd_sc_mcu7t5v0__fillcap_64
XTAP_TAPCELL_ROW_11_1_414 VDD VSS gf180mcu_fd_sc_mcu7t5v0__filltie
XFILLER_128_311 VDD VDD VSS VSS gf180mcu_fd_sc_mcu7t5v0__fillcap_4
XFILLER_8_34 VDD VDD VSS VSS gf180mcu_fd_sc_mcu7t5v0__fill_1
XFILLER_116_517 VDD VDD VSS VSS gf180mcu_fd_sc_mcu7t5v0__fillcap_8
XTAP_TAPCELL_ROW_77_1147 VDD VSS gf180mcu_fd_sc_mcu7t5v0__filltie
Xwire594 wire594/I wire594/Z VDD VDD VSS VSS gf180mcu_fd_sc_mcu7t5v0__buf_4
XFILLER_100_1151 VDD VDD VSS VSS gf180mcu_fd_sc_mcu7t5v0__fillcap_4
Xspi_regs_inst__1124_ spi_regs_inst__1124_/A1 spi_regs_inst__1124_/A2 spi_regs_inst__1124_/A3
+ spi_regs_inst__1124_/Z VDD VDD VSS VSS gf180mcu_fd_sc_mcu7t5v0__and3_1
Xspi_regs_inst__1055_ spi_regs_inst__1528_/Q spi_regs_inst_wire269/Z spi_regs_inst__1189_/B1
+ spi_regs_inst__1055_/B2 spi_regs_inst__1057_/A3 VDD VDD VSS VSS gf180mcu_fd_sc_mcu7t5v0__aoi22_1
XFILLER_112_734 VDD VDD VSS VSS gf180mcu_fd_sc_mcu7t5v0__fill_1
XFILLER_124_594 VDD VDD VSS VSS gf180mcu_fd_sc_mcu7t5v0__fill_1
XTAP_TAPCELL_ROW_90_1358 VDD VSS gf180mcu_fd_sc_mcu7t5v0__filltie
XFILLER_112_756 VDD VDD VSS VSS gf180mcu_fd_sc_mcu7t5v0__fill_2
XTAP_TAPCELL_ROW_90_1369 VDD VSS gf180mcu_fd_sc_mcu7t5v0__filltie
XFILLER_65_331 VDD VDD VSS VSS gf180mcu_fd_sc_mcu7t5v0__fill_1
XFILLER_84_139 VDD VDD VSS VSS gf180mcu_fd_sc_mcu7t5v0__fill_1
XFILLER_93_640 VDD VDD VSS VSS gf180mcu_fd_sc_mcu7t5v0__fillcap_4
XFILLER_65_364 VDD VDD VSS VSS gf180mcu_fd_sc_mcu7t5v0__fillcap_4
XFILLER_93_662 VDD VDD VSS VSS gf180mcu_fd_sc_mcu7t5v0__fillcap_16
Xwave_controller_y_inst_load_slew321 wave_controller_y_inst__2917_/A2 wave_controller_y_inst__3407_/B
+ VDD VDD VSS VSS gf180mcu_fd_sc_mcu7t5v0__buf_4
Xspi_regs_inst__0908_ spi_regs_inst__1636_/Q spi_regs_inst__0911_/B spi_regs_inst__0913_/A1
+ VDD VDD VSS VSS gf180mcu_fd_sc_mcu7t5v0__nand2_1
X_17_ _19_/Q _18_/A2 _17_/B _18_/B VDD VDD VSS VSS gf180mcu_fd_sc_mcu7t5v0__oai21_1
XFILLER_25_239 VDD VDD VSS VSS gf180mcu_fd_sc_mcu7t5v0__fill_1
XFILLER_65_386 VDD VDD VSS VSS gf180mcu_fd_sc_mcu7t5v0__fillcap_8
Xspi_regs_inst__0839_ spi_regs_inst__1580_/Q spi_regs_inst__0883_/I1 spi_regs_inst__0840_/S
+ spi_regs_inst__1580_/D VDD VDD VSS VSS gf180mcu_fd_sc_mcu7t5v0__mux2_2
XFILLER_61_570 VDD VDD VSS VSS gf180mcu_fd_sc_mcu7t5v0__fillcap_4
Xwave_controller_x_inst__3221_ wave_controller_x_inst__3126_/I wave_controller_x_inst__3221_/A2
+ wave_controller_x_inst__3145_/B wave_controller_x_inst__3222_/A2 VDD VDD VSS VSS
+ gf180mcu_fd_sc_mcu7t5v0__nand3_1
Xwave_controller_x_inst__3152_ wave_controller_x_inst__1790_/I spi_regs_inst__1529_/Q
+ wave_controller_x_inst__3153_/I VDD VDD VSS VSS gf180mcu_fd_sc_mcu7t5v0__xor2_1
Xwave_controller_x_inst__3083_ wave_controller_x_inst__3085_/A2 wave_controller_x_inst__3083_/A2
+ wave_controller_x_inst__3717_/D VDD VDD VSS VSS gf180mcu_fd_sc_mcu7t5v0__nor2_1
Xwave_controller_x_inst__2103_ wave_controller_x_inst__3728_/Q wave_controller_x_inst__2102_/I
+ wave_controller_x_inst__2104_/B VDD VDD VSS VSS gf180mcu_fd_sc_mcu7t5v0__xor2_1
XFILLER_107_517 VDD VDD VSS VSS gf180mcu_fd_sc_mcu7t5v0__fillcap_4
XFILLER_119_366 VDD VDD VSS VSS gf180mcu_fd_sc_mcu7t5v0__fill_2
XFILLER_134_314 VDD VDD VSS VSS gf180mcu_fd_sc_mcu7t5v0__fill_1
XFILLER_146_152 VDD VDD VSS VSS gf180mcu_fd_sc_mcu7t5v0__fill_1
XFILLER_147_697 VDD VDD VSS VSS gf180mcu_fd_sc_mcu7t5v0__fill_2
Xwave_controller_y_inst__2050_ wave_controller_y_inst__2050_/A1 wave_controller_y_inst__2080_/B
+ wave_controller_y_inst__2049_/Z wave_controller_y_inst__2108_/B wave_controller_y_inst__2062_/B2
+ VDD VDD VSS VSS gf180mcu_fd_sc_mcu7t5v0__aoi22_1
Xwave_controller_x_inst__2034_ wave_controller_x_inst__1785_/I wave_controller_x_inst__3089_/B
+ wave_controller_x_inst__2071_/A1 VDD VDD VSS VSS gf180mcu_fd_sc_mcu7t5v0__xnor2_1
XFILLER_135_859 VDD VDD VSS VSS gf180mcu_fd_sc_mcu7t5v0__fill_1
XFILLER_150_807 VDD VDD VSS VSS gf180mcu_fd_sc_mcu7t5v0__fillcap_64
XFILLER_162_667 VDD VDD VSS VSS gf180mcu_fd_sc_mcu7t5v0__fillcap_64
XFILLER_89_924 VDD VDD VSS VSS gf180mcu_fd_sc_mcu7t5v0__fill_2
XFILLER_0_305 VDD VDD VSS VSS gf180mcu_fd_sc_mcu7t5v0__fill_1
XFILLER_142_391 VDD VDD VSS VSS gf180mcu_fd_sc_mcu7t5v0__fill_1
XFILLER_88_445 VDD VDD VSS VSS gf180mcu_fd_sc_mcu7t5v0__fillcap_8
Xwave_controller_y_inst__2952_ wave_controller_y_inst__3570_/A1 wave_controller_y_inst__2952_/A2
+ wave_controller_y_inst__3055_/A2 VDD VDD VSS VSS gf180mcu_fd_sc_mcu7t5v0__nand2_1
Xwave_controller_x_inst__2936_ spi_regs_inst__1059_/A1 wave_controller_x_inst__3585_/S
+ wave_controller_x_inst__2936_/B1 fanout402/Z wave_controller_x_inst__2937_/I VDD
+ VDD VSS VSS gf180mcu_fd_sc_mcu7t5v0__aoi22_1
XFILLER_124_34 VDD VDD VSS VSS gf180mcu_fd_sc_mcu7t5v0__fill_1
XFILLER_130_597 VDD VDD VSS VSS gf180mcu_fd_sc_mcu7t5v0__fillcap_16
XFILLER_57_821 VDD VDD VSS VSS gf180mcu_fd_sc_mcu7t5v0__fillcap_8
Xwave_controller_y_inst__1903_ spi_regs_inst__1054_/B2 wave_controller_y_inst__3423_/A1
+ VDD VDD VSS VSS gf180mcu_fd_sc_mcu7t5v0__clkinv_1
XFILLER_112_1011 VDD VDD VSS VSS gf180mcu_fd_sc_mcu7t5v0__fillcap_4
XFILLER_75_139 VDD VDD VSS VSS gf180mcu_fd_sc_mcu7t5v0__fill_1
XTAP_TAPCELL_ROW_59_849 VDD VSS gf180mcu_fd_sc_mcu7t5v0__filltie
Xwave_controller_y_inst__2883_ wave_controller_y_inst__3699_/Q wave_controller_y_inst__3492_/A1
+ wave_controller_y_inst__2883_/A3 wave_controller_y_inst__2886_/B VDD VDD VSS VSS
+ gf180mcu_fd_sc_mcu7t5v0__xor3_1
Xwave_controller_x_inst__2867_ wave_controller_x_inst__2867_/A1 wave_controller_x_inst__2864_/Z
+ wave_controller_x_inst__2867_/A3 wave_controller_x_inst__2884_/A2 wave_controller_x_inst__2869_/B
+ VDD VDD VSS VSS gf180mcu_fd_sc_mcu7t5v0__nand4_1
XFILLER_44_515 VDD VDD VSS VSS gf180mcu_fd_sc_mcu7t5v0__fillcap_8
Xwave_controller_y_inst__1834_ spi_regs_inst__1583_/Q wave_controller_y_inst__3231_/A2
+ VDD VDD VSS VSS gf180mcu_fd_sc_mcu7t5v0__clkinv_1
Xwave_controller_x_inst__2798_ max_cap461/I max_cap466/Z wave_controller_x_inst__2805_/S
+ wave_controller_x_inst__2798_/Z VDD VDD VSS VSS gf180mcu_fd_sc_mcu7t5v0__mux2_2
Xwave_controller_x_inst__1818_ fanout536/Z wave_controller_x_inst__2671_/A1 VDD VDD
+ VSS VSS gf180mcu_fd_sc_mcu7t5v0__clkinv_1
XFILLER_16_228 VDD VDD VSS VSS gf180mcu_fd_sc_mcu7t5v0__fill_1
XFILLER_71_334 VDD VDD VSS VSS gf180mcu_fd_sc_mcu7t5v0__fill_1
XTAP_TAPCELL_ROW_106_1619 VDD VSS gf180mcu_fd_sc_mcu7t5v0__filltie
XTAP_TAPCELL_ROW_123_1900 VDD VSS gf180mcu_fd_sc_mcu7t5v0__filltie
XTAP_TAPCELL_ROW_123_1911 VDD VSS gf180mcu_fd_sc_mcu7t5v0__filltie
XFILLER_71_356 VDD VDD VSS VSS gf180mcu_fd_sc_mcu7t5v0__fill_1
Xwave_controller_y_inst__3504_ wave_controller_y_inst__3704_/Q wave_controller_y_inst__3528_/A2
+ wave_controller_y_inst__3506_/A2 VDD VDD VSS VSS gf180mcu_fd_sc_mcu7t5v0__nor2_1
Xwave_controller_y_inst__3435_ spi_regs_inst__1160_/A1 wave_controller_y_inst__3454_/A2
+ wave_controller_y_inst__3436_/A3 VDD VDD VSS VSS gf180mcu_fd_sc_mcu7t5v0__nor2_1
Xwave_controller_x_inst__3419_ wave_controller_x_inst__3723_/Q wave_controller_x_inst__3446_/A2
+ wave_controller_x_inst__3419_/B wave_controller_x_inst_wire84/Z wave_controller_x_inst__3489_/B1
+ VDD VDD VSS VSS gf180mcu_fd_sc_mcu7t5v0__oai211_1
XFILLER_130_2 VDD VDD VSS VSS gf180mcu_fd_sc_mcu7t5v0__fillcap_4
XFILLER_33_64 VDD VDD VSS VSS gf180mcu_fd_sc_mcu7t5v0__fillcap_4
XFILLER_8_405 VDD VDD VSS VSS gf180mcu_fd_sc_mcu7t5v0__fillcap_4
XTAP_TAPCELL_ROW_156_2443 VDD VSS gf180mcu_fd_sc_mcu7t5v0__filltie
XTAP_TAPCELL_ROW_156_2454 VDD VSS gf180mcu_fd_sc_mcu7t5v0__filltie
Xwave_controller_y_inst__3366_ wave_controller_y_inst__3387_/A1 wave_controller_y_inst__3365_/Z
+ wave_controller_y_inst__3386_/C VDD VDD VSS VSS gf180mcu_fd_sc_mcu7t5v0__nand2_1
XFILLER_12_489 VDD VDD VSS VSS gf180mcu_fd_sc_mcu7t5v0__fill_1
XFILLER_138_631 VDD VDD VSS VSS gf180mcu_fd_sc_mcu7t5v0__fill_1
Xwave_controller_y_inst__3297_ wave_controller_y_inst__3303_/A1 wave_controller_y_inst_wire119/Z
+ wave_controller_y_inst__3297_/Z VDD VDD VSS VSS gf180mcu_fd_sc_mcu7t5v0__and2_1
Xwave_controller_y_inst__2317_ wave_controller_y_inst__2288_/B wave_controller_y_inst__2320_/A3
+ wave_controller_y_inst__2319_/C VDD VDD VSS VSS gf180mcu_fd_sc_mcu7t5v0__nor2_1
XFILLER_126_837 VDD VDD VSS VSS gf180mcu_fd_sc_mcu7t5v0__fillcap_8
XTAP_TAPCELL_ROW_48_1_695 VDD VSS gf180mcu_fd_sc_mcu7t5v0__filltie
Xwave_controller_y_inst__2248_ wave_controller_y_inst__2248_/A1 wave_controller_y_inst__2248_/A2
+ wave_controller_y_inst__2212_/Z wave_controller_y_inst_wire111/Z wave_controller_y_inst__2248_/C1
+ wave_controller_y_inst__2229_/Z wave_controller_y_inst__2250_/A2 VDD VDD VSS VSS
+ gf180mcu_fd_sc_mcu7t5v0__oai222_1
XFILLER_125_325 VDD VDD VSS VSS gf180mcu_fd_sc_mcu7t5v0__fillcap_4
XFILLER_137_185 VDD VDD VSS VSS gf180mcu_fd_sc_mcu7t5v0__fill_2
XFILLER_106_550 VDD VDD VSS VSS gf180mcu_fd_sc_mcu7t5v0__fillcap_4
XFILLER_98_209 VDD VDD VSS VSS gf180mcu_fd_sc_mcu7t5v0__fill_1
Xwave_controller_y_inst__2179_ wave_controller_y_inst__2181_/A2 wave_controller_y_inst__2178_/Z
+ wave_controller_y_inst__2180_/A2 VDD VDD VSS VSS gf180mcu_fd_sc_mcu7t5v0__xnor2_1
XFILLER_106_594 VDD VDD VSS VSS gf180mcu_fd_sc_mcu7t5v0__fill_1
XFILLER_152_177 VDD VDD VSS VSS gf180mcu_fd_sc_mcu7t5v0__fillcap_16
XFILLER_121_553 VDD VDD VSS VSS gf180mcu_fd_sc_mcu7t5v0__fillcap_4
XTAP_TAPCELL_ROW_22_1_497 VDD VSS gf180mcu_fd_sc_mcu7t5v0__filltie
XTAP_TAPCELL_ROW_72_1066 VDD VSS gf180mcu_fd_sc_mcu7t5v0__filltie
XFILLER_67_629 VDD VDD VSS VSS gf180mcu_fd_sc_mcu7t5v0__fill_1
XFILLER_75_640 VDD VDD VSS VSS gf180mcu_fd_sc_mcu7t5v0__fillcap_4
XFILLER_75_662 VDD VDD VSS VSS gf180mcu_fd_sc_mcu7t5v0__fill_1
XFILLER_35_515 VDD VDD VSS VSS gf180mcu_fd_sc_mcu7t5v0__fillcap_16
XFILLER_63_835 VDD VDD VSS VSS gf180mcu_fd_sc_mcu7t5v0__fillcap_4
XFILLER_50_507 VDD VDD VSS VSS gf180mcu_fd_sc_mcu7t5v0__fillcap_8
XFILLER_74_93 VDD VDD VSS VSS gf180mcu_fd_sc_mcu7t5v0__fillcap_8
Xspi_regs_inst_load_slew187 spi_regs_inst__1412_/S spi_regs_inst__1410_/S VDD VDD
+ VSS VSS gf180mcu_fd_sc_mcu7t5v0__buf_2
XFILLER_30_275 VDD VDD VSS VSS gf180mcu_fd_sc_mcu7t5v0__fillcap_4
XFILLER_128_141 VDD VDD VSS VSS gf180mcu_fd_sc_mcu7t5v0__fillcap_16
XFILLER_128_163 VDD VDD VSS VSS gf180mcu_fd_sc_mcu7t5v0__fill_1
XTAP_TAPCELL_ROW_50_1_710 VDD VSS gf180mcu_fd_sc_mcu7t5v0__filltie
XFILLER_132_807 VDD VDD VSS VSS gf180mcu_fd_sc_mcu7t5v0__fillcap_16
Xspi_regs_inst__1107_ spi_regs_inst__1529_/Q spi_regs_inst_wire269/Z spi_regs_inst_wire254/I
+ spi_regs_inst__1579_/Q spi_regs_inst__1117_/A4 VDD VDD VSS VSS gf180mcu_fd_sc_mcu7t5v0__aoi22_1
XFILLER_97_220 VDD VDD VSS VSS gf180mcu_fd_sc_mcu7t5v0__fillcap_4
Xspi_regs_inst__1038_ spi_regs_inst__1038_/A1 spi_regs_inst__1169_/B1 spi_regs_inst__1038_/B1
+ spi_regs_inst__1038_/B2 spi_regs_inst__1039_/A4 VDD VDD VSS VSS gf180mcu_fd_sc_mcu7t5v0__aoi22_1
XFILLER_140_873 VDD VDD VSS VSS gf180mcu_fd_sc_mcu7t5v0__fill_2
XFILLER_85_426 VDD VDD VSS VSS gf180mcu_fd_sc_mcu7t5v0__fill_2
XFILLER_86_938 VDD VDD VSS VSS gf180mcu_fd_sc_mcu7t5v0__fillcap_4
XFILLER_100_737 VDD VDD VSS VSS gf180mcu_fd_sc_mcu7t5v0__fillcap_16
XFILLER_57_139 VDD VDD VSS VSS gf180mcu_fd_sc_mcu7t5v0__fill_1
Xwave_controller_x_inst__2721_ wave_controller_x_inst__2939_/A2 wave_controller_x_inst__2719_/Z
+ wave_controller_x_inst__2728_/A2 VDD VDD VSS VSS gf180mcu_fd_sc_mcu7t5v0__nand2_1
XFILLER_38_364 VDD VDD VSS VSS gf180mcu_fd_sc_mcu7t5v0__fillcap_4
XFILLER_65_150 VDD VDD VSS VSS gf180mcu_fd_sc_mcu7t5v0__fillcap_4
XTAP_TAPCELL_ROW_56_808 VDD VSS gf180mcu_fd_sc_mcu7t5v0__filltie
Xwave_controller_x_inst__2652_ wave_controller_x_inst__2652_/A1 wave_controller_x_inst__2652_/A2
+ wave_controller_x_inst__2652_/B wave_controller_x_inst__2688_/B1 VDD VDD VSS VSS
+ gf180mcu_fd_sc_mcu7t5v0__aoi21_1
XFILLER_81_632 VDD VDD VSS VSS gf180mcu_fd_sc_mcu7t5v0__fillcap_16
XFILLER_93_492 VDD VDD VSS VSS gf180mcu_fd_sc_mcu7t5v0__fillcap_4
Xwave_controller_x_inst__2583_ wave_controller_x_inst__2815_/A1 spi_regs_inst__1085_/C2
+ wave_controller_x_inst__2583_/B wave_controller_x_inst__2584_/I VDD VDD VSS VSS
+ gf180mcu_fd_sc_mcu7t5v0__oai21_1
XFILLER_59_1170 VDD VDD VSS VSS gf180mcu_fd_sc_mcu7t5v0__fillcap_4
XFILLER_146_1151 VDD VDD VSS VSS gf180mcu_fd_sc_mcu7t5v0__fillcap_4
XFILLER_146_1173 VDD VDD VSS VSS gf180mcu_fd_sc_mcu7t5v0__fill_1
XTAP_TAPCELL_ROW_101_1538 VDD VSS gf180mcu_fd_sc_mcu7t5v0__filltie
XFILLER_139_417 VDD VDD VSS VSS gf180mcu_fd_sc_mcu7t5v0__fill_2
XFILLER_21_231 VDD VDD VSS VSS gf180mcu_fd_sc_mcu7t5v0__fill_2
XTAP_TAPCELL_ROW_101_1549 VDD VSS gf180mcu_fd_sc_mcu7t5v0__filltie
Xwave_controller_y_inst__3220_ fanout504/Z wave_controller_y_inst__3236_/A1 wave_controller_y_inst__3236_/A2
+ wave_controller_y_inst__3237_/A1 VDD VDD VSS VSS gf180mcu_fd_sc_mcu7t5v0__nor3_1
Xwave_controller_x_inst__3204_ wave_controller_x_inst__3202_/Z wave_controller_x_inst__3242_/A3
+ wave_controller_x_inst__3204_/Z VDD VDD VSS VSS gf180mcu_fd_sc_mcu7t5v0__or2_1
XFILLER_166_247 VDD VDD VSS VSS gf180mcu_fd_sc_mcu7t5v0__fillcap_8
XTAP_TAPCELL_ROW_138_2151 VDD VSS gf180mcu_fd_sc_mcu7t5v0__filltie
XTAP_TAPCELL_ROW_138_2162 VDD VSS gf180mcu_fd_sc_mcu7t5v0__filltie
XTAP_TAPCELL_ROW_36_1_600 VDD VSS gf180mcu_fd_sc_mcu7t5v0__filltie
Xwave_controller_y_inst__3151_ wave_controller_y_inst__3211_/A1 wave_controller_y_inst__3211_/A2
+ wave_controller_y_inst__3211_/B wave_controller_y_inst__3151_/Z VDD VDD VSS VSS
+ gf180mcu_fd_sc_mcu7t5v0__and3_1
Xwave_controller_x_inst__3135_ wave_controller_x_inst__3703_/Q spi_regs_inst__1522_/Q
+ wave_controller_x_inst__3137_/B VDD VDD VSS VSS gf180mcu_fd_sc_mcu7t5v0__xor2_1
Xwave_controller_y_inst__3082_ wave_controller_y_inst__3091_/A1 wave_controller_y_inst__3082_/A2
+ wave_controller_y_inst__3082_/B wave_controller_y_inst__3083_/A2 VDD VDD VSS VSS
+ gf180mcu_fd_sc_mcu7t5v0__aoi21_1
Xwave_controller_y_inst__2102_ wave_controller_y_inst__2102_/I wave_controller_y_inst__2106_/A2
+ VDD VDD VSS VSS gf180mcu_fd_sc_mcu7t5v0__clkinv_1
XFILLER_108_848 VDD VDD VSS VSS gf180mcu_fd_sc_mcu7t5v0__fillcap_4
XFILLER_119_185 VDD VDD VSS VSS gf180mcu_fd_sc_mcu7t5v0__fill_1
Xwave_controller_y_inst__2033_ wave_controller_y_inst__1785_/I wave_controller_y_inst__2038_/A2
+ wave_controller_y_inst__2033_/Z VDD VDD VSS VSS gf180mcu_fd_sc_mcu7t5v0__xor2_1
Xwave_controller_x_inst__3066_ wave_controller_x_inst__3305_/A1 wave_controller_x_inst__3069_/B1
+ wave_controller_x_inst__3065_/Z wave_controller_x_inst_wire166/Z wave_controller_x_inst__3710_/D
+ VDD VDD VSS VSS gf180mcu_fd_sc_mcu7t5v0__oai22_1
XFILLER_123_829 VDD VDD VSS VSS gf180mcu_fd_sc_mcu7t5v0__fill_2
XFILLER_163_976 VDD VDD VSS VSS gf180mcu_fd_sc_mcu7t5v0__fillcap_4
XTAP_TAPCELL_ROW_151_2362 VDD VSS gf180mcu_fd_sc_mcu7t5v0__filltie
XTAP_TAPCELL_ROW_151_2373 VDD VSS gf180mcu_fd_sc_mcu7t5v0__filltie
Xwave_controller_x_inst__2017_ wave_controller_x_inst__2018_/A1 wave_controller_x_inst__2018_/B
+ wave_controller_x_inst__2018_/A2 wave_controller_x_inst__2017_/Z VDD VDD VSS VSS
+ gf180mcu_fd_sc_mcu7t5v0__and3_1
XFILLER_122_339 VDD VDD VSS VSS gf180mcu_fd_sc_mcu7t5v0__fillcap_4
XFILLER_134_177 VDD VDD VSS VSS gf180mcu_fd_sc_mcu7t5v0__fillcap_4
XFILLER_162_497 VDD VDD VSS VSS gf180mcu_fd_sc_mcu7t5v0__fillcap_8
XTAP_TAPCELL_ROW_116_1792 VDD VSS gf180mcu_fd_sc_mcu7t5v0__filltie
XFILLER_0_135 VDD VDD VSS VSS gf180mcu_fd_sc_mcu7t5v0__fill_1
XFILLER_131_851 VDD VDD VSS VSS gf180mcu_fd_sc_mcu7t5v0__fillcap_4
XFILLER_153_1122 VDD VDD VSS VSS gf180mcu_fd_sc_mcu7t5v0__fillcap_32
XFILLER_89_754 VDD VDD VSS VSS gf180mcu_fd_sc_mcu7t5v0__fillcap_16
XFILLER_131_895 VDD VDD VSS VSS gf180mcu_fd_sc_mcu7t5v0__fill_1
XFILLER_77_938 VDD VDD VSS VSS gf180mcu_fd_sc_mcu7t5v0__fill_1
XFILLER_130_383 VDD VDD VSS VSS gf180mcu_fd_sc_mcu7t5v0__fill_2
XFILLER_88_286 VDD VDD VSS VSS gf180mcu_fd_sc_mcu7t5v0__fill_2
Xwave_controller_y_inst__2935_ wave_controller_y_inst__3738_/Q wave_controller_y_inst__2935_/A2
+ wave_controller_y_inst__3588_/S wave_controller_y_inst__2936_/B1 VDD VDD VSS VSS
+ gf180mcu_fd_sc_mcu7t5v0__nor3_1
Xwave_controller_x_inst__2919_ wave_controller_x_inst__3716_/Q wave_controller_x_inst__3049_/A2
+ wave_controller_x_inst__3587_/A1 VDD VDD VSS VSS gf180mcu_fd_sc_mcu7t5v0__nand2_1
XFILLER_17_504 VDD VDD VSS VSS gf180mcu_fd_sc_mcu7t5v0__fillcap_8
XFILLER_29_331 VDD VDD VSS VSS gf180mcu_fd_sc_mcu7t5v0__fill_1
XFILLER_29_364 VDD VDD VSS VSS gf180mcu_fd_sc_mcu7t5v0__fillcap_8
XFILLER_85_982 VDD VDD VSS VSS gf180mcu_fd_sc_mcu7t5v0__fillcap_64
Xwave_controller_y_inst__2866_ wave_controller_y_inst__3440_/A1 spi_regs_inst__1160_/A1
+ wave_controller_y_inst__2884_/A2 VDD VDD VSS VSS gf180mcu_fd_sc_mcu7t5v0__nand2_1
XFILLER_56_150 VDD VDD VSS VSS gf180mcu_fd_sc_mcu7t5v0__fillcap_8
XFILLER_56_172 VDD VDD VSS VSS gf180mcu_fd_sc_mcu7t5v0__fill_2
Xwave_controller_y_inst__1817_ fanout513/Z wave_controller_y_inst__3245_/A1 VDD VDD
+ VSS VSS gf180mcu_fd_sc_mcu7t5v0__clkinv_1
XFILLER_71_142 VDD VDD VSS VSS gf180mcu_fd_sc_mcu7t5v0__fillcap_4
Xwave_controller_y_inst__2797_ wave_controller_y_inst__3279_/A1 wave_controller_y_inst__2795_/Z
+ wave_controller_y_inst__2797_/B wave_controller_y_inst__2797_/C wave_controller_y_inst__2802_/A1
+ VDD VDD VSS VSS gf180mcu_fd_sc_mcu7t5v0__oai211_1
XFILLER_32_518 VDD VDD VSS VSS gf180mcu_fd_sc_mcu7t5v0__fillcap_4
XFILLER_72_687 VDD VDD VSS VSS gf180mcu_fd_sc_mcu7t5v0__fill_2
XFILLER_158_737 VDD VDD VSS VSS gf180mcu_fd_sc_mcu7t5v0__fillcap_64
Xwave_controller_y_inst__3418_ wave_controller_y_inst__3723_/Q wave_controller_y_inst__1902_/I
+ wave_controller_y_inst__3419_/B wave_controller_y_inst__3441_/A1 VDD VDD VSS VSS
+ gf180mcu_fd_sc_mcu7t5v0__oai21_1
Xwave_controller_y_inst__3349_ wave_controller_y_inst__3400_/A1 wave_controller_y_inst__3348_/Z
+ wave_controller_y_inst__3401_/A1 VDD VDD VSS VSS gf180mcu_fd_sc_mcu7t5v0__nand2_1
XFILLER_158_1011 VDD VDD VSS VSS gf180mcu_fd_sc_mcu7t5v0__fillcap_4
XFILLER_114_807 VDD VDD VSS VSS gf180mcu_fd_sc_mcu7t5v0__fillcap_8
XTAP_TAPCELL_ROW_74_1106 VDD VSS gf180mcu_fd_sc_mcu7t5v0__filltie
XFILLER_113_306 VDD VDD VSS VSS gf180mcu_fd_sc_mcu7t5v0__fillcap_32
XFILLER_125_177 VDD VDD VSS VSS gf180mcu_fd_sc_mcu7t5v0__fill_2
XFILLER_140_136 VDD VDD VSS VSS gf180mcu_fd_sc_mcu7t5v0__fillcap_32
XFILLER_95_702 VDD VDD VSS VSS gf180mcu_fd_sc_mcu7t5v0__fillcap_8
XFILLER_67_448 VDD VDD VSS VSS gf180mcu_fd_sc_mcu7t5v0__fill_2
XFILLER_79_286 VDD VDD VSS VSS gf180mcu_fd_sc_mcu7t5v0__fill_2
XFILLER_94_278 VDD VDD VSS VSS gf180mcu_fd_sc_mcu7t5v0__fill_2
XFILLER_63_632 VDD VDD VSS VSS gf180mcu_fd_sc_mcu7t5v0__fillcap_8
XFILLER_75_492 VDD VDD VSS VSS gf180mcu_fd_sc_mcu7t5v0__fillcap_8
XFILLER_90_451 VDD VDD VSS VSS gf180mcu_fd_sc_mcu7t5v0__fillcap_4
XFILLER_91_974 VDD VDD VSS VSS gf180mcu_fd_sc_mcu7t5v0__fillcap_4
XFILLER_62_164 VDD VDD VSS VSS gf180mcu_fd_sc_mcu7t5v0__fillcap_8
XFILLER_63_698 VDD VDD VSS VSS gf180mcu_fd_sc_mcu7t5v0__fill_2
XTAP_TAPCELL_ROW_85_1279 VDD VSS gf180mcu_fd_sc_mcu7t5v0__filltie
XFILLER_93_2 VDD VDD VSS VSS gf180mcu_fd_sc_mcu7t5v0__fillcap_16
Xspi_regs_inst__1656_ spi_regs_inst__1656_/D fanout584/Z clkbuf_leaf_13_clk/Z spi_regs_inst__1656_/Q
+ VDD VDD VSS VSS gf180mcu_fd_sc_mcu7t5v0__dffrnq_1
XFILLER_31_551 VDD VDD VSS VSS gf180mcu_fd_sc_mcu7t5v0__fillcap_4
XTAP_TAPCELL_ROW_61_877 VDD VSS gf180mcu_fd_sc_mcu7t5v0__filltie
XTAP_TAPCELL_ROW_61_888 VDD VSS gf180mcu_fd_sc_mcu7t5v0__filltie
Xspi_regs_inst__1587_ spi_regs_inst__1587_/D fanout615/Z clkbuf_leaf_39_clk/Z spi_regs_inst__1587_/Q
+ VDD VDD VSS VSS gf180mcu_fd_sc_mcu7t5v0__dffrnq_1
XFILLER_148_247 VDD VDD VSS VSS gf180mcu_fd_sc_mcu7t5v0__fillcap_8
XFILLER_163_206 VDD VDD VSS VSS gf180mcu_fd_sc_mcu7t5v0__fillcap_4
XFILLER_116_122 VDD VDD VSS VSS gf180mcu_fd_sc_mcu7t5v0__fillcap_8
XFILLER_129_472 VDD VDD VSS VSS gf180mcu_fd_sc_mcu7t5v0__fill_1
XFILLER_102_1087 VDD VDD VSS VSS gf180mcu_fd_sc_mcu7t5v0__fillcap_64
XFILLER_144_453 VDD VDD VSS VSS gf180mcu_fd_sc_mcu7t5v0__fill_2
XFILLER_145_976 VDD VDD VSS VSS gf180mcu_fd_sc_mcu7t5v0__fillcap_4
XTAP_TAPCELL_ROW_133_2070 VDD VSS gf180mcu_fd_sc_mcu7t5v0__filltie
XFILLER_104_317 VDD VDD VSS VSS gf180mcu_fd_sc_mcu7t5v0__fillcap_16
XFILLER_116_177 VDD VDD VSS VSS gf180mcu_fd_sc_mcu7t5v0__fillcap_16
XFILLER_144_486 VDD VDD VSS VSS gf180mcu_fd_sc_mcu7t5v0__fillcap_16
XFILLER_98_551 VDD VDD VSS VSS gf180mcu_fd_sc_mcu7t5v0__fill_2
XFILLER_131_169 VDD VDD VSS VSS gf180mcu_fd_sc_mcu7t5v0__fillcap_16
XFILLER_59_927 VDD VDD VSS VSS gf180mcu_fd_sc_mcu7t5v0__fillcap_32
XFILLER_85_212 VDD VDD VSS VSS gf180mcu_fd_sc_mcu7t5v0__fillcap_4
XTAP_TAPCELL_ROW_39_1_626 VDD VSS gf180mcu_fd_sc_mcu7t5v0__filltie
XFILLER_105_69 VDD VDD VSS VSS gf180mcu_fd_sc_mcu7t5v0__fill_1
Xwave_controller_y_inst__2720_ wave_controller_y_inst__3400_/A1 wave_controller_y_inst__2719_/Z
+ wave_controller_y_inst__2728_/B VDD VDD VSS VSS gf180mcu_fd_sc_mcu7t5v0__nor2_1
Xwave_controller_y_inst_fanout51 wave_controller_y_inst_fanout52/Z wave_controller_y_inst__2923_/S
+ VDD VDD VSS VSS gf180mcu_fd_sc_mcu7t5v0__dlyb_1
Xwave_controller_x_inst__2704_ spi_regs_inst__1038_/A1 wave_controller_x_inst__2702_/Z
+ wave_controller_x_inst__2704_/Z VDD VDD VSS VSS gf180mcu_fd_sc_mcu7t5v0__xor2_1
XFILLER_26_312 VDD VDD VSS VSS gf180mcu_fd_sc_mcu7t5v0__fill_2
XFILLER_67_982 VDD VDD VSS VSS gf180mcu_fd_sc_mcu7t5v0__fillcap_64
XTAP_TAPCELL_ROW_47_1_683 VDD VSS gf180mcu_fd_sc_mcu7t5v0__filltie
Xwave_controller_y_inst__2651_ wave_controller_y_inst__2831_/A1 spi_regs_inst__1285_/B2
+ wave_controller_y_inst__2651_/B wave_controller_y_inst__2652_/B VDD VDD VSS VSS
+ gf180mcu_fd_sc_mcu7t5v0__oai21_1
Xwave_controller_x_inst__3684_ wave_controller_x_inst__3684_/D fanout592/Z clkbuf_leaf_26_clk/Z
+ spi_regs_inst__1309_/C2 VDD VDD VSS VSS gf180mcu_fd_sc_mcu7t5v0__dffrnq_1
XFILLER_26_345 VDD VDD VSS VSS gf180mcu_fd_sc_mcu7t5v0__fillcap_4
XFILLER_53_131 VDD VDD VSS VSS gf180mcu_fd_sc_mcu7t5v0__fillcap_4
Xwave_controller_x_inst__2635_ wave_controller_x_inst_wire85/Z wave_controller_x_inst__2646_/A2
+ wave_controller_x_inst__2713_/A1 VDD VDD VSS VSS gf180mcu_fd_sc_mcu7t5v0__nor2_1
XFILLER_53_142 VDD VDD VSS VSS gf180mcu_fd_sc_mcu7t5v0__fill_2
XFILLER_53_164 VDD VDD VSS VSS gf180mcu_fd_sc_mcu7t5v0__fillcap_4
Xwave_controller_y_inst__2582_ spi_regs_inst__1034_/A1 wave_controller_y_inst__3521_/B2
+ wave_controller_y_inst__2566_/Z wave_controller_y_inst__2583_/B VDD VDD VSS VSS
+ gf180mcu_fd_sc_mcu7t5v0__nand3_1
Xwave_controller_x_inst__2566_ wave_controller_x_inst__2815_/A1 spi_regs_inst__1085_/C2
+ wave_controller_x_inst__2566_/Z VDD VDD VSS VSS gf180mcu_fd_sc_mcu7t5v0__xor2_1
XFILLER_41_348 VDD VDD VSS VSS gf180mcu_fd_sc_mcu7t5v0__fill_2
XTAP_TAPCELL_ROW_13_1_428 VDD VSS gf180mcu_fd_sc_mcu7t5v0__filltie
XFILLER_139_214 VDD VDD VSS VSS gf180mcu_fd_sc_mcu7t5v0__fill_1
XFILLER_167_512 VDD VDD VSS VSS gf180mcu_fd_sc_mcu7t5v0__fillcap_32
XPHY_EDGE_ROW_132_Left_299 VDD VSS gf180mcu_fd_sc_mcu7t5v0__endcap
Xwave_controller_x_inst__2497_ wave_controller_x_inst__2497_/A1 wave_controller_x_inst__2497_/A2
+ wave_controller_x_inst__2497_/B wave_controller_x_inst__2509_/A3 VDD VDD VSS VSS
+ gf180mcu_fd_sc_mcu7t5v0__aoi21_1
XTAP_TAPCELL_ROW_153_2402 VDD VSS gf180mcu_fd_sc_mcu7t5v0__filltie
Xwave_controller_y_inst__3203_ wave_controller_y_inst__3203_/A1 wave_controller_y_inst__3206_/A1
+ wave_controller_y_inst__3203_/B wave_controller_y_inst__3242_/A3 VDD VDD VSS VSS
+ gf180mcu_fd_sc_mcu7t5v0__aoi21_1
XFILLER_154_206 VDD VDD VSS VSS gf180mcu_fd_sc_mcu7t5v0__fill_2
XTAP_TAPCELL_ROW_118_1821 VDD VSS gf180mcu_fd_sc_mcu7t5v0__filltie
XTAP_TAPCELL_ROW_118_1832 VDD VSS gf180mcu_fd_sc_mcu7t5v0__filltie
Xwave_controller_y_inst__3134_ wave_controller_y_inst__2797_/C spi_regs_inst__1583_/Q
+ wave_controller_y_inst__3134_/B wave_controller_y_inst__3232_/B1 VDD VDD VSS VSS
+ gf180mcu_fd_sc_mcu7t5v0__oai21_1
Xwave_controller_x_inst__3118_ wave_controller_x_inst__3570_/A1 spi_regs_inst__1526_/Q
+ wave_controller_x_inst__3149_/B1 VDD VDD VSS VSS gf180mcu_fd_sc_mcu7t5v0__nor2_1
XFILLER_108_667 VDD VDD VSS VSS gf180mcu_fd_sc_mcu7t5v0__fillcap_16
Xwave_controller_y_inst__3065_ wave_controller_y_inst__1790_/I wave_controller_y_inst__3209_/B
+ wave_controller_y_inst__2981_/B wave_controller_y_inst__3065_/Z VDD VDD VSS VSS
+ gf180mcu_fd_sc_mcu7t5v0__xor3_1
Xwave_controller_x_inst__3049_ wave_controller_x_inst__3705_/Q wave_controller_x_inst__3049_/A2
+ wave_controller_x_inst__3599_/A2 VDD VDD VSS VSS gf180mcu_fd_sc_mcu7t5v0__nand2_1
Xwave_controller_y_inst__2016_ fanout513/I wave_controller_y_inst__2380_/A1 wave_controller_y_inst__2008_/Z
+ wave_controller_y_inst_wire82/Z wave_controller_y_inst__2016_/C wave_controller_y_inst__2018_/A2
+ VDD VDD VSS VSS gf180mcu_fd_sc_mcu7t5v0__oai221_1
XFILLER_77_702 VDD VDD VSS VSS gf180mcu_fd_sc_mcu7t5v0__fillcap_8
XFILLER_89_562 VDD VDD VSS VSS gf180mcu_fd_sc_mcu7t5v0__fill_2
XFILLER_76_201 VDD VDD VSS VSS gf180mcu_fd_sc_mcu7t5v0__fillcap_4
XFILLER_77_757 VDD VDD VSS VSS gf180mcu_fd_sc_mcu7t5v0__fillcap_8
XTAP_TAPCELL_ROW_164_2575 VDD VSS gf180mcu_fd_sc_mcu7t5v0__filltie
Xwave_controller_y_inst__2918_ wave_controller_y_inst__3585_/I0 spi_regs_inst__1318_/C2
+ wave_controller_y_inst__2929_/S wave_controller_y_inst__3684_/D VDD VDD VSS VSS
+ gf180mcu_fd_sc_mcu7t5v0__mux2_2
XFILLER_17_312 VDD VDD VSS VSS gf180mcu_fd_sc_mcu7t5v0__fillcap_4
XFILLER_76_278 VDD VDD VSS VSS gf180mcu_fd_sc_mcu7t5v0__fillcap_8
XTAP_TAPCELL_ROW_164_2586 VDD VSS gf180mcu_fd_sc_mcu7t5v0__filltie
Xwave_controller_y_inst__2849_ wave_controller_y_inst__2850_/B1 wave_controller_y_inst__2847_/Z
+ wave_controller_y_inst__2849_/A3 wave_controller_y_inst__2852_/A2 VDD VDD VSS VSS
+ gf180mcu_fd_sc_mcu7t5v0__nor3_1
XFILLER_17_367 VDD VDD VSS VSS gf180mcu_fd_sc_mcu7t5v0__fillcap_8
XFILLER_72_473 VDD VDD VSS VSS gf180mcu_fd_sc_mcu7t5v0__fillcap_16
Xspi_regs_inst__1510_ spi_regs_inst__1510_/D spi_regs_inst__1648_/RN clkload29/I spi_regs_inst__1510_/Q
+ VDD VDD VSS VSS gf180mcu_fd_sc_mcu7t5v0__dffrnq_1
XFILLER_60_657 VDD VDD VSS VSS gf180mcu_fd_sc_mcu7t5v0__fill_2
XFILLER_111_90 VDD VDD VSS VSS gf180mcu_fd_sc_mcu7t5v0__fill_1
XFILLER_164_1081 VDD VDD VSS VSS gf180mcu_fd_sc_mcu7t5v0__fillcap_4
XFILLER_9_500 VDD VDD VSS VSS gf180mcu_fd_sc_mcu7t5v0__fillcap_16
Xspi_regs_inst__1441_ spi_regs_inst__1510_/Q spi_regs_inst__1441_/I1 spi_regs_inst__1441_/S
+ spi_regs_inst__1510_/D VDD VDD VSS VSS gf180mcu_fd_sc_mcu7t5v0__mux2_2
XFILLER_71_72 VDD VDD VSS VSS gf180mcu_fd_sc_mcu7t5v0__fillcap_4
Xspi_regs_inst__1372_ spi_regs_inst__1372_/A1 spi_regs_inst__1376_/A2 spi_regs_inst__1372_/B
+ spi_regs_inst__1654_/D VDD VDD VSS VSS gf180mcu_fd_sc_mcu7t5v0__oai21_1
XTAP_TAPCELL_ROW_80_1198 VDD VSS gf180mcu_fd_sc_mcu7t5v0__filltie
XFILLER_126_442 VDD VDD VSS VSS gf180mcu_fd_sc_mcu7t5v0__fillcap_8
XFILLER_113_125 VDD VDD VSS VSS gf180mcu_fd_sc_mcu7t5v0__fillcap_8
XFILLER_99_348 VDD VDD VSS VSS gf180mcu_fd_sc_mcu7t5v0__fill_2
Xwave_controller_x_inst_load_slew600 wave_controller_x_inst__3735_/RN wave_controller_x_inst__3736_/RN
+ VDD VDD VSS VSS gf180mcu_fd_sc_mcu7t5v0__buf_4
Xsignal_processor_y_inst__253_ signal_processor_y_inst__253_/D signal_processor_y_inst__253_/RN
+ clkbuf_leaf_0_clk/Z signal_processor_y_inst__253_/Q VDD VDD VSS VSS gf180mcu_fd_sc_mcu7t5v0__dffrnq_1
XFILLER_67_212 VDD VDD VSS VSS gf180mcu_fd_sc_mcu7t5v0__fillcap_8
Xsignal_processor_y_inst__184_ signal_processor_y_inst__239_/Q signal_processor_y_inst__240_/Q
+ signal_processor_y_inst__241_/Q signal_processor_y_inst__185_/I VDD VDD VSS VSS
+ gf180mcu_fd_sc_mcu7t5v0__nand3_1
XTAP_TAPCELL_ROW_87_1308 VDD VSS gf180mcu_fd_sc_mcu7t5v0__filltie
XFILLER_27_109 VDD VDD VSS VSS gf180mcu_fd_sc_mcu7t5v0__fill_1
XFILLER_83_738 VDD VDD VSS VSS gf180mcu_fd_sc_mcu7t5v0__fillcap_32
XFILLER_95_587 VDD VDD VSS VSS gf180mcu_fd_sc_mcu7t5v0__fillcap_4
XTAP_TAPCELL_ROW_87_1319 VDD VSS gf180mcu_fd_sc_mcu7t5v0__filltie
XFILLER_64_941 VDD VDD VSS VSS gf180mcu_fd_sc_mcu7t5v0__fillcap_4
XFILLER_82_237 VDD VDD VSS VSS gf180mcu_fd_sc_mcu7t5v0__fillcap_8
XTAP_TAPCELL_ROW_66_958 VDD VSS gf180mcu_fd_sc_mcu7t5v0__filltie
XTAP_TAPCELL_ROW_66_969 VDD VSS gf180mcu_fd_sc_mcu7t5v0__filltie
XFILLER_63_451 VDD VDD VSS VSS gf180mcu_fd_sc_mcu7t5v0__fillcap_4
Xwave_controller_x_inst__2420_ wave_controller_x_inst__2418_/Z wave_controller_x_inst__2434_/A2
+ wave_controller_x_inst__2435_/A1 VDD VDD VSS VSS gf180mcu_fd_sc_mcu7t5v0__nand2_1
Xwave_controller_x_inst__2351_ spi_regs_inst__1309_/C2 wave_controller_x_inst__2822_/A1
+ wave_controller_x_inst__2364_/B VDD VDD VSS VSS gf180mcu_fd_sc_mcu7t5v0__nand2_1
XFILLER_56_1151 VDD VDD VSS VSS gf180mcu_fd_sc_mcu7t5v0__fillcap_4
Xspi_regs_inst__1639_ spi_regs_inst__1639_/D spi_regs_inst__1659_/RN clkload8/I spi_regs_inst__1639_/Q
+ VDD VDD VSS VSS gf180mcu_fd_sc_mcu7t5v0__dffrnq_1
XFILLER_143_1154 VDD VDD VSS VSS gf180mcu_fd_sc_mcu7t5v0__fillcap_16
Xwave_controller_x_inst__2282_ wave_controller_x_inst__2346_/A1 wave_controller_x_inst__2280_/Z
+ spi_regs_inst__1006_/A1 VDD VDD VSS VSS gf180mcu_fd_sc_mcu7t5v0__xor2_1
XFILLER_149_589 VDD VDD VSS VSS gf180mcu_fd_sc_mcu7t5v0__fill_1
XTAP_TAPCELL_ROW_135_2110 VDD VSS gf180mcu_fd_sc_mcu7t5v0__filltie
XFILLER_136_217 VDD VDD VSS VSS gf180mcu_fd_sc_mcu7t5v0__fill_2
XFILLER_104_103 VDD VDD VSS VSS gf180mcu_fd_sc_mcu7t5v0__fill_2
XFILLER_117_486 VDD VDD VSS VSS gf180mcu_fd_sc_mcu7t5v0__fillcap_4
XTAP_TAPCELL_ROW_113_1740 VDD VSS gf180mcu_fd_sc_mcu7t5v0__filltie
XFILLER_132_489 VDD VDD VSS VSS gf180mcu_fd_sc_mcu7t5v0__fillcap_16
XFILLER_59_702 VDD VDD VSS VSS gf180mcu_fd_sc_mcu7t5v0__fillcap_16
XFILLER_63_1122 VDD VDD VSS VSS gf180mcu_fd_sc_mcu7t5v0__fillcap_32
XFILLER_99_882 VDD VDD VSS VSS gf180mcu_fd_sc_mcu7t5v0__fillcap_16
Xfanout523 fanout523/I fanout523/Z VDD VDD VSS VSS gf180mcu_fd_sc_mcu7t5v0__dlyb_1
Xfanout501 fanout501/I fanout501/Z VDD VDD VSS VSS gf180mcu_fd_sc_mcu7t5v0__dlyb_1
XFILLER_58_201 VDD VDD VSS VSS gf180mcu_fd_sc_mcu7t5v0__fill_2
XFILLER_59_757 VDD VDD VSS VSS gf180mcu_fd_sc_mcu7t5v0__fill_1
Xfanout556 fanout557/Z fanout556/Z VDD VDD VSS VSS gf180mcu_fd_sc_mcu7t5v0__dlyb_1
Xfanout545 fanout546/Z fanout545/Z VDD VDD VSS VSS gf180mcu_fd_sc_mcu7t5v0__dlyb_1
Xfanout534 fanout534/I fanout534/Z VDD VDD VSS VSS gf180mcu_fd_sc_mcu7t5v0__dlyb_1
XFILLER_101_876 VDD VDD VSS VSS gf180mcu_fd_sc_mcu7t5v0__fill_1
Xwave_controller_x_inst__1997_ fanout539/Z wave_controller_x_inst__2349_/C wave_controller_x_inst__2009_/A1
+ VDD VDD VSS VSS gf180mcu_fd_sc_mcu7t5v0__nor2_1
Xfanout589 fanout590/Z fanout589/Z VDD VDD VSS VSS gf180mcu_fd_sc_mcu7t5v0__dlyb_1
Xfanout578 fanout580/Z fanout578/Z VDD VDD VSS VSS gf180mcu_fd_sc_mcu7t5v0__dlyb_1
XFILLER_132_34 VDD VDD VSS VSS gf180mcu_fd_sc_mcu7t5v0__fill_1
XFILLER_132_45 VDD VDD VSS VSS gf180mcu_fd_sc_mcu7t5v0__fill_2
XTAP_TAPCELL_ROW_146_2283 VDD VSS gf180mcu_fd_sc_mcu7t5v0__filltie
XTAP_TAPCELL_ROW_146_2294 VDD VSS gf180mcu_fd_sc_mcu7t5v0__filltie
Xwave_controller_y_inst__2703_ max_cap430/Z wave_controller_y_inst__2702_/Z wave_controller_y_inst__2723_/B
+ VDD VDD VSS VSS gf180mcu_fd_sc_mcu7t5v0__nand2_1
Xwave_controller_x_inst__3736_ wave_controller_x_inst__3736_/D wave_controller_x_inst__3736_/RN
+ clkload26/I wave_controller_x_inst__3736_/Q VDD VDD VSS VSS gf180mcu_fd_sc_mcu7t5v0__dffrnq_1
Xwave_controller_y_inst__3683_ wave_controller_y_inst__3683_/D wave_controller_y_inst__3683_/RN
+ clkload12/I spi_regs_inst__1278_/A1 VDD VDD VSS VSS gf180mcu_fd_sc_mcu7t5v0__dffrnq_1
Xwave_controller_x_inst__3667_ wave_controller_x_inst__3667_/D fanout589/Z clkload22/I
+ wire450/I VDD VDD VSS VSS gf180mcu_fd_sc_mcu7t5v0__dffrnq_1
XFILLER_54_451 VDD VDD VSS VSS gf180mcu_fd_sc_mcu7t5v0__fillcap_4
XFILLER_92_49 VDD VDD VSS VSS gf180mcu_fd_sc_mcu7t5v0__fillcap_8
XPHY_EDGE_ROW_140_Left_307 VDD VSS gf180mcu_fd_sc_mcu7t5v0__endcap
Xwave_controller_y_inst__2634_ wave_controller_y_inst__2634_/A1 wave_controller_y_inst__2633_/C
+ wave_controller_y_inst__2634_/B wave_controller_y_inst__2634_/C wave_controller_y_inst__2646_/A2
+ VDD VDD VSS VSS gf180mcu_fd_sc_mcu7t5v0__oai211_1
Xwave_controller_x_inst__2618_ wave_controller_x_inst__2580_/Z wave_controller_x_inst__2595_/Z
+ wave_controller_x_inst__2620_/A3 VDD VDD VSS VSS gf180mcu_fd_sc_mcu7t5v0__nand2_1
Xwave_controller_y_inst__2565_ wave_controller_y_inst_wire99/Z wave_controller_y_inst_wire89/Z
+ wave_controller_y_inst__2607_/A1 VDD VDD VSS VSS gf180mcu_fd_sc_mcu7t5v0__nand2_1
Xwave_controller_x_inst__3598_ spi_regs_inst__1254_/B2 wave_controller_x_inst__3602_/S
+ wave_controller_x_inst__3599_/B VDD VDD VSS VSS gf180mcu_fd_sc_mcu7t5v0__nand2_1
XFILLER_148_1087 VDD VDD VSS VSS gf180mcu_fd_sc_mcu7t5v0__fillcap_64
Xwave_controller_x_inst__2549_ wave_controller_x_inst__2786_/A1 max_cap465/Z wave_controller_x_inst__2567_/B
+ VDD VDD VSS VSS gf180mcu_fd_sc_mcu7t5v0__nor2_1
Xwave_controller_y_inst__2496_ wave_controller_y_inst__2497_/A1 wave_controller_y_inst__2497_/A2
+ wave_controller_y_inst__2497_/B wave_controller_y_inst__2509_/B VDD VDD VSS VSS
+ gf180mcu_fd_sc_mcu7t5v0__nand3_1
XFILLER_128_707 VDD VDD VSS VSS gf180mcu_fd_sc_mcu7t5v0__fillcap_4
XFILLER_167_342 VDD VDD VSS VSS gf180mcu_fd_sc_mcu7t5v0__fillcap_32
XFILLER_127_228 VDD VDD VSS VSS gf180mcu_fd_sc_mcu7t5v0__fillcap_8
XTAP_TAPCELL_ROW_52_1_724 VDD VSS gf180mcu_fd_sc_mcu7t5v0__filltie
XFILLER_108_431 VDD VDD VSS VSS gf180mcu_fd_sc_mcu7t5v0__fillcap_8
XFILLER_109_976 VDD VDD VSS VSS gf180mcu_fd_sc_mcu7t5v0__fillcap_4
XFILLER_68_1011 VDD VDD VSS VSS gf180mcu_fd_sc_mcu7t5v0__fillcap_4
Xwave_controller_y_inst__3117_ wave_controller_y_inst__3570_/A1 spi_regs_inst__1589_/Q
+ wave_controller_y_inst__3149_/C VDD VDD VSS VSS gf180mcu_fd_sc_mcu7t5v0__nand2_1
XFILLER_135_294 VDD VDD VSS VSS gf180mcu_fd_sc_mcu7t5v0__fill_1
Xwave_controller_y_inst__3048_ wave_controller_y_inst__3564_/A1 wave_controller_y_inst__3059_/A2
+ wave_controller_y_inst__3047_/Z wave_controller_y_inst_wire147/Z wave_controller_y_inst__3704_/D
+ VDD VDD VSS VSS gf180mcu_fd_sc_mcu7t5v0__oai22_1
XFILLER_96_307 VDD VDD VSS VSS gf180mcu_fd_sc_mcu7t5v0__fill_2
XTAP_TAPCELL_ROW_166_2615 VDD VSS gf180mcu_fd_sc_mcu7t5v0__filltie
XFILLER_49_212 VDD VDD VSS VSS gf180mcu_fd_sc_mcu7t5v0__fill_2
XFILLER_89_370 VDD VDD VSS VSS gf180mcu_fd_sc_mcu7t5v0__fillcap_4
XFILLER_89_381 VDD VDD VSS VSS gf180mcu_fd_sc_mcu7t5v0__fillcap_4
XTAP_TAPCELL_ROW_8_1_393 VDD VSS gf180mcu_fd_sc_mcu7t5v0__filltie
Xspi_regs_inst__0941_ spi_regs_inst__1642_/Q spi_regs_inst__1266_/S spi_regs_inst__1076_/B
+ VDD VDD VSS VSS gf180mcu_fd_sc_mcu7t5v0__nand2_1
XFILLER_77_587 VDD VDD VSS VSS gf180mcu_fd_sc_mcu7t5v0__fill_2
XFILLER_92_524 VDD VDD VSS VSS gf180mcu_fd_sc_mcu7t5v0__fill_1
XTAP_TAPCELL_ROW_69_1016 VDD VSS gf180mcu_fd_sc_mcu7t5v0__filltie
XFILLER_80_708 VDD VDD VSS VSS gf180mcu_fd_sc_mcu7t5v0__fillcap_8
Xspi_regs_inst__0872_ spi_regs_inst__1607_/Q spi_regs_inst__1405_/I1 spi_regs_inst__0875_/S
+ spi_regs_inst__1607_/D VDD VDD VSS VSS gf180mcu_fd_sc_mcu7t5v0__mux2_2
XFILLER_17_142 VDD VDD VSS VSS gf180mcu_fd_sc_mcu7t5v0__fillcap_16
XFILLER_45_462 VDD VDD VSS VSS gf180mcu_fd_sc_mcu7t5v0__fillcap_16
XTAP_TAPCELL_ROW_63_917 VDD VSS gf180mcu_fd_sc_mcu7t5v0__filltie
XFILLER_127_1116 VDD VDD VSS VSS gf180mcu_fd_sc_mcu7t5v0__fillcap_4
XTAP_TAPCELL_ROW_82_1227 VDD VSS gf180mcu_fd_sc_mcu7t5v0__filltie
XTAP_TAPCELL_ROW_82_1238 VDD VSS gf180mcu_fd_sc_mcu7t5v0__filltie
XFILLER_82_93 VDD VDD VSS VSS gf180mcu_fd_sc_mcu7t5v0__fillcap_8
Xspi_regs_inst__1424_ spi_regs_inst__1448_/I1 spi_regs_inst__1495_/Q spi_regs_inst__1427_/S
+ spi_regs_inst__1495_/D VDD VDD VSS VSS gf180mcu_fd_sc_mcu7t5v0__mux2_2
XFILLER_13_392 VDD VDD VSS VSS gf180mcu_fd_sc_mcu7t5v0__fillcap_16
XFILLER_9_330 VDD VDD VSS VSS gf180mcu_fd_sc_mcu7t5v0__fillcap_4
XFILLER_9_352 VDD VDD VSS VSS gf180mcu_fd_sc_mcu7t5v0__fillcap_8
XTAP_TAPCELL_ROW_38_1_614 VDD VSS gf180mcu_fd_sc_mcu7t5v0__filltie
XFILLER_158_375 VDD VDD VSS VSS gf180mcu_fd_sc_mcu7t5v0__fillcap_4
Xspi_regs_inst__1355_ spi_regs_inst__1355_/A1 spi_regs_inst__1355_/A2 spi_regs_inst__1355_/A3
+ spi_regs_inst__1355_/A4 spi_regs_inst__1359_/A3 VDD VDD VSS VSS gf180mcu_fd_sc_mcu7t5v0__nand4_1
XFILLER_161_507 VDD VDD VSS VSS gf180mcu_fd_sc_mcu7t5v0__fillcap_8
Xspi_regs_inst__1286_ fanout504/Z spi_regs_inst_wire299/Z spi_regs_inst_wire214/Z
+ spi_regs_inst__1286_/B2 spi_regs_inst__1287_/A4 VDD VDD VSS VSS gf180mcu_fd_sc_mcu7t5v0__aoi22_1
XFILLER_127_795 VDD VDD VSS VSS gf180mcu_fd_sc_mcu7t5v0__fill_2
XFILLER_142_721 VDD VDD VSS VSS gf180mcu_fd_sc_mcu7t5v0__fill_1
XFILLER_56_2 VDD VDD VSS VSS gf180mcu_fd_sc_mcu7t5v0__fill_1
XTAP_TAPCELL_ROW_97_1481 VDD VSS gf180mcu_fd_sc_mcu7t5v0__filltie
XTAP_TAPCELL_ROW_97_1470 VDD VSS gf180mcu_fd_sc_mcu7t5v0__filltie
XFILLER_142_754 VDD VDD VSS VSS gf180mcu_fd_sc_mcu7t5v0__fillcap_4
XFILLER_154_592 VDD VDD VSS VSS gf180mcu_fd_sc_mcu7t5v0__fill_2
Xwave_controller_x_inst__1920_ spi_regs_inst__1502_/Q wave_controller_x_inst__3564_/A1
+ wave_controller_x_inst__1920_/B wave_controller_x_inst__1923_/A1 VDD VDD VSS VSS
+ gf180mcu_fd_sc_mcu7t5v0__oai21_1
XFILLER_96_830 VDD VDD VSS VSS gf180mcu_fd_sc_mcu7t5v0__fill_1
Xsignal_processor_y_inst__236_ signal_processor_y_inst__236_/D _17_/B _21_/CLK signal_processor_y_inst__236_/Q
+ VDD VDD VSS VSS gf180mcu_fd_sc_mcu7t5v0__dffrnq_1
XFILLER_101_139 VDD VDD VSS VSS gf180mcu_fd_sc_mcu7t5v0__fill_1
XFILLER_68_543 VDD VDD VSS VSS gf180mcu_fd_sc_mcu7t5v0__fill_2
XTAP_TAPCELL_ROW_20_1_484 VDD VSS gf180mcu_fd_sc_mcu7t5v0__filltie
Xwave_controller_x_inst__1851_ wire462/I wave_controller_x_inst__2451_/A1 VDD VDD
+ VSS VSS gf180mcu_fd_sc_mcu7t5v0__clkinv_1
XFILLER_110_662 VDD VDD VSS VSS gf180mcu_fd_sc_mcu7t5v0__fill_2
XFILLER_110_684 VDD VDD VSS VSS gf180mcu_fd_sc_mcu7t5v0__fillcap_4
XFILLER_68_587 VDD VDD VSS VSS gf180mcu_fd_sc_mcu7t5v0__fillcap_8
XFILLER_96_885 VDD VDD VSS VSS gf180mcu_fd_sc_mcu7t5v0__fill_1
Xwave_controller_x_inst__1782_ spi_regs_inst__1513_/Q wave_controller_x_inst__1937_/A1
+ VDD VDD VSS VSS gf180mcu_fd_sc_mcu7t5v0__clkinv_1
Xsignal_processor_y_inst__167_ signal_processor_y_inst__233_/Q signal_processor_y_inst__167_/A2
+ signal_processor_y_inst__209_/A2 VDD VDD VSS VSS gf180mcu_fd_sc_mcu7t5v0__xnor2_1
Xwave_controller_x_inst__3521_ wave_controller_x_inst__3530_/A1 wave_controller_x_inst__3521_/A2
+ wave_controller_x_inst__3521_/A3 wave_controller_x_inst__3530_/B1 wave_controller_x_inst__3521_/B2
+ wave_controller_x_inst__3636_/D VDD VDD VSS VSS gf180mcu_fd_sc_mcu7t5v0__oai32_1
XFILLER_102_37 VDD VDD VSS VSS gf180mcu_fd_sc_mcu7t5v0__fillcap_16
XFILLER_36_451 VDD VDD VSS VSS gf180mcu_fd_sc_mcu7t5v0__fillcap_4
XPHY_EDGE_ROW_16_1_Left_183 VDD VSS gf180mcu_fd_sc_mcu7t5v0__endcap
Xwave_controller_x_inst__3452_ wave_controller_x_inst__3452_/A1 wave_controller_x_inst__3557_/B1
+ wave_controller_x_inst__3452_/B1 wave_controller_x_inst__3452_/B2 wave_controller_x_inst__3623_/D
+ VDD VDD VSS VSS gf180mcu_fd_sc_mcu7t5v0__oai22_1
XFILLER_23_101 VDD VDD VSS VSS gf180mcu_fd_sc_mcu7t5v0__fill_2
XFILLER_23_112 VDD VDD VSS VSS gf180mcu_fd_sc_mcu7t5v0__fillcap_8
XFILLER_36_473 VDD VDD VSS VSS gf180mcu_fd_sc_mcu7t5v0__fill_1
Xwave_controller_x_inst__2403_ fanout534/Z wave_controller_x_inst__2403_/A2 wave_controller_x_inst__2403_/A3
+ wave_controller_x_inst__2403_/Z VDD VDD VSS VSS gf180mcu_fd_sc_mcu7t5v0__xor3_1
XFILLER_51_432 VDD VDD VSS VSS gf180mcu_fd_sc_mcu7t5v0__fillcap_16
Xwave_controller_x_inst__3383_ fanout526/Z wave_controller_x_inst__3372_/Z wave_controller_x_inst__3383_/B1
+ wave_controller_x_inst__3383_/B2 wave_controller_x_inst__3383_/C wave_controller_x_inst__3385_/A1
+ VDD VDD VSS VSS gf180mcu_fd_sc_mcu7t5v0__aoi221_1
Xwave_controller_y_inst__2350_ spi_regs_inst__1278_/A1 wave_controller_y_inst__2831_/A1
+ wave_controller_y_inst_wire128/Z wave_controller_y_inst__2348_/Z wave_controller_y_inst__2350_/C
+ wave_controller_y_inst_wire120/I VDD VDD VSS VSS gf180mcu_fd_sc_mcu7t5v0__aoi221_1
Xwave_controller_x_inst__2334_ wave_controller_x_inst__2332_/Z wave_controller_x_inst__2336_/A3
+ wave_controller_x_inst__2334_/Z VDD VDD VSS VSS gf180mcu_fd_sc_mcu7t5v0__xor2_1
Xwave_controller_y_inst__2281_ wave_controller_y_inst__2346_/A1 wave_controller_y_inst__2280_/Z
+ wave_controller_y_inst__2296_/A2 VDD VDD VSS VSS gf180mcu_fd_sc_mcu7t5v0__nand2_1
Xwave_controller_x_inst__2265_ wave_controller_x_inst__2265_/A1 wave_controller_x_inst__2265_/A2
+ wave_controller_x_inst__2265_/B wave_controller_x_inst__2270_/A1 VDD VDD VSS VSS
+ gf180mcu_fd_sc_mcu7t5v0__oai21_1
XFILLER_109_206 VDD VDD VSS VSS gf180mcu_fd_sc_mcu7t5v0__fillcap_4
Xwave_controller_x_inst__2196_ wave_controller_x_inst__2192_/Z wave_controller_x_inst__2204_/A2
+ wave_controller_x_inst__2196_/Z VDD VDD VSS VSS gf180mcu_fd_sc_mcu7t5v0__xor2_1
XFILLER_118_762 VDD VDD VSS VSS gf180mcu_fd_sc_mcu7t5v0__fill_2
XFILLER_145_570 VDD VDD VSS VSS gf180mcu_fd_sc_mcu7t5v0__fillcap_4
Xwave_controller_y_inst_fanout414 wave_controller_y_inst__1806_/I wave_controller_y_inst__3089_/B
+ VDD VDD VSS VSS gf180mcu_fd_sc_mcu7t5v0__dlyb_1
XTAP_TAPCELL_ROW_148_2312 VDD VSS gf180mcu_fd_sc_mcu7t5v0__filltie
XTAP_TAPCELL_ROW_148_2323 VDD VSS gf180mcu_fd_sc_mcu7t5v0__filltie
XFILLER_143_44 VDD VDD VSS VSS gf180mcu_fd_sc_mcu7t5v0__fillcap_16
XFILLER_19_418 VDD VDD VSS VSS gf180mcu_fd_sc_mcu7t5v0__fill_2
XFILLER_74_524 VDD VDD VSS VSS gf180mcu_fd_sc_mcu7t5v0__fill_1
Xwave_controller_y_inst__1996_ fanout519/Z wave_controller_y_inst__2318_/A1 wave_controller_y_inst__1996_/A3
+ spi_regs_inst__1179_/B2 VDD VDD VSS VSS gf180mcu_fd_sc_mcu7t5v0__xor3_1
Xfanout397 fanout402/Z fanout397/Z VDD VDD VSS VSS gf180mcu_fd_sc_mcu7t5v0__dlyb_1
XTAP_TAPCELL_ROW_161_2534 VDD VSS gf180mcu_fd_sc_mcu7t5v0__filltie
Xwave_controller_y_inst__3735_ wave_controller_y_inst__3735_/D fanout547/Z clkload6/I
+ wave_controller_y_inst__3735_/Q VDD VDD VSS VSS gf180mcu_fd_sc_mcu7t5v0__dffrnq_1
Xwave_controller_x_inst__3719_ wave_controller_x_inst__3719_/D fanout598/Z clkbuf_leaf_19_clk/Z
+ wave_controller_x_inst__3719_/Q VDD VDD VSS VSS gf180mcu_fd_sc_mcu7t5v0__dffrnq_1
XFILLER_46_259 VDD VDD VSS VSS gf180mcu_fd_sc_mcu7t5v0__fill_2
XFILLER_55_760 VDD VDD VSS VSS gf180mcu_fd_sc_mcu7t5v0__fill_1
XTAP_TAPCELL_ROW_126_1953 VDD VSS gf180mcu_fd_sc_mcu7t5v0__filltie
XTAP_TAPCELL_ROW_126_1964 VDD VSS gf180mcu_fd_sc_mcu7t5v0__filltie
Xwave_controller_y_inst__3666_ wave_controller_y_inst__3666_/D wave_controller_y_inst__3689_/RN
+ clkbuf_leaf_9_clk/Z spi_regs_inst__1078_/A1 VDD VDD VSS VSS gf180mcu_fd_sc_mcu7t5v0__dffrnq_1
XFILLER_160_2 VDD VDD VSS VSS gf180mcu_fd_sc_mcu7t5v0__fillcap_32
XFILLER_54_281 VDD VDD VSS VSS gf180mcu_fd_sc_mcu7t5v0__fillcap_8
Xwave_controller_y_inst__2617_ wave_controller_y_inst__2580_/Z wave_controller_y_inst__2595_/Z
+ wave_controller_y_inst__2617_/Z VDD VDD VSS VSS gf180mcu_fd_sc_mcu7t5v0__and2_1
Xspi_regs_inst_max_cap246 spi_regs_inst__1203_/A2 spi_regs_inst__1251_/B1 VDD VDD
+ VSS VSS gf180mcu_fd_sc_mcu7t5v0__buf_2
Xspi_regs_inst_max_cap235 spi_regs_inst__1333_/B1 spi_regs_inst__1232_/B1 VDD VDD
+ VSS VSS gf180mcu_fd_sc_mcu7t5v0__buf_2
Xspi_regs_inst_max_cap224 spi_regs_inst__1036_/B1 spi_regs_inst__1346_/B1 VDD VDD
+ VSS VSS gf180mcu_fd_sc_mcu7t5v0__buf_2
Xspi_regs_inst_max_cap213 spi_regs_inst__1132_/B1 spi_regs_inst__1306_/B1 VDD VDD
+ VSS VSS gf180mcu_fd_sc_mcu7t5v0__buf_2
XFILLER_42_454 VDD VDD VSS VSS gf180mcu_fd_sc_mcu7t5v0__fill_1
Xwave_controller_y_inst__3597_ wave_controller_y_inst__3597_/I0 max_cap423/Z wave_controller_y_inst__3597_/S
+ wave_controller_y_inst__3673_/D VDD VDD VSS VSS gf180mcu_fd_sc_mcu7t5v0__mux2_2
Xspi_regs_inst_max_cap279 spi_regs_inst__1336_/A2 spi_regs_inst__1306_/A2 VDD VDD
+ VSS VSS gf180mcu_fd_sc_mcu7t5v0__buf_2
Xspi_regs_inst_max_cap268 spi_regs_inst_wire269/Z spi_regs_inst__1348_/B1 VDD VDD
+ VSS VSS gf180mcu_fd_sc_mcu7t5v0__buf_2
Xspi_regs_inst_max_cap257 spi_regs_inst__1200_/A2 spi_regs_inst__1309_/A2 VDD VDD
+ VSS VSS gf180mcu_fd_sc_mcu7t5v0__buf_2
XFILLER_42_465 VDD VDD VSS VSS gf180mcu_fd_sc_mcu7t5v0__fill_1
XFILLER_52_41 VDD VDD VSS VSS gf180mcu_fd_sc_mcu7t5v0__fill_1
Xwave_controller_y_inst__2548_ wave_controller_y_inst__2561_/A1 wave_controller_y_inst__2561_/A2
+ wave_controller_y_inst__2562_/A1 VDD VDD VSS VSS gf180mcu_fd_sc_mcu7t5v0__nor2_1
Xsignal_processor_x_inst__256_ signal_processor_x_inst__256_/D fanout595/Z clkbuf_leaf_19_clk/Z
+ signal_processor_x_inst__256_/Q VDD VDD VSS VSS gf180mcu_fd_sc_mcu7t5v0__dffrnq_1
XFILLER_74_1081 VDD VDD VSS VSS gf180mcu_fd_sc_mcu7t5v0__fillcap_4
XTAP_TAPCELL_ROW_159_2496 VDD VSS gf180mcu_fd_sc_mcu7t5v0__filltie
Xwave_controller_y_inst__2479_ wave_controller_y_inst__2479_/I wave_controller_y_inst__2483_/A2
+ VDD VDD VSS VSS gf180mcu_fd_sc_mcu7t5v0__clkinv_1
XFILLER_155_301 VDD VDD VSS VSS gf180mcu_fd_sc_mcu7t5v0__fillcap_4
XFILLER_167_172 VDD VDD VSS VSS gf180mcu_fd_sc_mcu7t5v0__fillcap_32
XFILLER_6_311 VDD VDD VSS VSS gf180mcu_fd_sc_mcu7t5v0__fillcap_4
Xsignal_processor_x_inst__187_ signal_processor_x_inst__187_/A1 signal_processor_x_inst__187_/A2
+ signal_processor_x_inst__187_/B signal_processor_x_inst__190_/A2 VDD VDD VSS VSS
+ gf180mcu_fd_sc_mcu7t5v0__oai21_1
XFILLER_10_373 VDD VDD VSS VSS gf180mcu_fd_sc_mcu7t5v0__fill_2
XFILLER_10_384 VDD VDD VSS VSS gf180mcu_fd_sc_mcu7t5v0__fill_1
Xspi_regs_inst__1140_ spi_regs_inst__1496_/Q spi_regs_inst__1195_/A2 spi_regs_inst__1250_/B1
+ spi_regs_inst__1140_/B2 spi_regs_inst__1142_/A3 VDD VDD VSS VSS gf180mcu_fd_sc_mcu7t5v0__aoi22_1
XFILLER_115_209 VDD VDD VSS VSS gf180mcu_fd_sc_mcu7t5v0__fill_1
XFILLER_136_592 VDD VDD VSS VSS gf180mcu_fd_sc_mcu7t5v0__fill_2
Xspi_regs_inst__1071_ spi_regs_inst__1071_/A1 spi_regs_inst__1071_/A2 spi_regs_inst__1071_/A3
+ spi_regs_inst__1071_/A4 spi_regs_inst__1071_/Z VDD VDD VSS VSS gf180mcu_fd_sc_mcu7t5v0__or4_1
XFILLER_123_231 VDD VDD VSS VSS gf180mcu_fd_sc_mcu7t5v0__fillcap_16
XFILLER_151_562 VDD VDD VSS VSS gf180mcu_fd_sc_mcu7t5v0__fill_2
XFILLER_111_426 VDD VDD VSS VSS gf180mcu_fd_sc_mcu7t5v0__fill_2
XFILLER_123_286 VDD VDD VSS VSS gf180mcu_fd_sc_mcu7t5v0__fill_1
XFILLER_97_638 VDD VDD VSS VSS gf180mcu_fd_sc_mcu7t5v0__fillcap_4
XFILLER_81_1052 VDD VDD VSS VSS gf180mcu_fd_sc_mcu7t5v0__fillcap_64
XFILLER_96_159 VDD VDD VSS VSS gf180mcu_fd_sc_mcu7t5v0__fillcap_16
XFILLER_78_896 VDD VDD VSS VSS gf180mcu_fd_sc_mcu7t5v0__fill_2
XTAP_TAPCELL_ROW_49_1_697 VDD VSS gf180mcu_fd_sc_mcu7t5v0__filltie
XFILLER_92_321 VDD VDD VSS VSS gf180mcu_fd_sc_mcu7t5v0__fill_1
XFILLER_93_866 VDD VDD VSS VSS gf180mcu_fd_sc_mcu7t5v0__fillcap_4
Xspi_regs_inst__0924_ spi_regs_inst__0926_/B1 spi_regs_inst__0924_/A2 spi_regs_inst__0924_/B
+ spi_regs_inst__1632_/D VDD VDD VSS VSS gf180mcu_fd_sc_mcu7t5v0__oai21_1
XFILLER_52_207 VDD VDD VSS VSS gf180mcu_fd_sc_mcu7t5v0__fillcap_4
Xspi_regs_inst__0855_ spi_regs_inst__1592_/Q spi_regs_inst__1439_/I1 spi_regs_inst__0857_/S
+ spi_regs_inst__1592_/D VDD VDD VSS VSS gf180mcu_fd_sc_mcu7t5v0__mux2_2
XFILLER_18_473 VDD VDD VSS VSS gf180mcu_fd_sc_mcu7t5v0__fillcap_8
XFILLER_80_527 VDD VDD VSS VSS gf180mcu_fd_sc_mcu7t5v0__fillcap_32
XFILLER_92_387 VDD VDD VSS VSS gf180mcu_fd_sc_mcu7t5v0__fill_2
XFILLER_33_454 VDD VDD VSS VSS gf180mcu_fd_sc_mcu7t5v0__fillcap_8
XFILLER_61_763 VDD VDD VSS VSS gf180mcu_fd_sc_mcu7t5v0__fillcap_4
Xspi_regs_inst__0786_ spi_regs_inst_wire480/I spi_regs_inst__1539_/Q spi_regs_inst__0787_/S
+ spi_regs_inst__1539_/D VDD VDD VSS VSS gf180mcu_fd_sc_mcu7t5v0__mux2_2
XTAP_TAPCELL_ROW_99_1510 VDD VSS gf180mcu_fd_sc_mcu7t5v0__filltie
Xspi_regs_inst__1407_ fanout517/Z spi_regs_inst__1407_/I1 spi_regs_inst__1410_/S spi_regs_inst__1480_/D
+ VDD VDD VSS VSS gf180mcu_fd_sc_mcu7t5v0__mux2_2
XFILLER_140_1157 VDD VDD VSS VSS gf180mcu_fd_sc_mcu7t5v0__fillcap_16
Xwave_controller_x_inst__2050_ wave_controller_x_inst__2050_/A1 wave_controller_x_inst__2080_/B
+ wave_controller_x_inst__2049_/Z wave_controller_x_inst__2125_/C wave_controller_x_inst__2062_/B2
+ VDD VDD VSS VSS gf180mcu_fd_sc_mcu7t5v0__aoi22_1
Xspi_regs_inst__1338_ spi_regs_inst__1338_/A1 spi_regs_inst__1338_/A2 spi_regs_inst__1338_/A3
+ spi_regs_inst__1338_/A4 spi_regs_inst__1359_/A1 VDD VDD VSS VSS gf180mcu_fd_sc_mcu7t5v0__nand4_1
Xspi_regs_inst_wire302 spi_regs_inst__0877_/S spi_regs_inst__0875_/S VDD VDD VSS VSS
+ gf180mcu_fd_sc_mcu7t5v0__buf_2
Xspi_regs_inst__1269_ spi_regs_inst_wire28/Z spi_regs_inst__1309_/A2 spi_regs_inst__1346_/B1
+ spi_regs_inst_wire37/Z spi_regs_inst__1287_/A1 VDD VDD VSS VSS gf180mcu_fd_sc_mcu7t5v0__aoi22_1
XFILLER_115_776 VDD VDD VSS VSS gf180mcu_fd_sc_mcu7t5v0__fillcap_4
XFILLER_115_787 VDD VDD VSS VSS gf180mcu_fd_sc_mcu7t5v0__fill_1
Xspi_regs_inst_wire346 spi_regs_inst_wire346/I spi_regs_inst__0937_/S VDD VDD VSS
+ VSS gf180mcu_fd_sc_mcu7t5v0__buf_1
Xspi_regs_inst_wire335 spi_regs_inst__1184_/B spi_regs_inst__1357_/B VDD VDD VSS VSS
+ gf180mcu_fd_sc_mcu7t5v0__clkbuf_4
XFILLER_87_104 VDD VDD VSS VSS gf180mcu_fd_sc_mcu7t5v0__fillcap_8
Xwave_controller_x_inst__2952_ wave_controller_x_inst__3570_/A1 wave_controller_x_inst__2952_/A2
+ wave_controller_x_inst__3055_/A2 VDD VDD VSS VSS gf180mcu_fd_sc_mcu7t5v0__nand2_1
XFILLER_87_137 VDD VDD VSS VSS gf180mcu_fd_sc_mcu7t5v0__fill_2
Xwave_controller_x_inst__2883_ wave_controller_x_inst__3699_/Q wave_controller_x_inst__3492_/A1
+ wave_controller_x_inst__2883_/A3 wave_controller_x_inst__2886_/B VDD VDD VSS VSS
+ gf180mcu_fd_sc_mcu7t5v0__xor3_1
Xwave_controller_x_inst__1903_ spi_regs_inst__1050_/B2 wave_controller_x_inst__3423_/A1
+ VDD VDD VSS VSS gf180mcu_fd_sc_mcu7t5v0__clkinv_1
XFILLER_111_982 VDD VDD VSS VSS gf180mcu_fd_sc_mcu7t5v0__fillcap_64
XFILLER_68_362 VDD VDD VSS VSS gf180mcu_fd_sc_mcu7t5v0__fillcap_4
XFILLER_69_885 VDD VDD VSS VSS gf180mcu_fd_sc_mcu7t5v0__fillcap_4
XFILLER_84_822 VDD VDD VSS VSS gf180mcu_fd_sc_mcu7t5v0__fillcap_4
Xwave_controller_y_inst__1850_ max_cap429/I wave_controller_y_inst__2193_/A2 VDD VDD
+ VSS VSS gf180mcu_fd_sc_mcu7t5v0__clkinv_1
Xwave_controller_x_inst__1834_ spi_regs_inst__1520_/Q wave_controller_x_inst__3231_/A2
+ VDD VDD VSS VSS gf180mcu_fd_sc_mcu7t5v0__clkinv_1
Xsignal_processor_y_inst__219_ signal_processor_y_inst__219_/D _17_/B _21_/CLK spi_regs_inst__1131_/A1
+ VDD VDD VSS VSS gf180mcu_fd_sc_mcu7t5v0__dffrnq_1
XFILLER_68_395 VDD VDD VSS VSS gf180mcu_fd_sc_mcu7t5v0__fillcap_4
XFILLER_84_855 VDD VDD VSS VSS gf180mcu_fd_sc_mcu7t5v0__fillcap_16
XTAP_TAPCELL_ROW_143_2231 VDD VSS gf180mcu_fd_sc_mcu7t5v0__filltie
XTAP_TAPCELL_ROW_143_2242 VDD VSS gf180mcu_fd_sc_mcu7t5v0__filltie
XTAP_TAPCELL_ROW_51_1_712 VDD VSS gf180mcu_fd_sc_mcu7t5v0__filltie
Xwave_controller_y_inst__1781_ wave_controller_y_inst__1781_/I wave_controller_y_inst__3080_/A1
+ VDD VDD VSS VSS gf180mcu_fd_sc_mcu7t5v0__clkinv_1
XFILLER_113_58 VDD VDD VSS VSS gf180mcu_fd_sc_mcu7t5v0__fillcap_4
XFILLER_56_579 VDD VDD VSS VSS gf180mcu_fd_sc_mcu7t5v0__fill_2
XFILLER_83_365 VDD VDD VSS VSS gf180mcu_fd_sc_mcu7t5v0__fillcap_16
XFILLER_84_877 VDD VDD VSS VSS gf180mcu_fd_sc_mcu7t5v0__fillcap_64
Xwave_controller_y_inst__3520_ spi_regs_inst__1045_/B2 wave_controller_y_inst__3520_/A2
+ wave_controller_y_inst__3521_/A3 VDD VDD VSS VSS gf180mcu_fd_sc_mcu7t5v0__nor2_1
XFILLER_43_218 VDD VDD VSS VSS gf180mcu_fd_sc_mcu7t5v0__fill_1
XFILLER_83_398 VDD VDD VSS VSS gf180mcu_fd_sc_mcu7t5v0__fillcap_4
XTAP_TAPCELL_ROW_108_1661 VDD VSS gf180mcu_fd_sc_mcu7t5v0__filltie
Xwave_controller_x_inst_max_cap327 wave_controller_x_inst__2892_/Z wave_controller_x_inst__2896_/B
+ VDD VDD VSS VSS gf180mcu_fd_sc_mcu7t5v0__buf_2
Xwave_controller_x_inst__3504_ wave_controller_x_inst__3704_/Q wave_controller_x_inst__3537_/A2
+ wave_controller_x_inst__3506_/A2 VDD VDD VSS VSS gf180mcu_fd_sc_mcu7t5v0__nor2_1
XTAP_TAPCELL_ROW_54_769 VDD VSS gf180mcu_fd_sc_mcu7t5v0__filltie
Xwave_controller_y_inst__3451_ wave_controller_y_inst__3465_/B wave_controller_y_inst__3451_/A2
+ wave_controller_y_inst__3491_/B wave_controller_y_inst__3452_/B2 VDD VDD VSS VSS
+ gf180mcu_fd_sc_mcu7t5v0__oai21_1
Xwave_controller_x_inst__3435_ spi_regs_inst__1134_/A1 wave_controller_x_inst__3454_/A2
+ wave_controller_x_inst__3436_/A3 VDD VDD VSS VSS gf180mcu_fd_sc_mcu7t5v0__nor2_1
XFILLER_11_104 VDD VDD VSS VSS gf180mcu_fd_sc_mcu7t5v0__fillcap_8
XFILLER_145_1046 VDD VDD VSS VSS gf180mcu_fd_sc_mcu7t5v0__fillcap_4
XFILLER_58_1087 VDD VDD VSS VSS gf180mcu_fd_sc_mcu7t5v0__fillcap_64
Xwave_controller_y_inst__2402_ wave_controller_y_inst__2403_/A2 wave_controller_y_inst__2403_/A3
+ wave_controller_y_inst__2402_/Z VDD VDD VSS VSS gf180mcu_fd_sc_mcu7t5v0__xor2_1
Xwave_controller_y_inst__3382_ wave_controller_y_inst__3382_/A1 wave_controller_y_inst__3382_/A2
+ wave_controller_y_inst__3382_/A3 wave_controller_y_inst__3382_/B wave_controller_y_inst__3383_/B2
+ VDD VDD VSS VSS gf180mcu_fd_sc_mcu7t5v0__oai31_1
Xwave_controller_x_inst__3366_ wave_controller_x_inst__3387_/A1 wave_controller_x_inst__3365_/Z
+ wave_controller_x_inst__3386_/C VDD VDD VSS VSS gf180mcu_fd_sc_mcu7t5v0__nand2_1
Xsignal_processor_x_inst__110_ signal_processor_x_inst__229_/Q signal_processor_x_inst__161_/A2
+ VDD VDD VSS VSS gf180mcu_fd_sc_mcu7t5v0__clkinv_1
XTAP_TAPCELL_ROW_121_1872 VDD VSS gf180mcu_fd_sc_mcu7t5v0__filltie
Xwave_controller_y_inst__2333_ wave_controller_y_inst_wire128/Z wave_controller_y_inst__2322_/Z
+ wave_controller_y_inst__2333_/B wave_controller_y_inst__2336_/A3 VDD VDD VSS VSS
+ gf180mcu_fd_sc_mcu7t5v0__aoi21_1
Xwave_controller_x_inst__2317_ wave_controller_x_inst__2288_/B wave_controller_x_inst__2320_/A3
+ wave_controller_x_inst__2319_/C VDD VDD VSS VSS gf180mcu_fd_sc_mcu7t5v0__nor2_1
XFILLER_137_312 VDD VDD VSS VSS gf180mcu_fd_sc_mcu7t5v0__fillcap_16
XTAP_TAPCELL_ROW_7_1_381 VDD VSS gf180mcu_fd_sc_mcu7t5v0__filltie
Xwave_controller_x_inst__3297_ wave_controller_x_inst__3303_/A1 wave_controller_x_inst__3303_/A2
+ wave_controller_x_inst__3297_/Z VDD VDD VSS VSS gf180mcu_fd_sc_mcu7t5v0__and2_1
XFILLER_137_356 VDD VDD VSS VSS gf180mcu_fd_sc_mcu7t5v0__fill_1
XFILLER_138_868 VDD VDD VSS VSS gf180mcu_fd_sc_mcu7t5v0__fillcap_4
XFILLER_165_632 VDD VDD VSS VSS gf180mcu_fd_sc_mcu7t5v0__fillcap_64
Xwave_controller_y_inst__2264_ spi_regs_inst__1353_/A1 wave_controller_y_inst__2262_/Z
+ wave_controller_y_inst__2265_/B VDD VDD VSS VSS gf180mcu_fd_sc_mcu7t5v0__xor2_1
Xwave_controller_x_inst__2248_ wave_controller_x_inst__2248_/A1 wave_controller_x_inst__2248_/A2
+ wave_controller_x_inst__2212_/Z wave_controller_x_inst_wire118/Z wave_controller_x_inst__2248_/C1
+ wave_controller_x_inst__2229_/Z wave_controller_x_inst__2250_/A2 VDD VDD VSS VSS
+ gf180mcu_fd_sc_mcu7t5v0__oai222_1
XFILLER_137_378 VDD VDD VSS VSS gf180mcu_fd_sc_mcu7t5v0__fill_1
XFILLER_138_77 VDD VDD VSS VSS gf180mcu_fd_sc_mcu7t5v0__fillcap_16
XFILLER_153_838 VDD VDD VSS VSS gf180mcu_fd_sc_mcu7t5v0__fill_2
Xwave_controller_y_inst__2195_ wave_controller_y_inst__2221_/A1 wave_controller_y_inst__2194_/I
+ wave_controller_y_inst__2221_/C wave_controller_y_inst__2204_/A2 VDD VDD VSS VSS
+ gf180mcu_fd_sc_mcu7t5v0__aoi21_1
Xwave_controller_x_inst__2179_ wave_controller_x_inst__2181_/A2 wave_controller_x_inst__2178_/Z
+ wave_controller_x_inst__2180_/A2 VDD VDD VSS VSS gf180mcu_fd_sc_mcu7t5v0__xnor2_1
XFILLER_121_702 VDD VDD VSS VSS gf180mcu_fd_sc_mcu7t5v0__fillcap_16
XFILLER_133_562 VDD VDD VSS VSS gf180mcu_fd_sc_mcu7t5v0__fillcap_4
XFILLER_79_605 VDD VDD VSS VSS gf180mcu_fd_sc_mcu7t5v0__fillcap_4
XFILLER_152_1017 VDD VDD VSS VSS gf180mcu_fd_sc_mcu7t5v0__fillcap_64
XFILLER_154_32 VDD VDD VSS VSS gf180mcu_fd_sc_mcu7t5v0__fill_2
XFILLER_78_104 VDD VDD VSS VSS gf180mcu_fd_sc_mcu7t5v0__fill_1
XFILLER_78_115 VDD VDD VSS VSS gf180mcu_fd_sc_mcu7t5v0__fill_1
XFILLER_101_492 VDD VDD VSS VSS gf180mcu_fd_sc_mcu7t5v0__fillcap_32
XFILLER_47_52 VDD VDD VSS VSS gf180mcu_fd_sc_mcu7t5v0__fillcap_4
XFILLER_74_332 VDD VDD VSS VSS gf180mcu_fd_sc_mcu7t5v0__fillcap_4
XFILLER_47_96 VDD VDD VSS VSS gf180mcu_fd_sc_mcu7t5v0__fill_2
XFILLER_62_516 VDD VDD VSS VSS gf180mcu_fd_sc_mcu7t5v0__fillcap_8
XTAP_TAPCELL_ROW_45_1_670 VDD VSS gf180mcu_fd_sc_mcu7t5v0__filltie
Xwave_controller_y_inst__3718_ wave_controller_y_inst__3718_/D fanout545/Z clkload2/I
+ wave_controller_y_inst__3718_/Q VDD VDD VSS VSS gf180mcu_fd_sc_mcu7t5v0__dffrnq_1
Xwave_controller_y_inst__1979_ wave_controller_y_inst__2952_/A2 spi_regs_inst__1033_/C2
+ wave_controller_y_inst__1986_/B VDD VDD VSS VSS gf180mcu_fd_sc_mcu7t5v0__nand2_1
XFILLER_62_527 VDD VDD VSS VSS gf180mcu_fd_sc_mcu7t5v0__fillcap_4
XFILLER_62_538 VDD VDD VSS VSS gf180mcu_fd_sc_mcu7t5v0__fill_1
XFILLER_74_376 VDD VDD VSS VSS gf180mcu_fd_sc_mcu7t5v0__fillcap_8
XFILLER_74_387 VDD VDD VSS VSS gf180mcu_fd_sc_mcu7t5v0__fillcap_16
XFILLER_103_91 VDD VDD VSS VSS gf180mcu_fd_sc_mcu7t5v0__fillcap_32
Xwave_controller_y_inst__3649_ wave_controller_y_inst__3649_/D fanout615/Z clkbuf_leaf_35_clk/Z
+ spi_regs_inst__0967_/A1 VDD VDD VSS VSS gf180mcu_fd_sc_mcu7t5v0__dffrnq_1
XFILLER_15_487 VDD VDD VSS VSS gf180mcu_fd_sc_mcu7t5v0__fill_2
XFILLER_70_560 VDD VDD VSS VSS gf180mcu_fd_sc_mcu7t5v0__fillcap_4
XTAP_TAPCELL_ROW_11_1_415 VDD VSS gf180mcu_fd_sc_mcu7t5v0__filltie
XFILLER_156_621 VDD VDD VSS VSS gf180mcu_fd_sc_mcu7t5v0__fillcap_16
XFILLER_30_457 VDD VDD VSS VSS gf180mcu_fd_sc_mcu7t5v0__fillcap_4
Xsignal_processor_x_inst__239_ signal_processor_x_inst__239_/D fanout587/Z clkload23/I
+ signal_processor_x_inst__239_/Q VDD VDD VSS VSS gf180mcu_fd_sc_mcu7t5v0__dffrnq_1
XFILLER_10_170 VDD VDD VSS VSS gf180mcu_fd_sc_mcu7t5v0__fillcap_4
XFILLER_155_142 VDD VDD VSS VSS gf180mcu_fd_sc_mcu7t5v0__fillcap_16
XFILLER_155_164 VDD VDD VSS VSS gf180mcu_fd_sc_mcu7t5v0__fill_1
XFILLER_155_175 VDD VDD VSS VSS gf180mcu_fd_sc_mcu7t5v0__fill_1
XTAP_TAPCELL_ROW_77_1148 VDD VSS gf180mcu_fd_sc_mcu7t5v0__filltie
Xspi_regs_inst__1123_ spi_regs_inst__1123_/A1 spi_regs_inst__1123_/A2 spi_regs_inst__1123_/A3
+ spi_regs_inst__1123_/A4 spi_regs_inst__1124_/A3 VDD VDD VSS VSS gf180mcu_fd_sc_mcu7t5v0__nor4_1
XFILLER_152_871 VDD VDD VSS VSS gf180mcu_fd_sc_mcu7t5v0__fillcap_4
Xspi_regs_inst__1054_ spi_regs_inst__1549_/Q spi_regs_inst__1304_/A2 spi_regs_inst_wire284/I
+ spi_regs_inst__1054_/B2 spi_regs_inst__1057_/A2 VDD VDD VSS VSS gf180mcu_fd_sc_mcu7t5v0__aoi22_1
XFILLER_111_212 VDD VDD VSS VSS gf180mcu_fd_sc_mcu7t5v0__fillcap_4
XFILLER_98_947 VDD VDD VSS VSS gf180mcu_fd_sc_mcu7t5v0__fillcap_64
XTAP_TAPCELL_ROW_90_1359 VDD VSS gf180mcu_fd_sc_mcu7t5v0__filltie
XFILLER_111_267 VDD VDD VSS VSS gf180mcu_fd_sc_mcu7t5v0__fillcap_8
XFILLER_112_779 VDD VDD VSS VSS gf180mcu_fd_sc_mcu7t5v0__fillcap_4
XFILLER_38_513 VDD VDD VSS VSS gf180mcu_fd_sc_mcu7t5v0__fillcap_4
XFILLER_66_800 VDD VDD VSS VSS gf180mcu_fd_sc_mcu7t5v0__fillcap_4
XFILLER_19_2 VDD VDD VSS VSS gf180mcu_fd_sc_mcu7t5v0__fillcap_64
XFILLER_66_844 VDD VDD VSS VSS gf180mcu_fd_sc_mcu7t5v0__fill_1
XFILLER_66_877 VDD VDD VSS VSS gf180mcu_fd_sc_mcu7t5v0__fillcap_16
Xspi_regs_inst__0907_ spi_regs_inst__0907_/I spi_regs_inst__1629_/D VDD VDD VSS VSS
+ gf180mcu_fd_sc_mcu7t5v0__clkinv_1
X_16_ _17_/B _16_/A2 _21_/D VDD VDD VSS VSS gf180mcu_fd_sc_mcu7t5v0__and2_1
XFILLER_65_398 VDD VDD VSS VSS gf180mcu_fd_sc_mcu7t5v0__fill_2
XFILLER_92_173 VDD VDD VSS VSS gf180mcu_fd_sc_mcu7t5v0__fill_2
XFILLER_80_335 VDD VDD VSS VSS gf180mcu_fd_sc_mcu7t5v0__fillcap_16
XFILLER_80_357 VDD VDD VSS VSS gf180mcu_fd_sc_mcu7t5v0__fill_1
XFILLER_92_195 VDD VDD VSS VSS gf180mcu_fd_sc_mcu7t5v0__fill_1
Xspi_regs_inst__0838_ spi_regs_inst__1579_/Q spi_regs_inst__1378_/I1 spi_regs_inst__0838_/S
+ spi_regs_inst__1579_/D VDD VDD VSS VSS gf180mcu_fd_sc_mcu7t5v0__mux2_2
Xwave_controller_x_inst__3220_ wave_controller_x_inst__3236_/B wave_controller_x_inst__3236_/A1
+ wave_controller_x_inst__3236_/A2 wave_controller_x_inst__3237_/A1 VDD VDD VSS VSS
+ gf180mcu_fd_sc_mcu7t5v0__nor3_1
Xspi_regs_inst__0769_ spi_regs_inst__0816_/A1 spi_regs_inst__1651_/Q spi_regs_inst__0842_/A1
+ VDD VDD VSS VSS gf180mcu_fd_sc_mcu7t5v0__nor2_1
XTAP_TAPCELL_ROW_103_1580 VDD VSS gf180mcu_fd_sc_mcu7t5v0__filltie
XFILLER_21_468 VDD VDD VSS VSS gf180mcu_fd_sc_mcu7t5v0__fillcap_16
Xwave_controller_x_inst__3151_ wave_controller_x_inst__3211_/A1 wave_controller_x_inst__3211_/A2
+ wave_controller_x_inst__3211_/B wave_controller_x_inst__3151_/Z VDD VDD VSS VSS
+ gf180mcu_fd_sc_mcu7t5v0__and3_1
XFILLER_105_1052 VDD VDD VSS VSS gf180mcu_fd_sc_mcu7t5v0__fillcap_64
XFILLER_147_632 VDD VDD VSS VSS gf180mcu_fd_sc_mcu7t5v0__fill_2
XFILLER_159_492 VDD VDD VSS VSS gf180mcu_fd_sc_mcu7t5v0__fill_1
Xwave_controller_x_inst__3082_ wave_controller_x_inst__3091_/A1 wave_controller_x_inst__3082_/A2
+ wave_controller_x_inst__3082_/B wave_controller_x_inst__3083_/A2 VDD VDD VSS VSS
+ gf180mcu_fd_sc_mcu7t5v0__aoi21_1
Xwave_controller_x_inst__2102_ wave_controller_x_inst__2102_/I wave_controller_x_inst__2106_/A2
+ VDD VDD VSS VSS gf180mcu_fd_sc_mcu7t5v0__clkinv_1
Xwave_controller_x_inst__2033_ wave_controller_x_inst__1785_/I wave_controller_x_inst__3089_/B
+ wave_controller_x_inst__2033_/Z VDD VDD VSS VSS gf180mcu_fd_sc_mcu7t5v0__xor2_1
XFILLER_103_702 VDD VDD VSS VSS gf180mcu_fd_sc_mcu7t5v0__fill_2
Xspi_regs_inst_wire132 spi_regs_inst_wire132/I spi_regs_inst_wire132/Z VDD VDD VSS
+ VSS gf180mcu_fd_sc_mcu7t5v0__clkbuf_2
XFILLER_115_562 VDD VDD VSS VSS gf180mcu_fd_sc_mcu7t5v0__fillcap_8
XFILLER_103_746 VDD VDD VSS VSS gf180mcu_fd_sc_mcu7t5v0__fill_1
XFILLER_130_532 VDD VDD VSS VSS gf180mcu_fd_sc_mcu7t5v0__fillcap_8
XFILLER_88_435 VDD VDD VSS VSS gf180mcu_fd_sc_mcu7t5v0__fill_1
Xwave_controller_y_inst__2951_ wave_controller_y_inst__2951_/I wave_controller_y_inst__2974_/B
+ VDD VDD VSS VSS gf180mcu_fd_sc_mcu7t5v0__clkinv_1
Xwave_controller_x_inst__2935_ wave_controller_x_inst__3738_/Q wave_controller_x_inst__2935_/A2
+ wave_controller_x_inst__3591_/S wave_controller_x_inst__2936_/B1 VDD VDD VSS VSS
+ gf180mcu_fd_sc_mcu7t5v0__nor3_1
Xspi_regs_inst_wire198 spi_regs_inst__0767_/S spi_regs_inst__0766_/S VDD VDD VSS VSS
+ gf180mcu_fd_sc_mcu7t5v0__buf_4
Xwave_controller_y_inst__2882_ wave_controller_y_inst__2882_/A1 wave_controller_y_inst__2861_/Z
+ wave_controller_y_inst__2886_/C VDD VDD VSS VSS gf180mcu_fd_sc_mcu7t5v0__xor2_1
Xwave_controller_y_inst__1902_ wave_controller_y_inst__1902_/I wave_controller_y_inst__2902_/B2
+ VDD VDD VSS VSS gf180mcu_fd_sc_mcu7t5v0__clkinv_1
XFILLER_29_546 VDD VDD VSS VSS gf180mcu_fd_sc_mcu7t5v0__fillcap_8
Xwave_controller_y_inst__1833_ spi_regs_inst__1587_/Q wave_controller_y_inst__3143_/A2
+ VDD VDD VSS VSS gf180mcu_fd_sc_mcu7t5v0__clkinv_1
Xwave_controller_x_inst__2866_ wave_controller_x_inst__3440_/A1 spi_regs_inst__1134_/A1
+ wave_controller_x_inst__2884_/A2 VDD VDD VSS VSS gf180mcu_fd_sc_mcu7t5v0__nand2_1
XFILLER_72_803 VDD VDD VSS VSS gf180mcu_fd_sc_mcu7t5v0__fill_2
XFILLER_84_663 VDD VDD VSS VSS gf180mcu_fd_sc_mcu7t5v0__fill_2
XFILLER_99_1154 VDD VDD VSS VSS gf180mcu_fd_sc_mcu7t5v0__fillcap_16
Xwave_controller_x_inst__2797_ wave_controller_x_inst__3279_/A1 wave_controller_x_inst__2795_/Z
+ wave_controller_x_inst__2797_/B wave_controller_x_inst__2797_/C wave_controller_x_inst__2802_/A1
+ VDD VDD VSS VSS gf180mcu_fd_sc_mcu7t5v0__oai211_1
Xwave_controller_x_inst__1817_ fanout535/Z wave_controller_x_inst__3245_/A1 VDD VDD
+ VSS VSS gf180mcu_fd_sc_mcu7t5v0__clkinv_1
XFILLER_140_34 VDD VDD VSS VSS gf180mcu_fd_sc_mcu7t5v0__fill_1
XFILLER_44_527 VDD VDD VSS VSS gf180mcu_fd_sc_mcu7t5v0__fill_2
XFILLER_56_387 VDD VDD VSS VSS gf180mcu_fd_sc_mcu7t5v0__fillcap_16
XFILLER_83_162 VDD VDD VSS VSS gf180mcu_fd_sc_mcu7t5v0__fill_1
XPHY_EDGE_ROW_162_Right_162 VDD VSS gf180mcu_fd_sc_mcu7t5v0__endcap
XTAP_TAPCELL_ROW_123_1901 VDD VSS gf180mcu_fd_sc_mcu7t5v0__filltie
XTAP_TAPCELL_ROW_123_1912 VDD VSS gf180mcu_fd_sc_mcu7t5v0__filltie
XFILLER_17_66 VDD VDD VSS VSS gf180mcu_fd_sc_mcu7t5v0__fillcap_4
Xwave_controller_y_inst__3503_ wave_controller_y_inst_wire144/Z wave_controller_y_inst__3503_/A2
+ wave_controller_y_inst__3503_/A3 wave_controller_y_inst_wire139/Z wave_controller_y_inst__3503_/B2
+ wave_controller_y_inst__3630_/D VDD VDD VSS VSS gf180mcu_fd_sc_mcu7t5v0__oai32_1
Xwave_controller_y_inst__3434_ wave_controller_y_inst__3694_/Q wave_controller_y_inst__3483_/A2
+ wave_controller_y_inst__3436_/A2 VDD VDD VSS VSS gf180mcu_fd_sc_mcu7t5v0__nor2_1
Xwave_controller_x_inst_max_cap168 wave_controller_x_inst_wire169/Z wave_controller_x_inst__2620_/A1
+ VDD VDD VSS VSS gf180mcu_fd_sc_mcu7t5v0__clkbuf_1
Xwave_controller_x_inst__3418_ wave_controller_x_inst__3723_/Q wave_controller_x_inst__3446_/A2
+ wave_controller_x_inst__3419_/B wave_controller_x_inst__3441_/A1 VDD VDD VSS VSS
+ gf180mcu_fd_sc_mcu7t5v0__oai21_1
XFILLER_12_457 VDD VDD VSS VSS gf180mcu_fd_sc_mcu7t5v0__fillcap_16
XFILLER_157_418 VDD VDD VSS VSS gf180mcu_fd_sc_mcu7t5v0__fill_2
XTAP_TAPCELL_ROW_156_2444 VDD VSS gf180mcu_fd_sc_mcu7t5v0__filltie
XTAP_TAPCELL_ROW_156_2455 VDD VSS gf180mcu_fd_sc_mcu7t5v0__filltie
Xwave_controller_y_inst__3365_ wave_controller_y_inst__1792_/I wave_controller_y_inst__3365_/A2
+ wave_controller_y_inst__3365_/A3 wave_controller_y_inst__3365_/Z VDD VDD VSS VSS
+ gf180mcu_fd_sc_mcu7t5v0__xor3_1
Xwave_controller_x_inst__3349_ fanout532/Z wave_controller_x_inst__3348_/Z wave_controller_x_inst__3401_/A1
+ VDD VDD VSS VSS gf180mcu_fd_sc_mcu7t5v0__nand2_1
XFILLER_123_2 VDD VDD VSS VSS gf180mcu_fd_sc_mcu7t5v0__fillcap_4
XFILLER_166_941 VDD VDD VSS VSS gf180mcu_fd_sc_mcu7t5v0__fillcap_4
Xwave_controller_y_inst__3296_ wave_controller_y_inst__1792_/I wave_controller_y_inst__3365_/A2
+ wave_controller_y_inst__3271_/Z wave_controller_y_inst_wire122/Z wave_controller_y_inst__3296_/C
+ wave_controller_y_inst_wire119/I VDD VDD VSS VSS gf180mcu_fd_sc_mcu7t5v0__oai221_1
Xwave_controller_y_inst__2316_ wave_controller_y_inst__2284_/Z wave_controller_y_inst__2298_/Z
+ wave_controller_y_inst__2320_/A3 VDD VDD VSS VSS gf180mcu_fd_sc_mcu7t5v0__nand2_1
XFILLER_153_602 VDD VDD VSS VSS gf180mcu_fd_sc_mcu7t5v0__fillcap_4
Xwave_controller_y_inst__2247_ wave_controller_y_inst__2247_/A1 wave_controller_y_inst__2245_/I
+ wave_controller_y_inst__2250_/B VDD VDD VSS VSS gf180mcu_fd_sc_mcu7t5v0__xnor2_1
XFILLER_119_890 VDD VDD VSS VSS gf180mcu_fd_sc_mcu7t5v0__fillcap_8
XFILLER_153_646 VDD VDD VSS VSS gf180mcu_fd_sc_mcu7t5v0__fill_1
XFILLER_141_819 VDD VDD VSS VSS gf180mcu_fd_sc_mcu7t5v0__fillcap_8
XFILLER_165_64 VDD VDD VSS VSS gf180mcu_fd_sc_mcu7t5v0__fillcap_4
Xwave_controller_y_inst__2178_ max_cap423/I spi_regs_inst__1218_/A1 wave_controller_y_inst__2178_/Z
+ VDD VDD VSS VSS gf180mcu_fd_sc_mcu7t5v0__xor2_1
XTAP_TAPCELL_ROW_72_1067 VDD VSS gf180mcu_fd_sc_mcu7t5v0__filltie
XFILLER_94_405 VDD VDD VSS VSS gf180mcu_fd_sc_mcu7t5v0__fill_1
XTAP_TAPCELL_ROW_22_1_498 VDD VSS gf180mcu_fd_sc_mcu7t5v0__filltie
XFILLER_114_90 VDD VDD VSS VSS gf180mcu_fd_sc_mcu7t5v0__fillcap_8
XFILLER_35_549 VDD VDD VSS VSS gf180mcu_fd_sc_mcu7t5v0__fillcap_4
XFILLER_167_1090 VDD VDD VSS VSS gf180mcu_fd_sc_mcu7t5v0__fillcap_32
XFILLER_90_688 VDD VDD VSS VSS gf180mcu_fd_sc_mcu7t5v0__fill_2
XFILLER_129_632 VDD VDD VSS VSS gf180mcu_fd_sc_mcu7t5v0__fillcap_16
Xclkbuf_leaf_10_clk clkbuf_leaf_9_clk/I clkload17/I VDD VDD VSS VSS gf180mcu_fd_sc_mcu7t5v0__clkbuf_8
XFILLER_116_337 VDD VDD VSS VSS gf180mcu_fd_sc_mcu7t5v0__fill_2
XFILLER_144_646 VDD VDD VSS VSS gf180mcu_fd_sc_mcu7t5v0__fillcap_4
XFILLER_99_80 VDD VDD VSS VSS gf180mcu_fd_sc_mcu7t5v0__fillcap_4
XPHY_EDGE_ROW_25_1_Left_192 VDD VSS gf180mcu_fd_sc_mcu7t5v0__endcap
Xspi_regs_inst__1106_ spi_regs_inst__1542_/Q spi_regs_inst_wire252/I spi_regs_inst__1106_/B1
+ spi_regs_inst__1616_/Q spi_regs_inst__1117_/A3 VDD VDD VSS VSS gf180mcu_fd_sc_mcu7t5v0__aoi22_1
XFILLER_98_733 VDD VDD VSS VSS gf180mcu_fd_sc_mcu7t5v0__fill_2
Xspi_regs_inst__1037_ spi_regs_inst__1037_/A1 spi_regs_inst__1252_/A2 spi_regs_inst__1198_/A2
+ spi_regs_inst__1583_/Q spi_regs_inst__1039_/A3 VDD VDD VSS VSS gf180mcu_fd_sc_mcu7t5v0__aoi22_1
XFILLER_100_705 VDD VDD VSS VSS gf180mcu_fd_sc_mcu7t5v0__fillcap_16
XFILLER_66_630 VDD VDD VSS VSS gf180mcu_fd_sc_mcu7t5v0__fillcap_4
Xwave_controller_x_inst__2720_ wave_controller_x_inst__2939_/A2 wave_controller_x_inst__2719_/Z
+ wave_controller_x_inst__2728_/B VDD VDD VSS VSS gf180mcu_fd_sc_mcu7t5v0__nor2_1
XTAP_TAPCELL_ROW_56_809 VDD VSS gf180mcu_fd_sc_mcu7t5v0__filltie
XTAP_TAPCELL_ROW_6_1_380 VDD VSS gf180mcu_fd_sc_mcu7t5v0__filltie
Xwave_controller_x_inst__2651_ wave_controller_x_inst__2831_/A1 spi_regs_inst__1284_/A1
+ wave_controller_x_inst__2651_/B wave_controller_x_inst__2652_/B VDD VDD VSS VSS
+ gf180mcu_fd_sc_mcu7t5v0__oai21_1
XFILLER_26_527 VDD VDD VSS VSS gf180mcu_fd_sc_mcu7t5v0__fill_2
XFILLER_38_387 VDD VDD VSS VSS gf180mcu_fd_sc_mcu7t5v0__fillcap_64
XFILLER_66_696 VDD VDD VSS VSS gf180mcu_fd_sc_mcu7t5v0__fillcap_8
Xwave_controller_x_inst__2582_ wire456/Z wave_controller_x_inst__3521_/B2 wave_controller_x_inst__2566_/Z
+ wave_controller_x_inst__2583_/B VDD VDD VSS VSS gf180mcu_fd_sc_mcu7t5v0__nand3_1
XFILLER_81_699 VDD VDD VSS VSS gf180mcu_fd_sc_mcu7t5v0__fill_1
XFILLER_55_1046 VDD VDD VSS VSS gf180mcu_fd_sc_mcu7t5v0__fillcap_4
XTAP_TAPCELL_ROW_101_1539 VDD VSS gf180mcu_fd_sc_mcu7t5v0__filltie
XFILLER_167_716 VDD VDD VSS VSS gf180mcu_fd_sc_mcu7t5v0__fillcap_32
Xwave_controller_x_inst__3203_ wave_controller_x_inst__3203_/A1 wave_controller_x_inst__3206_/A1
+ wave_controller_x_inst__3203_/B wave_controller_x_inst__3242_/A3 VDD VDD VSS VSS
+ gf180mcu_fd_sc_mcu7t5v0__aoi21_1
XFILLER_148_941 VDD VDD VSS VSS gf180mcu_fd_sc_mcu7t5v0__fillcap_4
XFILLER_21_265 VDD VDD VSS VSS gf180mcu_fd_sc_mcu7t5v0__fill_1
XTAP_TAPCELL_ROW_138_2152 VDD VSS gf180mcu_fd_sc_mcu7t5v0__filltie
XTAP_TAPCELL_ROW_36_1_601 VDD VSS gf180mcu_fd_sc_mcu7t5v0__filltie
Xwave_controller_y_inst__3150_ wave_controller_y_inst__3305_/B2 spi_regs_inst__1591_/Q
+ wave_controller_y_inst__3211_/B VDD VDD VSS VSS gf180mcu_fd_sc_mcu7t5v0__xor2_1
Xwave_controller_x_inst__3134_ wave_controller_x_inst__2797_/C spi_regs_inst__1520_/Q
+ wave_controller_x_inst__3134_/B wave_controller_x_inst__3232_/B1 VDD VDD VSS VSS
+ gf180mcu_fd_sc_mcu7t5v0__oai21_1
XFILLER_21_298 VDD VDD VSS VSS gf180mcu_fd_sc_mcu7t5v0__fill_2
XFILLER_5_409 VDD VDD VSS VSS gf180mcu_fd_sc_mcu7t5v0__fillcap_4
Xwave_controller_y_inst__3081_ wave_controller_y_inst__3081_/A1 wave_controller_y_inst__3081_/A2
+ wave_controller_y_inst__3081_/B wave_controller_y_inst__3081_/C wave_controller_y_inst__3085_/A2
+ VDD VDD VSS VSS gf180mcu_fd_sc_mcu7t5v0__aoi211_1
Xwave_controller_y_inst__2101_ wave_controller_y_inst__2754_/A2 wave_controller_y_inst__2100_/Z
+ wave_controller_y_inst__2102_/I VDD VDD VSS VSS gf180mcu_fd_sc_mcu7t5v0__nand2_1
Xwave_controller_y_inst__2032_ wave_controller_y_inst__3004_/B wave_controller_y_inst__3089_/B
+ wave_controller_y_inst__2032_/Z VDD VDD VSS VSS gf180mcu_fd_sc_mcu7t5v0__xor2_1
Xwave_controller_x_inst__3065_ wave_controller_x_inst__3710_/Q wave_controller_x_inst__3209_/B
+ wave_controller_x_inst__2981_/B wave_controller_x_inst__3065_/Z VDD VDD VSS VSS
+ gf180mcu_fd_sc_mcu7t5v0__xor3_1
XFILLER_162_454 VDD VDD VSS VSS gf180mcu_fd_sc_mcu7t5v0__fill_1
XTAP_TAPCELL_ROW_151_2363 VDD VSS gf180mcu_fd_sc_mcu7t5v0__filltie
XTAP_TAPCELL_ROW_151_2374 VDD VSS gf180mcu_fd_sc_mcu7t5v0__filltie
Xwave_controller_x_inst__2016_ fanout535/Z wave_controller_x_inst__2380_/A1 wave_controller_x_inst__2008_/Z
+ wave_controller_x_inst_wire87/Z wave_controller_x_inst__2016_/C wave_controller_x_inst__2018_/A2
+ VDD VDD VSS VSS gf180mcu_fd_sc_mcu7t5v0__oai221_1
XTAP_TAPCELL_ROW_116_1793 VDD VSS gf180mcu_fd_sc_mcu7t5v0__filltie
XFILLER_0_125 VDD VDD VSS VSS gf180mcu_fd_sc_mcu7t5v0__fillcap_8
XFILLER_62_1017 VDD VDD VSS VSS gf180mcu_fd_sc_mcu7t5v0__fillcap_64
XTAP_TAPCELL_ROW_10_1_403 VDD VSS gf180mcu_fd_sc_mcu7t5v0__filltie
XFILLER_48_107 VDD VDD VSS VSS gf180mcu_fd_sc_mcu7t5v0__fillcap_16
Xwave_controller_y_inst__2934_ wave_controller_y_inst__3407_/B wave_controller_y_inst__2934_/A2
+ wave_controller_y_inst__2934_/B wave_controller_y_inst__2934_/ZN VDD VDD VSS VSS
+ gf180mcu_fd_sc_mcu7t5v0__oai21_1
XFILLER_130_395 VDD VDD VSS VSS gf180mcu_fd_sc_mcu7t5v0__fillcap_4
Xwave_controller_x_inst__2918_ wave_controller_x_inst__3585_/I0 spi_regs_inst__1309_/C2
+ wave_controller_x_inst__2918_/S wave_controller_x_inst__3684_/D VDD VDD VSS VSS
+ gf180mcu_fd_sc_mcu7t5v0__mux2_2
XFILLER_91_408 VDD VDD VSS VSS gf180mcu_fd_sc_mcu7t5v0__fillcap_4
Xwave_controller_y_inst__2865_ wave_controller_y_inst__3694_/Q wave_controller_y_inst__3443_/A1
+ wave_controller_y_inst__2867_/A3 VDD VDD VSS VSS gf180mcu_fd_sc_mcu7t5v0__nand2_1
Xwave_controller_x_inst__2849_ wave_controller_x_inst__2850_/B1 wave_controller_x_inst__2847_/Z
+ wave_controller_x_inst__2849_/A3 wave_controller_x_inst__2852_/A2 VDD VDD VSS VSS
+ gf180mcu_fd_sc_mcu7t5v0__nor3_1
XFILLER_57_696 VDD VDD VSS VSS gf180mcu_fd_sc_mcu7t5v0__fillcap_4
Xwave_controller_y_inst__2796_ spi_regs_inst__0967_/A1 spi_regs_inst__1063_/B2 wave_controller_y_inst__2800_/S
+ wave_controller_y_inst__2797_/B VDD VDD VSS VSS gf180mcu_fd_sc_mcu7t5v0__mux2_2
Xwave_controller_y_inst__1816_ wave_controller_y_inst__1816_/I wave_controller_y_inst__3352_/B
+ VDD VDD VSS VSS gf180mcu_fd_sc_mcu7t5v0__clkinv_1
XFILLER_17_549 VDD VDD VSS VSS gf180mcu_fd_sc_mcu7t5v0__fillcap_4
XFILLER_56_195 VDD VDD VSS VSS gf180mcu_fd_sc_mcu7t5v0__fill_1
XFILLER_44_97 VDD VDD VSS VSS gf180mcu_fd_sc_mcu7t5v0__fill_1
Xwave_controller_y_inst__3417_ wave_controller_y_inst__3417_/I wave_controller_y_inst__3420_/B1
+ VDD VDD VSS VSS gf180mcu_fd_sc_mcu7t5v0__clkinv_1
Xwave_controller_y_inst__3348_ wave_controller_y_inst__3321_/Z wave_controller_y_inst__3348_/A2
+ wave_controller_y_inst__3348_/Z VDD VDD VSS VSS gf180mcu_fd_sc_mcu7t5v0__xor2_1
XFILLER_100_92 VDD VDD VSS VSS gf180mcu_fd_sc_mcu7t5v0__fillcap_8
XFILLER_8_247 VDD VDD VSS VSS gf180mcu_fd_sc_mcu7t5v0__fillcap_64
Xwave_controller_y_inst__3279_ wave_controller_y_inst__3279_/A1 spi_regs_inst__1600_/Q
+ wave_controller_y_inst__3286_/A1 VDD VDD VSS VSS gf180mcu_fd_sc_mcu7t5v0__nand2_1
XFILLER_153_465 VDD VDD VSS VSS gf180mcu_fd_sc_mcu7t5v0__fill_1
XFILLER_125_189 VDD VDD VSS VSS gf180mcu_fd_sc_mcu7t5v0__fillcap_4
XFILLER_140_104 VDD VDD VSS VSS gf180mcu_fd_sc_mcu7t5v0__fill_1
XFILLER_141_638 VDD VDD VSS VSS gf180mcu_fd_sc_mcu7t5v0__fill_1
XFILLER_106_381 VDD VDD VSS VSS gf180mcu_fd_sc_mcu7t5v0__fillcap_4
XFILLER_122_841 VDD VDD VSS VSS gf180mcu_fd_sc_mcu7t5v0__fill_1
XFILLER_69_72 VDD VDD VSS VSS gf180mcu_fd_sc_mcu7t5v0__fillcap_16
XFILLER_122_874 VDD VDD VSS VSS gf180mcu_fd_sc_mcu7t5v0__fill_1
XFILLER_122_885 VDD VDD VSS VSS gf180mcu_fd_sc_mcu7t5v0__fillcap_16
XFILLER_95_758 VDD VDD VSS VSS gf180mcu_fd_sc_mcu7t5v0__fill_2
XFILLER_85_60 VDD VDD VSS VSS gf180mcu_fd_sc_mcu7t5v0__fillcap_8
XTAP_TAPCELL_ROW_89_1350 VDD VSS gf180mcu_fd_sc_mcu7t5v0__filltie
Xwave_controller_y_inst_max_cap40 wave_controller_y_inst__3447_/S wave_controller_y_inst__3493_/A2
+ VDD VDD VSS VSS gf180mcu_fd_sc_mcu7t5v0__buf_2
XFILLER_91_942 VDD VDD VSS VSS gf180mcu_fd_sc_mcu7t5v0__fillcap_32
Xspi_regs_inst__1655_ spi_regs_inst__1655_/D fanout584/Z clkbuf_leaf_13_clk/Z spi_regs_inst__1655_/Q
+ VDD VDD VSS VSS gf180mcu_fd_sc_mcu7t5v0__dffrnq_1
XFILLER_50_338 VDD VDD VSS VSS gf180mcu_fd_sc_mcu7t5v0__fillcap_16
XFILLER_149_716 VDD VDD VSS VSS gf180mcu_fd_sc_mcu7t5v0__fillcap_8
XTAP_TAPCELL_ROW_61_878 VDD VSS gf180mcu_fd_sc_mcu7t5v0__filltie
Xspi_regs_inst__1586_ spi_regs_inst__1586_/D fanout578/Z clkload19/I spi_regs_inst__1586_/Q
+ VDD VDD VSS VSS gf180mcu_fd_sc_mcu7t5v0__dffrnq_1
XFILLER_86_2 VDD VDD VSS VSS gf180mcu_fd_sc_mcu7t5v0__fillcap_32
XTAP_TAPCELL_ROW_61_889 VDD VSS gf180mcu_fd_sc_mcu7t5v0__filltie
XFILLER_102_1011 VDD VDD VSS VSS gf180mcu_fd_sc_mcu7t5v0__fillcap_4
XFILLER_163_229 VDD VDD VSS VSS gf180mcu_fd_sc_mcu7t5v0__fillcap_4
XTAP_TAPCELL_ROW_133_2071 VDD VSS gf180mcu_fd_sc_mcu7t5v0__filltie
XFILLER_160_947 VDD VDD VSS VSS gf180mcu_fd_sc_mcu7t5v0__fillcap_64
XFILLER_131_137 VDD VDD VSS VSS gf180mcu_fd_sc_mcu7t5v0__fill_2
XFILLER_100_524 VDD VDD VSS VSS gf180mcu_fd_sc_mcu7t5v0__fill_1
XFILLER_112_373 VDD VDD VSS VSS gf180mcu_fd_sc_mcu7t5v0__fill_2
XFILLER_112_395 VDD VDD VSS VSS gf180mcu_fd_sc_mcu7t5v0__fillcap_4
XFILLER_85_235 VDD VDD VSS VSS gf180mcu_fd_sc_mcu7t5v0__fillcap_4
XTAP_TAPCELL_ROW_39_1_627 VDD VSS gf180mcu_fd_sc_mcu7t5v0__filltie
XFILLER_67_972 VDD VDD VSS VSS gf180mcu_fd_sc_mcu7t5v0__fillcap_8
XPHY_EDGE_ROW_53_Left_220 VDD VSS gf180mcu_fd_sc_mcu7t5v0__endcap
Xwave_controller_y_inst_fanout52 wave_controller_y_inst__2911_/ZN wave_controller_y_inst_fanout52/Z
+ VDD VDD VSS VSS gf180mcu_fd_sc_mcu7t5v0__dlyb_1
Xwave_controller_x_inst__2703_ spi_regs_inst__1038_/A1 wave_controller_x_inst__2702_/Z
+ wave_controller_x_inst__2723_/B VDD VDD VSS VSS gf180mcu_fd_sc_mcu7t5v0__nand2_1
XFILLER_54_611 VDD VDD VSS VSS gf180mcu_fd_sc_mcu7t5v0__fill_2
XFILLER_85_279 VDD VDD VSS VSS gf180mcu_fd_sc_mcu7t5v0__fill_1
XTAP_TAPCELL_ROW_47_1_684 VDD VSS gf180mcu_fd_sc_mcu7t5v0__filltie
Xwave_controller_y_inst__2650_ spi_regs_inst__1275_/B2 wave_controller_y_inst__3536_/B2
+ wave_controller_y_inst__2650_/B wave_controller_y_inst__2651_/B VDD VDD VSS VSS
+ gf180mcu_fd_sc_mcu7t5v0__oai21_1
Xwave_controller_x_inst__3683_ wave_controller_x_inst__3683_/D wave_controller_x_inst__3710_/RN
+ clkload34/I spi_regs_inst__1277_/A1 VDD VDD VSS VSS gf180mcu_fd_sc_mcu7t5v0__dffrnq_1
XFILLER_26_335 VDD VDD VSS VSS gf180mcu_fd_sc_mcu7t5v0__fillcap_4
XFILLER_96_1157 VDD VDD VSS VSS gf180mcu_fd_sc_mcu7t5v0__fillcap_8
Xwave_controller_x_inst__2634_ wave_controller_x_inst__2634_/A1 wave_controller_x_inst__2633_/C
+ wave_controller_x_inst__2634_/B wave_controller_x_inst__2634_/C wave_controller_x_inst__2646_/A2
+ VDD VDD VSS VSS gf180mcu_fd_sc_mcu7t5v0__oai211_1
XFILLER_121_69 VDD VDD VSS VSS gf180mcu_fd_sc_mcu7t5v0__fill_1
Xwave_controller_y_inst__2581_ wave_controller_y_inst__2550_/Z wave_controller_y_inst__2566_/Z
+ wave_controller_y_inst__2620_/A2 VDD VDD VSS VSS gf180mcu_fd_sc_mcu7t5v0__nand2_1
Xwave_controller_x_inst__2565_ wave_controller_x_inst__2633_/A1 wave_controller_x_inst__2633_/A2
+ wave_controller_x_inst__2607_/A1 VDD VDD VSS VSS gf180mcu_fd_sc_mcu7t5v0__nand2_1
XTAP_TAPCELL_ROW_13_1_429 VDD VSS gf180mcu_fd_sc_mcu7t5v0__filltie
Xwave_controller_x_inst__2496_ wave_controller_x_inst__2497_/A1 wave_controller_x_inst__2497_/A2
+ wave_controller_x_inst__2497_/B wave_controller_x_inst__2509_/B VDD VDD VSS VSS
+ gf180mcu_fd_sc_mcu7t5v0__nand3_1
XFILLER_167_502 VDD VDD VSS VSS gf180mcu_fd_sc_mcu7t5v0__fillcap_8
XFILLER_139_237 VDD VDD VSS VSS gf180mcu_fd_sc_mcu7t5v0__fill_1
XFILLER_167_546 VDD VDD VSS VSS gf180mcu_fd_sc_mcu7t5v0__fillcap_8
XTAP_TAPCELL_ROW_153_2403 VDD VSS gf180mcu_fd_sc_mcu7t5v0__filltie
XTAP_TAPCELL_ROW_21_1_486 VDD VSS gf180mcu_fd_sc_mcu7t5v0__filltie
Xwave_controller_y_inst__3202_ wave_controller_y_inst__3203_/A1 wave_controller_y_inst__3206_/A1
+ wave_controller_y_inst__3203_/B wave_controller_y_inst__3202_/Z VDD VDD VSS VSS
+ gf180mcu_fd_sc_mcu7t5v0__and3_1
Xwave_controller_y_inst__3133_ wave_controller_y_inst__3701_/Q wave_controller_y_inst__3231_/A2
+ wave_controller_y_inst__3133_/B wave_controller_y_inst__3233_/A2 VDD VDD VSS VSS
+ gf180mcu_fd_sc_mcu7t5v0__aoi21_1
XFILLER_5_206 VDD VDD VSS VSS gf180mcu_fd_sc_mcu7t5v0__fillcap_4
XTAP_TAPCELL_ROW_118_1822 VDD VSS gf180mcu_fd_sc_mcu7t5v0__filltie
Xwave_controller_x_inst__3117_ wave_controller_x_inst__3570_/A1 spi_regs_inst__1526_/Q
+ wave_controller_x_inst__3149_/C VDD VDD VSS VSS gf180mcu_fd_sc_mcu7t5v0__nand2_1
Xwave_controller_y_inst__3064_ wave_controller_y_inst__3710_/Q fanout402/I wave_controller_y_inst__3606_/A2
+ VDD VDD VSS VSS gf180mcu_fd_sc_mcu7t5v0__nand2_1
Xwave_controller_x_inst__3048_ wave_controller_x_inst__3564_/A1 wave_controller_x_inst__3069_/B1
+ wave_controller_x_inst__3047_/Z wave_controller_x_inst__2762_/I wave_controller_x_inst__3704_/D
+ VDD VDD VSS VSS gf180mcu_fd_sc_mcu7t5v0__oai22_1
XFILLER_30_66 VDD VDD VSS VSS gf180mcu_fd_sc_mcu7t5v0__fillcap_4
Xwave_controller_y_inst__2015_ wave_controller_y_inst__3352_/B spi_regs_inst__0974_/B2
+ wave_controller_y_inst__2018_/B VDD VDD VSS VSS gf180mcu_fd_sc_mcu7t5v0__xor2_1
XFILLER_150_457 VDD VDD VSS VSS gf180mcu_fd_sc_mcu7t5v0__fillcap_4
XFILLER_162_295 VDD VDD VSS VSS gf180mcu_fd_sc_mcu7t5v0__fillcap_8
XFILLER_130_170 VDD VDD VSS VSS gf180mcu_fd_sc_mcu7t5v0__fill_1
XFILLER_77_769 VDD VDD VSS VSS gf180mcu_fd_sc_mcu7t5v0__fill_1
Xwave_controller_y_inst__2917_ wave_controller_y_inst__3320_/A1 wave_controller_y_inst__2917_/A2
+ wave_controller_y_inst__3585_/I0 VDD VDD VSS VSS gf180mcu_fd_sc_mcu7t5v0__nor2_1
XFILLER_64_419 VDD VDD VSS VSS gf180mcu_fd_sc_mcu7t5v0__fillcap_4
XFILLER_73_920 VDD VDD VSS VSS gf180mcu_fd_sc_mcu7t5v0__fillcap_4
XFILLER_91_216 VDD VDD VSS VSS gf180mcu_fd_sc_mcu7t5v0__fill_2
XTAP_TAPCELL_ROW_164_2576 VDD VSS gf180mcu_fd_sc_mcu7t5v0__filltie
XTAP_TAPCELL_ROW_164_2587 VDD VSS gf180mcu_fd_sc_mcu7t5v0__filltie
Xwave_controller_y_inst__2848_ wave_controller_y_inst__2845_/Z wave_controller_y_inst__2851_/A1
+ wave_controller_y_inst__2849_/A3 VDD VDD VSS VSS gf180mcu_fd_sc_mcu7t5v0__nand2_1
XFILLER_55_85 VDD VDD VSS VSS gf180mcu_fd_sc_mcu7t5v0__fillcap_16
XFILLER_60_614 VDD VDD VSS VSS gf180mcu_fd_sc_mcu7t5v0__fill_1
XFILLER_72_463 VDD VDD VSS VSS gf180mcu_fd_sc_mcu7t5v0__fill_1
Xwave_controller_y_inst__2779_ wave_controller_y_inst__3719_/Q wave_controller_y_inst__2850_/A2
+ wave_controller_y_inst__2854_/A2 VDD VDD VSS VSS gf180mcu_fd_sc_mcu7t5v0__nor2_1
Xspi_regs_inst__1440_ spi_regs_inst__1509_/Q spi_regs_inst_wire487/Z spi_regs_inst__1441_/S
+ spi_regs_inst__1509_/D VDD VDD VSS VSS gf180mcu_fd_sc_mcu7t5v0__mux2_2
Xspi_regs_inst__1371_ spi_regs_inst__1654_/Q spi_regs_inst__1379_/S spi_regs_inst__1372_/B
+ VDD VDD VSS VSS gf180mcu_fd_sc_mcu7t5v0__nand2_1
XTAP_TAPCELL_ROW_80_1199 VDD VSS gf180mcu_fd_sc_mcu7t5v0__filltie
XFILLER_126_454 VDD VDD VSS VSS gf180mcu_fd_sc_mcu7t5v0__fill_1
XFILLER_153_240 VDD VDD VSS VSS gf180mcu_fd_sc_mcu7t5v0__fill_1
XFILLER_154_774 VDD VDD VSS VSS gf180mcu_fd_sc_mcu7t5v0__fill_2
XFILLER_154_785 VDD VDD VSS VSS gf180mcu_fd_sc_mcu7t5v0__fillcap_16
XFILLER_113_137 VDD VDD VSS VSS gf180mcu_fd_sc_mcu7t5v0__fill_2
XFILLER_114_649 VDD VDD VSS VSS gf180mcu_fd_sc_mcu7t5v0__fillcap_16
XFILLER_142_947 VDD VDD VSS VSS gf180mcu_fd_sc_mcu7t5v0__fillcap_64
XFILLER_99_338 VDD VDD VSS VSS gf180mcu_fd_sc_mcu7t5v0__fill_1
Xsignal_processor_y_inst__252_ signal_processor_y_inst__252_/D fanout546/Z clkload1/I
+ signal_processor_y_inst__252_/Q VDD VDD VSS VSS gf180mcu_fd_sc_mcu7t5v0__dffrnq_1
XFILLER_136_1151 VDD VDD VSS VSS gf180mcu_fd_sc_mcu7t5v0__fillcap_4
XFILLER_110_811 VDD VDD VSS VSS gf180mcu_fd_sc_mcu7t5v0__fill_2
XFILLER_136_1173 VDD VDD VSS VSS gf180mcu_fd_sc_mcu7t5v0__fill_1
XFILLER_67_224 VDD VDD VSS VSS gf180mcu_fd_sc_mcu7t5v0__fill_2
Xsignal_processor_y_inst__183_ signal_processor_y_inst__183_/A1 signal_processor_y_inst__187_/B
+ signal_processor_y_inst__191_/A2 signal_processor_y_inst__182_/Z signal_processor_y_inst__240_/D
+ VDD VDD VSS VSS gf180mcu_fd_sc_mcu7t5v0__oai22_1
XFILLER_110_877 VDD VDD VSS VSS gf180mcu_fd_sc_mcu7t5v0__fillcap_16
XFILLER_68_769 VDD VDD VSS VSS gf180mcu_fd_sc_mcu7t5v0__fill_2
XFILLER_55_419 VDD VDD VSS VSS gf180mcu_fd_sc_mcu7t5v0__fill_1
XTAP_TAPCELL_ROW_87_1309 VDD VSS gf180mcu_fd_sc_mcu7t5v0__filltie
XTAP_TAPCELL_ROW_66_959 VDD VSS gf180mcu_fd_sc_mcu7t5v0__filltie
XFILLER_90_293 VDD VDD VSS VSS gf180mcu_fd_sc_mcu7t5v0__fillcap_16
Xwave_controller_x_inst__2350_ spi_regs_inst__1277_/A1 wave_controller_x_inst__2831_/A1
+ wave_controller_x_inst__2350_/B1 wave_controller_x_inst__2348_/Z wave_controller_x_inst__2350_/C
+ wave_controller_x_inst_wire121/I VDD VDD VSS VSS gf180mcu_fd_sc_mcu7t5v0__aoi221_1
Xspi_regs_inst__1638_ spi_regs_inst__1638_/D spi_regs_inst__1659_/RN clkload8/I spi_regs_inst__1638_/Q
+ VDD VDD VSS VSS gf180mcu_fd_sc_mcu7t5v0__dffrnq_1
XFILLER_143_1122 VDD VDD VSS VSS gf180mcu_fd_sc_mcu7t5v0__fillcap_32
XFILLER_50_168 VDD VDD VSS VSS gf180mcu_fd_sc_mcu7t5v0__fill_2
Xwave_controller_x_inst__2281_ wave_controller_x_inst__2346_/A1 wave_controller_x_inst__2280_/Z
+ wave_controller_x_inst__2296_/A2 VDD VDD VSS VSS gf180mcu_fd_sc_mcu7t5v0__nand2_1
Xspi_regs_inst__1569_ spi_regs_inst__1569_/D fanout581/Z clkbuf_leaf_41_clk/Z spi_regs_inst__1569_/Q
+ VDD VDD VSS VSS gf180mcu_fd_sc_mcu7t5v0__dffrnq_1
XTAP_TAPCELL_ROW_135_2100 VDD VSS gf180mcu_fd_sc_mcu7t5v0__filltie
XTAP_TAPCELL_ROW_135_2111 VDD VSS gf180mcu_fd_sc_mcu7t5v0__filltie
XFILLER_118_944 VDD VDD VSS VSS gf180mcu_fd_sc_mcu7t5v0__fill_1
XFILLER_164_516 VDD VDD VSS VSS gf180mcu_fd_sc_mcu7t5v0__fill_1
XTAP_TAPCELL_ROW_113_1741 VDD VSS gf180mcu_fd_sc_mcu7t5v0__filltie
XFILLER_132_457 VDD VDD VSS VSS gf180mcu_fd_sc_mcu7t5v0__fillcap_32
XFILLER_99_850 VDD VDD VSS VSS gf180mcu_fd_sc_mcu7t5v0__fillcap_32
Xfanout524 fanout524/I fanout524/Z VDD VDD VSS VSS gf180mcu_fd_sc_mcu7t5v0__dlyb_1
Xfanout513 fanout513/I fanout513/Z VDD VDD VSS VSS gf180mcu_fd_sc_mcu7t5v0__dlyb_1
Xfanout502 fanout502/I fanout502/Z VDD VDD VSS VSS gf180mcu_fd_sc_mcu7t5v0__dlyb_1
XFILLER_112_170 VDD VDD VSS VSS gf180mcu_fd_sc_mcu7t5v0__fillcap_4
XFILLER_113_693 VDD VDD VSS VSS gf180mcu_fd_sc_mcu7t5v0__fill_1
XFILLER_76_29 VDD VDD VSS VSS gf180mcu_fd_sc_mcu7t5v0__fill_1
XFILLER_86_511 VDD VDD VSS VSS gf180mcu_fd_sc_mcu7t5v0__fillcap_8
Xfanout557 fanout569/Z fanout557/Z VDD VDD VSS VSS gf180mcu_fd_sc_mcu7t5v0__dlyb_1
Xfanout546 fanout547/Z fanout546/Z VDD VDD VSS VSS gf180mcu_fd_sc_mcu7t5v0__dlyb_1
Xfanout535 fanout535/I fanout535/Z VDD VDD VSS VSS gf180mcu_fd_sc_mcu7t5v0__dlyb_1
Xwave_controller_x_inst__1996_ fanout540/Z wave_controller_x_inst__2318_/A1 wave_controller_x_inst__1996_/A3
+ spi_regs_inst__1213_/B2 VDD VDD VSS VSS gf180mcu_fd_sc_mcu7t5v0__xor3_1
XFILLER_100_387 VDD VDD VSS VSS gf180mcu_fd_sc_mcu7t5v0__fillcap_4
XTAP_TAPCELL_ROW_146_2284 VDD VSS gf180mcu_fd_sc_mcu7t5v0__filltie
Xwave_controller_y_inst__2702_ wave_controller_y_inst__3352_/B wave_controller_y_inst__2699_/Z
+ wave_controller_y_inst__2702_/A3 wave_controller_y_inst__2702_/Z VDD VDD VSS VSS
+ gf180mcu_fd_sc_mcu7t5v0__xor3_1
Xwave_controller_x_inst__3735_ wave_controller_x_inst__3735_/D wave_controller_x_inst__3735_/RN
+ clkload26/I wave_controller_x_inst__3735_/Q VDD VDD VSS VSS gf180mcu_fd_sc_mcu7t5v0__dffrnq_1
Xwave_controller_y_inst__3682_ wave_controller_y_inst__3682_/D wave_controller_y_inst__3683_/RN
+ clkbuf_leaf_46_clk/Z spi_regs_inst__1232_/B2 VDD VDD VSS VSS gf180mcu_fd_sc_mcu7t5v0__dffrnq_1
Xwave_controller_x_inst__3666_ wave_controller_x_inst__3666_/D fanout591/Z clkload22/I
+ max_cap451/I VDD VDD VSS VSS gf180mcu_fd_sc_mcu7t5v0__dffrnq_1
XFILLER_148_1011 VDD VDD VSS VSS gf180mcu_fd_sc_mcu7t5v0__fillcap_4
XFILLER_54_441 VDD VDD VSS VSS gf180mcu_fd_sc_mcu7t5v0__fillcap_4
Xwave_controller_y_inst__2633_ wave_controller_y_inst_wire99/Z wave_controller_y_inst_wire89/Z
+ wave_controller_y_inst__2633_/B wave_controller_y_inst__2633_/C wave_controller_y_inst__2646_/A1
+ VDD VDD VSS VSS gf180mcu_fd_sc_mcu7t5v0__aoi211_1
Xwave_controller_x_inst__2617_ wave_controller_x_inst__2580_/Z wave_controller_x_inst__2595_/Z
+ wave_controller_x_inst__2617_/Z VDD VDD VSS VSS gf180mcu_fd_sc_mcu7t5v0__and2_1
XFILLER_81_282 VDD VDD VSS VSS gf180mcu_fd_sc_mcu7t5v0__fillcap_4
Xwave_controller_y_inst__2564_ wave_controller_y_inst__2564_/A1 wave_controller_y_inst__2563_/B
+ spi_regs_inst_wire81/I VDD VDD VSS VSS gf180mcu_fd_sc_mcu7t5v0__xnor2_1
Xwave_controller_x_inst__3597_ wave_controller_x_inst__3597_/I0 spi_regs_inst__1193_/B2
+ wave_controller_x_inst__3601_/S wave_controller_x_inst__3673_/D VDD VDD VSS VSS
+ gf180mcu_fd_sc_mcu7t5v0__mux2_2
XFILLER_14_349 VDD VDD VSS VSS gf180mcu_fd_sc_mcu7t5v0__fillcap_4
XFILLER_25_66 VDD VDD VSS VSS gf180mcu_fd_sc_mcu7t5v0__fillcap_4
Xwave_controller_x_inst__2548_ wave_controller_x_inst__2561_/A1 wave_controller_x_inst__2561_/A2
+ wave_controller_x_inst__2562_/A1 VDD VDD VSS VSS gf180mcu_fd_sc_mcu7t5v0__nor2_1
Xwave_controller_y_inst__2495_ wave_controller_y_inst__3506_/B2 wave_controller_y_inst__2493_/Z
+ wave_controller_y_inst__2497_/B VDD VDD VSS VSS gf180mcu_fd_sc_mcu7t5v0__xor2_1
Xwave_controller_x_inst__2479_ wave_controller_x_inst__2479_/I wave_controller_x_inst__2483_/A2
+ VDD VDD VSS VSS gf180mcu_fd_sc_mcu7t5v0__clkinv_1
XFILLER_41_32 VDD VDD VSS VSS gf180mcu_fd_sc_mcu7t5v0__fillcap_4
XFILLER_167_376 VDD VDD VSS VSS gf180mcu_fd_sc_mcu7t5v0__fillcap_32
XTAP_TAPCELL_ROW_52_1_725 VDD VSS gf180mcu_fd_sc_mcu7t5v0__filltie
Xwave_controller_y_inst__3116_ wave_controller_y_inst__1792_/I wave_controller_y_inst__3213_/A2
+ wave_controller_y_inst__3211_/A1 VDD VDD VSS VSS gf180mcu_fd_sc_mcu7t5v0__nand2_1
XFILLER_108_454 VDD VDD VSS VSS gf180mcu_fd_sc_mcu7t5v0__fill_1
XFILLER_136_796 VDD VDD VSS VSS gf180mcu_fd_sc_mcu7t5v0__fillcap_8
Xwave_controller_y_inst__3047_ wave_controller_y_inst__3704_/Q wave_controller_y_inst__1826_/I
+ wave_controller_y_inst__3047_/A3 wave_controller_y_inst__3047_/Z VDD VDD VSS VSS
+ gf180mcu_fd_sc_mcu7t5v0__xor3_1
XFILLER_123_435 VDD VDD VSS VSS gf180mcu_fd_sc_mcu7t5v0__fillcap_8
XFILLER_124_947 VDD VDD VSS VSS gf180mcu_fd_sc_mcu7t5v0__fillcap_64
XTAP_TAPCELL_ROW_166_2616 VDD VSS gf180mcu_fd_sc_mcu7t5v0__filltie
XFILLER_104_671 VDD VDD VSS VSS gf180mcu_fd_sc_mcu7t5v0__fill_2
XFILLER_110_107 VDD VDD VSS VSS gf180mcu_fd_sc_mcu7t5v0__fillcap_16
XFILLER_110_129 VDD VDD VSS VSS gf180mcu_fd_sc_mcu7t5v0__fill_1
XFILLER_89_360 VDD VDD VSS VSS gf180mcu_fd_sc_mcu7t5v0__fill_2
XFILLER_2_37 VDD VDD VSS VSS gf180mcu_fd_sc_mcu7t5v0__fillcap_64
XFILLER_49_246 VDD VDD VSS VSS gf180mcu_fd_sc_mcu7t5v0__fillcap_4
XFILLER_77_544 VDD VDD VSS VSS gf180mcu_fd_sc_mcu7t5v0__fillcap_4
XTAP_TAPCELL_ROW_8_1_394 VDD VSS gf180mcu_fd_sc_mcu7t5v0__filltie
Xspi_regs_inst__0940_ spi_regs_inst__0940_/A1 spi_regs_inst__1455_/Q spi_regs_inst__1453_/D
+ spi_regs_inst__0940_/ZN VDD VDD VSS VSS gf180mcu_fd_sc_mcu7t5v0__nand3_1
XFILLER_37_419 VDD VDD VSS VSS gf180mcu_fd_sc_mcu7t5v0__fill_1
XFILLER_49_268 VDD VDD VSS VSS gf180mcu_fd_sc_mcu7t5v0__fill_2
XFILLER_66_51 VDD VDD VSS VSS gf180mcu_fd_sc_mcu7t5v0__fill_1
XTAP_TAPCELL_ROW_69_1017 VDD VSS gf180mcu_fd_sc_mcu7t5v0__filltie
Xspi_regs_inst__0871_ spi_regs_inst__1437_/A1 spi_regs_inst__0880_/A2 spi_regs_inst__1428_/A2
+ spi_regs_inst__0879_/S VDD VDD VSS VSS gf180mcu_fd_sc_mcu7t5v0__nor3_2
XFILLER_92_536 VDD VDD VSS VSS gf180mcu_fd_sc_mcu7t5v0__fillcap_8
XFILLER_61_912 VDD VDD VSS VSS gf180mcu_fd_sc_mcu7t5v0__fill_2
XFILLER_73_772 VDD VDD VSS VSS gf180mcu_fd_sc_mcu7t5v0__fillcap_8
XTAP_TAPCELL_ROW_63_918 VDD VSS gf180mcu_fd_sc_mcu7t5v0__filltie
XTAP_TAPCELL_ROW_82_1228 VDD VSS gf180mcu_fd_sc_mcu7t5v0__filltie
XFILLER_32_146 VDD VDD VSS VSS gf180mcu_fd_sc_mcu7t5v0__fill_1
XFILLER_60_499 VDD VDD VSS VSS gf180mcu_fd_sc_mcu7t5v0__fill_2
Xspi_regs_inst__1423_ spi_regs_inst__1447_/I1 spi_regs_inst__1494_/Q spi_regs_inst__1427_/S
+ spi_regs_inst__1494_/D VDD VDD VSS VSS gf180mcu_fd_sc_mcu7t5v0__mux2_2
XFILLER_146_505 VDD VDD VSS VSS gf180mcu_fd_sc_mcu7t5v0__fill_1
XFILLER_158_332 VDD VDD VSS VSS gf180mcu_fd_sc_mcu7t5v0__fill_1
XTAP_TAPCELL_ROW_38_1_615 VDD VSS gf180mcu_fd_sc_mcu7t5v0__filltie
XFILLER_146_527 VDD VDD VSS VSS gf180mcu_fd_sc_mcu7t5v0__fillcap_16
XFILLER_158_387 VDD VDD VSS VSS gf180mcu_fd_sc_mcu7t5v0__fillcap_16
XFILLER_9_364 VDD VDD VSS VSS gf180mcu_fd_sc_mcu7t5v0__fill_2
Xspi_regs_inst__1354_ spi_regs_inst__1354_/A1 spi_regs_inst_wire290/Z spi_regs_inst__1354_/B1
+ spi_regs_inst_wire86/Z spi_regs_inst__1355_/A4 VDD VDD VSS VSS gf180mcu_fd_sc_mcu7t5v0__aoi22_1
XFILLER_9_397 VDD VDD VSS VSS gf180mcu_fd_sc_mcu7t5v0__fillcap_4
Xspi_regs_inst__1285_ spi_regs_inst__1285_/A1 spi_regs_inst_wire297/Z spi_regs_inst_wire221/Z
+ spi_regs_inst__1285_/B2 spi_regs_inst__1287_/A3 VDD VDD VSS VSS gf180mcu_fd_sc_mcu7t5v0__aoi22_1
XTAP_TAPCELL_ROW_97_1482 VDD VSS gf180mcu_fd_sc_mcu7t5v0__filltie
XTAP_TAPCELL_ROW_97_1471 VDD VSS gf180mcu_fd_sc_mcu7t5v0__filltie
XFILLER_49_2 VDD VDD VSS VSS gf180mcu_fd_sc_mcu7t5v0__fill_2
XFILLER_99_135 VDD VDD VSS VSS gf180mcu_fd_sc_mcu7t5v0__fillcap_4
XTAP_TAPCELL_ROW_130_2030 VDD VSS gf180mcu_fd_sc_mcu7t5v0__filltie
XFILLER_114_457 VDD VDD VSS VSS gf180mcu_fd_sc_mcu7t5v0__fillcap_16
Xsignal_processor_y_inst__235_ signal_processor_y_inst__235_/D fanout557/Z clkload2/I
+ signal_processor_y_inst__235_/Q VDD VDD VSS VSS gf180mcu_fd_sc_mcu7t5v0__dffrnq_1
XTAP_TAPCELL_ROW_20_1_485 VDD VSS gf180mcu_fd_sc_mcu7t5v0__filltie
Xwave_controller_x_inst__1850_ max_cap461/Z wave_controller_x_inst__2193_/A2 VDD VDD
+ VSS VSS gf180mcu_fd_sc_mcu7t5v0__clkinv_1
Xsignal_processor_y_inst__166_ signal_processor_y_inst__233_/Q signal_processor_y_inst__166_/A2
+ signal_processor_y_inst__192_/B VDD VDD VSS VSS gf180mcu_fd_sc_mcu7t5v0__xor2_1
XFILLER_95_352 VDD VDD VSS VSS gf180mcu_fd_sc_mcu7t5v0__fillcap_4
Xwave_controller_x_inst__1781_ wave_controller_x_inst__1781_/I wave_controller_x_inst__3080_/A1
+ VDD VDD VSS VSS gf180mcu_fd_sc_mcu7t5v0__clkinv_1
Xwave_controller_x_inst__3520_ max_cap465/I wave_controller_x_inst__3523_/A2 wave_controller_x_inst__3521_/A3
+ VDD VDD VSS VSS gf180mcu_fd_sc_mcu7t5v0__nor2_1
XFILLER_102_16 VDD VDD VSS VSS gf180mcu_fd_sc_mcu7t5v0__fillcap_16
Xwave_controller_x_inst__3451_ wave_controller_x_inst__3465_/B wave_controller_x_inst__3451_/A2
+ wave_controller_x_inst__3471_/B wave_controller_x_inst__3452_/B2 VDD VDD VSS VSS
+ gf180mcu_fd_sc_mcu7t5v0__oai21_1
XFILLER_51_411 VDD VDD VSS VSS gf180mcu_fd_sc_mcu7t5v0__fillcap_8
XFILLER_63_282 VDD VDD VSS VSS gf180mcu_fd_sc_mcu7t5v0__fill_2
XFILLER_64_783 VDD VDD VSS VSS gf180mcu_fd_sc_mcu7t5v0__fillcap_8
XFILLER_93_1116 VDD VDD VSS VSS gf180mcu_fd_sc_mcu7t5v0__fillcap_4
Xwave_controller_x_inst__2402_ wave_controller_x_inst__2403_/A2 wave_controller_x_inst__2403_/A3
+ wave_controller_x_inst__2402_/Z VDD VDD VSS VSS gf180mcu_fd_sc_mcu7t5v0__xor2_1
XFILLER_23_124 VDD VDD VSS VSS gf180mcu_fd_sc_mcu7t5v0__fill_2
XFILLER_23_146 VDD VDD VSS VSS gf180mcu_fd_sc_mcu7t5v0__fill_1
Xwave_controller_x_inst__3382_ wave_controller_x_inst__3382_/A1 wave_controller_x_inst__3382_/A2
+ wave_controller_x_inst__3382_/A3 wave_controller_x_inst__3382_/B wave_controller_x_inst__3383_/B2
+ VDD VDD VSS VSS gf180mcu_fd_sc_mcu7t5v0__oai31_1
XFILLER_51_466 VDD VDD VSS VSS gf180mcu_fd_sc_mcu7t5v0__fillcap_4
Xwave_controller_x_inst__2333_ wave_controller_x_inst__2350_/B1 wave_controller_x_inst__2322_/Z
+ wave_controller_x_inst__2333_/B wave_controller_x_inst__2336_/A3 VDD VDD VSS VSS
+ gf180mcu_fd_sc_mcu7t5v0__aoi21_1
Xwave_controller_y_inst__2280_ wave_controller_y_inst__2277_/Z wave_controller_y_inst__2280_/A2
+ wave_controller_y_inst__2280_/Z VDD VDD VSS VSS gf180mcu_fd_sc_mcu7t5v0__xor2_1
Xwave_controller_x_inst__2264_ max_cap457/Z wave_controller_x_inst__2262_/Z wave_controller_x_inst__2265_/B
+ VDD VDD VSS VSS gf180mcu_fd_sc_mcu7t5v0__xor2_1
XFILLER_164_313 VDD VDD VSS VSS gf180mcu_fd_sc_mcu7t5v0__fill_2
XFILLER_165_836 VDD VDD VSS VSS gf180mcu_fd_sc_mcu7t5v0__fillcap_4
Xwave_controller_x_inst__2195_ wave_controller_x_inst__2221_/A1 wave_controller_x_inst__2194_/I
+ wave_controller_x_inst__2221_/C wave_controller_x_inst__2204_/A2 VDD VDD VSS VSS
+ gf180mcu_fd_sc_mcu7t5v0__aoi21_1
XFILLER_106_947 VDD VDD VSS VSS gf180mcu_fd_sc_mcu7t5v0__fillcap_64
XFILLER_117_273 VDD VDD VSS VSS gf180mcu_fd_sc_mcu7t5v0__fillcap_4
XFILLER_127_57 VDD VDD VSS VSS gf180mcu_fd_sc_mcu7t5v0__fill_2
Xwave_controller_y_inst_fanout415 wave_controller_y_inst__1806_/I wave_controller_y_inst__2038_/A2
+ VDD VDD VSS VSS gf180mcu_fd_sc_mcu7t5v0__dlyb_1
XFILLER_105_468 VDD VDD VSS VSS gf180mcu_fd_sc_mcu7t5v0__fillcap_4
XFILLER_127_68 VDD VDD VSS VSS gf180mcu_fd_sc_mcu7t5v0__fill_2
XFILLER_87_39 VDD VDD VSS VSS gf180mcu_fd_sc_mcu7t5v0__fillcap_16
XFILLER_132_265 VDD VDD VSS VSS gf180mcu_fd_sc_mcu7t5v0__fill_1
XFILLER_87_831 VDD VDD VSS VSS gf180mcu_fd_sc_mcu7t5v0__fillcap_4
XTAP_TAPCELL_ROW_148_2313 VDD VSS gf180mcu_fd_sc_mcu7t5v0__filltie
XTAP_TAPCELL_ROW_148_2324 VDD VSS gf180mcu_fd_sc_mcu7t5v0__filltie
XFILLER_154_1081 VDD VDD VSS VSS gf180mcu_fd_sc_mcu7t5v0__fillcap_4
XFILLER_87_842 VDD VDD VSS VSS gf180mcu_fd_sc_mcu7t5v0__fill_1
Xwave_controller_y_inst__1995_ fanout519/Z wave_controller_y_inst__2318_/A1 wave_controller_y_inst__2001_/A1
+ VDD VDD VSS VSS gf180mcu_fd_sc_mcu7t5v0__nand2_1
Xwave_controller_x_inst__1979_ wave_controller_x_inst__2952_/A2 spi_regs_inst__1068_/B2
+ wave_controller_x_inst__1986_/B VDD VDD VSS VSS gf180mcu_fd_sc_mcu7t5v0__nand2_1
XFILLER_100_173 VDD VDD VSS VSS gf180mcu_fd_sc_mcu7t5v0__fill_2
XTAP_TAPCELL_ROW_161_2535 VDD VSS gf180mcu_fd_sc_mcu7t5v0__filltie
Xwave_controller_y_inst_max_cap354 wave_controller_y_inst__2039_/B wave_controller_y_inst__2125_/B
+ VDD VDD VSS VSS gf180mcu_fd_sc_mcu7t5v0__clkbuf_2
Xwave_controller_y_inst__3734_ wave_controller_y_inst__3734_/D fanout544/Z clkload6/I
+ wave_controller_y_inst__3734_/Q VDD VDD VSS VSS gf180mcu_fd_sc_mcu7t5v0__dffrnq_1
Xwave_controller_x_inst__3718_ wave_controller_x_inst__3718_/D fanout598/Z clkbuf_leaf_19_clk/Z
+ wave_controller_x_inst__3718_/Q VDD VDD VSS VSS gf180mcu_fd_sc_mcu7t5v0__dffrnq_1
XFILLER_55_772 VDD VDD VSS VSS gf180mcu_fd_sc_mcu7t5v0__fillcap_4
XTAP_TAPCELL_ROW_126_1954 VDD VSS gf180mcu_fd_sc_mcu7t5v0__filltie
Xwave_controller_y_inst_max_cap365 wave_controller_y_inst__1945_/A1 wave_controller_y_inst__2117_/B
+ VDD VDD VSS VSS gf180mcu_fd_sc_mcu7t5v0__buf_3
Xwave_controller_y_inst__3665_ wave_controller_y_inst__3665_/D wave_controller_y_inst__3721_/RN
+ clkload4/I spi_regs_inst__1045_/A1 VDD VDD VSS VSS gf180mcu_fd_sc_mcu7t5v0__dffrnq_1
Xspi_regs_inst_max_cap203 spi_regs_inst_wire202/I spi_regs_inst__1445_/S VDD VDD VSS
+ VSS gf180mcu_fd_sc_mcu7t5v0__buf_2
XFILLER_42_422 VDD VDD VSS VSS gf180mcu_fd_sc_mcu7t5v0__fillcap_32
Xwave_controller_y_inst__2616_ wave_controller_y_inst__2616_/A1 spi_regs_inst__1216_/B2
+ max_cap432/Z wave_controller_y_inst__2616_/C wave_controller_y_inst__2619_/C VDD
+ VDD VSS VSS gf180mcu_fd_sc_mcu7t5v0__aoi211_1
Xwave_controller_x_inst__3649_ wave_controller_x_inst__3649_/D wave_controller_x_inst__3701_/RN
+ clkload31/I spi_regs_inst__1064_/A1 VDD VDD VSS VSS gf180mcu_fd_sc_mcu7t5v0__dffrnq_1
Xspi_regs_inst_max_cap236 spi_regs_inst__1357_/A2 spi_regs_inst__1315_/B1 VDD VDD
+ VSS VSS gf180mcu_fd_sc_mcu7t5v0__buf_2
Xspi_regs_inst_max_cap225 spi_regs_inst__1189_/A2 spi_regs_inst__1224_/A2 VDD VDD
+ VSS VSS gf180mcu_fd_sc_mcu7t5v0__buf_2
XFILLER_153_2 VDD VDD VSS VSS gf180mcu_fd_sc_mcu7t5v0__fillcap_32
XFILLER_54_293 VDD VDD VSS VSS gf180mcu_fd_sc_mcu7t5v0__fill_2
XFILLER_70_742 VDD VDD VSS VSS gf180mcu_fd_sc_mcu7t5v0__fillcap_16
Xwave_controller_y_inst__3596_ wave_controller_y_inst__3596_/I0 spi_regs_inst__1159_/A1
+ wave_controller_y_inst__3597_/S wave_controller_y_inst__3672_/D VDD VDD VSS VSS
+ gf180mcu_fd_sc_mcu7t5v0__mux2_2
Xspi_regs_inst_max_cap258 spi_regs_inst__1245_/B1 spi_regs_inst__1169_/B1 VDD VDD
+ VSS VSS gf180mcu_fd_sc_mcu7t5v0__buf_2
Xwave_controller_y_inst__2547_ wave_controller_y_inst__2563_/A1 wave_controller_y_inst__2544_/Z
+ wave_controller_y_inst__2564_/A1 VDD VDD VSS VSS gf180mcu_fd_sc_mcu7t5v0__nor2_1
Xsignal_processor_x_inst__255_ signal_processor_x_inst__255_/D fanout595/Z clkbuf_leaf_20_clk/Z
+ signal_processor_x_inst__255_/Q VDD VDD VSS VSS gf180mcu_fd_sc_mcu7t5v0__dffrnq_1
XFILLER_161_1052 VDD VDD VSS VSS gf180mcu_fd_sc_mcu7t5v0__fillcap_64
XFILLER_52_64 VDD VDD VSS VSS gf180mcu_fd_sc_mcu7t5v0__fillcap_8
XTAP_TAPCELL_ROW_159_2497 VDD VSS gf180mcu_fd_sc_mcu7t5v0__filltie
Xwave_controller_y_inst__2478_ wave_controller_y_inst__3503_/B2 wave_controller_y_inst__2476_/Z
+ wave_controller_y_inst__2479_/I VDD VDD VSS VSS gf180mcu_fd_sc_mcu7t5v0__xor2_1
XFILLER_128_527 VDD VDD VSS VSS gf180mcu_fd_sc_mcu7t5v0__fill_1
XFILLER_128_538 VDD VDD VSS VSS gf180mcu_fd_sc_mcu7t5v0__fillcap_4
Xsignal_processor_x_inst__186_ signal_processor_x_inst__214_/A2 signal_processor_x_inst__185_/I
+ signal_processor_x_inst__189_/A2 VDD VDD VSS VSS gf180mcu_fd_sc_mcu7t5v0__nand2_1
Xspi_regs_inst__1070_ spi_regs_inst__1070_/A1 spi_regs_inst__1070_/A2 spi_regs_inst__1070_/A3
+ spi_regs_inst__1070_/A4 spi_regs_inst__1071_/A4 VDD VDD VSS VSS gf180mcu_fd_sc_mcu7t5v0__nand4_1
XFILLER_124_777 VDD VDD VSS VSS gf180mcu_fd_sc_mcu7t5v0__fillcap_4
XFILLER_2_551 VDD VDD VSS VSS gf180mcu_fd_sc_mcu7t5v0__fillcap_4
XFILLER_117_90 VDD VDD VSS VSS gf180mcu_fd_sc_mcu7t5v0__fill_1
XTAP_TAPCELL_ROW_92_1390 VDD VSS gf180mcu_fd_sc_mcu7t5v0__filltie
XFILLER_133_1154 VDD VDD VSS VSS gf180mcu_fd_sc_mcu7t5v0__fillcap_16
XFILLER_77_352 VDD VDD VSS VSS gf180mcu_fd_sc_mcu7t5v0__fillcap_4
XFILLER_77_83 VDD VDD VSS VSS gf180mcu_fd_sc_mcu7t5v0__fill_1
XTAP_TAPCELL_ROW_49_1_698 VDD VSS gf180mcu_fd_sc_mcu7t5v0__filltie
Xspi_regs_inst__0923_ spi_regs_inst__1632_/Q spi_regs_inst__0925_/A4 spi_regs_inst__0924_/A2
+ VDD VDD VSS VSS gf180mcu_fd_sc_mcu7t5v0__nor2_1
Xspi_regs_inst__0854_ spi_regs_inst__1591_/Q spi_regs_inst__1405_/I1 spi_regs_inst__0857_/S
+ spi_regs_inst__1591_/D VDD VDD VSS VSS gf180mcu_fd_sc_mcu7t5v0__mux2_2
Xspi_regs_inst__0785_ spi_regs_inst__1379_/I1 spi_regs_inst__1538_/Q spi_regs_inst__0787_/S
+ spi_regs_inst__1538_/D VDD VDD VSS VSS gf180mcu_fd_sc_mcu7t5v0__mux2_2
XFILLER_33_422 VDD VDD VSS VSS gf180mcu_fd_sc_mcu7t5v0__fillcap_8
XFILLER_45_282 VDD VDD VSS VSS gf180mcu_fd_sc_mcu7t5v0__fillcap_16
XFILLER_60_263 VDD VDD VSS VSS gf180mcu_fd_sc_mcu7t5v0__fillcap_8
XTAP_TAPCELL_ROW_99_1511 VDD VSS gf180mcu_fd_sc_mcu7t5v0__filltie
XFILLER_119_516 VDD VDD VSS VSS gf180mcu_fd_sc_mcu7t5v0__fill_1
Xspi_regs_inst__1406_ fanout519/Z spi_regs_inst__1406_/I1 spi_regs_inst__1410_/S spi_regs_inst__1479_/D
+ VDD VDD VSS VSS gf180mcu_fd_sc_mcu7t5v0__mux2_2
Xspi_regs_inst__1337_ spi_regs_inst__1337_/A1 spi_regs_inst__1337_/A2 spi_regs_inst_wire249/Z
+ fanout532/Z spi_regs_inst__1338_/A4 VDD VDD VSS VSS gf180mcu_fd_sc_mcu7t5v0__aoi22_1
XFILLER_161_316 VDD VDD VSS VSS gf180mcu_fd_sc_mcu7t5v0__fill_2
XFILLER_115_722 VDD VDD VSS VSS gf180mcu_fd_sc_mcu7t5v0__fillcap_8
XFILLER_127_582 VDD VDD VSS VSS gf180mcu_fd_sc_mcu7t5v0__fill_1
XFILLER_161_338 VDD VDD VSS VSS gf180mcu_fd_sc_mcu7t5v0__fillcap_8
Xspi_regs_inst__1268_ spi_regs_inst__1588_/Q spi_regs_inst__1342_/A2 spi_regs_inst__1273_/A1
+ VDD VDD VSS VSS gf180mcu_fd_sc_mcu7t5v0__nand2_1
XFILLER_142_563 VDD VDD VSS VSS gf180mcu_fd_sc_mcu7t5v0__fill_1
Xspi_regs_inst__1199_ spi_regs_inst__1199_/A1 spi_regs_inst_wire231/I spi_regs_inst__1227_/B1
+ spi_regs_inst__1618_/Q spi_regs_inst__1201_/A3 VDD VDD VSS VSS gf180mcu_fd_sc_mcu7t5v0__aoi22_1
XFILLER_138_1087 VDD VDD VSS VSS gf180mcu_fd_sc_mcu7t5v0__fillcap_64
XPHY_EDGE_ROW_143_Right_143 VDD VSS gf180mcu_fd_sc_mcu7t5v0__endcap
XTAP_TAPCELL_ROW_110_1700 VDD VSS gf180mcu_fd_sc_mcu7t5v0__filltie
Xwave_controller_x_inst__2951_ wave_controller_x_inst__2951_/I wave_controller_x_inst__2974_/B
+ VDD VDD VSS VSS gf180mcu_fd_sc_mcu7t5v0__clkinv_1
XFILLER_69_831 VDD VDD VSS VSS gf180mcu_fd_sc_mcu7t5v0__fillcap_8
XFILLER_69_842 VDD VDD VSS VSS gf180mcu_fd_sc_mcu7t5v0__fillcap_4
Xwave_controller_x_inst__2882_ wave_controller_x_inst__2882_/A1 wave_controller_x_inst__2861_/Z
+ wave_controller_x_inst__2886_/C VDD VDD VSS VSS gf180mcu_fd_sc_mcu7t5v0__xor2_1
Xwave_controller_x_inst__1902_ wave_controller_x_inst__1902_/I wave_controller_x_inst__2902_/B2
+ VDD VDD VSS VSS gf180mcu_fd_sc_mcu7t5v0__clkinv_1
XFILLER_56_514 VDD VDD VSS VSS gf180mcu_fd_sc_mcu7t5v0__fill_2
Xwave_controller_x_inst__1833_ spi_regs_inst__1524_/Q wave_controller_x_inst__3143_/A2
+ VDD VDD VSS VSS gf180mcu_fd_sc_mcu7t5v0__clkinv_1
Xsignal_processor_y_inst__218_ signal_processor_y_inst__218_/D fanout556/Z _21_/CLK
+ spi_regs_inst__1100_/A1 VDD VDD VSS VSS gf180mcu_fd_sc_mcu7t5v0__dffrnq_1
XFILLER_110_471 VDD VDD VSS VSS gf180mcu_fd_sc_mcu7t5v0__fillcap_4
XFILLER_95_193 VDD VDD VSS VSS gf180mcu_fd_sc_mcu7t5v0__fill_1
XTAP_TAPCELL_ROW_143_2232 VDD VSS gf180mcu_fd_sc_mcu7t5v0__filltie
XTAP_TAPCELL_ROW_51_1_713 VDD VSS gf180mcu_fd_sc_mcu7t5v0__filltie
Xwave_controller_y_inst__1780_ spi_regs_inst__1577_/Q wave_controller_y_inst__1940_/A1
+ VDD VDD VSS VSS gf180mcu_fd_sc_mcu7t5v0__clkinv_1
Xsignal_processor_y_inst__149_ signal_processor_y_inst__252_/Q fanout393/Z signal_processor_y_inst__248_/Q
+ signal_processor_y_inst__151_/B VDD VDD VSS VSS gf180mcu_fd_sc_mcu7t5v0__nand3_1
XTAP_TAPCELL_ROW_108_1651 VDD VSS gf180mcu_fd_sc_mcu7t5v0__filltie
XTAP_TAPCELL_ROW_143_2243 VDD VSS gf180mcu_fd_sc_mcu7t5v0__filltie
Xwave_controller_x_inst__3503_ wave_controller_x_inst__3539_/A1 wave_controller_x_inst__3503_/A2
+ wave_controller_x_inst__3503_/A3 wave_controller_x_inst__3530_/B1 wave_controller_x_inst__3503_/B2
+ wave_controller_x_inst__3630_/D VDD VDD VSS VSS gf180mcu_fd_sc_mcu7t5v0__oai32_1
XFILLER_58_1011 VDD VDD VSS VSS gf180mcu_fd_sc_mcu7t5v0__fillcap_4
XTAP_TAPCELL_ROW_108_1662 VDD VSS gf180mcu_fd_sc_mcu7t5v0__filltie
Xwave_controller_y_inst__3450_ wave_controller_y_inst__3450_/A1 wave_controller_y_inst__3447_/Z
+ wave_controller_y_inst__3450_/B wave_controller_y_inst__3700_/Q wave_controller_y_inst__3452_/B1
+ VDD VDD VSS VSS gf180mcu_fd_sc_mcu7t5v0__aoi211_1
Xwave_controller_y_inst__2401_ wave_controller_y_inst__2379_/Z wave_controller_y_inst__2412_/A2
+ wave_controller_y_inst__2412_/C wave_controller_y_inst__2403_/A3 VDD VDD VSS VSS
+ gf180mcu_fd_sc_mcu7t5v0__aoi21_1
Xwave_controller_x_inst_max_cap328 wave_controller_x_inst__2144_/B wave_controller_x_inst__2098_/C
+ VDD VDD VSS VSS gf180mcu_fd_sc_mcu7t5v0__clkbuf_2
Xwave_controller_x_inst__3434_ wave_controller_x_inst__3694_/Q wave_controller_x_inst__3483_/A2
+ wave_controller_x_inst__3436_/A2 VDD VDD VSS VSS gf180mcu_fd_sc_mcu7t5v0__nor2_1
Xwave_controller_y_inst__3381_ wave_controller_y_inst__3381_/A1 wave_controller_y_inst__3381_/A2
+ fanout508/Z wave_controller_y_inst__3382_/B VDD VDD VSS VSS gf180mcu_fd_sc_mcu7t5v0__oai21_1
Xwave_controller_x_inst__3365_ wave_controller_x_inst__1792_/I wave_controller_x_inst__3365_/A2
+ wave_controller_x_inst__3365_/A3 wave_controller_x_inst__3365_/Z VDD VDD VSS VSS
+ gf180mcu_fd_sc_mcu7t5v0__xor3_1
XTAP_TAPCELL_ROW_121_1873 VDD VSS gf180mcu_fd_sc_mcu7t5v0__filltie
Xwave_controller_y_inst__2332_ wave_controller_y_inst__2349_/A1 spi_regs_inst__1275_/B2
+ wave_controller_y_inst__2332_/Z VDD VDD VSS VSS gf180mcu_fd_sc_mcu7t5v0__xor2_1
Xwave_controller_x_inst__2316_ wave_controller_x_inst__2284_/Z wave_controller_x_inst__2298_/Z
+ wave_controller_x_inst__2320_/A3 VDD VDD VSS VSS gf180mcu_fd_sc_mcu7t5v0__nand2_1
XFILLER_138_814 VDD VDD VSS VSS gf180mcu_fd_sc_mcu7t5v0__fill_2
XFILLER_149_162 VDD VDD VSS VSS gf180mcu_fd_sc_mcu7t5v0__fillcap_4
XFILLER_22_34 VDD VDD VSS VSS gf180mcu_fd_sc_mcu7t5v0__fill_1
Xwave_controller_y_inst__2263_ spi_regs_inst__1353_/A1 wave_controller_y_inst__2262_/Z
+ wave_controller_y_inst__2278_/B VDD VDD VSS VSS gf180mcu_fd_sc_mcu7t5v0__nand2_1
Xwave_controller_x_inst__3296_ wave_controller_x_inst__1792_/I wave_controller_x_inst__3365_/A2
+ wave_controller_x_inst__3271_/Z wave_controller_x_inst__3296_/B2 wave_controller_x_inst__3296_/C
+ wave_controller_x_inst__3303_/A2 VDD VDD VSS VSS gf180mcu_fd_sc_mcu7t5v0__oai221_1
XFILLER_138_858 VDD VDD VSS VSS gf180mcu_fd_sc_mcu7t5v0__fill_2
XTAP_TAPCELL_ROW_7_1_382 VDD VSS gf180mcu_fd_sc_mcu7t5v0__filltie
Xwave_controller_x_inst__2247_ wave_controller_x_inst__2247_/A1 wave_controller_x_inst__2245_/I
+ wave_controller_x_inst__2250_/B VDD VDD VSS VSS gf180mcu_fd_sc_mcu7t5v0__xnor2_1
XFILLER_138_45 VDD VDD VSS VSS gf180mcu_fd_sc_mcu7t5v0__fillcap_32
Xwave_controller_y_inst__2194_ wave_controller_y_inst__2194_/I wave_controller_y_inst__2222_/B2
+ VDD VDD VSS VSS gf180mcu_fd_sc_mcu7t5v0__clkinv_1
Xwave_controller_x_inst__2178_ spi_regs_inst__1193_/B2 max_cap460/Z wave_controller_x_inst__2178_/Z
+ VDD VDD VSS VSS gf180mcu_fd_sc_mcu7t5v0__xor2_1
XFILLER_106_733 VDD VDD VSS VSS gf180mcu_fd_sc_mcu7t5v0__fill_2
XFILLER_133_552 VDD VDD VSS VSS gf180mcu_fd_sc_mcu7t5v0__fillcap_8
XFILLER_105_265 VDD VDD VSS VSS gf180mcu_fd_sc_mcu7t5v0__fillcap_8
XFILLER_117_1116 VDD VDD VSS VSS gf180mcu_fd_sc_mcu7t5v0__fillcap_4
XFILLER_120_202 VDD VDD VSS VSS gf180mcu_fd_sc_mcu7t5v0__fill_1
XFILLER_79_628 VDD VDD VSS VSS gf180mcu_fd_sc_mcu7t5v0__fill_2
XFILLER_105_298 VDD VDD VSS VSS gf180mcu_fd_sc_mcu7t5v0__fillcap_4
XFILLER_94_609 VDD VDD VSS VSS gf180mcu_fd_sc_mcu7t5v0__fill_1
XPHY_EDGE_ROW_110_Right_110 VDD VSS gf180mcu_fd_sc_mcu7t5v0__endcap
XFILLER_120_257 VDD VDD VSS VSS gf180mcu_fd_sc_mcu7t5v0__fill_1
XFILLER_19_227 VDD VDD VSS VSS gf180mcu_fd_sc_mcu7t5v0__fill_1
XFILLER_47_525 VDD VDD VSS VSS gf180mcu_fd_sc_mcu7t5v0__fillcap_4
XFILLER_47_547 VDD VDD VSS VSS gf180mcu_fd_sc_mcu7t5v0__fillcap_8
XFILLER_59_396 VDD VDD VSS VSS gf180mcu_fd_sc_mcu7t5v0__fillcap_16
XFILLER_75_856 VDD VDD VSS VSS gf180mcu_fd_sc_mcu7t5v0__fill_1
XFILLER_86_182 VDD VDD VSS VSS gf180mcu_fd_sc_mcu7t5v0__fillcap_32
XTAP_TAPCELL_ROW_45_1_671 VDD VSS gf180mcu_fd_sc_mcu7t5v0__filltie
Xwave_controller_y_inst_max_cap140 wave_controller_y_inst__2891_/ZN wave_controller_y_inst__3521_/B1
+ VDD VDD VSS VSS gf180mcu_fd_sc_mcu7t5v0__clkbuf_3
Xwave_controller_y_inst__3717_ wave_controller_y_inst__3717_/D wave_controller_y_inst__3717_/RN
+ clkload5/I wave_controller_y_inst__3717_/Q VDD VDD VSS VSS gf180mcu_fd_sc_mcu7t5v0__dffrnq_1
Xwave_controller_y_inst__1978_ fanout502/Z wave_controller_y_inst__2254_/A1 wave_controller_y_inst__1980_/A1
+ VDD VDD VSS VSS gf180mcu_fd_sc_mcu7t5v0__nand2_1
XFILLER_15_422 VDD VDD VSS VSS gf180mcu_fd_sc_mcu7t5v0__fillcap_16
XFILLER_27_282 VDD VDD VSS VSS gf180mcu_fd_sc_mcu7t5v0__fillcap_4
Xwave_controller_y_inst__3648_ wave_controller_y_inst__3648_/D wave_controller_y_inst__3648_/RN
+ clkload4/I spi_regs_inst__1261_/B2 VDD VDD VSS VSS gf180mcu_fd_sc_mcu7t5v0__dffrnq_1
XFILLER_63_63 VDD VDD VSS VSS gf180mcu_fd_sc_mcu7t5v0__fillcap_4
XTAP_TAPCELL_ROW_11_1_416 VDD VSS gf180mcu_fd_sc_mcu7t5v0__filltie
Xwave_controller_y_inst__3579_ wave_controller_y_inst__3579_/A1 wave_controller_y_inst__3608_/A2
+ wave_controller_y_inst__3579_/B wave_controller_y_inst__3659_/D VDD VDD VSS VSS
+ gf180mcu_fd_sc_mcu7t5v0__oai21_1
Xsignal_processor_x_inst__238_ signal_processor_x_inst__238_/D fanout582/Z clkload10/I
+ signal_processor_x_inst__238_/Q VDD VDD VSS VSS gf180mcu_fd_sc_mcu7t5v0__dffrnq_1
Xsignal_processor_x_inst__169_ signal_processor_x_inst__234_/Q signal_processor_x_inst__169_/A2
+ signal_processor_x_inst__169_/Z VDD VDD VSS VSS gf180mcu_fd_sc_mcu7t5v0__xor2_1
Xspi_regs_inst__1122_ spi_regs_inst__1122_/A1 spi_regs_inst__1122_/A2 spi_regs_inst__1122_/A3
+ spi_regs_inst__1122_/A4 spi_regs_inst__1123_/A4 VDD VDD VSS VSS gf180mcu_fd_sc_mcu7t5v0__nand4_1
XTAP_TAPCELL_ROW_77_1149 VDD VSS gf180mcu_fd_sc_mcu7t5v0__filltie
XTAP_TAPCELL_ROW_94_1430 VDD VSS gf180mcu_fd_sc_mcu7t5v0__filltie
Xspi_regs_inst__1053_ spi_regs_inst__1049_/Z spi_regs_inst__1053_/A2 spi_regs_inst__1053_/A3
+ spi_regs_inst__1053_/A4 spi_regs_inst__1072_/A3 VDD VDD VSS VSS gf180mcu_fd_sc_mcu7t5v0__nand4_1
XFILLER_97_403 VDD VDD VSS VSS gf180mcu_fd_sc_mcu7t5v0__fillcap_8
XFILLER_112_758 VDD VDD VSS VSS gf180mcu_fd_sc_mcu7t5v0__fill_1
XFILLER_69_138 VDD VDD VSS VSS gf180mcu_fd_sc_mcu7t5v0__fill_2
XFILLER_111_279 VDD VDD VSS VSS gf180mcu_fd_sc_mcu7t5v0__fill_1
Xspi_regs_inst__0906_ spi_regs_inst__1629_/Q spi_regs_inst__0889_/B spi_regs_inst__0753_/I
+ spi_regs_inst__0905_/Z spi_regs_inst__0911_/B spi_regs_inst__1635_/Q spi_regs_inst__0907_/I
+ VDD VDD VSS VSS gf180mcu_fd_sc_mcu7t5v0__aoi222_1
X_15_ _21_/Q _15_/A2 _16_/A2 VDD VDD VSS VSS gf180mcu_fd_sc_mcu7t5v0__xnor2_1
XFILLER_80_325 VDD VDD VSS VSS gf180mcu_fd_sc_mcu7t5v0__fill_1
XFILLER_81_848 VDD VDD VSS VSS gf180mcu_fd_sc_mcu7t5v0__fill_1
XFILLER_92_185 VDD VDD VSS VSS gf180mcu_fd_sc_mcu7t5v0__fillcap_8
Xspi_regs_inst__0837_ spi_regs_inst__1578_/Q spi_regs_inst__1377_/I1 spi_regs_inst__0838_/S
+ spi_regs_inst__1578_/D VDD VDD VSS VSS gf180mcu_fd_sc_mcu7t5v0__mux2_2
Xspi_regs_inst__0768_ spi_regs_inst__1653_/Q spi_regs_inst__0827_/A2 spi_regs_inst__1454_/Q
+ spi_regs_inst__1446_/A1 VDD VDD VSS VSS gf180mcu_fd_sc_mcu7t5v0__nand3_1
XFILLER_167_909 VDD VDD VSS VSS gf180mcu_fd_sc_mcu7t5v0__fillcap_8
XFILLER_21_414 VDD VDD VSS VSS gf180mcu_fd_sc_mcu7t5v0__fillcap_4
XTAP_TAPCELL_ROW_103_1570 VDD VSS gf180mcu_fd_sc_mcu7t5v0__filltie
XTAP_TAPCELL_ROW_103_1581 VDD VSS gf180mcu_fd_sc_mcu7t5v0__filltie
Xwave_controller_x_inst__3150_ wave_controller_x_inst__3305_/B2 spi_regs_inst__1528_/Q
+ wave_controller_x_inst__3211_/B VDD VDD VSS VSS gf180mcu_fd_sc_mcu7t5v0__xor2_1
XFILLER_119_335 VDD VDD VSS VSS gf180mcu_fd_sc_mcu7t5v0__fill_2
XFILLER_146_121 VDD VDD VSS VSS gf180mcu_fd_sc_mcu7t5v0__fill_2
Xwave_controller_x_inst__3081_ wave_controller_x_inst__3081_/A1 wave_controller_x_inst__3081_/A2
+ wave_controller_x_inst__3081_/B wave_controller_x_inst__3081_/C wave_controller_x_inst__3085_/A2
+ VDD VDD VSS VSS gf180mcu_fd_sc_mcu7t5v0__aoi211_1
Xwave_controller_x_inst__2101_ wave_controller_x_inst__2153_/A2 wave_controller_x_inst__2100_/Z
+ wave_controller_x_inst__2102_/I VDD VDD VSS VSS gf180mcu_fd_sc_mcu7t5v0__nand2_1
Xwave_controller_x_inst__2032_ wave_controller_x_inst__3004_/B wave_controller_x_inst__2052_/A2
+ wave_controller_x_inst__2032_/Z VDD VDD VSS VSS gf180mcu_fd_sc_mcu7t5v0__xor2_1
XFILLER_147_699 VDD VDD VSS VSS gf180mcu_fd_sc_mcu7t5v0__fill_1
Xspi_regs_inst_wire100 spi_regs_inst_wire100/I spi_regs_inst_wire100/Z VDD VDD VSS
+ VSS gf180mcu_fd_sc_mcu7t5v0__buf_2
XFILLER_115_530 VDD VDD VSS VSS gf180mcu_fd_sc_mcu7t5v0__fillcap_16
XFILLER_162_658 VDD VDD VSS VSS gf180mcu_fd_sc_mcu7t5v0__fillcap_4
XFILLER_115_574 VDD VDD VSS VSS gf180mcu_fd_sc_mcu7t5v0__fill_1
Xspi_regs_inst_fanout609 spi_regs_inst__1605_/RN spi_regs_inst__1647_/RN VDD VDD VSS
+ VSS gf180mcu_fd_sc_mcu7t5v0__dlyb_1
XFILLER_103_736 VDD VDD VSS VSS gf180mcu_fd_sc_mcu7t5v0__fillcap_8
Xwave_controller_y_inst__2950_ wave_controller_y_inst__3707_/Q fanout502/Z wave_controller_y_inst__2951_/I
+ VDD VDD VSS VSS gf180mcu_fd_sc_mcu7t5v0__nand2_1
Xwave_controller_x_inst__2934_ wave_controller_x_inst__3406_/A1 wave_controller_x_inst__2934_/A2
+ wave_controller_x_inst__2934_/B wave_controller_x_inst_wire68/I VDD VDD VSS VSS
+ gf180mcu_fd_sc_mcu7t5v0__oai21_1
Xspi_regs_inst_wire188 spi_regs_inst__1403_/S spi_regs_inst__1402_/S VDD VDD VSS VSS
+ gf180mcu_fd_sc_mcu7t5v0__buf_3
XFILLER_130_577 VDD VDD VSS VSS gf180mcu_fd_sc_mcu7t5v0__fill_2
XFILLER_64_1081 VDD VDD VSS VSS gf180mcu_fd_sc_mcu7t5v0__fillcap_4
Xwave_controller_y_inst__2881_ wave_controller_y_inst__2881_/A1 wave_controller_y_inst__2881_/A2
+ wave_controller_y_inst__2880_/Z wave_controller_y_inst__2881_/B wave_controller_y_inst__2887_/A2
+ VDD VDD VSS VSS gf180mcu_fd_sc_mcu7t5v0__oai31_1
Xwave_controller_y_inst__1901_ wave_controller_y_inst__3723_/Q wave_controller_y_inst__3489_/C
+ VDD VDD VSS VSS gf180mcu_fd_sc_mcu7t5v0__clkinv_1
XFILLER_111_780 VDD VDD VSS VSS gf180mcu_fd_sc_mcu7t5v0__fillcap_4
XFILLER_99_1122 VDD VDD VSS VSS gf180mcu_fd_sc_mcu7t5v0__fillcap_32
Xwave_controller_y_inst__1832_ spi_regs_inst__1588_/Q wave_controller_y_inst__3122_/A2
+ VDD VDD VSS VSS gf180mcu_fd_sc_mcu7t5v0__clkinv_1
Xwave_controller_x_inst__2865_ wave_controller_x_inst__3694_/Q wave_controller_x_inst__3443_/A1
+ wave_controller_x_inst__2867_/A3 VDD VDD VSS VSS gf180mcu_fd_sc_mcu7t5v0__nand2_1
XFILLER_44_506 VDD VDD VSS VSS gf180mcu_fd_sc_mcu7t5v0__fill_1
XFILLER_56_333 VDD VDD VSS VSS gf180mcu_fd_sc_mcu7t5v0__fillcap_4
XFILLER_57_856 VDD VDD VSS VSS gf180mcu_fd_sc_mcu7t5v0__fillcap_8
Xwave_controller_x_inst__2796_ spi_regs_inst__1064_/A1 spi_regs_inst__1064_/B2 wave_controller_x_inst__2805_/S
+ wave_controller_x_inst__2797_/B VDD VDD VSS VSS gf180mcu_fd_sc_mcu7t5v0__mux2_2
Xwave_controller_x_inst__1816_ fanout534/Z wave_controller_x_inst__3352_/B VDD VDD
+ VSS VSS gf180mcu_fd_sc_mcu7t5v0__clkinv_1
XFILLER_71_314 VDD VDD VSS VSS gf180mcu_fd_sc_mcu7t5v0__fillcap_16
XTAP_TAPCELL_ROW_123_1902 VDD VSS gf180mcu_fd_sc_mcu7t5v0__filltie
XTAP_TAPCELL_ROW_123_1913 VDD VSS gf180mcu_fd_sc_mcu7t5v0__filltie
XFILLER_72_859 VDD VDD VSS VSS gf180mcu_fd_sc_mcu7t5v0__fill_2
Xwave_controller_y_inst__3502_ spi_regs_inst__1139_/A1 wave_controller_y_inst__3529_/A2
+ wave_controller_y_inst__3503_/A3 VDD VDD VSS VSS gf180mcu_fd_sc_mcu7t5v0__nor2_1
Xwave_controller_x_inst_max_cap114 wave_controller_x_inst_wire115/Z wave_controller_x_inst__2543_/A2
+ VDD VDD VSS VSS gf180mcu_fd_sc_mcu7t5v0__clkbuf_1
Xwave_controller_y_inst__3433_ wave_controller_y_inst__3433_/A1 wave_controller_y_inst__3557_/B1
+ wave_controller_y_inst__3433_/B1 wave_controller_y_inst__3433_/B2 wave_controller_y_inst__3621_/D
+ VDD VDD VSS VSS gf180mcu_fd_sc_mcu7t5v0__oai22_1
Xwave_controller_x_inst__3417_ wave_controller_x_inst__3417_/I wave_controller_x_inst__3420_/B1
+ VDD VDD VSS VSS gf180mcu_fd_sc_mcu7t5v0__clkinv_1
XFILLER_24_285 VDD VDD VSS VSS gf180mcu_fd_sc_mcu7t5v0__fill_2
Xwave_controller_y_inst__3364_ wave_controller_y_inst__3297_/Z wave_controller_y_inst__3364_/A2
+ wave_controller_y_inst__3364_/Z VDD VDD VSS VSS gf180mcu_fd_sc_mcu7t5v0__xor2_1
XFILLER_71_1052 VDD VDD VSS VSS gf180mcu_fd_sc_mcu7t5v0__fillcap_64
XTAP_TAPCELL_ROW_156_2445 VDD VSS gf180mcu_fd_sc_mcu7t5v0__filltie
XTAP_TAPCELL_ROW_156_2456 VDD VSS gf180mcu_fd_sc_mcu7t5v0__filltie
Xwave_controller_y_inst__2315_ wave_controller_y_inst__2308_/Z wave_controller_y_inst__2315_/A2
+ spi_regs_inst__1130_/A1 VDD VDD VSS VSS gf180mcu_fd_sc_mcu7t5v0__xor2_1
Xwave_controller_x_inst__3348_ wave_controller_x_inst__3321_/Z wave_controller_x_inst__3348_/A2
+ wave_controller_x_inst__3348_/Z VDD VDD VSS VSS gf180mcu_fd_sc_mcu7t5v0__xor2_1
Xwave_controller_y_inst__3295_ wave_controller_y_inst__3271_/Z wave_controller_y_inst_wire122/Z
+ wave_controller_y_inst__3296_/C wave_controller_y_inst__3365_/A3 VDD VDD VSS VSS
+ gf180mcu_fd_sc_mcu7t5v0__oai21_1
Xwave_controller_x_inst__3279_ wave_controller_x_inst__3279_/A1 spi_regs_inst__1542_/Q
+ wave_controller_x_inst__3286_/A1 VDD VDD VSS VSS gf180mcu_fd_sc_mcu7t5v0__nand2_1
XFILLER_138_655 VDD VDD VSS VSS gf180mcu_fd_sc_mcu7t5v0__fillcap_8
XFILLER_165_452 VDD VDD VSS VSS gf180mcu_fd_sc_mcu7t5v0__fillcap_4
Xwave_controller_y_inst__2246_ wave_controller_y_inst__2247_/A1 wave_controller_y_inst__2246_/A2
+ wave_controller_y_inst__2268_/A1 VDD VDD VSS VSS gf180mcu_fd_sc_mcu7t5v0__nor2_1
XFILLER_116_2 VDD VDD VSS VSS gf180mcu_fd_sc_mcu7t5v0__fillcap_16
Xwave_controller_y_inst__2177_ max_cap423/I wave_controller_y_inst__2516_/A1 wave_controller_y_inst__2221_/C
+ VDD VDD VSS VSS gf180mcu_fd_sc_mcu7t5v0__nor2_1
XFILLER_133_360 VDD VDD VSS VSS gf180mcu_fd_sc_mcu7t5v0__fillcap_4
XFILLER_134_872 VDD VDD VSS VSS gf180mcu_fd_sc_mcu7t5v0__fill_2
XFILLER_121_522 VDD VDD VSS VSS gf180mcu_fd_sc_mcu7t5v0__fill_1
XTAP_TAPCELL_ROW_72_1057 VDD VSS gf180mcu_fd_sc_mcu7t5v0__filltie
XTAP_TAPCELL_ROW_72_1068 VDD VSS gf180mcu_fd_sc_mcu7t5v0__filltie
XTAP_TAPCELL_ROW_22_1_499 VDD VSS gf180mcu_fd_sc_mcu7t5v0__filltie
XFILLER_121_599 VDD VDD VSS VSS gf180mcu_fd_sc_mcu7t5v0__fillcap_8
XFILLER_130_1157 VDD VDD VSS VSS gf180mcu_fd_sc_mcu7t5v0__fillcap_16
XTAP_TAPCELL_ROW_58_840 VDD VSS gf180mcu_fd_sc_mcu7t5v0__filltie
XFILLER_74_174 VDD VDD VSS VSS gf180mcu_fd_sc_mcu7t5v0__fill_1
XFILLER_90_612 VDD VDD VSS VSS gf180mcu_fd_sc_mcu7t5v0__fill_2
XFILLER_74_185 VDD VDD VSS VSS gf180mcu_fd_sc_mcu7t5v0__fillcap_4
XFILLER_90_656 VDD VDD VSS VSS gf180mcu_fd_sc_mcu7t5v0__fill_2
XFILLER_90_667 VDD VDD VSS VSS gf180mcu_fd_sc_mcu7t5v0__fillcap_4
XFILLER_30_244 VDD VDD VSS VSS gf180mcu_fd_sc_mcu7t5v0__fill_1
Xspi_regs_inst__1105_ spi_regs_inst__1571_/Q spi_regs_inst__1281_/B1 spi_regs_inst__1141_/B1
+ spi_regs_inst__1105_/B2 spi_regs_inst__1122_/A3 VDD VDD VSS VSS gf180mcu_fd_sc_mcu7t5v0__aoi22_1
XFILLER_143_168 VDD VDD VSS VSS gf180mcu_fd_sc_mcu7t5v0__fill_2
Xspi_regs_inst__1036_ spi_regs_inst_wire76/Z spi_regs_inst__1309_/A2 spi_regs_inst__1036_/B1
+ spi_regs_inst_wire77/Z spi_regs_inst__1261_/B1 max_cap430/Z spi_regs_inst__1039_/A2
+ VDD VDD VSS VSS gf180mcu_fd_sc_mcu7t5v0__aoi222_1
XFILLER_135_1046 VDD VDD VSS VSS gf180mcu_fd_sc_mcu7t5v0__fillcap_4
XFILLER_97_277 VDD VDD VSS VSS gf180mcu_fd_sc_mcu7t5v0__fill_2
XFILLER_85_428 VDD VDD VSS VSS gf180mcu_fd_sc_mcu7t5v0__fill_1
XFILLER_85_439 VDD VDD VSS VSS gf180mcu_fd_sc_mcu7t5v0__fill_2
Xwave_controller_x_inst__2650_ max_cap452/Z wave_controller_x_inst__3536_/B2 wave_controller_x_inst__2650_/B
+ wave_controller_x_inst__2651_/B VDD VDD VSS VSS gf180mcu_fd_sc_mcu7t5v0__oai21_1
XFILLER_81_612 VDD VDD VSS VSS gf180mcu_fd_sc_mcu7t5v0__fill_2
Xwave_controller_x_inst__2581_ wave_controller_x_inst__2550_/Z wave_controller_x_inst__2566_/Z
+ wave_controller_x_inst__2620_/A2 VDD VDD VSS VSS gf180mcu_fd_sc_mcu7t5v0__nand2_1
XFILLER_0_70 VDD VDD VSS VSS gf180mcu_fd_sc_mcu7t5v0__fillcap_32
XFILLER_53_325 VDD VDD VSS VSS gf180mcu_fd_sc_mcu7t5v0__fillcap_4
XTAP_TAPCELL_ROW_105_1610 VDD VSS gf180mcu_fd_sc_mcu7t5v0__filltie
XFILLER_80_155 VDD VDD VSS VSS gf180mcu_fd_sc_mcu7t5v0__fillcap_4
XFILLER_80_177 VDD VDD VSS VSS gf180mcu_fd_sc_mcu7t5v0__fillcap_8
XFILLER_139_419 VDD VDD VSS VSS gf180mcu_fd_sc_mcu7t5v0__fill_1
XFILLER_142_1017 VDD VDD VSS VSS gf180mcu_fd_sc_mcu7t5v0__fillcap_64
Xwave_controller_x_inst__3202_ wave_controller_x_inst__3203_/A1 wave_controller_x_inst__3206_/A1
+ wave_controller_x_inst__3203_/B wave_controller_x_inst__3202_/Z VDD VDD VSS VSS
+ gf180mcu_fd_sc_mcu7t5v0__and3_1
XFILLER_147_430 VDD VDD VSS VSS gf180mcu_fd_sc_mcu7t5v0__fillcap_4
XTAP_TAPCELL_ROW_138_2153 VDD VSS gf180mcu_fd_sc_mcu7t5v0__filltie
XTAP_TAPCELL_ROW_36_1_602 VDD VSS gf180mcu_fd_sc_mcu7t5v0__filltie
Xwave_controller_x_inst__3133_ wave_controller_x_inst__3701_/Q wave_controller_x_inst__3231_/A2
+ wave_controller_x_inst__3133_/B wave_controller_x_inst__3233_/A2 VDD VDD VSS VSS
+ gf180mcu_fd_sc_mcu7t5v0__aoi21_1
XFILLER_119_132 VDD VDD VSS VSS gf180mcu_fd_sc_mcu7t5v0__fillcap_8
XFILLER_119_36 VDD VDD VSS VSS gf180mcu_fd_sc_mcu7t5v0__fillcap_16
XFILLER_163_912 VDD VDD VSS VSS gf180mcu_fd_sc_mcu7t5v0__fillcap_64
Xwave_controller_y_inst__3080_ wave_controller_y_inst__3080_/A1 wave_controller_y_inst__3090_/B1
+ wave_controller_y_inst__3079_/Z wave_controller_y_inst__2762_/I wave_controller_y_inst__3716_/D
+ VDD VDD VSS VSS gf180mcu_fd_sc_mcu7t5v0__oai22_1
Xwave_controller_y_inst__2100_ wave_controller_y_inst__2100_/A1 wave_controller_y_inst__2117_/A2
+ wave_controller_y_inst__2100_/Z VDD VDD VSS VSS gf180mcu_fd_sc_mcu7t5v0__xor2_1
XFILLER_162_411 VDD VDD VSS VSS gf180mcu_fd_sc_mcu7t5v0__fill_2
XFILLER_162_422 VDD VDD VSS VSS gf180mcu_fd_sc_mcu7t5v0__fillcap_32
Xwave_controller_y_inst__2031_ wave_controller_y_inst__3718_/Q wave_controller_y_inst__3089_/B
+ wave_controller_y_inst__2114_/B VDD VDD VSS VSS gf180mcu_fd_sc_mcu7t5v0__xor2_1
Xwave_controller_x_inst__3064_ wave_controller_x_inst__1790_/I fanout404/Z wave_controller_x_inst__3606_/A2
+ VDD VDD VSS VSS gf180mcu_fd_sc_mcu7t5v0__nand2_1
XFILLER_119_198 VDD VDD VSS VSS gf180mcu_fd_sc_mcu7t5v0__fillcap_4
XTAP_TAPCELL_ROW_151_2364 VDD VSS gf180mcu_fd_sc_mcu7t5v0__filltie
XTAP_TAPCELL_ROW_151_2375 VDD VSS gf180mcu_fd_sc_mcu7t5v0__filltie
Xwave_controller_x_inst__2015_ wave_controller_x_inst__3352_/B spi_regs_inst__1052_/B2
+ wave_controller_x_inst__2018_/B VDD VDD VSS VSS gf180mcu_fd_sc_mcu7t5v0__xor2_1
XFILLER_103_500 VDD VDD VSS VSS gf180mcu_fd_sc_mcu7t5v0__fill_1
XFILLER_150_639 VDD VDD VSS VSS gf180mcu_fd_sc_mcu7t5v0__fillcap_4
XTAP_TAPCELL_ROW_116_1783 VDD VSS gf180mcu_fd_sc_mcu7t5v0__filltie
XTAP_TAPCELL_ROW_116_1794 VDD VSS gf180mcu_fd_sc_mcu7t5v0__filltie
XFILLER_0_104 VDD VDD VSS VSS gf180mcu_fd_sc_mcu7t5v0__fillcap_16
XFILLER_131_842 VDD VDD VSS VSS gf180mcu_fd_sc_mcu7t5v0__fillcap_4
XFILLER_143_680 VDD VDD VSS VSS gf180mcu_fd_sc_mcu7t5v0__fillcap_8
XFILLER_89_734 VDD VDD VSS VSS gf180mcu_fd_sc_mcu7t5v0__fillcap_4
XTAP_TAPCELL_ROW_10_1_404 VDD VSS gf180mcu_fd_sc_mcu7t5v0__filltie
XFILLER_103_577 VDD VDD VSS VSS gf180mcu_fd_sc_mcu7t5v0__fillcap_16
XFILLER_130_363 VDD VDD VSS VSS gf180mcu_fd_sc_mcu7t5v0__fillcap_4
XFILLER_142_190 VDD VDD VSS VSS gf180mcu_fd_sc_mcu7t5v0__fillcap_4
Xwave_controller_y_inst__2933_ wave_controller_y_inst__2933_/A1 wave_controller_y_inst__2933_/A2
+ wave_controller_y_inst__2934_/B VDD VDD VSS VSS gf180mcu_fd_sc_mcu7t5v0__nor2_1
Xwave_controller_x_inst__2917_ wave_controller_x_inst__3078_/A1 wave_controller_x_inst_wire333/Z
+ wave_controller_x_inst__3585_/I0 VDD VDD VSS VSS gf180mcu_fd_sc_mcu7t5v0__nor2_1
XFILLER_29_344 VDD VDD VSS VSS gf180mcu_fd_sc_mcu7t5v0__fillcap_4
XFILLER_85_973 VDD VDD VSS VSS gf180mcu_fd_sc_mcu7t5v0__fillcap_4
Xwave_controller_y_inst__2864_ wave_controller_y_inst__3449_/A1 spi_regs_inst__1190_/A1
+ wave_controller_y_inst__2864_/Z VDD VDD VSS VSS gf180mcu_fd_sc_mcu7t5v0__xor2_1
Xwave_controller_x_inst__2848_ wave_controller_x_inst__2845_/Z wave_controller_x_inst__2851_/A1
+ wave_controller_x_inst__2849_/A3 VDD VDD VSS VSS gf180mcu_fd_sc_mcu7t5v0__nand2_1
XFILLER_56_174 VDD VDD VSS VSS gf180mcu_fd_sc_mcu7t5v0__fill_1
XFILLER_84_450 VDD VDD VSS VSS gf180mcu_fd_sc_mcu7t5v0__fillcap_4
Xwave_controller_y_inst__2795_ spi_regs_inst__1101_/A1 spi_regs_inst__1097_/A1 wave_controller_y_inst__2805_/S
+ wave_controller_y_inst__2795_/Z VDD VDD VSS VSS gf180mcu_fd_sc_mcu7t5v0__mux2_2
Xwave_controller_y_inst__1815_ spi_regs_inst__1599_/Q wave_controller_y_inst__3378_/A2
+ VDD VDD VSS VSS gf180mcu_fd_sc_mcu7t5v0__clkinv_1
XFILLER_151_78 VDD VDD VSS VSS gf180mcu_fd_sc_mcu7t5v0__fillcap_8
XFILLER_71_100 VDD VDD VSS VSS gf180mcu_fd_sc_mcu7t5v0__fillcap_4
XFILLER_72_656 VDD VDD VSS VSS gf180mcu_fd_sc_mcu7t5v0__fillcap_8
Xwave_controller_x_inst__2779_ wave_controller_x_inst__3719_/Q wave_controller_x_inst__2850_/A2
+ wave_controller_x_inst__2854_/A2 VDD VDD VSS VSS gf180mcu_fd_sc_mcu7t5v0__nor2_1
XFILLER_32_509 VDD VDD VSS VSS gf180mcu_fd_sc_mcu7t5v0__fill_2
XFILLER_60_807 VDD VDD VSS VSS gf180mcu_fd_sc_mcu7t5v0__fillcap_4
XFILLER_72_667 VDD VDD VSS VSS gf180mcu_fd_sc_mcu7t5v0__fillcap_16
XFILLER_44_65 VDD VDD VSS VSS gf180mcu_fd_sc_mcu7t5v0__fillcap_32
XFILLER_12_244 VDD VDD VSS VSS gf180mcu_fd_sc_mcu7t5v0__fill_1
XFILLER_157_205 VDD VDD VSS VSS gf180mcu_fd_sc_mcu7t5v0__fill_1
XFILLER_40_553 VDD VDD VSS VSS gf180mcu_fd_sc_mcu7t5v0__fill_2
Xwave_controller_y_inst__3416_ wave_controller_y_inst__3420_/A1 wave_controller_y_inst__3494_/A1
+ wave_controller_y_inst__3416_/B wave_controller_y_inst__3417_/I VDD VDD VSS VSS
+ gf180mcu_fd_sc_mcu7t5v0__oai21_1
XFILLER_100_71 VDD VDD VSS VSS gf180mcu_fd_sc_mcu7t5v0__fillcap_8
XFILLER_12_255 VDD VDD VSS VSS gf180mcu_fd_sc_mcu7t5v0__fillcap_16
Xwave_controller_y_inst__3347_ wave_controller_y_inst__3350_/A1 wave_controller_y_inst__3315_/Z
+ wave_controller_y_inst__3350_/B wave_controller_y_inst__3347_/B wave_controller_y_inst__3348_/A2
+ VDD VDD VSS VSS gf180mcu_fd_sc_mcu7t5v0__oai31_1
XFILLER_153_422 VDD VDD VSS VSS gf180mcu_fd_sc_mcu7t5v0__fill_2
XFILLER_165_282 VDD VDD VSS VSS gf180mcu_fd_sc_mcu7t5v0__fill_1
Xwave_controller_y_inst__3278_ wave_controller_y_inst__3279_/A1 spi_regs_inst__1600_/Q
+ wave_controller_y_inst__3278_/Z VDD VDD VSS VSS gf180mcu_fd_sc_mcu7t5v0__and2_1
XFILLER_4_410 VDD VDD VSS VSS gf180mcu_fd_sc_mcu7t5v0__fill_1
Xwave_controller_y_inst__2229_ wave_controller_y_inst__2229_/A1 wave_controller_y_inst__2228_/Z
+ wave_controller_y_inst__2229_/Z VDD VDD VSS VSS gf180mcu_fd_sc_mcu7t5v0__xor2_1
XFILLER_125_179 VDD VDD VSS VSS gf180mcu_fd_sc_mcu7t5v0__fill_1
XFILLER_4_454 VDD VDD VSS VSS gf180mcu_fd_sc_mcu7t5v0__fill_1
XFILLER_107_894 VDD VDD VSS VSS gf180mcu_fd_sc_mcu7t5v0__fill_2
XFILLER_134_691 VDD VDD VSS VSS gf180mcu_fd_sc_mcu7t5v0__fillcap_4
XFILLER_69_62 VDD VDD VSS VSS gf180mcu_fd_sc_mcu7t5v0__fillcap_8
XFILLER_121_352 VDD VDD VSS VSS gf180mcu_fd_sc_mcu7t5v0__fillcap_16
XFILLER_79_288 VDD VDD VSS VSS gf180mcu_fd_sc_mcu7t5v0__fill_1
XFILLER_79_299 VDD VDD VSS VSS gf180mcu_fd_sc_mcu7t5v0__fill_2
XTAP_TAPCELL_ROW_89_1340 VDD VSS gf180mcu_fd_sc_mcu7t5v0__filltie
Xwave_controller_y_inst_max_cap41 wave_controller_y_inst__3494_/A2 wave_controller_y_inst__3447_/S
+ VDD VDD VSS VSS gf180mcu_fd_sc_mcu7t5v0__buf_2
XFILLER_63_601 VDD VDD VSS VSS gf180mcu_fd_sc_mcu7t5v0__fillcap_4
XFILLER_76_984 VDD VDD VSS VSS gf180mcu_fd_sc_mcu7t5v0__fillcap_16
XTAP_TAPCELL_ROW_89_1351 VDD VSS gf180mcu_fd_sc_mcu7t5v0__filltie
Xspi_regs_inst__1654_ spi_regs_inst__1654_/D fanout563/Z clkbuf_leaf_7_clk/Z spi_regs_inst__1654_/Q
+ VDD VDD VSS VSS gf180mcu_fd_sc_mcu7t5v0__dffrnq_1
XFILLER_62_177 VDD VDD VSS VSS gf180mcu_fd_sc_mcu7t5v0__fillcap_16
XTAP_TAPCELL_ROW_61_879 VDD VSS gf180mcu_fd_sc_mcu7t5v0__filltie
Xspi_regs_inst__1585_ spi_regs_inst__1585_/D load_slew576/Z clkbuf_leaf_41_clk/Z spi_regs_inst__1585_/Q
+ VDD VDD VSS VSS gf180mcu_fd_sc_mcu7t5v0__dffrnq_1
XTAP_TAPCELL_ROW_9_1_396 VDD VSS gf180mcu_fd_sc_mcu7t5v0__filltie
XFILLER_145_912 VDD VDD VSS VSS gf180mcu_fd_sc_mcu7t5v0__fillcap_64
XFILLER_79_2 VDD VDD VSS VSS gf180mcu_fd_sc_mcu7t5v0__fillcap_8
XFILLER_116_102 VDD VDD VSS VSS gf180mcu_fd_sc_mcu7t5v0__fill_2
XFILLER_157_772 VDD VDD VSS VSS gf180mcu_fd_sc_mcu7t5v0__fillcap_64
XFILLER_89_1154 VDD VDD VSS VSS gf180mcu_fd_sc_mcu7t5v0__fillcap_16
XFILLER_105_809 VDD VDD VSS VSS gf180mcu_fd_sc_mcu7t5v0__fill_2
XTAP_TAPCELL_ROW_133_2072 VDD VSS gf180mcu_fd_sc_mcu7t5v0__filltie
XFILLER_113_842 VDD VDD VSS VSS gf180mcu_fd_sc_mcu7t5v0__fillcap_4
XFILLER_132_639 VDD VDD VSS VSS gf180mcu_fd_sc_mcu7t5v0__fillcap_8
XFILLER_98_553 VDD VDD VSS VSS gf180mcu_fd_sc_mcu7t5v0__fill_1
Xspi_regs_inst__1019_ spi_regs_inst__1019_/A1 spi_regs_inst__1019_/A2 spi_regs_inst_wire222/I
+ VDD VDD VSS VSS gf180mcu_fd_sc_mcu7t5v0__nor2_1
XFILLER_113_897 VDD VDD VSS VSS gf180mcu_fd_sc_mcu7t5v0__fillcap_4
XFILLER_86_737 VDD VDD VSS VSS gf180mcu_fd_sc_mcu7t5v0__fillcap_4
XFILLER_100_558 VDD VDD VSS VSS gf180mcu_fd_sc_mcu7t5v0__fillcap_4
Xwave_controller_x_inst__3682_ wave_controller_x_inst__3682_/D wave_controller_x_inst__3682_/RN
+ clkload34/I spi_regs_inst__1250_/B2 VDD VDD VSS VSS gf180mcu_fd_sc_mcu7t5v0__dffrnq_1
Xwave_controller_x_inst__2702_ wave_controller_x_inst__3352_/B wave_controller_x_inst__2699_/Z
+ wave_controller_x_inst__2702_/A3 wave_controller_x_inst__2702_/Z VDD VDD VSS VSS
+ gf180mcu_fd_sc_mcu7t5v0__xor3_1
XTAP_TAPCELL_ROW_47_1_685 VDD VSS gf180mcu_fd_sc_mcu7t5v0__filltie
Xwave_controller_x_inst__2633_ wave_controller_x_inst__2633_/A1 wave_controller_x_inst__2633_/A2
+ wave_controller_x_inst__2633_/B wave_controller_x_inst__2633_/C wave_controller_x_inst_wire85/I
+ VDD VDD VSS VSS gf180mcu_fd_sc_mcu7t5v0__aoi211_1
XFILLER_26_314 VDD VDD VSS VSS gf180mcu_fd_sc_mcu7t5v0__fill_1
XFILLER_38_174 VDD VDD VSS VSS gf180mcu_fd_sc_mcu7t5v0__fill_1
XFILLER_53_100 VDD VDD VSS VSS gf180mcu_fd_sc_mcu7t5v0__fill_2
XFILLER_82_943 VDD VDD VSS VSS gf180mcu_fd_sc_mcu7t5v0__fill_2
Xwave_controller_y_inst__2580_ wave_controller_y_inst__2616_/C max_cap432/Z wave_controller_y_inst__2580_/Z
+ VDD VDD VSS VSS gf180mcu_fd_sc_mcu7t5v0__xor2_1
XFILLER_41_306 VDD VDD VSS VSS gf180mcu_fd_sc_mcu7t5v0__fill_2
XFILLER_54_667 VDD VDD VSS VSS gf180mcu_fd_sc_mcu7t5v0__fill_2
XFILLER_96_1169 VDD VDD VSS VSS gf180mcu_fd_sc_mcu7t5v0__fill_1
Xwave_controller_x_inst__2564_ wave_controller_x_inst__2564_/A1 wave_controller_x_inst__2563_/B
+ spi_regs_inst_wire86/I VDD VDD VSS VSS gf180mcu_fd_sc_mcu7t5v0__xnor2_1
Xwave_controller_x_inst__2495_ wave_controller_x_inst__3506_/B2 wave_controller_x_inst__2493_/Z
+ wave_controller_x_inst__2497_/B VDD VDD VSS VSS gf180mcu_fd_sc_mcu7t5v0__xor2_1
XTAP_TAPCELL_ROW_153_2404 VDD VSS gf180mcu_fd_sc_mcu7t5v0__filltie
XTAP_TAPCELL_ROW_21_1_487 VDD VSS gf180mcu_fd_sc_mcu7t5v0__filltie
Xwave_controller_y_inst__3201_ wave_controller_y_inst__1818_/I wave_controller_y_inst__3244_/A2
+ wave_controller_y_inst__3245_/C VDD VDD VSS VSS gf180mcu_fd_sc_mcu7t5v0__nor2_1
Xwave_controller_y_inst__3132_ wave_controller_y_inst__3702_/Q spi_regs_inst__1584_/Q
+ wave_controller_y_inst__3133_/B VDD VDD VSS VSS gf180mcu_fd_sc_mcu7t5v0__xor2_1
XFILLER_135_411 VDD VDD VSS VSS gf180mcu_fd_sc_mcu7t5v0__fill_2
XFILLER_154_208 VDD VDD VSS VSS gf180mcu_fd_sc_mcu7t5v0__fill_1
XTAP_TAPCELL_ROW_118_1823 VDD VSS gf180mcu_fd_sc_mcu7t5v0__filltie
Xwave_controller_x_inst__3116_ wave_controller_x_inst__1792_/I wave_controller_x_inst__3213_/A2
+ wave_controller_x_inst__3211_/A1 VDD VDD VSS VSS gf180mcu_fd_sc_mcu7t5v0__nand2_1
XFILLER_107_146 VDD VDD VSS VSS gf180mcu_fd_sc_mcu7t5v0__fill_2
XFILLER_108_658 VDD VDD VSS VSS gf180mcu_fd_sc_mcu7t5v0__fillcap_4
XFILLER_135_422 VDD VDD VSS VSS gf180mcu_fd_sc_mcu7t5v0__fillcap_16
XFILLER_147_282 VDD VDD VSS VSS gf180mcu_fd_sc_mcu7t5v0__fill_2
XFILLER_30_34 VDD VDD VSS VSS gf180mcu_fd_sc_mcu7t5v0__fill_1
Xwave_controller_y_inst__3063_ wave_controller_y_inst__3305_/B2 wave_controller_y_inst__3090_/B1
+ wave_controller_y_inst__3063_/B1 wave_controller_y_inst__3063_/B2 wave_controller_y_inst__3709_/D
+ VDD VDD VSS VSS gf180mcu_fd_sc_mcu7t5v0__oai22_1
Xwave_controller_x_inst__3047_ wave_controller_x_inst__3704_/Q spi_regs_inst__1473_/Q
+ wave_controller_x_inst__3047_/A3 wave_controller_x_inst__3047_/Z VDD VDD VSS VSS
+ gf180mcu_fd_sc_mcu7t5v0__xor3_1
XFILLER_146_34 VDD VDD VSS VSS gf180mcu_fd_sc_mcu7t5v0__fill_1
Xwave_controller_y_inst__2014_ wave_controller_y_inst__1816_/I wave_controller_y_inst__2379_/A1
+ wave_controller_y_inst__2024_/A1 VDD VDD VSS VSS gf180mcu_fd_sc_mcu7t5v0__nor2_1
XFILLER_1_413 VDD VDD VSS VSS gf180mcu_fd_sc_mcu7t5v0__fillcap_4
XFILLER_89_531 VDD VDD VSS VSS gf180mcu_fd_sc_mcu7t5v0__fillcap_16
XFILLER_103_352 VDD VDD VSS VSS gf180mcu_fd_sc_mcu7t5v0__fillcap_4
XFILLER_77_748 VDD VDD VSS VSS gf180mcu_fd_sc_mcu7t5v0__fillcap_4
Xwave_controller_y_inst__2916_ wave_controller_y_inst__3584_/I0 spi_regs_inst__1278_/A1
+ wave_controller_y_inst__3602_/S wave_controller_y_inst__3683_/D VDD VDD VSS VSS
+ gf180mcu_fd_sc_mcu7t5v0__mux2_2
XTAP_TAPCELL_ROW_164_2577 VDD VSS gf180mcu_fd_sc_mcu7t5v0__filltie
XTAP_TAPCELL_ROW_164_2588 VDD VSS gf180mcu_fd_sc_mcu7t5v0__filltie
Xwave_controller_y_inst__2847_ wave_controller_y_inst__3081_/B wave_controller_y_inst__2847_/A2
+ wave_controller_y_inst__2847_/Z VDD VDD VSS VSS gf180mcu_fd_sc_mcu7t5v0__and2_1
XFILLER_17_325 VDD VDD VSS VSS gf180mcu_fd_sc_mcu7t5v0__fill_2
Xwave_controller_y_inst__2778_ spi_regs_inst__1150_/A1 wave_controller_y_inst__2844_/A2
+ wave_controller_y_inst__2778_/B wave_controller_y_inst__2850_/A2 VDD VDD VSS VSS
+ gf180mcu_fd_sc_mcu7t5v0__oai21_1
XFILLER_44_166 VDD VDD VSS VSS gf180mcu_fd_sc_mcu7t5v0__fillcap_8
XFILLER_44_177 VDD VDD VSS VSS gf180mcu_fd_sc_mcu7t5v0__fillcap_4
XFILLER_72_497 VDD VDD VSS VSS gf180mcu_fd_sc_mcu7t5v0__fill_2
XTAP_TAPCELL_ROW_84_1270 VDD VSS gf180mcu_fd_sc_mcu7t5v0__filltie
XFILLER_129_1170 VDD VDD VSS VSS gf180mcu_fd_sc_mcu7t5v0__fillcap_4
XFILLER_71_52 VDD VDD VSS VSS gf180mcu_fd_sc_mcu7t5v0__fill_2
XFILLER_9_524 VDD VDD VSS VSS gf180mcu_fd_sc_mcu7t5v0__fillcap_4
Xspi_regs_inst__1370_ spi_regs_inst__1370_/A1 spi_regs_inst__1379_/S spi_regs_inst__1370_/B
+ spi_regs_inst__1653_/D VDD VDD VSS VSS gf180mcu_fd_sc_mcu7t5v0__oai21_1
XFILLER_139_750 VDD VDD VSS VSS gf180mcu_fd_sc_mcu7t5v0__fill_2
XTAP_TAPCELL_ROW_80_1189 VDD VSS gf180mcu_fd_sc_mcu7t5v0__filltie
XFILLER_139_772 VDD VDD VSS VSS gf180mcu_fd_sc_mcu7t5v0__fillcap_4
XFILLER_126_488 VDD VDD VSS VSS gf180mcu_fd_sc_mcu7t5v0__fillcap_8
XFILLER_107_691 VDD VDD VSS VSS gf180mcu_fd_sc_mcu7t5v0__fill_2
Xsignal_processor_y_inst__251_ signal_processor_y_inst__251_/D signal_processor_y_inst__253_/RN
+ clkbuf_leaf_0_clk/Z signal_processor_y_inst__251_/Q VDD VDD VSS VSS gf180mcu_fd_sc_mcu7t5v0__dffrnq_1
XFILLER_68_737 VDD VDD VSS VSS gf180mcu_fd_sc_mcu7t5v0__fillcap_32
XFILLER_95_534 VDD VDD VSS VSS gf180mcu_fd_sc_mcu7t5v0__fill_1
Xsignal_processor_y_inst__182_ signal_processor_y_inst__239_/Q signal_processor_y_inst__183_/A1
+ signal_processor_y_inst__182_/Z VDD VDD VSS VSS gf180mcu_fd_sc_mcu7t5v0__xor2_1
XFILLER_48_461 VDD VDD VSS VSS gf180mcu_fd_sc_mcu7t5v0__fillcap_16
XFILLER_90_283 VDD VDD VSS VSS gf180mcu_fd_sc_mcu7t5v0__fill_1
XFILLER_91_795 VDD VDD VSS VSS gf180mcu_fd_sc_mcu7t5v0__fillcap_4
XFILLER_149_514 VDD VDD VSS VSS gf180mcu_fd_sc_mcu7t5v0__fillcap_8
Xspi_regs_inst__1637_ spi_regs_inst__1637_/D spi_regs_inst__1659_/RN clkload8/I spi_regs_inst__1637_/Q
+ VDD VDD VSS VSS gf180mcu_fd_sc_mcu7t5v0__dffrnq_1
Xwave_controller_x_inst__2280_ wave_controller_x_inst__2277_/Z wave_controller_x_inst__2280_/A2
+ wave_controller_x_inst__2280_/Z VDD VDD VSS VSS gf180mcu_fd_sc_mcu7t5v0__xor2_1
Xspi_regs_inst__1568_ spi_regs_inst__1568_/D spi_regs_inst__1649_/RN clkbuf_leaf_41_clk/Z
+ spi_regs_inst__1568_/Q VDD VDD VSS VSS gf180mcu_fd_sc_mcu7t5v0__dffrnq_1
XFILLER_149_558 VDD VDD VSS VSS gf180mcu_fd_sc_mcu7t5v0__fill_2
XTAP_TAPCELL_ROW_135_2101 VDD VSS gf180mcu_fd_sc_mcu7t5v0__filltie
XTAP_TAPCELL_ROW_135_2112 VDD VSS gf180mcu_fd_sc_mcu7t5v0__filltie
XFILLER_129_271 VDD VDD VSS VSS gf180mcu_fd_sc_mcu7t5v0__fill_2
Xspi_regs_inst__1499_ spi_regs_inst__1499_/D spi_regs_inst__1527_/RN clkbuf_leaf_38_clk/Z
+ spi_regs_inst__1499_/Q VDD VDD VSS VSS gf180mcu_fd_sc_mcu7t5v0__dffrnq_1
XFILLER_117_422 VDD VDD VSS VSS gf180mcu_fd_sc_mcu7t5v0__fillcap_16
XFILLER_129_282 VDD VDD VSS VSS gf180mcu_fd_sc_mcu7t5v0__fillcap_16
XFILLER_105_628 VDD VDD VSS VSS gf180mcu_fd_sc_mcu7t5v0__fill_2
XFILLER_133_904 VDD VDD VSS VSS gf180mcu_fd_sc_mcu7t5v0__fillcap_4
XFILLER_144_263 VDD VDD VSS VSS gf180mcu_fd_sc_mcu7t5v0__fillcap_4
XTAP_TAPCELL_ROW_113_1742 VDD VSS gf180mcu_fd_sc_mcu7t5v0__filltie
XFILLER_98_350 VDD VDD VSS VSS gf180mcu_fd_sc_mcu7t5v0__fill_2
XFILLER_86_523 VDD VDD VSS VSS gf180mcu_fd_sc_mcu7t5v0__fill_2
Xfanout547 fanout570/Z fanout547/Z VDD VDD VSS VSS gf180mcu_fd_sc_mcu7t5v0__dlyb_1
Xfanout536 fanout536/I fanout536/Z VDD VDD VSS VSS gf180mcu_fd_sc_mcu7t5v0__dlyb_1
Xwave_controller_x_inst__3734_ wave_controller_x_inst__3734_/D fanout595/Z clkbuf_leaf_20_clk/Z
+ wave_controller_x_inst__3734_/Q VDD VDD VSS VSS gf180mcu_fd_sc_mcu7t5v0__dffrnq_1
Xwave_controller_x_inst__1995_ fanout540/Z wave_controller_x_inst__2318_/A1 wave_controller_x_inst__2001_/A1
+ VDD VDD VSS VSS gf180mcu_fd_sc_mcu7t5v0__nand2_1
Xfanout569 fanout570/Z fanout569/Z VDD VDD VSS VSS gf180mcu_fd_sc_mcu7t5v0__dlyb_1
Xfanout558 fanout560/Z fanout558/Z VDD VDD VSS VSS gf180mcu_fd_sc_mcu7t5v0__dlyb_1
XFILLER_86_589 VDD VDD VSS VSS gf180mcu_fd_sc_mcu7t5v0__fillcap_4
XTAP_TAPCELL_ROW_146_2285 VDD VSS gf180mcu_fd_sc_mcu7t5v0__filltie
Xwave_controller_y_inst__2701_ wave_controller_y_inst__2699_/Z wave_controller_y_inst__2702_/A3
+ wave_controller_y_inst__2723_/A2 VDD VDD VSS VSS gf180mcu_fd_sc_mcu7t5v0__xnor2_1
XFILLER_132_47 VDD VDD VSS VSS gf180mcu_fd_sc_mcu7t5v0__fill_1
XFILLER_67_781 VDD VDD VSS VSS gf180mcu_fd_sc_mcu7t5v0__fillcap_8
Xwave_controller_y_inst__3681_ wave_controller_y_inst__3681_/D wave_controller_y_inst__3683_/RN
+ clkbuf_leaf_46_clk/Z spi_regs_inst__1179_/A1 VDD VDD VSS VSS gf180mcu_fd_sc_mcu7t5v0__dffrnq_1
Xwave_controller_x_inst__3665_ wave_controller_x_inst__3665_/D wave_controller_x_inst__3686_/RN
+ clkload27/I spi_regs_inst__1060_/A1 VDD VDD VSS VSS gf180mcu_fd_sc_mcu7t5v0__dffrnq_1
XFILLER_26_122 VDD VDD VSS VSS gf180mcu_fd_sc_mcu7t5v0__fillcap_4
XFILLER_55_976 VDD VDD VSS VSS gf180mcu_fd_sc_mcu7t5v0__fillcap_4
XFILLER_66_291 VDD VDD VSS VSS gf180mcu_fd_sc_mcu7t5v0__fill_1
Xwave_controller_y_inst__2632_ wave_controller_y_inst__2604_/I wave_controller_y_inst__2634_/C
+ wave_controller_y_inst__2627_/Z wave_controller_y_inst__2633_/C VDD VDD VSS VSS
+ gf180mcu_fd_sc_mcu7t5v0__nand3_1
Xwave_controller_x_inst__3596_ wave_controller_x_inst__3596_/I0 spi_regs_inst__1128_/B2
+ wave_controller_x_inst__3601_/S wave_controller_x_inst__3672_/D VDD VDD VSS VSS
+ gf180mcu_fd_sc_mcu7t5v0__mux2_2
Xwave_controller_x_inst__2616_ wave_controller_x_inst__2616_/A1 spi_regs_inst__1186_/B2
+ max_cap464/Z wave_controller_x_inst__2616_/C wave_controller_x_inst__2619_/C VDD
+ VDD VSS VSS gf180mcu_fd_sc_mcu7t5v0__aoi211_1
XFILLER_14_306 VDD VDD VSS VSS gf180mcu_fd_sc_mcu7t5v0__fillcap_8
XFILLER_14_317 VDD VDD VSS VSS gf180mcu_fd_sc_mcu7t5v0__fillcap_8
XFILLER_26_177 VDD VDD VSS VSS gf180mcu_fd_sc_mcu7t5v0__fill_2
XFILLER_82_784 VDD VDD VSS VSS gf180mcu_fd_sc_mcu7t5v0__fillcap_16
Xwave_controller_y_inst__2563_ wave_controller_y_inst__2563_/A1 wave_controller_y_inst__2544_/Z
+ wave_controller_y_inst__2563_/B wave_controller_y_inst_wire89/I VDD VDD VSS VSS
+ gf180mcu_fd_sc_mcu7t5v0__oai21_1
Xwave_controller_x_inst__2547_ wave_controller_x_inst__2563_/A1 wave_controller_x_inst__2544_/Z
+ wave_controller_x_inst__2564_/A1 VDD VDD VSS VSS gf180mcu_fd_sc_mcu7t5v0__nor2_1
XFILLER_41_147 VDD VDD VSS VSS gf180mcu_fd_sc_mcu7t5v0__fillcap_8
Xwave_controller_y_inst__2494_ spi_regs_inst__1183_/A1 wave_controller_y_inst__2493_/Z
+ wave_controller_y_inst__2506_/B VDD VDD VSS VSS gf180mcu_fd_sc_mcu7t5v0__nand2_1
Xwave_controller_x_inst__2478_ wave_controller_x_inst__3503_/B2 wave_controller_x_inst__2476_/Z
+ wave_controller_x_inst__2479_/I VDD VDD VSS VSS gf180mcu_fd_sc_mcu7t5v0__xor2_1
XFILLER_109_912 VDD VDD VSS VSS gf180mcu_fd_sc_mcu7t5v0__fillcap_64
XFILLER_6_527 VDD VDD VSS VSS gf180mcu_fd_sc_mcu7t5v0__fill_1
XFILLER_136_753 VDD VDD VSS VSS gf180mcu_fd_sc_mcu7t5v0__fillcap_4
XFILLER_6_538 VDD VDD VSS VSS gf180mcu_fd_sc_mcu7t5v0__fillcap_16
XPHY_EDGE_ROW_157_Right_157 VDD VSS gf180mcu_fd_sc_mcu7t5v0__endcap
Xwave_controller_y_inst__3115_ wave_controller_y_inst__3305_/B2 spi_regs_inst__1591_/Q
+ wave_controller_y_inst__3115_/Z VDD VDD VSS VSS gf180mcu_fd_sc_mcu7t5v0__and2_1
XFILLER_136_764 VDD VDD VSS VSS gf180mcu_fd_sc_mcu7t5v0__fillcap_32
XFILLER_157_88 VDD VDD VSS VSS gf180mcu_fd_sc_mcu7t5v0__fillcap_4
XFILLER_163_550 VDD VDD VSS VSS gf180mcu_fd_sc_mcu7t5v0__fill_2
Xwave_controller_y_inst__3046_ wave_controller_y_inst_wire147/Z wave_controller_y_inst__2966_/Z
+ wave_controller_y_inst__3046_/A3 wave_controller_y_inst__3059_/A2 wave_controller_y_inst__3562_/A1
+ wave_controller_y_inst__3703_/D VDD VDD VSS VSS gf180mcu_fd_sc_mcu7t5v0__oai32_1
XFILLER_108_488 VDD VDD VSS VSS gf180mcu_fd_sc_mcu7t5v0__fill_2
XFILLER_9_2 VDD VDD VSS VSS gf180mcu_fd_sc_mcu7t5v0__fillcap_64
XFILLER_123_469 VDD VDD VSS VSS gf180mcu_fd_sc_mcu7t5v0__fillcap_4
XFILLER_151_756 VDD VDD VSS VSS gf180mcu_fd_sc_mcu7t5v0__fillcap_8
XTAP_TAPCELL_ROW_166_2617 VDD VSS gf180mcu_fd_sc_mcu7t5v0__filltie
XFILLER_1_276 VDD VDD VSS VSS gf180mcu_fd_sc_mcu7t5v0__fillcap_4
XFILLER_77_589 VDD VDD VSS VSS gf180mcu_fd_sc_mcu7t5v0__fill_1
XTAP_TAPCELL_ROW_69_1018 VDD VSS gf180mcu_fd_sc_mcu7t5v0__filltie
XTAP_TAPCELL_ROW_8_1_395 VDD VSS gf180mcu_fd_sc_mcu7t5v0__filltie
Xspi_regs_inst__0870_ spi_regs_inst__1606_/Q spi_regs_inst__1445_/I1 spi_regs_inst__0870_/S
+ spi_regs_inst__1606_/D VDD VDD VSS VSS gf180mcu_fd_sc_mcu7t5v0__mux2_2
XFILLER_64_239 VDD VDD VSS VSS gf180mcu_fd_sc_mcu7t5v0__fillcap_4
XFILLER_92_548 VDD VDD VSS VSS gf180mcu_fd_sc_mcu7t5v0__fill_1
XTAP_TAPCELL_ROW_63_919 VDD VSS gf180mcu_fd_sc_mcu7t5v0__filltie
XFILLER_17_177 VDD VDD VSS VSS gf180mcu_fd_sc_mcu7t5v0__fillcap_16
XFILLER_45_486 VDD VDD VSS VSS gf180mcu_fd_sc_mcu7t5v0__fillcap_4
XFILLER_60_401 VDD VDD VSS VSS gf180mcu_fd_sc_mcu7t5v0__fill_1
XFILLER_73_784 VDD VDD VSS VSS gf180mcu_fd_sc_mcu7t5v0__fill_2
XTAP_TAPCELL_ROW_82_1229 VDD VSS gf180mcu_fd_sc_mcu7t5v0__filltie
XFILLER_61_979 VDD VDD VSS VSS gf180mcu_fd_sc_mcu7t5v0__fill_1
XPHY_EDGE_ROW_72_Left_239 VDD VSS gf180mcu_fd_sc_mcu7t5v0__endcap
Xspi_regs_inst__1422_ spi_regs_inst__1437_/A1 spi_regs_inst__1422_/A2 spi_regs_inst__1437_/A3
+ spi_regs_inst__1427_/S VDD VDD VSS VSS gf180mcu_fd_sc_mcu7t5v0__or3_1
XTAP_TAPCELL_ROW_38_1_616 VDD VSS gf180mcu_fd_sc_mcu7t5v0__filltie
Xspi_regs_inst__1353_ spi_regs_inst__1353_/A1 spi_regs_inst__1353_/A2 spi_regs_inst__1353_/B1
+ spi_regs_inst__1353_/B2 spi_regs_inst__1355_/A3 VDD VDD VSS VSS gf180mcu_fd_sc_mcu7t5v0__aoi22_1
XFILLER_127_720 VDD VDD VSS VSS gf180mcu_fd_sc_mcu7t5v0__fillcap_8
XPHY_EDGE_ROW_124_Right_124 VDD VSS gf180mcu_fd_sc_mcu7t5v0__endcap
XTAP_TAPCELL_ROW_46_1_673 VDD VSS gf180mcu_fd_sc_mcu7t5v0__filltie
Xspi_regs_inst__1284_ spi_regs_inst__1284_/A1 spi_regs_inst__1337_/A2 spi_regs_inst_wire227/Z
+ spi_regs_inst__1284_/B2 spi_regs_inst__1287_/A2 VDD VDD VSS VSS gf180mcu_fd_sc_mcu7t5v0__aoi22_1
XFILLER_126_263 VDD VDD VSS VSS gf180mcu_fd_sc_mcu7t5v0__fillcap_8
XFILLER_142_712 VDD VDD VSS VSS gf180mcu_fd_sc_mcu7t5v0__fill_2
XFILLER_154_550 VDD VDD VSS VSS gf180mcu_fd_sc_mcu7t5v0__fillcap_16
XTAP_TAPCELL_ROW_97_1483 VDD VSS gf180mcu_fd_sc_mcu7t5v0__filltie
XTAP_TAPCELL_ROW_97_1472 VDD VSS gf180mcu_fd_sc_mcu7t5v0__filltie
XFILLER_127_797 VDD VDD VSS VSS gf180mcu_fd_sc_mcu7t5v0__fill_1
XFILLER_142_734 VDD VDD VSS VSS gf180mcu_fd_sc_mcu7t5v0__fill_1
XFILLER_142_745 VDD VDD VSS VSS gf180mcu_fd_sc_mcu7t5v0__fillcap_4
XFILLER_154_594 VDD VDD VSS VSS gf180mcu_fd_sc_mcu7t5v0__fill_1
XFILLER_86_1157 VDD VDD VSS VSS gf180mcu_fd_sc_mcu7t5v0__fillcap_16
XPHY_EDGE_ROW_81_Left_248 VDD VSS gf180mcu_fd_sc_mcu7t5v0__endcap
XTAP_TAPCELL_ROW_130_2020 VDD VSS gf180mcu_fd_sc_mcu7t5v0__filltie
XFILLER_130_918 VDD VDD VSS VSS gf180mcu_fd_sc_mcu7t5v0__fillcap_16
XTAP_TAPCELL_ROW_12_1_418 VDD VSS gf180mcu_fd_sc_mcu7t5v0__filltie
XFILLER_141_277 VDD VDD VSS VSS gf180mcu_fd_sc_mcu7t5v0__fill_2
Xsignal_processor_y_inst__234_ signal_processor_y_inst__234_/D fanout556/Z clkload7/I
+ signal_processor_y_inst__234_/Q VDD VDD VSS VSS gf180mcu_fd_sc_mcu7t5v0__dffrnq_1
XFILLER_68_545 VDD VDD VSS VSS gf180mcu_fd_sc_mcu7t5v0__fill_1
Xsignal_processor_y_inst__165_ signal_processor_y_inst__233_/Q signal_processor_y_inst__167_/A2
+ signal_processor_y_inst__169_/A2 VDD VDD VSS VSS gf180mcu_fd_sc_mcu7t5v0__nand2_1
XFILLER_110_664 VDD VDD VSS VSS gf180mcu_fd_sc_mcu7t5v0__fill_1
XFILLER_95_364 VDD VDD VSS VSS gf180mcu_fd_sc_mcu7t5v0__fillcap_4
Xwave_controller_x_inst__1780_ spi_regs_inst__1514_/Q wave_controller_x_inst__1940_/A1
+ VDD VDD VSS VSS gf180mcu_fd_sc_mcu7t5v0__clkinv_1
Xwave_controller_x_inst__3450_ wave_controller_x_inst__3450_/A1 wave_controller_x_inst__3447_/Z
+ wave_controller_x_inst__3450_/B wave_controller_x_inst__3700_/Q wave_controller_x_inst__3452_/B1
+ VDD VDD VSS VSS gf180mcu_fd_sc_mcu7t5v0__aoi211_1
Xspi_regs_inst__0999_ spi_regs_inst__1029_/A1 spi_regs_inst__1031_/A2 spi_regs_inst__1203_/A2
+ VDD VDD VSS VSS gf180mcu_fd_sc_mcu7t5v0__nor2_1
XFILLER_23_103 VDD VDD VSS VSS gf180mcu_fd_sc_mcu7t5v0__fill_1
XFILLER_64_795 VDD VDD VSS VSS gf180mcu_fd_sc_mcu7t5v0__fill_2
XPHY_EDGE_ROW_90_Left_257 VDD VSS gf180mcu_fd_sc_mcu7t5v0__endcap
Xwave_controller_x_inst__2401_ wave_controller_x_inst__2379_/Z wave_controller_x_inst__2412_/A2
+ wave_controller_x_inst__2412_/C wave_controller_x_inst__2403_/A3 VDD VDD VSS VSS
+ gf180mcu_fd_sc_mcu7t5v0__aoi21_1
Xwave_controller_x_inst__3381_ wave_controller_x_inst__3381_/A1 wave_controller_x_inst__3381_/A2
+ fanout528/Z wave_controller_x_inst__3382_/B VDD VDD VSS VSS gf180mcu_fd_sc_mcu7t5v0__oai21_1
XFILLER_149_300 VDD VDD VSS VSS gf180mcu_fd_sc_mcu7t5v0__fillcap_16
XFILLER_51_489 VDD VDD VSS VSS gf180mcu_fd_sc_mcu7t5v0__fill_1
Xwave_controller_x_inst__2332_ wave_controller_x_inst__2349_/A1 max_cap452/Z wave_controller_x_inst__2332_/Z
+ VDD VDD VSS VSS gf180mcu_fd_sc_mcu7t5v0__xor2_1
Xwave_controller_x_inst__2263_ max_cap457/Z wave_controller_x_inst__2262_/Z wave_controller_x_inst__2278_/B
+ VDD VDD VSS VSS gf180mcu_fd_sc_mcu7t5v0__nand2_1
Xwave_controller_x_inst__2194_ wave_controller_x_inst__2194_/I wave_controller_x_inst__2222_/B2
+ VDD VDD VSS VSS gf180mcu_fd_sc_mcu7t5v0__clkinv_1
XFILLER_118_764 VDD VDD VSS VSS gf180mcu_fd_sc_mcu7t5v0__fill_1
Xwave_controller_y_inst_fanout416 wave_controller_y_inst__3720_/Q wave_controller_y_inst__1806_/I
+ VDD VDD VSS VSS gf180mcu_fd_sc_mcu7t5v0__dlyb_1
XFILLER_132_244 VDD VDD VSS VSS gf180mcu_fd_sc_mcu7t5v0__fill_1
XFILLER_133_778 VDD VDD VSS VSS gf180mcu_fd_sc_mcu7t5v0__fillcap_4
XFILLER_160_597 VDD VDD VSS VSS gf180mcu_fd_sc_mcu7t5v0__fillcap_16
XTAP_TAPCELL_ROW_148_2314 VDD VSS gf180mcu_fd_sc_mcu7t5v0__filltie
XTAP_TAPCELL_ROW_148_2325 VDD VSS gf180mcu_fd_sc_mcu7t5v0__filltie
XFILLER_98_1017 VDD VDD VSS VSS gf180mcu_fd_sc_mcu7t5v0__fillcap_64
Xwave_controller_y_inst__1994_ wave_controller_y_inst__1999_/B1 wave_controller_y_inst__1999_/B2
+ wave_controller_y_inst__1999_/C wave_controller_y_inst__1996_/A3 VDD VDD VSS VSS
+ gf180mcu_fd_sc_mcu7t5v0__oai21_1
Xwave_controller_x_inst__1978_ fanout523/Z wave_controller_x_inst__2254_/A1 wave_controller_x_inst__1980_/A1
+ VDD VDD VSS VSS gf180mcu_fd_sc_mcu7t5v0__nand2_1
Xfanout399 fanout400/Z fanout399/Z VDD VDD VSS VSS gf180mcu_fd_sc_mcu7t5v0__dlyb_1
XPHY_EDGE_ROW_129_Left_296 VDD VSS gf180mcu_fd_sc_mcu7t5v0__endcap
XTAP_TAPCELL_ROW_161_2536 VDD VSS gf180mcu_fd_sc_mcu7t5v0__filltie
Xwave_controller_y_inst__3733_ wave_controller_y_inst__3733_/D fanout544/Z clkload6/I
+ wave_controller_y_inst__3733_/Q VDD VDD VSS VSS gf180mcu_fd_sc_mcu7t5v0__dffrnq_1
Xwave_controller_x_inst__3717_ wave_controller_x_inst__3717_/D fanout598/Z clkbuf_leaf_22_clk/Z
+ wave_controller_x_inst__3717_/Q VDD VDD VSS VSS gf180mcu_fd_sc_mcu7t5v0__dffrnq_1
XFILLER_27_442 VDD VDD VSS VSS gf180mcu_fd_sc_mcu7t5v0__fillcap_16
XFILLER_74_559 VDD VDD VSS VSS gf180mcu_fd_sc_mcu7t5v0__fillcap_4
XTAP_TAPCELL_ROW_126_1955 VDD VSS gf180mcu_fd_sc_mcu7t5v0__filltie
Xwave_controller_y_inst_max_cap355 wave_controller_y_inst__2039_/B wave_controller_y_inst__2077_/A1
+ VDD VDD VSS VSS gf180mcu_fd_sc_mcu7t5v0__clkbuf_2
Xwave_controller_y_inst__3664_ wave_controller_y_inst__3664_/D wave_controller_y_inst__3711_/RN
+ clkload15/I max_cap425/I VDD VDD VSS VSS gf180mcu_fd_sc_mcu7t5v0__dffrnq_1
Xwave_controller_x_inst__3648_ wave_controller_x_inst__3648_/D fanout591/Z clkbuf_leaf_26_clk/Z
+ spi_regs_inst__1245_/B2 VDD VDD VSS VSS gf180mcu_fd_sc_mcu7t5v0__dffrnq_1
XFILLER_27_475 VDD VDD VSS VSS gf180mcu_fd_sc_mcu7t5v0__fillcap_4
XFILLER_42_412 VDD VDD VSS VSS gf180mcu_fd_sc_mcu7t5v0__fill_2
Xwave_controller_y_inst__2615_ wave_controller_y_inst__2615_/I wave_controller_y_inst__2637_/A1
+ VDD VDD VSS VSS gf180mcu_fd_sc_mcu7t5v0__clkinv_1
Xspi_regs_inst_max_cap237 spi_regs_inst__1151_/B1 spi_regs_inst__1357_/A2 VDD VDD
+ VSS VSS gf180mcu_fd_sc_mcu7t5v0__buf_2
Xspi_regs_inst_max_cap215 spi_regs_inst__1146_/B1 spi_regs_inst_wire214/I VDD VDD
+ VSS VSS gf180mcu_fd_sc_mcu7t5v0__buf_2
Xwave_controller_y_inst__3595_ wave_controller_y_inst__3595_/I0 spi_regs_inst__1090_/B2
+ wave_controller_y_inst__3597_/S wave_controller_y_inst__3671_/D VDD VDD VSS VSS
+ gf180mcu_fd_sc_mcu7t5v0__mux2_2
Xwave_controller_x_inst__3579_ wave_controller_x_inst__3588_/S wave_controller_x_inst__3608_/A2
+ wave_controller_x_inst__3579_/B wave_controller_x_inst__3659_/D VDD VDD VSS VSS
+ gf180mcu_fd_sc_mcu7t5v0__oai21_1
Xspi_regs_inst_max_cap259 spi_regs_inst__1304_/C1 spi_regs_inst__1342_/A2 VDD VDD
+ VSS VSS gf180mcu_fd_sc_mcu7t5v0__buf_2
Xspi_regs_inst_max_cap248 spi_regs_inst_wire249/Z spi_regs_inst__1156_/A2 VDD VDD
+ VSS VSS gf180mcu_fd_sc_mcu7t5v0__buf_2
XFILLER_146_2 VDD VDD VSS VSS gf180mcu_fd_sc_mcu7t5v0__fillcap_32
Xwave_controller_y_inst__2546_ wave_controller_y_inst__2544_/Z wave_controller_y_inst__2546_/A2
+ spi_regs_inst_wire90/I VDD VDD VSS VSS gf180mcu_fd_sc_mcu7t5v0__nor2_1
Xsignal_processor_x_inst__254_ signal_processor_x_inst__254_/D fanout595/Z clkbuf_leaf_20_clk/Z
+ signal_processor_x_inst__254_/Q VDD VDD VSS VSS gf180mcu_fd_sc_mcu7t5v0__dffrnq_1
XFILLER_126_1151 VDD VDD VSS VSS gf180mcu_fd_sc_mcu7t5v0__fillcap_4
XFILLER_156_804 VDD VDD VSS VSS gf180mcu_fd_sc_mcu7t5v0__fill_1
XTAP_TAPCELL_ROW_159_2498 VDD VSS gf180mcu_fd_sc_mcu7t5v0__filltie
Xwave_controller_y_inst__2477_ spi_regs_inst__1139_/A1 wave_controller_y_inst__2476_/Z
+ wave_controller_y_inst__2497_/A2 VDD VDD VSS VSS gf180mcu_fd_sc_mcu7t5v0__nand2_1
Xsignal_processor_x_inst__185_ signal_processor_x_inst__185_/I signal_processor_x_inst__187_/A2
+ VDD VDD VSS VSS gf180mcu_fd_sc_mcu7t5v0__clkinv_1
XFILLER_10_375 VDD VDD VSS VSS gf180mcu_fd_sc_mcu7t5v0__fill_1
XFILLER_155_347 VDD VDD VSS VSS gf180mcu_fd_sc_mcu7t5v0__fill_2
XFILLER_108_230 VDD VDD VSS VSS gf180mcu_fd_sc_mcu7t5v0__fillcap_8
XFILLER_124_734 VDD VDD VSS VSS gf180mcu_fd_sc_mcu7t5v0__fill_1
XFILLER_136_572 VDD VDD VSS VSS gf180mcu_fd_sc_mcu7t5v0__fillcap_4
XFILLER_136_594 VDD VDD VSS VSS gf180mcu_fd_sc_mcu7t5v0__fill_1
XTAP_TAPCELL_ROW_79_1180 VDD VSS gf180mcu_fd_sc_mcu7t5v0__filltie
XFILLER_123_222 VDD VDD VSS VSS gf180mcu_fd_sc_mcu7t5v0__fill_2
Xwave_controller_y_inst__3029_ wave_controller_y_inst__3458_/A1 wave_controller_y_inst__3029_/A2
+ wave_controller_y_inst__3029_/B1 wave_controller_y_inst__3034_/B1 wave_controller_y_inst__3696_/D
+ VDD VDD VSS VSS gf180mcu_fd_sc_mcu7t5v0__aoi22_1
XFILLER_111_428 VDD VDD VSS VSS gf180mcu_fd_sc_mcu7t5v0__fill_1
XFILLER_123_255 VDD VDD VSS VSS gf180mcu_fd_sc_mcu7t5v0__fillcap_4
XFILLER_133_1122 VDD VDD VSS VSS gf180mcu_fd_sc_mcu7t5v0__fillcap_32
XFILLER_77_62 VDD VDD VSS VSS gf180mcu_fd_sc_mcu7t5v0__fill_2
XTAP_TAPCELL_ROW_92_1391 VDD VSS gf180mcu_fd_sc_mcu7t5v0__filltie
XFILLER_65_504 VDD VDD VSS VSS gf180mcu_fd_sc_mcu7t5v0__fill_2
XFILLER_65_515 VDD VDD VSS VSS gf180mcu_fd_sc_mcu7t5v0__fillcap_16
XFILLER_77_342 VDD VDD VSS VSS gf180mcu_fd_sc_mcu7t5v0__fillcap_8
Xspi_regs_inst__0922_ spi_regs_inst__0928_/B spi_regs_inst__0928_/A2 spi_regs_inst__0926_/B1
+ VDD VDD VSS VSS gf180mcu_fd_sc_mcu7t5v0__nand2_1
XFILLER_37_228 VDD VDD VSS VSS gf180mcu_fd_sc_mcu7t5v0__fillcap_4
XTAP_TAPCELL_ROW_49_1_699 VDD VSS gf180mcu_fd_sc_mcu7t5v0__filltie
XFILLER_93_50 VDD VDD VSS VSS gf180mcu_fd_sc_mcu7t5v0__fill_2
Xwave_controller_y_inst_load_slew549 wave_controller_y_inst__3618_/RN wave_controller_y_inst__3739_/RN
+ VDD VDD VSS VSS gf180mcu_fd_sc_mcu7t5v0__buf_4
Xspi_regs_inst__0853_ spi_regs_inst__0880_/A2 spi_regs_inst__1386_/A1 spi_regs_inst__0861_/S
+ VDD VDD VSS VSS gf180mcu_fd_sc_mcu7t5v0__nor2_1
XFILLER_33_412 VDD VDD VSS VSS gf180mcu_fd_sc_mcu7t5v0__fillcap_8
XFILLER_93_61 VDD VDD VSS VSS gf180mcu_fd_sc_mcu7t5v0__fill_1
XFILLER_93_72 VDD VDD VSS VSS gf180mcu_fd_sc_mcu7t5v0__fillcap_16
Xspi_regs_inst__0784_ spi_regs_inst__1448_/I1 spi_regs_inst__1537_/Q spi_regs_inst__0787_/S
+ spi_regs_inst__1537_/D VDD VDD VSS VSS gf180mcu_fd_sc_mcu7t5v0__mux2_2
XFILLER_61_787 VDD VDD VSS VSS gf180mcu_fd_sc_mcu7t5v0__fillcap_16
XFILLER_20_128 VDD VDD VSS VSS gf180mcu_fd_sc_mcu7t5v0__fill_1
XFILLER_33_489 VDD VDD VSS VSS gf180mcu_fd_sc_mcu7t5v0__fill_1
Xspi_regs_inst__1405_ spi_regs_inst__1478_/Q spi_regs_inst__1405_/I1 spi_regs_inst__1410_/S
+ spi_regs_inst__1478_/D VDD VDD VSS VSS gf180mcu_fd_sc_mcu7t5v0__mux2_2
XTAP_TAPCELL_ROW_99_1512 VDD VSS gf180mcu_fd_sc_mcu7t5v0__filltie
Xspi_regs_inst__1336_ spi_regs_inst__1336_/A1 spi_regs_inst__1336_/A2 spi_regs_inst__1336_/B1
+ spi_regs_inst__1336_/B2 spi_regs_inst__1338_/A3 VDD VDD VSS VSS gf180mcu_fd_sc_mcu7t5v0__aoi22_1
XFILLER_162_807 VDD VDD VSS VSS gf180mcu_fd_sc_mcu7t5v0__fillcap_64
XFILLER_61_2 VDD VDD VSS VSS gf180mcu_fd_sc_mcu7t5v0__fill_2
XFILLER_115_734 VDD VDD VSS VSS gf180mcu_fd_sc_mcu7t5v0__fill_2
XFILLER_138_1011 VDD VDD VSS VSS gf180mcu_fd_sc_mcu7t5v0__fillcap_4
XFILLER_154_380 VDD VDD VSS VSS gf180mcu_fd_sc_mcu7t5v0__fill_1
Xspi_regs_inst__1267_ spi_regs_inst__1647_/Q spi_regs_inst__1266_/S spi_regs_inst__1298_/B
+ VDD VDD VSS VSS gf180mcu_fd_sc_mcu7t5v0__nand2_1
Xwave_controller_x_inst__2950_ wave_controller_x_inst__3707_/Q fanout523/Z wave_controller_x_inst__2951_/I
+ VDD VDD VSS VSS gf180mcu_fd_sc_mcu7t5v0__nand2_1
Xspi_regs_inst__1198_ spi_regs_inst__1586_/Q spi_regs_inst__1198_/A2 spi_regs_inst__1252_/B1
+ spi_regs_inst__1198_/B2 spi_regs_inst__1201_/A2 VDD VDD VSS VSS gf180mcu_fd_sc_mcu7t5v0__aoi22_1
XFILLER_130_737 VDD VDD VSS VSS gf180mcu_fd_sc_mcu7t5v0__fillcap_4
Xwave_controller_x_inst__1901_ wave_controller_x_inst__3723_/Q wave_controller_x_inst__3489_/C
+ VDD VDD VSS VSS gf180mcu_fd_sc_mcu7t5v0__clkinv_1
XFILLER_142_597 VDD VDD VSS VSS gf180mcu_fd_sc_mcu7t5v0__fill_1
XFILLER_87_139 VDD VDD VSS VSS gf180mcu_fd_sc_mcu7t5v0__fill_1
Xwave_controller_x_inst__2881_ wave_controller_x_inst__2881_/A1 wave_controller_x_inst__2881_/A2
+ wave_controller_x_inst__2880_/Z wave_controller_x_inst__2881_/B wave_controller_x_inst__2887_/A2
+ VDD VDD VSS VSS gf180mcu_fd_sc_mcu7t5v0__oai31_1
Xsignal_processor_y_inst__217_ signal_processor_y_inst__217_/D fanout558/Z clkload7/I
+ _91_/I VDD VDD VSS VSS gf180mcu_fd_sc_mcu7t5v0__dffrnq_1
Xwave_controller_x_inst__1832_ spi_regs_inst__1525_/Q wave_controller_x_inst__3122_/A2
+ VDD VDD VSS VSS gf180mcu_fd_sc_mcu7t5v0__clkinv_1
XFILLER_110_461 VDD VDD VSS VSS gf180mcu_fd_sc_mcu7t5v0__fill_1
XTAP_TAPCELL_ROW_143_2233 VDD VSS gf180mcu_fd_sc_mcu7t5v0__filltie
Xsignal_processor_y_inst__148_ signal_processor_y_inst__215_/A1 signal_processor_y_inst__146_/Z
+ signal_processor_y_inst__148_/B signal_processor_y_inst__228_/D VDD VDD VSS VSS
+ gf180mcu_fd_sc_mcu7t5v0__oai21_1
XFILLER_56_559 VDD VDD VSS VSS gf180mcu_fd_sc_mcu7t5v0__fillcap_16
XFILLER_83_356 VDD VDD VSS VSS gf180mcu_fd_sc_mcu7t5v0__fill_1
XTAP_TAPCELL_ROW_143_2244 VDD VSS gf180mcu_fd_sc_mcu7t5v0__filltie
XTAP_TAPCELL_ROW_51_1_714 VDD VSS gf180mcu_fd_sc_mcu7t5v0__filltie
Xwave_controller_x_inst__3502_ max_cap466/Z wave_controller_x_inst__3538_/A2 wave_controller_x_inst__3503_/A3
+ VDD VDD VSS VSS gf180mcu_fd_sc_mcu7t5v0__nor2_1
XFILLER_24_401 VDD VDD VSS VSS gf180mcu_fd_sc_mcu7t5v0__fill_2
XFILLER_43_209 VDD VDD VSS VSS gf180mcu_fd_sc_mcu7t5v0__fill_1
XTAP_TAPCELL_ROW_108_1652 VDD VSS gf180mcu_fd_sc_mcu7t5v0__filltie
XTAP_TAPCELL_ROW_108_1663 VDD VSS gf180mcu_fd_sc_mcu7t5v0__filltie
XFILLER_64_592 VDD VDD VSS VSS gf180mcu_fd_sc_mcu7t5v0__fill_2
Xwave_controller_y_inst__2400_ wave_controller_y_inst__2412_/B wave_controller_y_inst__2399_/Z
+ wave_controller_y_inst__2403_/A2 VDD VDD VSS VSS gf180mcu_fd_sc_mcu7t5v0__nor2_1
Xwave_controller_x_inst__3433_ wave_controller_x_inst__3433_/A1 wave_controller_x_inst__3557_/B1
+ wave_controller_x_inst__3433_/B1 wave_controller_x_inst__3433_/B2 wave_controller_x_inst__3621_/D
+ VDD VDD VSS VSS gf180mcu_fd_sc_mcu7t5v0__oai22_1
Xwave_controller_y_inst__3380_ fanout508/Z wave_controller_y_inst__3381_/A1 wave_controller_y_inst__3381_/A2
+ wave_controller_y_inst__3382_/A3 VDD VDD VSS VSS gf180mcu_fd_sc_mcu7t5v0__nor3_1
Xwave_controller_x_inst__3364_ wave_controller_x_inst__3297_/Z wave_controller_x_inst__3364_/A2
+ wave_controller_x_inst__3364_/Z VDD VDD VSS VSS gf180mcu_fd_sc_mcu7t5v0__xor2_1
XTAP_TAPCELL_ROW_121_1874 VDD VSS gf180mcu_fd_sc_mcu7t5v0__filltie
Xwave_controller_y_inst__2331_ wave_controller_y_inst__2331_/A1 wave_controller_y_inst__2331_/A2
+ spi_regs_inst__1211_/A1 VDD VDD VSS VSS gf180mcu_fd_sc_mcu7t5v0__xor2_1
Xwave_controller_x_inst__2315_ wave_controller_x_inst__2308_/Z wave_controller_x_inst__2315_/A2
+ spi_regs_inst__1166_/B2 VDD VDD VSS VSS gf180mcu_fd_sc_mcu7t5v0__xor2_1
Xwave_controller_y_inst__2262_ wave_controller_y_inst__1825_/I wave_controller_y_inst__2254_/Z
+ wave_controller_y_inst_wire153/Z wave_controller_y_inst__2262_/Z VDD VDD VSS VSS
+ gf180mcu_fd_sc_mcu7t5v0__xor3_1
Xwave_controller_x_inst__3295_ wave_controller_x_inst__3271_/Z wave_controller_x_inst__3296_/B2
+ wave_controller_x_inst__3296_/C wave_controller_x_inst__3365_/A3 VDD VDD VSS VSS
+ gf180mcu_fd_sc_mcu7t5v0__oai21_1
XTAP_TAPCELL_ROW_7_1_383 VDD VSS gf180mcu_fd_sc_mcu7t5v0__filltie
Xwave_controller_x_inst__2246_ wave_controller_x_inst__2247_/A1 wave_controller_x_inst__2246_/A2
+ wave_controller_x_inst__2268_/A1 VDD VDD VSS VSS gf180mcu_fd_sc_mcu7t5v0__nor2_1
Xwave_controller_y_inst__2193_ spi_regs_inst__1159_/A1 wave_controller_y_inst__2193_/A2
+ wave_controller_y_inst__2516_/A1 max_cap423/I wave_controller_y_inst__2194_/I VDD
+ VDD VSS VSS gf180mcu_fd_sc_mcu7t5v0__aoi22_1
Xwave_controller_x_inst__2177_ spi_regs_inst__1193_/B2 wave_controller_x_inst__2516_/A1
+ wave_controller_x_inst__2221_/C VDD VDD VSS VSS gf180mcu_fd_sc_mcu7t5v0__nor2_1
XFILLER_118_583 VDD VDD VSS VSS gf180mcu_fd_sc_mcu7t5v0__fillcap_8
XFILLER_152_317 VDD VDD VSS VSS gf180mcu_fd_sc_mcu7t5v0__fillcap_4
XFILLER_164_177 VDD VDD VSS VSS gf180mcu_fd_sc_mcu7t5v0__fillcap_8
XFILLER_98_28 VDD VDD VSS VSS gf180mcu_fd_sc_mcu7t5v0__fillcap_4
XFILLER_106_767 VDD VDD VSS VSS gf180mcu_fd_sc_mcu7t5v0__fillcap_4
XFILLER_105_277 VDD VDD VSS VSS gf180mcu_fd_sc_mcu7t5v0__fill_2
XFILLER_121_726 VDD VDD VSS VSS gf180mcu_fd_sc_mcu7t5v0__fillcap_4
XFILLER_154_34 VDD VDD VSS VSS gf180mcu_fd_sc_mcu7t5v0__fill_1
XFILLER_154_45 VDD VDD VSS VSS gf180mcu_fd_sc_mcu7t5v0__fill_2
XFILLER_121_759 VDD VDD VSS VSS gf180mcu_fd_sc_mcu7t5v0__fill_2
XPHY_EDGE_ROW_137_Left_304 VDD VSS gf180mcu_fd_sc_mcu7t5v0__endcap
XFILLER_101_483 VDD VDD VSS VSS gf180mcu_fd_sc_mcu7t5v0__fillcap_4
XFILLER_19_217 VDD VDD VSS VSS gf180mcu_fd_sc_mcu7t5v0__fillcap_4
XFILLER_47_32 VDD VDD VSS VSS gf180mcu_fd_sc_mcu7t5v0__fillcap_4
XFILLER_86_172 VDD VDD VSS VSS gf180mcu_fd_sc_mcu7t5v0__fill_2
Xwave_controller_y_inst__1977_ fanout504/Z spi_regs_inst__1354_/A1 wave_controller_y_inst__1977_/A3
+ spi_regs_inst__1345_/B2 VDD VDD VSS VSS gf180mcu_fd_sc_mcu7t5v0__xor3_1
XFILLER_74_345 VDD VDD VSS VSS gf180mcu_fd_sc_mcu7t5v0__fillcap_4
XTAP_TAPCELL_ROW_45_1_672 VDD VSS gf180mcu_fd_sc_mcu7t5v0__filltie
Xwave_controller_y_inst_max_cap152 wave_controller_y_inst_wire153/Z wave_controller_y_inst__2320_/A1
+ VDD VDD VSS VSS gf180mcu_fd_sc_mcu7t5v0__clkbuf_1
Xwave_controller_y_inst__3716_ wave_controller_y_inst__3716_/D wave_controller_y_inst__3716_/RN
+ clkload5/I wave_controller_y_inst__3716_/Q VDD VDD VSS VSS gf180mcu_fd_sc_mcu7t5v0__dffrnq_1
XFILLER_90_849 VDD VDD VSS VSS gf180mcu_fd_sc_mcu7t5v0__fillcap_4
Xwave_controller_y_inst__3647_ wave_controller_y_inst__3647_/D wave_controller_y_inst__3716_/RN
+ clkload14/I spi_regs_inst__1194_/B2 VDD VDD VSS VSS gf180mcu_fd_sc_mcu7t5v0__dffrnq_1
XFILLER_15_456 VDD VDD VSS VSS gf180mcu_fd_sc_mcu7t5v0__fill_1
XFILLER_15_467 VDD VDD VSS VSS gf180mcu_fd_sc_mcu7t5v0__fillcap_16
XFILLER_42_231 VDD VDD VSS VSS gf180mcu_fd_sc_mcu7t5v0__fillcap_4
XFILLER_70_573 VDD VDD VSS VSS gf180mcu_fd_sc_mcu7t5v0__fillcap_4
XPHY_EDGE_ROW_69_Right_69 VDD VSS gf180mcu_fd_sc_mcu7t5v0__endcap
XTAP_TAPCELL_ROW_11_1_417 VDD VSS gf180mcu_fd_sc_mcu7t5v0__filltie
Xwave_controller_y_inst__3578_ spi_regs_inst__1139_/B2 wave_controller_y_inst__3579_/A1
+ wave_controller_y_inst__3579_/B VDD VDD VSS VSS gf180mcu_fd_sc_mcu7t5v0__nand2_1
XFILLER_15_489 VDD VDD VSS VSS gf180mcu_fd_sc_mcu7t5v0__fill_1
XFILLER_30_415 VDD VDD VSS VSS gf180mcu_fd_sc_mcu7t5v0__fillcap_4
Xwave_controller_y_inst__2529_ wave_controller_y_inst__2789_/A1 spi_regs_inst__1343_/A1
+ wave_controller_y_inst__2555_/C VDD VDD VSS VSS gf180mcu_fd_sc_mcu7t5v0__nand2_1
Xsignal_processor_x_inst__237_ signal_processor_x_inst__237_/D fanout582/Z clkload10/I
+ signal_processor_x_inst__237_/Q VDD VDD VSS VSS gf180mcu_fd_sc_mcu7t5v0__dffrnq_1
XFILLER_156_601 VDD VDD VSS VSS gf180mcu_fd_sc_mcu7t5v0__fill_2
XFILLER_8_37 VDD VDD VSS VSS gf180mcu_fd_sc_mcu7t5v0__fillcap_64
XPHY_EDGE_ROW_146_Left_313 VDD VSS gf180mcu_fd_sc_mcu7t5v0__endcap
XFILLER_129_837 VDD VDD VSS VSS gf180mcu_fd_sc_mcu7t5v0__fill_2
XFILLER_129_848 VDD VDD VSS VSS gf180mcu_fd_sc_mcu7t5v0__fill_2
XFILLER_156_645 VDD VDD VSS VSS gf180mcu_fd_sc_mcu7t5v0__fillcap_4
Xsignal_processor_x_inst__168_ signal_processor_x_inst__187_/A1 signal_processor_x_inst__209_/A2
+ signal_processor_x_inst__233_/D VDD VDD VSS VSS gf180mcu_fd_sc_mcu7t5v0__nor2_1
XFILLER_144_807 VDD VDD VSS VSS gf180mcu_fd_sc_mcu7t5v0__fillcap_4
XFILLER_156_689 VDD VDD VSS VSS gf180mcu_fd_sc_mcu7t5v0__fillcap_16
Xspi_regs_inst__1121_ spi_regs_inst__1121_/A1 spi_regs_inst__1261_/B1 spi_regs_inst__1189_/B1
+ spi_regs_inst__1121_/B2 spi_regs_inst__1122_/A4 VDD VDD VSS VSS gf180mcu_fd_sc_mcu7t5v0__aoi22_1
XPHY_EDGE_ROW_15_1_Left_182 VDD VSS gf180mcu_fd_sc_mcu7t5v0__endcap
XTAP_TAPCELL_ROW_94_1431 VDD VSS gf180mcu_fd_sc_mcu7t5v0__filltie
XTAP_TAPCELL_ROW_94_1420 VDD VSS gf180mcu_fd_sc_mcu7t5v0__filltie
XFILLER_100_1165 VDD VDD VSS VSS gf180mcu_fd_sc_mcu7t5v0__fill_1
XFILLER_124_520 VDD VDD VSS VSS gf180mcu_fd_sc_mcu7t5v0__fillcap_4
XFILLER_124_531 VDD VDD VSS VSS gf180mcu_fd_sc_mcu7t5v0__fill_1
XFILLER_83_1116 VDD VDD VSS VSS gf180mcu_fd_sc_mcu7t5v0__fillcap_4
XPHY_EDGE_ROW_78_Right_78 VDD VSS gf180mcu_fd_sc_mcu7t5v0__endcap
Xspi_regs_inst__1052_ spi_regs_inst__1599_/Q spi_regs_inst__1167_/A2 spi_regs_inst__1148_/B1
+ spi_regs_inst__1052_/B2 spi_regs_inst__1053_/A4 VDD VDD VSS VSS gf180mcu_fd_sc_mcu7t5v0__aoi22_1
XFILLER_124_586 VDD VDD VSS VSS gf180mcu_fd_sc_mcu7t5v0__fillcap_8
XFILLER_88_61 VDD VDD VSS VSS gf180mcu_fd_sc_mcu7t5v0__fillcap_8
XPHY_EDGE_ROW_155_Left_322 VDD VSS gf180mcu_fd_sc_mcu7t5v0__endcap
XFILLER_93_632 VDD VDD VSS VSS gf180mcu_fd_sc_mcu7t5v0__fillcap_8
XFILLER_65_356 VDD VDD VSS VSS gf180mcu_fd_sc_mcu7t5v0__fill_2
Xspi_regs_inst__0905_ spi_regs_inst__1629_/Q spi_regs_inst__1628_/Q spi_regs_inst__0905_/Z
+ VDD VDD VSS VSS gf180mcu_fd_sc_mcu7t5v0__xor2_1
X_14_ _14_/A1 _14_/A2 _20_/D VDD VDD VSS VSS gf180mcu_fd_sc_mcu7t5v0__nor2_1
XFILLER_53_507 VDD VDD VSS VSS gf180mcu_fd_sc_mcu7t5v0__fill_2
Xspi_regs_inst__0836_ spi_regs_inst__1653_/Q spi_regs_inst__1652_/Q spi_regs_inst__1422_/A2
+ spi_regs_inst__0880_/A2 spi_regs_inst__0841_/S VDD VDD VSS VSS gf180mcu_fd_sc_mcu7t5v0__nor4_2
XPHY_EDGE_ROW_87_Right_87 VDD VSS gf180mcu_fd_sc_mcu7t5v0__endcap
XFILLER_61_562 VDD VDD VSS VSS gf180mcu_fd_sc_mcu7t5v0__fillcap_8
XPHY_EDGE_ROW_164_Left_331 VDD VSS gf180mcu_fd_sc_mcu7t5v0__endcap
Xspi_regs_inst__0767_ spi_regs_inst__1527_/Q spi_regs_inst__1412_/I1 spi_regs_inst__0767_/S
+ spi_regs_inst__1527_/D VDD VDD VSS VSS gf180mcu_fd_sc_mcu7t5v0__mux2_2
XFILLER_33_286 VDD VDD VSS VSS gf180mcu_fd_sc_mcu7t5v0__fill_2
XTAP_TAPCELL_ROW_103_1571 VDD VSS gf180mcu_fd_sc_mcu7t5v0__filltie
XFILLER_166_409 VDD VDD VSS VSS gf180mcu_fd_sc_mcu7t5v0__fillcap_4
XTAP_TAPCELL_ROW_103_1582 VDD VSS gf180mcu_fd_sc_mcu7t5v0__filltie
Xwave_controller_x_inst__2100_ wave_controller_x_inst__2100_/A1 wave_controller_x_inst__2117_/A2
+ wave_controller_x_inst__2100_/Z VDD VDD VSS VSS gf180mcu_fd_sc_mcu7t5v0__xor2_1
XFILLER_144_1081 VDD VDD VSS VSS gf180mcu_fd_sc_mcu7t5v0__fillcap_4
XFILLER_147_634 VDD VDD VSS VSS gf180mcu_fd_sc_mcu7t5v0__fill_1
Xwave_controller_x_inst__3080_ wave_controller_x_inst__3080_/A1 wave_controller_x_inst__3090_/B1
+ wave_controller_x_inst__3079_/Z wave_controller_x_inst__2762_/I wave_controller_x_inst__3716_/D
+ VDD VDD VSS VSS gf180mcu_fd_sc_mcu7t5v0__oai22_1
XFILLER_107_509 VDD VDD VSS VSS gf180mcu_fd_sc_mcu7t5v0__fillcap_8
Xwave_controller_x_inst__2031_ wave_controller_x_inst__3718_/Q wave_controller_x_inst__3089_/B
+ wave_controller_x_inst__2079_/B VDD VDD VSS VSS gf180mcu_fd_sc_mcu7t5v0__xor2_1
XFILLER_134_306 VDD VDD VSS VSS gf180mcu_fd_sc_mcu7t5v0__fillcap_8
XFILLER_134_317 VDD VDD VSS VSS gf180mcu_fd_sc_mcu7t5v0__fill_2
XPHY_EDGE_ROW_96_Right_96 VDD VSS gf180mcu_fd_sc_mcu7t5v0__endcap
Xspi_regs_inst__1319_ spi_regs_inst__1319_/A1 spi_regs_inst__1319_/A2 spi_regs_inst__1319_/A3
+ spi_regs_inst__1319_/A4 spi_regs_inst__1327_/A2 VDD VDD VSS VSS gf180mcu_fd_sc_mcu7t5v0__nand4_1
XFILLER_161_136 VDD VDD VSS VSS gf180mcu_fd_sc_mcu7t5v0__fillcap_4
Xspi_regs_inst_wire112 spi_regs_inst_wire112/I spi_regs_inst_wire112/Z VDD VDD VSS
+ VSS gf180mcu_fd_sc_mcu7t5v0__buf_2
Xspi_regs_inst_wire101 spi_regs_inst_wire101/I spi_regs_inst_wire101/Z VDD VDD VSS
+ VSS gf180mcu_fd_sc_mcu7t5v0__buf_2
XFILLER_0_308 VDD VDD VSS VSS gf180mcu_fd_sc_mcu7t5v0__fillcap_32
Xspi_regs_inst_wire167 spi_regs_inst_wire167/I spi_regs_inst_wire167/Z VDD VDD VSS
+ VSS gf180mcu_fd_sc_mcu7t5v0__clkbuf_2
Xspi_regs_inst_wire134 spi_regs_inst_wire134/I spi_regs_inst_wire134/Z VDD VDD VSS
+ VSS gf180mcu_fd_sc_mcu7t5v0__buf_2
Xwave_controller_x_inst__2933_ wave_controller_x_inst__2933_/A1 wave_controller_x_inst__2933_/A2
+ wave_controller_x_inst__2934_/B VDD VDD VSS VSS gf180mcu_fd_sc_mcu7t5v0__nor2_1
XFILLER_102_247 VDD VDD VSS VSS gf180mcu_fd_sc_mcu7t5v0__fill_2
XFILLER_124_37 VDD VDD VSS VSS gf180mcu_fd_sc_mcu7t5v0__fillcap_8
Xwave_controller_y_inst__2880_ wave_controller_y_inst__2880_/A1 wave_controller_y_inst__2883_/A3
+ wave_controller_y_inst__2880_/A3 wave_controller_y_inst__2880_/Z VDD VDD VSS VSS
+ gf180mcu_fd_sc_mcu7t5v0__and3_1
Xwave_controller_y_inst__1900_ _09_/A1 wave_controller_y_inst__3407_/A1 VDD VDD VSS
+ VSS gf180mcu_fd_sc_mcu7t5v0__clkinv_1
Xwave_controller_x_inst__2864_ wave_controller_x_inst__3449_/A1 spi_regs_inst__1197_/B2
+ wave_controller_x_inst__2864_/Z VDD VDD VSS VSS gf180mcu_fd_sc_mcu7t5v0__xor2_1
XFILLER_151_1052 VDD VDD VSS VSS gf180mcu_fd_sc_mcu7t5v0__fillcap_64
XFILLER_97_982 VDD VDD VSS VSS gf180mcu_fd_sc_mcu7t5v0__fillcap_64
Xwave_controller_y_inst__1831_ spi_regs_inst__1590_/Q wave_controller_y_inst__3213_/A2
+ VDD VDD VSS VSS gf180mcu_fd_sc_mcu7t5v0__clkinv_1
Xwave_controller_x_inst__1815_ spi_regs_inst__1541_/Q wave_controller_x_inst__3378_/A2
+ VDD VDD VSS VSS gf180mcu_fd_sc_mcu7t5v0__clkinv_1
XFILLER_110_280 VDD VDD VSS VSS gf180mcu_fd_sc_mcu7t5v0__fillcap_4
XFILLER_110_291 VDD VDD VSS VSS gf180mcu_fd_sc_mcu7t5v0__fill_2
XFILLER_57_868 VDD VDD VSS VSS gf180mcu_fd_sc_mcu7t5v0__fill_2
Xwave_controller_x_inst__2795_ wire462/Z max_cap467/Z wave_controller_x_inst__2805_/S
+ wave_controller_x_inst__2795_/Z VDD VDD VSS VSS gf180mcu_fd_sc_mcu7t5v0__mux2_2
XFILLER_83_175 VDD VDD VSS VSS gf180mcu_fd_sc_mcu7t5v0__fill_1
XTAP_TAPCELL_ROW_123_1903 VDD VSS gf180mcu_fd_sc_mcu7t5v0__filltie
Xwave_controller_y_inst__3501_ wave_controller_y_inst__3703_/Q wave_controller_y_inst__3528_/A2
+ wave_controller_y_inst__3503_/A2 VDD VDD VSS VSS gf180mcu_fd_sc_mcu7t5v0__nor2_1
XFILLER_83_197 VDD VDD VSS VSS gf180mcu_fd_sc_mcu7t5v0__fillcap_4
XTAP_TAPCELL_ROW_123_1914 VDD VSS gf180mcu_fd_sc_mcu7t5v0__filltie
Xwave_controller_y_inst__3432_ wave_controller_y_inst__3465_/B wave_controller_y_inst__3429_/I
+ wave_controller_y_inst__3491_/B wave_controller_y_inst__3433_/B2 VDD VDD VSS VSS
+ gf180mcu_fd_sc_mcu7t5v0__oai21_1
Xwave_controller_x_inst__3416_ wave_controller_x_inst__3420_/A1 wave_controller_x_inst__3494_/A1
+ wave_controller_x_inst__3416_/B wave_controller_x_inst__3417_/I VDD VDD VSS VSS
+ gf180mcu_fd_sc_mcu7t5v0__oai21_1
XFILLER_80_893 VDD VDD VSS VSS gf180mcu_fd_sc_mcu7t5v0__fillcap_8
Xwave_controller_y_inst__3363_ wave_controller_y_inst__3363_/A1 wave_controller_y_inst__3301_/Z
+ wave_controller_y_inst__3363_/Z VDD VDD VSS VSS gf180mcu_fd_sc_mcu7t5v0__xor2_1
XFILLER_138_601 VDD VDD VSS VSS gf180mcu_fd_sc_mcu7t5v0__fill_2
XTAP_TAPCELL_ROW_156_2446 VDD VSS gf180mcu_fd_sc_mcu7t5v0__filltie
Xwave_controller_y_inst__2314_ wave_controller_y_inst__2308_/Z wave_controller_y_inst__2315_/A2
+ wave_controller_y_inst__2330_/B VDD VDD VSS VSS gf180mcu_fd_sc_mcu7t5v0__nor2_1
Xwave_controller_x_inst__3347_ wave_controller_x_inst__3350_/A1 wave_controller_x_inst__3315_/Z
+ wave_controller_x_inst__3350_/B wave_controller_x_inst__3347_/B wave_controller_x_inst__3348_/A2
+ VDD VDD VSS VSS gf180mcu_fd_sc_mcu7t5v0__oai31_1
XFILLER_123_1154 VDD VDD VSS VSS gf180mcu_fd_sc_mcu7t5v0__fillcap_16
XTAP_TAPCELL_ROW_156_2457 VDD VSS gf180mcu_fd_sc_mcu7t5v0__filltie
Xwave_controller_y_inst__3294_ wave_controller_y_inst__3294_/A1 wave_controller_y_inst__3274_/Z
+ wave_controller_y_inst__3384_/A2 wave_controller_y_inst__3294_/B wave_controller_y_inst_wire122/I
+ VDD VDD VSS VSS gf180mcu_fd_sc_mcu7t5v0__oai31_1
Xwave_controller_x_inst__3278_ wave_controller_x_inst__3279_/A1 spi_regs_inst__1542_/Q
+ wave_controller_x_inst__3278_/Z VDD VDD VSS VSS gf180mcu_fd_sc_mcu7t5v0__and2_1
XFILLER_126_807 VDD VDD VSS VSS gf180mcu_fd_sc_mcu7t5v0__fill_1
XFILLER_138_667 VDD VDD VSS VSS gf180mcu_fd_sc_mcu7t5v0__fill_1
Xwave_controller_y_inst__2245_ wave_controller_y_inst__2245_/I wave_controller_y_inst__2246_/A2
+ VDD VDD VSS VSS gf180mcu_fd_sc_mcu7t5v0__clkinv_1
Xwave_controller_x_inst__2229_ wave_controller_x_inst__2229_/A1 wave_controller_x_inst__2228_/Z
+ wave_controller_x_inst__2229_/Z VDD VDD VSS VSS gf180mcu_fd_sc_mcu7t5v0__xor2_1
XFILLER_138_689 VDD VDD VSS VSS gf180mcu_fd_sc_mcu7t5v0__fillcap_32
Xwave_controller_y_inst__2176_ wave_controller_y_inst__2176_/A1 wave_controller_y_inst__2221_/A1
+ wave_controller_y_inst__2181_/A2 VDD VDD VSS VSS gf180mcu_fd_sc_mcu7t5v0__nand2_1
XFILLER_106_542 VDD VDD VSS VSS gf180mcu_fd_sc_mcu7t5v0__fillcap_8
XFILLER_109_2 VDD VDD VSS VSS gf180mcu_fd_sc_mcu7t5v0__fillcap_16
XFILLER_152_169 VDD VDD VSS VSS gf180mcu_fd_sc_mcu7t5v0__fillcap_4
XFILLER_161_670 VDD VDD VSS VSS gf180mcu_fd_sc_mcu7t5v0__fillcap_16
XFILLER_79_404 VDD VDD VSS VSS gf180mcu_fd_sc_mcu7t5v0__fillcap_16
XFILLER_121_545 VDD VDD VSS VSS gf180mcu_fd_sc_mcu7t5v0__fillcap_8
XFILLER_95_908 VDD VDD VSS VSS gf180mcu_fd_sc_mcu7t5v0__fill_2
XTAP_TAPCELL_ROW_72_1058 VDD VSS gf180mcu_fd_sc_mcu7t5v0__filltie
XFILLER_121_578 VDD VDD VSS VSS gf180mcu_fd_sc_mcu7t5v0__fill_1
XTAP_TAPCELL_ROW_72_1069 VDD VSS gf180mcu_fd_sc_mcu7t5v0__filltie
Xwave_controller_x_inst_fanout621 wave_controller_x_inst__3710_/RN wave_controller_x_inst__3682_/RN
+ VDD VDD VSS VSS gf180mcu_fd_sc_mcu7t5v0__dlyb_1
XFILLER_58_75 VDD VDD VSS VSS gf180mcu_fd_sc_mcu7t5v0__fill_2
XFILLER_58_97 VDD VDD VSS VSS gf180mcu_fd_sc_mcu7t5v0__fill_2
XFILLER_59_150 VDD VDD VSS VSS gf180mcu_fd_sc_mcu7t5v0__fillcap_4
XFILLER_63_805 VDD VDD VSS VSS gf180mcu_fd_sc_mcu7t5v0__fill_2
XFILLER_75_632 VDD VDD VSS VSS gf180mcu_fd_sc_mcu7t5v0__fillcap_8
XFILLER_87_492 VDD VDD VSS VSS gf180mcu_fd_sc_mcu7t5v0__fillcap_16
XTAP_TAPCELL_ROW_58_830 VDD VSS gf180mcu_fd_sc_mcu7t5v0__filltie
XTAP_TAPCELL_ROW_58_841 VDD VSS gf180mcu_fd_sc_mcu7t5v0__filltie
XFILLER_62_304 VDD VDD VSS VSS gf180mcu_fd_sc_mcu7t5v0__fill_2
XFILLER_63_827 VDD VDD VSS VSS gf180mcu_fd_sc_mcu7t5v0__fillcap_8
XFILLER_75_698 VDD VDD VSS VSS gf180mcu_fd_sc_mcu7t5v0__fill_2
XFILLER_167_1081 VDD VDD VSS VSS gf180mcu_fd_sc_mcu7t5v0__fillcap_4
XFILLER_128_1087 VDD VDD VSS VSS gf180mcu_fd_sc_mcu7t5v0__fillcap_64
XFILLER_129_612 VDD VDD VSS VSS gf180mcu_fd_sc_mcu7t5v0__fillcap_4
XFILLER_30_267 VDD VDD VSS VSS gf180mcu_fd_sc_mcu7t5v0__fillcap_8
XFILLER_11_492 VDD VDD VSS VSS gf180mcu_fd_sc_mcu7t5v0__fillcap_16
XFILLER_156_453 VDD VDD VSS VSS gf180mcu_fd_sc_mcu7t5v0__fill_2
XFILLER_157_976 VDD VDD VSS VSS gf180mcu_fd_sc_mcu7t5v0__fillcap_4
XFILLER_117_829 VDD VDD VSS VSS gf180mcu_fd_sc_mcu7t5v0__fillcap_4
XFILLER_128_177 VDD VDD VSS VSS gf180mcu_fd_sc_mcu7t5v0__fillcap_4
XFILLER_7_485 VDD VDD VSS VSS gf180mcu_fd_sc_mcu7t5v0__fillcap_4
XFILLER_116_339 VDD VDD VSS VSS gf180mcu_fd_sc_mcu7t5v0__fill_1
Xspi_regs_inst__1104_ spi_regs_inst__1104_/A1 spi_regs_inst__1104_/A2 spi_regs_inst__1104_/A3
+ spi_regs_inst__1104_/A4 spi_regs_inst__1113_/A3 VDD VDD VSS VSS gf180mcu_fd_sc_mcu7t5v0__nand4_1
Xspi_regs_inst__1035_ spi_regs_inst__1035_/A1 spi_regs_inst__1035_/A2 spi_regs_inst__1072_/A1
+ VDD VDD VSS VSS gf180mcu_fd_sc_mcu7t5v0__nand2_1
XFILLER_97_212 VDD VDD VSS VSS gf180mcu_fd_sc_mcu7t5v0__fillcap_8
XFILLER_98_746 VDD VDD VSS VSS gf180mcu_fd_sc_mcu7t5v0__fill_1
XFILLER_151_191 VDD VDD VSS VSS gf180mcu_fd_sc_mcu7t5v0__fill_2
XFILLER_24_2 VDD VDD VSS VSS gf180mcu_fd_sc_mcu7t5v0__fillcap_32
XFILLER_79_982 VDD VDD VSS VSS gf180mcu_fd_sc_mcu7t5v0__fillcap_64
XFILLER_26_529 VDD VDD VSS VSS gf180mcu_fd_sc_mcu7t5v0__fill_1
XFILLER_65_142 VDD VDD VSS VSS gf180mcu_fd_sc_mcu7t5v0__fillcap_8
Xwave_controller_x_inst__2580_ wave_controller_x_inst__2616_/C max_cap464/Z wave_controller_x_inst__2580_/Z
+ VDD VDD VSS VSS gf180mcu_fd_sc_mcu7t5v0__xor2_1
XFILLER_80_123 VDD VDD VSS VSS gf180mcu_fd_sc_mcu7t5v0__fill_2
XTAP_TAPCELL_ROW_105_1611 VDD VSS gf180mcu_fd_sc_mcu7t5v0__filltie
XFILLER_81_668 VDD VDD VSS VSS gf180mcu_fd_sc_mcu7t5v0__fillcap_8
Xspi_regs_inst__0819_ spi_regs_inst__1438_/I1 spi_regs_inst__1562_/Q spi_regs_inst__0826_/S
+ spi_regs_inst__1562_/D VDD VDD VSS VSS gf180mcu_fd_sc_mcu7t5v0__mux2_2
XFILLER_107_1116 VDD VDD VSS VSS gf180mcu_fd_sc_mcu7t5v0__fillcap_4
XFILLER_21_201 VDD VDD VSS VSS gf180mcu_fd_sc_mcu7t5v0__fill_1
XFILLER_21_212 VDD VDD VSS VSS gf180mcu_fd_sc_mcu7t5v0__fill_1
Xwave_controller_x_inst__3201_ fanout536/Z wave_controller_x_inst__3244_/A2 wave_controller_x_inst__3245_/C
+ VDD VDD VSS VSS gf180mcu_fd_sc_mcu7t5v0__nor2_1
XFILLER_139_409 VDD VDD VSS VSS gf180mcu_fd_sc_mcu7t5v0__fillcap_8
XFILLER_21_278 VDD VDD VSS VSS gf180mcu_fd_sc_mcu7t5v0__fill_2
XTAP_TAPCELL_ROW_138_2154 VDD VSS gf180mcu_fd_sc_mcu7t5v0__filltie
Xwave_controller_x_inst__3132_ wave_controller_x_inst__3702_/Q spi_regs_inst__1521_/Q
+ wave_controller_x_inst__3133_/B VDD VDD VSS VSS gf180mcu_fd_sc_mcu7t5v0__xor2_1
XFILLER_108_807 VDD VDD VSS VSS gf180mcu_fd_sc_mcu7t5v0__fillcap_4
XTAP_TAPCELL_ROW_36_1_603 VDD VSS gf180mcu_fd_sc_mcu7t5v0__filltie
Xwave_controller_x_inst__3063_ wave_controller_x_inst__3305_/B2 wave_controller_x_inst__3069_/B1
+ wave_controller_x_inst__3063_/B1 wave_controller_x_inst__3063_/B2 wave_controller_x_inst__3709_/D
+ VDD VDD VSS VSS gf180mcu_fd_sc_mcu7t5v0__oai22_1
XFILLER_119_155 VDD VDD VSS VSS gf180mcu_fd_sc_mcu7t5v0__fill_2
XFILLER_119_166 VDD VDD VSS VSS gf180mcu_fd_sc_mcu7t5v0__fill_1
XFILLER_119_177 VDD VDD VSS VSS gf180mcu_fd_sc_mcu7t5v0__fillcap_8
Xwave_controller_y_inst__2030_ spi_regs_inst__1486_/Q spi_regs_inst__1159_/A1 spi_regs_inst__1132_/B2
+ VDD VDD VSS VSS gf180mcu_fd_sc_mcu7t5v0__xor2_1
Xwave_controller_x_inst__2014_ fanout534/Z wave_controller_x_inst__2379_/A1 wave_controller_x_inst__2024_/A1
+ VDD VDD VSS VSS gf180mcu_fd_sc_mcu7t5v0__nor2_1
XTAP_TAPCELL_ROW_151_2365 VDD VSS gf180mcu_fd_sc_mcu7t5v0__filltie
XTAP_TAPCELL_ROW_151_2376 VDD VSS gf180mcu_fd_sc_mcu7t5v0__filltie
XTAP_TAPCELL_ROW_44_1_660 VDD VSS gf180mcu_fd_sc_mcu7t5v0__filltie
XFILLER_116_873 VDD VDD VSS VSS gf180mcu_fd_sc_mcu7t5v0__fill_2
XFILLER_89_702 VDD VDD VSS VSS gf180mcu_fd_sc_mcu7t5v0__fillcap_32
XTAP_TAPCELL_ROW_116_1784 VDD VSS gf180mcu_fd_sc_mcu7t5v0__filltie
XTAP_TAPCELL_ROW_116_1795 VDD VSS gf180mcu_fd_sc_mcu7t5v0__filltie
XFILLER_131_832 VDD VDD VSS VSS gf180mcu_fd_sc_mcu7t5v0__fillcap_8
XFILLER_0_138 VDD VDD VSS VSS gf180mcu_fd_sc_mcu7t5v0__fillcap_32
XFILLER_130_342 VDD VDD VSS VSS gf180mcu_fd_sc_mcu7t5v0__fillcap_4
XFILLER_135_69 VDD VDD VSS VSS gf180mcu_fd_sc_mcu7t5v0__fill_1
XFILLER_76_407 VDD VDD VSS VSS gf180mcu_fd_sc_mcu7t5v0__fill_2
XFILLER_88_267 VDD VDD VSS VSS gf180mcu_fd_sc_mcu7t5v0__fill_2
XTAP_TAPCELL_ROW_10_1_405 VDD VSS gf180mcu_fd_sc_mcu7t5v0__filltie
Xwave_controller_y_inst__2932_ wave_controller_y_inst__2923_/S wave_controller_y_inst__3593_/A1
+ wave_controller_y_inst__2932_/B wave_controller_y_inst__3690_/D VDD VDD VSS VSS
+ gf180mcu_fd_sc_mcu7t5v0__oai21_1
XFILLER_57_621 VDD VDD VSS VSS gf180mcu_fd_sc_mcu7t5v0__fill_1
XFILLER_69_481 VDD VDD VSS VSS gf180mcu_fd_sc_mcu7t5v0__fill_2
XFILLER_88_278 VDD VDD VSS VSS gf180mcu_fd_sc_mcu7t5v0__fill_2
Xwave_controller_x_inst__2916_ wave_controller_x_inst__3584_/I0 spi_regs_inst__1277_/A1
+ wave_controller_x_inst__2923_/S wave_controller_x_inst__3683_/D VDD VDD VSS VSS
+ gf180mcu_fd_sc_mcu7t5v0__mux2_2
XFILLER_28_34 VDD VDD VSS VSS gf180mcu_fd_sc_mcu7t5v0__fill_1
XFILLER_57_632 VDD VDD VSS VSS gf180mcu_fd_sc_mcu7t5v0__fillcap_64
XFILLER_85_941 VDD VDD VSS VSS gf180mcu_fd_sc_mcu7t5v0__fillcap_32
Xwave_controller_y_inst__2863_ wave_controller_y_inst__2885_/A1 wave_controller_y_inst__2885_/A2
+ wave_controller_y_inst__2867_/A1 VDD VDD VSS VSS gf180mcu_fd_sc_mcu7t5v0__nand2_1
Xwave_controller_x_inst__2847_ wave_controller_x_inst__3081_/B wave_controller_x_inst__2847_/A2
+ wave_controller_x_inst__2847_/Z VDD VDD VSS VSS gf180mcu_fd_sc_mcu7t5v0__and2_1
Xwave_controller_y_inst__2794_ wave_controller_y_inst__3290_/A1 wave_controller_y_inst__2793_/Z
+ wave_controller_y_inst__2809_/A2 VDD VDD VSS VSS gf180mcu_fd_sc_mcu7t5v0__nor2_1
Xwave_controller_y_inst__1814_ spi_regs_inst__1604_/Q wave_controller_y_inst__3273_/A2
+ VDD VDD VSS VSS gf180mcu_fd_sc_mcu7t5v0__clkinv_1
Xwave_controller_x_inst__2778_ wire450/Z wave_controller_x_inst__1902_/I wave_controller_x_inst__2778_/B
+ wave_controller_x_inst__2850_/A2 VDD VDD VSS VSS gf180mcu_fd_sc_mcu7t5v0__oai21_1
XFILLER_84_484 VDD VDD VSS VSS gf180mcu_fd_sc_mcu7t5v0__fill_2
XFILLER_84_495 VDD VDD VSS VSS gf180mcu_fd_sc_mcu7t5v0__fillcap_16
XFILLER_44_55 VDD VDD VSS VSS gf180mcu_fd_sc_mcu7t5v0__fill_1
Xwave_controller_y_inst__3415_ spi_regs_inst__1054_/B2 wave_controller_y_inst__3494_/A1
+ wave_controller_y_inst__3416_/B VDD VDD VSS VSS gf180mcu_fd_sc_mcu7t5v0__nand2_1
Xwave_controller_y_inst__3346_ wave_controller_y_inst__3402_/A1 wave_controller_y_inst__3346_/A2
+ wave_controller_y_inst__3346_/Z VDD VDD VSS VSS gf180mcu_fd_sc_mcu7t5v0__or2_1
XFILLER_139_976 VDD VDD VSS VSS gf180mcu_fd_sc_mcu7t5v0__fillcap_4
Xwave_controller_y_inst__3277_ wave_controller_y_inst__3277_/I wave_controller_y_inst__3373_/A1
+ VDD VDD VSS VSS gf180mcu_fd_sc_mcu7t5v0__clkinv_1
Xwave_controller_y_inst__2228_ wave_controller_y_inst__1826_/I wave_controller_y_inst__2226_/Z
+ wave_controller_y_inst__2228_/Z VDD VDD VSS VSS gf180mcu_fd_sc_mcu7t5v0__xor2_1
XFILLER_125_125 VDD VDD VSS VSS gf180mcu_fd_sc_mcu7t5v0__fillcap_4
XFILLER_153_434 VDD VDD VSS VSS gf180mcu_fd_sc_mcu7t5v0__fillcap_4
XFILLER_153_489 VDD VDD VSS VSS gf180mcu_fd_sc_mcu7t5v0__fill_1
Xwave_controller_y_inst__2159_ spi_regs_inst__1101_/A1 spi_regs_inst__1090_/B2 wave_controller_y_inst__2163_/B
+ VDD VDD VSS VSS gf180mcu_fd_sc_mcu7t5v0__xnor2_1
XFILLER_68_908 VDD VDD VSS VSS gf180mcu_fd_sc_mcu7t5v0__fill_2
XFILLER_67_418 VDD VDD VSS VSS gf180mcu_fd_sc_mcu7t5v0__fill_2
Xwave_controller_x_inst_fanout440 wave_controller_x_inst__3721_/Q wave_controller_x_inst__2124_/B
+ VDD VDD VSS VSS gf180mcu_fd_sc_mcu7t5v0__dlyb_1
XFILLER_125_80 VDD VDD VSS VSS gf180mcu_fd_sc_mcu7t5v0__fill_2
XFILLER_75_440 VDD VDD VSS VSS gf180mcu_fd_sc_mcu7t5v0__fillcap_4
XFILLER_76_952 VDD VDD VSS VSS gf180mcu_fd_sc_mcu7t5v0__fillcap_32
XFILLER_88_790 VDD VDD VSS VSS gf180mcu_fd_sc_mcu7t5v0__fillcap_4
XFILLER_94_259 VDD VDD VSS VSS gf180mcu_fd_sc_mcu7t5v0__fill_1
Xwave_controller_y_inst_max_cap42 wave_controller_y_inst__3441_/A1 wave_controller_y_inst__3490_/A1
+ VDD VDD VSS VSS gf180mcu_fd_sc_mcu7t5v0__buf_2
XTAP_TAPCELL_ROW_89_1341 VDD VSS gf180mcu_fd_sc_mcu7t5v0__filltie
XTAP_TAPCELL_ROW_89_1352 VDD VSS gf180mcu_fd_sc_mcu7t5v0__filltie
XFILLER_63_624 VDD VDD VSS VSS gf180mcu_fd_sc_mcu7t5v0__fillcap_4
XFILLER_90_443 VDD VDD VSS VSS gf180mcu_fd_sc_mcu7t5v0__fillcap_8
Xspi_regs_inst__1653_ spi_regs_inst__1653_/D wire594/Z clkbuf_leaf_13_clk/Z spi_regs_inst__1653_/Q
+ VDD VDD VSS VSS gf180mcu_fd_sc_mcu7t5v0__dffrnq_1
XFILLER_50_329 VDD VDD VSS VSS gf180mcu_fd_sc_mcu7t5v0__fillcap_4
XFILLER_90_498 VDD VDD VSS VSS gf180mcu_fd_sc_mcu7t5v0__fill_1
XFILLER_149_729 VDD VDD VSS VSS gf180mcu_fd_sc_mcu7t5v0__fill_1
XFILLER_31_543 VDD VDD VSS VSS gf180mcu_fd_sc_mcu7t5v0__fillcap_8
Xspi_regs_inst__1584_ spi_regs_inst__1584_/D fanout581/Z clkbuf_leaf_41_clk/Z spi_regs_inst__1584_/Q
+ VDD VDD VSS VSS gf180mcu_fd_sc_mcu7t5v0__dffrnq_1
XTAP_TAPCELL_ROW_100_1530 VDD VSS gf180mcu_fd_sc_mcu7t5v0__filltie
XTAP_TAPCELL_ROW_9_1_397 VDD VSS gf180mcu_fd_sc_mcu7t5v0__filltie
XFILLER_54_1081 VDD VDD VSS VSS gf180mcu_fd_sc_mcu7t5v0__fillcap_4
XFILLER_89_1122 VDD VDD VSS VSS gf180mcu_fd_sc_mcu7t5v0__fillcap_32
XFILLER_7_282 VDD VDD VSS VSS gf180mcu_fd_sc_mcu7t5v0__fillcap_32
XTAP_TAPCELL_ROW_133_2073 VDD VSS gf180mcu_fd_sc_mcu7t5v0__filltie
XFILLER_131_139 VDD VDD VSS VSS gf180mcu_fd_sc_mcu7t5v0__fill_1
Xspi_regs_inst__1018_ spi_regs_inst__1019_/A2 spi_regs_inst__1028_/A2 spi_regs_inst__1261_/B1
+ VDD VDD VSS VSS gf180mcu_fd_sc_mcu7t5v0__nor2_1
XFILLER_112_375 VDD VDD VSS VSS gf180mcu_fd_sc_mcu7t5v0__fill_1
Xwave_controller_y_inst_fanout21 wave_controller_y_inst__3529_/A2 wave_controller_y_inst__3556_/A2
+ VDD VDD VSS VSS gf180mcu_fd_sc_mcu7t5v0__dlyb_1
XFILLER_61_1052 VDD VDD VSS VSS gf180mcu_fd_sc_mcu7t5v0__fillcap_64
Xwave_controller_y_inst_fanout54 wave_controller_y_inst__3602_/S wave_controller_y_inst__3606_/A1
+ VDD VDD VSS VSS gf180mcu_fd_sc_mcu7t5v0__dlyb_1
Xwave_controller_x_inst__3681_ wave_controller_x_inst__3681_/D wave_controller_x_inst__3710_/RN
+ clkbuf_leaf_31_clk/Z spi_regs_inst__1211_/B2 VDD VDD VSS VSS gf180mcu_fd_sc_mcu7t5v0__dffrnq_1
Xwave_controller_x_inst__2701_ wave_controller_x_inst__2699_/Z wave_controller_x_inst__2702_/A3
+ wave_controller_x_inst__2723_/A2 VDD VDD VSS VSS gf180mcu_fd_sc_mcu7t5v0__xnor2_1
XFILLER_26_304 VDD VDD VSS VSS gf180mcu_fd_sc_mcu7t5v0__fillcap_8
XFILLER_54_613 VDD VDD VSS VSS gf180mcu_fd_sc_mcu7t5v0__fill_1
XFILLER_66_473 VDD VDD VSS VSS gf180mcu_fd_sc_mcu7t5v0__fillcap_4
XFILLER_82_900 VDD VDD VSS VSS gf180mcu_fd_sc_mcu7t5v0__fillcap_4
XTAP_TAPCELL_ROW_47_1_686 VDD VSS gf180mcu_fd_sc_mcu7t5v0__filltie
Xwave_controller_x_inst__2632_ wave_controller_x_inst__2604_/I wave_controller_x_inst__2634_/C
+ wave_controller_x_inst__2627_/Z wave_controller_x_inst__2633_/C VDD VDD VSS VSS
+ gf180mcu_fd_sc_mcu7t5v0__nand3_1
XFILLER_54_624 VDD VDD VSS VSS gf180mcu_fd_sc_mcu7t5v0__fill_2
XFILLER_54_646 VDD VDD VSS VSS gf180mcu_fd_sc_mcu7t5v0__fillcap_4
XFILLER_82_933 VDD VDD VSS VSS gf180mcu_fd_sc_mcu7t5v0__fillcap_4
Xwave_controller_x_inst__2563_ wave_controller_x_inst__2563_/A1 wave_controller_x_inst__2544_/Z
+ wave_controller_x_inst__2563_/B wave_controller_x_inst__2633_/A2 VDD VDD VSS VSS
+ gf180mcu_fd_sc_mcu7t5v0__oai21_1
XPHY_EDGE_ROW_138_Right_138 VDD VSS gf180mcu_fd_sc_mcu7t5v0__endcap
Xwave_controller_x_inst__2494_ spi_regs_inst__1212_/B2 wave_controller_x_inst__2493_/Z
+ wave_controller_x_inst__2506_/B VDD VDD VSS VSS gf180mcu_fd_sc_mcu7t5v0__nand2_1
XTAP_TAPCELL_ROW_21_1_488 VDD VSS gf180mcu_fd_sc_mcu7t5v0__filltie
Xwave_controller_y_inst__3200_ wave_controller_y_inst__3166_/B wave_controller_y_inst__3165_/Z
+ wave_controller_y_inst__3244_/A2 VDD VDD VSS VSS gf180mcu_fd_sc_mcu7t5v0__xnor2_1
XTAP_TAPCELL_ROW_153_2405 VDD VSS gf180mcu_fd_sc_mcu7t5v0__filltie
Xwave_controller_y_inst__3131_ wave_controller_y_inst__3702_/Q spi_regs_inst__1584_/Q
+ wave_controller_y_inst__3134_/B VDD VDD VSS VSS gf180mcu_fd_sc_mcu7t5v0__xnor2_1
Xwave_controller_x_inst__3115_ wave_controller_x_inst__3305_/B2 spi_regs_inst__1528_/Q
+ wave_controller_x_inst__3115_/Z VDD VDD VSS VSS gf180mcu_fd_sc_mcu7t5v0__and2_1
XPHY_EDGE_ROW_101_Left_268 VDD VSS gf180mcu_fd_sc_mcu7t5v0__endcap
XTAP_TAPCELL_ROW_118_1824 VDD VSS gf180mcu_fd_sc_mcu7t5v0__filltie
XFILLER_120_1157 VDD VDD VSS VSS gf180mcu_fd_sc_mcu7t5v0__fillcap_16
Xwave_controller_y_inst__3062_ wave_controller_y_inst__3062_/A1 wave_controller_y_inst__2979_/B
+ wave_controller_y_inst__3063_/B2 VDD VDD VSS VSS gf180mcu_fd_sc_mcu7t5v0__nand2_1
Xwave_controller_x_inst__3046_ wave_controller_x_inst__2762_/I wave_controller_x_inst__2966_/Z
+ wave_controller_x_inst__3046_/A3 wave_controller_x_inst__3069_/B1 wave_controller_x_inst__3562_/A1
+ wave_controller_x_inst__3703_/D VDD VDD VSS VSS gf180mcu_fd_sc_mcu7t5v0__oai32_1
XFILLER_100_6 VDD VDD VSS VSS gf180mcu_fd_sc_mcu7t5v0__fill_2
XFILLER_123_629 VDD VDD VSS VSS gf180mcu_fd_sc_mcu7t5v0__fill_1
XFILLER_30_57 VDD VDD VSS VSS gf180mcu_fd_sc_mcu7t5v0__fill_1
Xwave_controller_y_inst__2013_ fanout513/I wave_controller_y_inst__2380_/A1 wave_controller_y_inst__2013_/A3
+ spi_regs_inst__1352_/B2 VDD VDD VSS VSS gf180mcu_fd_sc_mcu7t5v0__xor3_1
XFILLER_146_68 VDD VDD VSS VSS gf180mcu_fd_sc_mcu7t5v0__fillcap_4
XFILLER_89_521 VDD VDD VSS VSS gf180mcu_fd_sc_mcu7t5v0__fill_1
XFILLER_103_331 VDD VDD VSS VSS gf180mcu_fd_sc_mcu7t5v0__fillcap_16
XFILLER_131_640 VDD VDD VSS VSS gf180mcu_fd_sc_mcu7t5v0__fillcap_4
XFILLER_162_34 VDD VDD VSS VSS gf180mcu_fd_sc_mcu7t5v0__fill_1
XFILLER_39_66 VDD VDD VSS VSS gf180mcu_fd_sc_mcu7t5v0__fillcap_4
XFILLER_89_587 VDD VDD VSS VSS gf180mcu_fd_sc_mcu7t5v0__fill_2
XFILLER_58_941 VDD VDD VSS VSS gf180mcu_fd_sc_mcu7t5v0__fillcap_4
XPHY_EDGE_ROW_110_Left_277 VDD VSS gf180mcu_fd_sc_mcu7t5v0__endcap
Xwave_controller_y_inst__2915_ wave_controller_y_inst__2915_/A1 wave_controller_y_inst_wire323/Z
+ wave_controller_y_inst__3584_/I0 VDD VDD VSS VSS gf180mcu_fd_sc_mcu7t5v0__nor2_1
XFILLER_29_131 VDD VDD VSS VSS gf180mcu_fd_sc_mcu7t5v0__fillcap_8
XFILLER_29_142 VDD VDD VSS VSS gf180mcu_fd_sc_mcu7t5v0__fillcap_4
XFILLER_91_218 VDD VDD VSS VSS gf180mcu_fd_sc_mcu7t5v0__fill_1
XTAP_TAPCELL_ROW_164_2578 VDD VSS gf180mcu_fd_sc_mcu7t5v0__filltie
XTAP_TAPCELL_ROW_164_2589 VDD VSS gf180mcu_fd_sc_mcu7t5v0__filltie
Xwave_controller_y_inst__2846_ wave_controller_y_inst__3718_/Q wave_controller_y_inst__2846_/A2
+ wave_controller_y_inst__2851_/A1 VDD VDD VSS VSS gf180mcu_fd_sc_mcu7t5v0__nand2_1
XTAP_TAPCELL_ROW_68_991 VDD VSS gf180mcu_fd_sc_mcu7t5v0__filltie
XFILLER_55_65 VDD VDD VSS VSS gf180mcu_fd_sc_mcu7t5v0__fillcap_4
XFILLER_73_977 VDD VDD VSS VSS gf180mcu_fd_sc_mcu7t5v0__fill_2
XPHY_EDGE_ROW_24_1_Left_191 VDD VSS gf180mcu_fd_sc_mcu7t5v0__endcap
Xwave_controller_y_inst__2777_ wave_controller_y_inst__3551_/B2 wave_controller_y_inst__2844_/A2
+ wave_controller_y_inst__2778_/B VDD VDD VSS VSS gf180mcu_fd_sc_mcu7t5v0__nand2_1
XPHY_EDGE_ROW_105_Right_105 VDD VSS gf180mcu_fd_sc_mcu7t5v0__endcap
XTAP_TAPCELL_ROW_84_1260 VDD VSS gf180mcu_fd_sc_mcu7t5v0__filltie
XTAP_TAPCELL_ROW_84_1271 VDD VSS gf180mcu_fd_sc_mcu7t5v0__filltie
XFILLER_111_82 VDD VDD VSS VSS gf180mcu_fd_sc_mcu7t5v0__fillcap_8
XFILLER_53_690 VDD VDD VSS VSS gf180mcu_fd_sc_mcu7t5v0__fillcap_4
XFILLER_60_649 VDD VDD VSS VSS gf180mcu_fd_sc_mcu7t5v0__fillcap_8
XFILLER_125_1046 VDD VDD VSS VSS gf180mcu_fd_sc_mcu7t5v0__fillcap_4
XFILLER_158_559 VDD VDD VSS VSS gf180mcu_fd_sc_mcu7t5v0__fillcap_16
XFILLER_40_395 VDD VDD VSS VSS gf180mcu_fd_sc_mcu7t5v0__fillcap_8
Xwave_controller_y_inst__3329_ wave_controller_y_inst__3336_/A1 wave_controller_y_inst__3328_/Z
+ wave_controller_y_inst__3398_/A2 VDD VDD VSS VSS gf180mcu_fd_sc_mcu7t5v0__nand2_1
XFILLER_139_795 VDD VDD VSS VSS gf180mcu_fd_sc_mcu7t5v0__fillcap_16
XFILLER_145_209 VDD VDD VSS VSS gf180mcu_fd_sc_mcu7t5v0__fill_1
XTAP_TAPCELL_ROW_5_1_370 VDD VSS gf180mcu_fd_sc_mcu7t5v0__filltie
XFILLER_138_283 VDD VDD VSS VSS gf180mcu_fd_sc_mcu7t5v0__fillcap_4
XFILLER_154_776 VDD VDD VSS VSS gf180mcu_fd_sc_mcu7t5v0__fill_1
XFILLER_4_241 VDD VDD VSS VSS gf180mcu_fd_sc_mcu7t5v0__fillcap_4
Xsignal_processor_y_inst__250_ signal_processor_y_inst__250_/D signal_processor_y_inst__253_/RN
+ clkbuf_leaf_0_clk/Z signal_processor_y_inst__250_/Q VDD VDD VSS VSS gf180mcu_fd_sc_mcu7t5v0__dffrnq_1
XFILLER_113_139 VDD VDD VSS VSS gf180mcu_fd_sc_mcu7t5v0__fill_1
Xwave_controller_x_inst_load_slew603 wave_controller_x_inst__3690_/RN wave_controller_x_inst__3686_/RN
+ VDD VDD VSS VSS gf180mcu_fd_sc_mcu7t5v0__buf_4
XFILLER_132_1017 VDD VDD VSS VSS gf180mcu_fd_sc_mcu7t5v0__fillcap_64
Xwave_controller_x_inst_load_slew625 wave_controller_x_inst__3707_/RN wave_controller_x_inst__3706_/RN
+ VDD VDD VSS VSS gf180mcu_fd_sc_mcu7t5v0__buf_4
Xsignal_processor_y_inst__181_ signal_processor_y_inst__239_/Q signal_processor_y_inst__191_/A2
+ signal_processor_y_inst__181_/B signal_processor_y_inst__239_/D VDD VDD VSS VSS
+ gf180mcu_fd_sc_mcu7t5v0__oai21_1
XFILLER_67_226 VDD VDD VSS VSS gf180mcu_fd_sc_mcu7t5v0__fill_1
XFILLER_76_771 VDD VDD VSS VSS gf180mcu_fd_sc_mcu7t5v0__fillcap_8
XFILLER_48_484 VDD VDD VSS VSS gf180mcu_fd_sc_mcu7t5v0__fillcap_16
XFILLER_90_240 VDD VDD VSS VSS gf180mcu_fd_sc_mcu7t5v0__fillcap_4
Xspi_regs_inst__1636_ spi_regs_inst__1636_/D fanout582/Z clkload8/I spi_regs_inst__1636_/Q
+ VDD VDD VSS VSS gf180mcu_fd_sc_mcu7t5v0__dffrnq_1
XFILLER_56_1165 VDD VDD VSS VSS gf180mcu_fd_sc_mcu7t5v0__fill_1
Xspi_regs_inst__1567_ spi_regs_inst__1567_/D spi_regs_inst__1647_/RN clkbuf_leaf_39_clk/Z
+ spi_regs_inst__1567_/Q VDD VDD VSS VSS gf180mcu_fd_sc_mcu7t5v0__dffrnq_1
XTAP_TAPCELL_ROW_135_2102 VDD VSS gf180mcu_fd_sc_mcu7t5v0__filltie
Xspi_regs_inst__1498_ spi_regs_inst__1498_/D fanout588/Z clkload25/I spi_regs_inst__1498_/Q
+ VDD VDD VSS VSS gf180mcu_fd_sc_mcu7t5v0__dffrnq_1
XFILLER_117_456 VDD VDD VSS VSS gf180mcu_fd_sc_mcu7t5v0__fill_2
XFILLER_145_787 VDD VDD VSS VSS gf180mcu_fd_sc_mcu7t5v0__fill_2
XFILLER_99_830 VDD VDD VSS VSS gf180mcu_fd_sc_mcu7t5v0__fillcap_4
XFILLER_132_448 VDD VDD VSS VSS gf180mcu_fd_sc_mcu7t5v0__fillcap_4
XTAP_TAPCELL_ROW_113_1743 VDD VSS gf180mcu_fd_sc_mcu7t5v0__filltie
Xfanout504 fanout504/I fanout504/Z VDD VDD VSS VSS gf180mcu_fd_sc_mcu7t5v0__dlyb_1
XFILLER_100_301 VDD VDD VSS VSS gf180mcu_fd_sc_mcu7t5v0__fillcap_8
XFILLER_113_673 VDD VDD VSS VSS gf180mcu_fd_sc_mcu7t5v0__fillcap_4
XFILLER_141_982 VDD VDD VSS VSS gf180mcu_fd_sc_mcu7t5v0__fillcap_64
Xwave_controller_x_inst__1994_ wave_controller_x_inst__1999_/B1 wave_controller_x_inst__1999_/B2
+ wave_controller_x_inst__1999_/C wave_controller_x_inst__1996_/A3 VDD VDD VSS VSS
+ gf180mcu_fd_sc_mcu7t5v0__oai21_1
Xfanout537 fanout537/I fanout537/Z VDD VDD VSS VSS gf180mcu_fd_sc_mcu7t5v0__dlyb_1
Xfanout526 fanout527/Z fanout526/Z VDD VDD VSS VSS gf180mcu_fd_sc_mcu7t5v0__dlyb_1
XFILLER_101_835 VDD VDD VSS VSS gf180mcu_fd_sc_mcu7t5v0__fillcap_4
Xwave_controller_x_inst__3733_ wave_controller_x_inst__3733_/D fanout597/Z clkbuf_leaf_20_clk/Z
+ wave_controller_x_inst__3733_/Q VDD VDD VSS VSS gf180mcu_fd_sc_mcu7t5v0__dffrnq_1
Xwave_controller_y_inst__2700_ wave_controller_y_inst__2717_/B1 wave_controller_y_inst__2717_/B2
+ wave_controller_y_inst__2717_/C wave_controller_y_inst__2702_/A3 VDD VDD VSS VSS
+ gf180mcu_fd_sc_mcu7t5v0__aoi21_1
Xwave_controller_y_inst__3680_ wave_controller_y_inst__3680_/D wave_controller_y_inst__3683_/RN
+ clkbuf_leaf_46_clk/Z spi_regs_inst__1159_/C2 VDD VDD VSS VSS gf180mcu_fd_sc_mcu7t5v0__dffrnq_1
XFILLER_132_37 VDD VDD VSS VSS gf180mcu_fd_sc_mcu7t5v0__fillcap_8
XTAP_TAPCELL_ROW_146_2286 VDD VSS gf180mcu_fd_sc_mcu7t5v0__filltie
Xwave_controller_y_inst__2631_ wave_controller_y_inst__2601_/Z wave_controller_y_inst__2631_/A2
+ wave_controller_y_inst__2627_/Z wave_controller_y_inst__2634_/B VDD VDD VSS VSS
+ gf180mcu_fd_sc_mcu7t5v0__nand3_1
Xwave_controller_x_inst__3664_ wave_controller_x_inst__3664_/D wave_controller_x_inst__3686_/RN
+ clkbuf_leaf_26_clk/Z spi_regs_inst__1336_/A1 VDD VDD VSS VSS gf180mcu_fd_sc_mcu7t5v0__dffrnq_1
XFILLER_54_432 VDD VDD VSS VSS gf180mcu_fd_sc_mcu7t5v0__fillcap_4
XTAP_TAPCELL_ROW_65_950 VDD VSS gf180mcu_fd_sc_mcu7t5v0__filltie
Xwave_controller_x_inst__3595_ wave_controller_x_inst__3595_/I0 spi_regs_inst__1112_/A1
+ wave_controller_x_inst__3601_/S wave_controller_x_inst__3671_/D VDD VDD VSS VSS
+ gf180mcu_fd_sc_mcu7t5v0__mux2_2
Xwave_controller_x_inst__2615_ wave_controller_x_inst__2615_/I wave_controller_x_inst__2637_/A1
+ VDD VDD VSS VSS gf180mcu_fd_sc_mcu7t5v0__clkinv_1
XFILLER_14_329 VDD VDD VSS VSS gf180mcu_fd_sc_mcu7t5v0__fill_2
XFILLER_54_476 VDD VDD VSS VSS gf180mcu_fd_sc_mcu7t5v0__fillcap_4
XFILLER_70_947 VDD VDD VSS VSS gf180mcu_fd_sc_mcu7t5v0__fillcap_64
Xwave_controller_y_inst__2562_ wave_controller_y_inst__2562_/A1 wave_controller_y_inst__2561_/B
+ wave_controller_y_inst__2563_/B VDD VDD VSS VSS gf180mcu_fd_sc_mcu7t5v0__xnor2_1
Xwave_controller_x_inst__2546_ wave_controller_x_inst__2544_/Z wave_controller_x_inst__2546_/A2
+ spi_regs_inst_wire92/I VDD VDD VSS VSS gf180mcu_fd_sc_mcu7t5v0__nor2_1
Xwave_controller_y_inst__2493_ fanout509/Z wave_controller_y_inst__2488_/Z wave_controller_y_inst__2501_/A2
+ wave_controller_y_inst__2493_/Z VDD VDD VSS VSS gf180mcu_fd_sc_mcu7t5v0__xor3_1
XFILLER_41_159 VDD VDD VSS VSS gf180mcu_fd_sc_mcu7t5v0__fill_1
Xwave_controller_x_inst__2477_ max_cap466/I wave_controller_x_inst__2476_/Z wave_controller_x_inst__2497_/A2
+ VDD VDD VSS VSS gf180mcu_fd_sc_mcu7t5v0__nand2_1
XFILLER_127_209 VDD VDD VSS VSS gf180mcu_fd_sc_mcu7t5v0__fill_1
XFILLER_135_220 VDD VDD VSS VSS gf180mcu_fd_sc_mcu7t5v0__fill_1
XFILLER_157_34 VDD VDD VSS VSS gf180mcu_fd_sc_mcu7t5v0__fillcap_16
Xwave_controller_y_inst__3114_ wave_controller_y_inst__3305_/A1 spi_regs_inst__1592_/Q
+ wave_controller_y_inst__3156_/B VDD VDD VSS VSS gf180mcu_fd_sc_mcu7t5v0__nand2_1
XFILLER_151_702 VDD VDD VSS VSS gf180mcu_fd_sc_mcu7t5v0__fillcap_16
Xwave_controller_y_inst__3045_ wave_controller_y_inst__2960_/I wave_controller_y_inst__2961_/Z
+ wave_controller_y_inst__3045_/B wave_controller_y_inst__3046_/A3 VDD VDD VSS VSS
+ gf180mcu_fd_sc_mcu7t5v0__aoi21_1
Xwave_controller_x_inst__3029_ wave_controller_x_inst__3458_/A1 wave_controller_x_inst__3029_/A2
+ wave_controller_x_inst__3029_/B1 wave_controller_x_inst_wire60/Z wave_controller_x_inst__3696_/D
+ VDD VDD VSS VSS gf180mcu_fd_sc_mcu7t5v0__aoi22_1
XFILLER_123_448 VDD VDD VSS VSS gf180mcu_fd_sc_mcu7t5v0__fillcap_4
XFILLER_151_768 VDD VDD VSS VSS gf180mcu_fd_sc_mcu7t5v0__fill_2
XTAP_TAPCELL_ROW_166_2618 VDD VSS gf180mcu_fd_sc_mcu7t5v0__filltie
XFILLER_131_492 VDD VDD VSS VSS gf180mcu_fd_sc_mcu7t5v0__fillcap_8
XFILLER_65_708 VDD VDD VSS VSS gf180mcu_fd_sc_mcu7t5v0__fill_2
XTAP_TAPCELL_ROW_69_1008 VDD VSS gf180mcu_fd_sc_mcu7t5v0__filltie
XTAP_TAPCELL_ROW_69_1019 VDD VSS gf180mcu_fd_sc_mcu7t5v0__filltie
XTAP_TAPCELL_ROW_86_1300 VDD VSS gf180mcu_fd_sc_mcu7t5v0__filltie
XFILLER_79_1154 VDD VDD VSS VSS gf180mcu_fd_sc_mcu7t5v0__fillcap_16
XTAP_TAPCELL_ROW_63_909 VDD VSS gf180mcu_fd_sc_mcu7t5v0__filltie
Xwave_controller_y_inst__2829_ wave_controller_y_inst__2829_/A1 wave_controller_y_inst__1902_/I
+ wave_controller_y_inst__2829_/B wave_controller_y_inst__2834_/A2 VDD VDD VSS VSS
+ gf180mcu_fd_sc_mcu7t5v0__oai21_1
XFILLER_166_1157 VDD VDD VSS VSS gf180mcu_fd_sc_mcu7t5v0__fillcap_4
XFILLER_61_914 VDD VDD VSS VSS gf180mcu_fd_sc_mcu7t5v0__fill_1
XFILLER_32_126 VDD VDD VSS VSS gf180mcu_fd_sc_mcu7t5v0__fillcap_16
Xspi_regs_inst__1421_ spi_regs_inst__1445_/I1 fanout501/Z spi_regs_inst__1421_/S spi_regs_inst__1493_/D
+ VDD VDD VSS VSS gf180mcu_fd_sc_mcu7t5v0__mux2_2
XFILLER_40_170 VDD VDD VSS VSS gf180mcu_fd_sc_mcu7t5v0__fillcap_4
XTAP_TAPCELL_ROW_38_1_617 VDD VSS gf180mcu_fd_sc_mcu7t5v0__filltie
Xspi_regs_inst__1352_ spi_regs_inst__1598_/Q spi_regs_inst__1352_/A2 spi_regs_inst_wire210/Z
+ spi_regs_inst__1352_/B2 spi_regs_inst__1355_/A2 VDD VDD VSS VSS gf180mcu_fd_sc_mcu7t5v0__aoi22_1
XFILLER_127_710 VDD VDD VSS VSS gf180mcu_fd_sc_mcu7t5v0__fillcap_4
XFILLER_158_367 VDD VDD VSS VSS gf180mcu_fd_sc_mcu7t5v0__fillcap_8
XFILLER_63_6 VDD VDD VSS VSS gf180mcu_fd_sc_mcu7t5v0__fill_1
XTAP_TAPCELL_ROW_46_1_674 VDD VSS gf180mcu_fd_sc_mcu7t5v0__filltie
Xspi_regs_inst__1283_ max_cap427/Z spi_regs_inst__1316_/A2 spi_regs_inst__1324_/B1
+ spi_regs_inst__1283_/B2 spi_regs_inst__1294_/A2 VDD VDD VSS VSS gf180mcu_fd_sc_mcu7t5v0__aoi22_1
XFILLER_115_905 VDD VDD VSS VSS gf180mcu_fd_sc_mcu7t5v0__fillcap_4
XTAP_TAPCELL_ROW_97_1484 VDD VSS gf180mcu_fd_sc_mcu7t5v0__filltie
XTAP_TAPCELL_ROW_97_1473 VDD VSS gf180mcu_fd_sc_mcu7t5v0__filltie
XFILLER_114_404 VDD VDD VSS VSS gf180mcu_fd_sc_mcu7t5v0__fill_2
XTAP_TAPCELL_ROW_130_2021 VDD VSS gf180mcu_fd_sc_mcu7t5v0__filltie
XTAP_TAPCELL_ROW_12_1_419 VDD VSS gf180mcu_fd_sc_mcu7t5v0__filltie
XFILLER_123_982 VDD VDD VSS VSS gf180mcu_fd_sc_mcu7t5v0__fillcap_64
XFILLER_96_822 VDD VDD VSS VSS gf180mcu_fd_sc_mcu7t5v0__fillcap_8
Xsignal_processor_y_inst__233_ signal_processor_y_inst__233_/D fanout556/Z clkload7/I
+ signal_processor_y_inst__233_/Q VDD VDD VSS VSS gf180mcu_fd_sc_mcu7t5v0__dffrnq_1
XFILLER_122_470 VDD VDD VSS VSS gf180mcu_fd_sc_mcu7t5v0__fillcap_8
XFILLER_122_492 VDD VDD VSS VSS gf180mcu_fd_sc_mcu7t5v0__fillcap_32
Xsignal_processor_y_inst__164_ signal_processor_y_inst__187_/A1 signal_processor_y_inst__163_/Z
+ signal_processor_y_inst__232_/D VDD VDD VSS VSS gf180mcu_fd_sc_mcu7t5v0__nor2_1
XFILLER_110_676 VDD VDD VSS VSS gf180mcu_fd_sc_mcu7t5v0__fillcap_8
XFILLER_55_207 VDD VDD VSS VSS gf180mcu_fd_sc_mcu7t5v0__fill_2
XFILLER_56_719 VDD VDD VSS VSS gf180mcu_fd_sc_mcu7t5v0__fill_1
XFILLER_95_343 VDD VDD VSS VSS gf180mcu_fd_sc_mcu7t5v0__fillcap_4
Xspi_regs_inst__0998_ spi_regs_inst__1021_/A1 spi_regs_inst__1031_/A2 spi_regs_inst__1100_/A2
+ VDD VDD VSS VSS gf180mcu_fd_sc_mcu7t5v0__nor2_1
XFILLER_36_487 VDD VDD VSS VSS gf180mcu_fd_sc_mcu7t5v0__fillcap_4
XFILLER_63_273 VDD VDD VSS VSS gf180mcu_fd_sc_mcu7t5v0__fill_1
Xwave_controller_x_inst__3380_ fanout528/Z wave_controller_x_inst__3381_/A1 wave_controller_x_inst__3381_/A2
+ wave_controller_x_inst__3382_/A3 VDD VDD VSS VSS gf180mcu_fd_sc_mcu7t5v0__nor3_1
Xwave_controller_x_inst__2400_ wave_controller_x_inst__2412_/B wave_controller_x_inst__2399_/Z
+ wave_controller_x_inst__2403_/A2 VDD VDD VSS VSS gf180mcu_fd_sc_mcu7t5v0__nor2_1
XFILLER_23_126 VDD VDD VSS VSS gf180mcu_fd_sc_mcu7t5v0__fill_1
Xwave_controller_x_inst__2331_ wave_controller_x_inst__2331_/A1 wave_controller_x_inst__2331_/A2
+ spi_regs_inst__1193_/A1 VDD VDD VSS VSS gf180mcu_fd_sc_mcu7t5v0__xor2_1
Xspi_regs_inst__1619_ spi_regs_inst__1619_/D spi_regs_inst__1662_/RN clkbuf_leaf_7_clk/Z
+ spi_regs_inst__1619_/Q VDD VDD VSS VSS gf180mcu_fd_sc_mcu7t5v0__dffrnq_1
Xwave_controller_x_inst__2262_ fanout524/Z wave_controller_x_inst__2254_/Z wave_controller_x_inst_wire170/I
+ wave_controller_x_inst__2262_/Z VDD VDD VSS VSS gf180mcu_fd_sc_mcu7t5v0__xor3_1
Xwave_controller_x_inst__2193_ spi_regs_inst__1128_/B2 wave_controller_x_inst__2193_/A2
+ wave_controller_x_inst__2516_/A1 spi_regs_inst__1193_/B2 wave_controller_x_inst__2194_/I
+ VDD VDD VSS VSS gf180mcu_fd_sc_mcu7t5v0__aoi22_1
XFILLER_118_710 VDD VDD VSS VSS gf180mcu_fd_sc_mcu7t5v0__fill_1
XFILLER_106_916 VDD VDD VSS VSS gf180mcu_fd_sc_mcu7t5v0__fillcap_16
XFILLER_117_220 VDD VDD VSS VSS gf180mcu_fd_sc_mcu7t5v0__fill_2
XFILLER_117_253 VDD VDD VSS VSS gf180mcu_fd_sc_mcu7t5v0__fillcap_8
XFILLER_118_754 VDD VDD VSS VSS gf180mcu_fd_sc_mcu7t5v0__fillcap_8
XFILLER_133_702 VDD VDD VSS VSS gf180mcu_fd_sc_mcu7t5v0__fill_2
XFILLER_145_562 VDD VDD VSS VSS gf180mcu_fd_sc_mcu7t5v0__fillcap_8
XFILLER_118_798 VDD VDD VSS VSS gf180mcu_fd_sc_mcu7t5v0__fillcap_4
XFILLER_132_201 VDD VDD VSS VSS gf180mcu_fd_sc_mcu7t5v0__fill_1
Xwave_controller_y_inst_fanout406 wave_controller_y_inst_wire412/I wave_controller_y_inst__2844_/A2
+ VDD VDD VSS VSS gf180mcu_fd_sc_mcu7t5v0__dlyb_1
XFILLER_121_908 VDD VDD VSS VSS gf180mcu_fd_sc_mcu7t5v0__fill_2
XFILLER_127_59 VDD VDD VSS VSS gf180mcu_fd_sc_mcu7t5v0__fill_1
Xwave_controller_y_inst_fanout428 spi_regs_inst__1247_/A1 wave_controller_y_inst__3566_/A1
+ VDD VDD VSS VSS gf180mcu_fd_sc_mcu7t5v0__dlyb_1
XFILLER_119_1170 VDD VDD VSS VSS gf180mcu_fd_sc_mcu7t5v0__fillcap_4
XFILLER_120_418 VDD VDD VSS VSS gf180mcu_fd_sc_mcu7t5v0__fillcap_32
XTAP_TAPCELL_ROW_148_2315 VDD VSS gf180mcu_fd_sc_mcu7t5v0__filltie
XTAP_TAPCELL_ROW_148_2326 VDD VSS gf180mcu_fd_sc_mcu7t5v0__filltie
XFILLER_101_632 VDD VDD VSS VSS gf180mcu_fd_sc_mcu7t5v0__fill_2
XFILLER_59_524 VDD VDD VSS VSS gf180mcu_fd_sc_mcu7t5v0__fillcap_4
XFILLER_59_546 VDD VDD VSS VSS gf180mcu_fd_sc_mcu7t5v0__fillcap_4
XFILLER_86_343 VDD VDD VSS VSS gf180mcu_fd_sc_mcu7t5v0__fillcap_4
Xwave_controller_y_inst__3732_ wave_controller_y_inst__3732_/D fanout544/Z clkload6/I
+ wave_controller_y_inst__3732_/Q VDD VDD VSS VSS gf180mcu_fd_sc_mcu7t5v0__dffrnq_1
Xwave_controller_y_inst__1993_ wave_controller_y_inst__1999_/B1 wave_controller_y_inst__1999_/B2
+ spi_regs_inst__1158_/C2 VDD VDD VSS VSS gf180mcu_fd_sc_mcu7t5v0__xor2_1
Xwave_controller_x_inst__1977_ fanout524/Z spi_regs_inst__1343_/B2 wave_controller_x_inst__1977_/A3
+ spi_regs_inst__1336_/B2 VDD VDD VSS VSS gf180mcu_fd_sc_mcu7t5v0__xor3_1
Xsignal_processor_x_inst_max_cap349 signal_processor_x_inst__167_/A2 signal_processor_x_inst__166_/A2
+ VDD VDD VSS VSS gf180mcu_fd_sc_mcu7t5v0__clkbuf_1
Xfanout389 fanout392/Z fanout389/Z VDD VDD VSS VSS gf180mcu_fd_sc_mcu7t5v0__dlyb_1
XFILLER_46_229 VDD VDD VSS VSS gf180mcu_fd_sc_mcu7t5v0__fill_1
XFILLER_74_527 VDD VDD VSS VSS gf180mcu_fd_sc_mcu7t5v0__fillcap_32
XFILLER_86_387 VDD VDD VSS VSS gf180mcu_fd_sc_mcu7t5v0__fill_1
XFILLER_86_398 VDD VDD VSS VSS gf180mcu_fd_sc_mcu7t5v0__fill_1
XTAP_TAPCELL_ROW_161_2526 VDD VSS gf180mcu_fd_sc_mcu7t5v0__filltie
XTAP_TAPCELL_ROW_161_2537 VDD VSS gf180mcu_fd_sc_mcu7t5v0__filltie
Xwave_controller_y_inst_max_cap334 state_machine_inst__34_/A1 wave_controller_y_inst__3100_/B
+ VDD VDD VSS VSS gf180mcu_fd_sc_mcu7t5v0__buf_4
Xwave_controller_x_inst__3716_ wave_controller_x_inst__3716_/D wave_controller_x_inst__3716_/RN
+ clkbuf_leaf_25_clk/Z wave_controller_x_inst__3716_/Q VDD VDD VSS VSS gf180mcu_fd_sc_mcu7t5v0__dffrnq_1
XFILLER_36_34 VDD VDD VSS VSS gf180mcu_fd_sc_mcu7t5v0__fill_1
XTAP_TAPCELL_ROW_126_1956 VDD VSS gf180mcu_fd_sc_mcu7t5v0__filltie
Xwave_controller_y_inst_max_cap367 wave_controller_y_inst__2915_/A1 wave_controller_y_inst__3265_/A1
+ VDD VDD VSS VSS gf180mcu_fd_sc_mcu7t5v0__buf_4
Xwave_controller_y_inst__3663_ wave_controller_y_inst__3663_/D wave_controller_y_inst__3716_/RN
+ clkload14/I spi_regs_inst__1321_/A1 VDD VDD VSS VSS gf180mcu_fd_sc_mcu7t5v0__dffrnq_1
Xwave_controller_x_inst__3647_ wave_controller_x_inst__3647_/D wave_controller_x_inst__3686_/RN
+ clkbuf_leaf_26_clk/Z spi_regs_inst__1188_/C1 VDD VDD VSS VSS gf180mcu_fd_sc_mcu7t5v0__dffrnq_1
XFILLER_27_487 VDD VDD VSS VSS gf180mcu_fd_sc_mcu7t5v0__fill_2
XFILLER_54_251 VDD VDD VSS VSS gf180mcu_fd_sc_mcu7t5v0__fillcap_8
XFILLER_70_700 VDD VDD VSS VSS gf180mcu_fd_sc_mcu7t5v0__fillcap_16
Xwave_controller_y_inst__2614_ max_cap426/Z spi_regs_inst__1256_/A1 wave_controller_y_inst__2615_/I
+ VDD VDD VSS VSS gf180mcu_fd_sc_mcu7t5v0__xor2_1
Xwave_controller_y_inst__3594_ wave_controller_y_inst__3594_/I0 spi_regs_inst__1065_/B2
+ wave_controller_y_inst__3597_/S wave_controller_y_inst__3670_/D VDD VDD VSS VSS
+ gf180mcu_fd_sc_mcu7t5v0__mux2_2
Xspi_regs_inst_max_cap216 spi_regs_inst__1225_/A2 spi_regs_inst__1185_/B1 VDD VDD
+ VSS VSS gf180mcu_fd_sc_mcu7t5v0__buf_2
Xspi_regs_inst_max_cap205 spi_regs_inst__1421_/S spi_regs_inst__1419_/S VDD VDD VSS
+ VSS gf180mcu_fd_sc_mcu7t5v0__buf_3
XFILLER_54_295 VDD VDD VSS VSS gf180mcu_fd_sc_mcu7t5v0__fill_1
Xwave_controller_y_inst__2545_ wave_controller_y_inst__2545_/A1 wave_controller_y_inst__2545_/A2
+ wave_controller_y_inst__2545_/B wave_controller_y_inst__2546_/A2 VDD VDD VSS VSS
+ gf180mcu_fd_sc_mcu7t5v0__aoi21_1
Xwave_controller_x_inst__3578_ max_cap455/I wave_controller_x_inst__3588_/S wave_controller_x_inst__3579_/B
+ VDD VDD VSS VSS gf180mcu_fd_sc_mcu7t5v0__nand2_1
Xspi_regs_inst_max_cap238 spi_regs_inst__1247_/B1 spi_regs_inst__1342_/B1 VDD VDD
+ VSS VSS gf180mcu_fd_sc_mcu7t5v0__buf_2
XFILLER_42_457 VDD VDD VSS VSS gf180mcu_fd_sc_mcu7t5v0__fillcap_8
Xwave_controller_x_inst__2529_ wave_controller_x_inst__2789_/A1 spi_regs_inst__1332_/A1
+ wave_controller_x_inst__2555_/C VDD VDD VSS VSS gf180mcu_fd_sc_mcu7t5v0__nand2_1
Xsignal_processor_x_inst__253_ signal_processor_x_inst__253_/D fanout596/Z clkbuf_leaf_19_clk/Z
+ signal_processor_x_inst__253_/Q VDD VDD VSS VSS gf180mcu_fd_sc_mcu7t5v0__dffrnq_1
XFILLER_167_120 VDD VDD VSS VSS gf180mcu_fd_sc_mcu7t5v0__fill_2
XTAP_TAPCELL_ROW_159_2499 VDD VSS gf180mcu_fd_sc_mcu7t5v0__filltie
Xwave_controller_y_inst__2476_ wave_controller_y_inst__3376_/B wave_controller_y_inst__2470_/Z
+ wave_controller_y_inst__2476_/A3 wave_controller_y_inst__2476_/Z VDD VDD VSS VSS
+ gf180mcu_fd_sc_mcu7t5v0__xor3_1
Xsignal_processor_x_inst__184_ signal_processor_x_inst__239_/Q signal_processor_x_inst__240_/Q
+ signal_processor_x_inst__241_/Q signal_processor_x_inst__185_/I VDD VDD VSS VSS
+ gf180mcu_fd_sc_mcu7t5v0__nand3_1
XFILLER_139_2 VDD VDD VSS VSS gf180mcu_fd_sc_mcu7t5v0__fillcap_4
XFILLER_10_365 VDD VDD VSS VSS gf180mcu_fd_sc_mcu7t5v0__fillcap_8
XFILLER_108_242 VDD VDD VSS VSS gf180mcu_fd_sc_mcu7t5v0__fill_2
XFILLER_109_776 VDD VDD VSS VSS gf180mcu_fd_sc_mcu7t5v0__fill_2
XFILLER_10_387 VDD VDD VSS VSS gf180mcu_fd_sc_mcu7t5v0__fillcap_16
XFILLER_136_584 VDD VDD VSS VSS gf180mcu_fd_sc_mcu7t5v0__fillcap_8
XFILLER_164_871 VDD VDD VSS VSS gf180mcu_fd_sc_mcu7t5v0__fillcap_4
XTAP_TAPCELL_ROW_79_1181 VDD VSS gf180mcu_fd_sc_mcu7t5v0__filltie
XFILLER_108_297 VDD VDD VSS VSS gf180mcu_fd_sc_mcu7t5v0__fillcap_4
XFILLER_124_757 VDD VDD VSS VSS gf180mcu_fd_sc_mcu7t5v0__fill_2
XFILLER_151_554 VDD VDD VSS VSS gf180mcu_fd_sc_mcu7t5v0__fillcap_4
XFILLER_163_381 VDD VDD VSS VSS gf180mcu_fd_sc_mcu7t5v0__fill_1
Xwave_controller_y_inst__3028_ wave_controller_y_inst__3034_/B1 wave_controller_y_inst__3029_/B1
+ wave_controller_y_inst__3030_/A2 VDD VDD VSS VSS gf180mcu_fd_sc_mcu7t5v0__nand2_1
XFILLER_105_982 VDD VDD VSS VSS gf180mcu_fd_sc_mcu7t5v0__fillcap_64
XFILLER_151_576 VDD VDD VSS VSS gf180mcu_fd_sc_mcu7t5v0__fillcap_16
XFILLER_77_321 VDD VDD VSS VSS gf180mcu_fd_sc_mcu7t5v0__fillcap_4
XTAP_TAPCELL_ROW_92_1392 VDD VSS gf180mcu_fd_sc_mcu7t5v0__filltie
XFILLER_77_365 VDD VDD VSS VSS gf180mcu_fd_sc_mcu7t5v0__fillcap_8
XFILLER_78_877 VDD VDD VSS VSS gf180mcu_fd_sc_mcu7t5v0__fill_1
Xspi_regs_inst__0921_ spi_regs_inst__1632_/Q spi_regs_inst__0925_/A4 spi_regs_inst__0928_/A2
+ VDD VDD VSS VSS gf180mcu_fd_sc_mcu7t5v0__nand2_1
XFILLER_58_590 VDD VDD VSS VSS gf180mcu_fd_sc_mcu7t5v0__fillcap_4
Xspi_regs_inst__0852_ spi_regs_inst__0852_/A1 spi_regs_inst__0852_/A2 spi_regs_inst__1386_/A1
+ VDD VDD VSS VSS gf180mcu_fd_sc_mcu7t5v0__nand2_1
XFILLER_18_454 VDD VDD VSS VSS gf180mcu_fd_sc_mcu7t5v0__fill_1
Xspi_regs_inst__0783_ spi_regs_inst__1447_/I1 spi_regs_inst__1536_/Q spi_regs_inst__0787_/S
+ spi_regs_inst__1536_/D VDD VDD VSS VSS gf180mcu_fd_sc_mcu7t5v0__mux2_2
XFILLER_61_755 VDD VDD VSS VSS gf180mcu_fd_sc_mcu7t5v0__fillcap_8
XFILLER_33_468 VDD VDD VSS VSS gf180mcu_fd_sc_mcu7t5v0__fillcap_4
XFILLER_92_1151 VDD VDD VSS VSS gf180mcu_fd_sc_mcu7t5v0__fillcap_4
XFILLER_159_632 VDD VDD VSS VSS gf180mcu_fd_sc_mcu7t5v0__fill_2
XFILLER_20_107 VDD VDD VSS VSS gf180mcu_fd_sc_mcu7t5v0__fillcap_4
XFILLER_53_1124 VDD VDD VSS VSS gf180mcu_fd_sc_mcu7t5v0__fillcap_32
Xspi_regs_inst__1404_ spi_regs_inst__1437_/A1 spi_regs_inst__1404_/A2 spi_regs_inst__1412_/S
+ VDD VDD VSS VSS gf180mcu_fd_sc_mcu7t5v0__nor2_1
XFILLER_159_676 VDD VDD VSS VSS gf180mcu_fd_sc_mcu7t5v0__fillcap_16
Xclkbuf_leaf_40_clk clkbuf_leaf_9_clk/I clkload18/I VDD VDD VSS VSS gf180mcu_fd_sc_mcu7t5v0__clkbuf_8
XTAP_TAPCELL_ROW_99_1513 VDD VSS gf180mcu_fd_sc_mcu7t5v0__filltie
XFILLER_146_337 VDD VDD VSS VSS gf180mcu_fd_sc_mcu7t5v0__fill_2
Xspi_regs_inst__1335_ spi_regs_inst__1335_/A1 spi_regs_inst_wire296/Z spi_regs_inst_wire277/Z
+ spi_regs_inst__1506_/Q spi_regs_inst__1338_/A2 VDD VDD VSS VSS gf180mcu_fd_sc_mcu7t5v0__aoi22_1
Xspi_regs_inst__1266_ spi_regs_inst__1266_/I0 spi_regs_inst__1646_/Q spi_regs_inst__1266_/S
+ spi_regs_inst__1646_/D VDD VDD VSS VSS gf180mcu_fd_sc_mcu7t5v0__mux2_2
XFILLER_115_702 VDD VDD VSS VSS gf180mcu_fd_sc_mcu7t5v0__fillcap_16
XFILLER_127_562 VDD VDD VSS VSS gf180mcu_fd_sc_mcu7t5v0__fillcap_16
Xspi_regs_inst__1197_ spi_regs_inst__1518_/Q spi_regs_inst__1246_/A2 spi_regs_inst_wire288/Z
+ spi_regs_inst__1197_/B2 spi_regs_inst__1197_/C spi_regs_inst_wire17/I VDD VDD VSS
+ VSS gf180mcu_fd_sc_mcu7t5v0__aoi221_1
Xwave_controller_x_inst__1900_ _09_/A2 wave_controller_x_inst__3407_/A1 VDD VDD VSS
+ VSS gf180mcu_fd_sc_mcu7t5v0__clkinv_1
XFILLER_87_129 VDD VDD VSS VSS gf180mcu_fd_sc_mcu7t5v0__fillcap_8
Xwave_controller_x_inst__2880_ wave_controller_x_inst__2880_/A1 wave_controller_x_inst__2883_/A3
+ wave_controller_x_inst__2880_/A3 wave_controller_x_inst__2880_/Z VDD VDD VSS VSS
+ gf180mcu_fd_sc_mcu7t5v0__and3_1
Xsignal_processor_y_inst__216_ signal_processor_y_inst__216_/D _17_/B clkload7/I _92_/I
+ VDD VDD VSS VSS gf180mcu_fd_sc_mcu7t5v0__dffrnq_1
Xwave_controller_x_inst__1831_ spi_regs_inst__1527_/Q wave_controller_x_inst__3213_/A2
+ VDD VDD VSS VSS gf180mcu_fd_sc_mcu7t5v0__clkinv_1
XFILLER_56_516 VDD VDD VSS VSS gf180mcu_fd_sc_mcu7t5v0__fill_1
XFILLER_56_527 VDD VDD VSS VSS gf180mcu_fd_sc_mcu7t5v0__fillcap_32
XFILLER_68_387 VDD VDD VSS VSS gf180mcu_fd_sc_mcu7t5v0__fillcap_8
Xsignal_processor_y_inst__147_ spi_regs_inst__1176_/B2 signal_processor_y_inst__212_/A2
+ signal_processor_y_inst__148_/B VDD VDD VSS VSS gf180mcu_fd_sc_mcu7t5v0__nand2_1
XTAP_TAPCELL_ROW_143_2234 VDD VSS gf180mcu_fd_sc_mcu7t5v0__filltie
XTAP_TAPCELL_ROW_51_1_715 VDD VSS gf180mcu_fd_sc_mcu7t5v0__filltie
Xwave_controller_x_inst__3501_ wave_controller_x_inst__3703_/Q wave_controller_x_inst__3537_/A2
+ wave_controller_x_inst__3503_/A2 VDD VDD VSS VSS gf180mcu_fd_sc_mcu7t5v0__nor2_1
XFILLER_36_240 VDD VDD VSS VSS gf180mcu_fd_sc_mcu7t5v0__fillcap_4
XTAP_TAPCELL_ROW_108_1653 VDD VSS gf180mcu_fd_sc_mcu7t5v0__filltie
XTAP_TAPCELL_ROW_108_1664 VDD VSS gf180mcu_fd_sc_mcu7t5v0__filltie
Xwave_controller_x_inst__3432_ wave_controller_x_inst__3465_/B wave_controller_x_inst__3429_/I
+ wave_controller_x_inst__3471_/B wave_controller_x_inst__3433_/B2 VDD VDD VSS VSS
+ gf180mcu_fd_sc_mcu7t5v0__oai21_1
XFILLER_24_446 VDD VDD VSS VSS gf180mcu_fd_sc_mcu7t5v0__fill_1
XFILLER_51_232 VDD VDD VSS VSS gf180mcu_fd_sc_mcu7t5v0__fill_2
Xwave_controller_x_inst__3363_ wave_controller_x_inst__3363_/A1 wave_controller_x_inst__3301_/Z
+ wave_controller_x_inst__3363_/Z VDD VDD VSS VSS gf180mcu_fd_sc_mcu7t5v0__xor2_1
XTAP_TAPCELL_ROW_121_1875 VDD VSS gf180mcu_fd_sc_mcu7t5v0__filltie
Xwave_controller_y_inst__2330_ wave_controller_y_inst__2304_/Z wave_controller_y_inst__2342_/A2
+ wave_controller_y_inst__2330_/B wave_controller_y_inst__2331_/A2 VDD VDD VSS VSS
+ gf180mcu_fd_sc_mcu7t5v0__aoi21_1
Xwave_controller_x_inst__3294_ wave_controller_x_inst__3294_/A1 wave_controller_x_inst__3274_/Z
+ wave_controller_x_inst__3384_/A2 wave_controller_x_inst__3294_/B wave_controller_x_inst__3367_/A2
+ VDD VDD VSS VSS gf180mcu_fd_sc_mcu7t5v0__oai31_1
Xwave_controller_x_inst__2314_ wave_controller_x_inst__2308_/Z wave_controller_x_inst__2315_/A2
+ wave_controller_x_inst__2330_/B VDD VDD VSS VSS gf180mcu_fd_sc_mcu7t5v0__nor2_1
XFILLER_138_816 VDD VDD VSS VSS gf180mcu_fd_sc_mcu7t5v0__fill_1
XFILLER_149_142 VDD VDD VSS VSS gf180mcu_fd_sc_mcu7t5v0__fill_2
Xwave_controller_y_inst__2261_ wave_controller_y_inst__2254_/Z wave_controller_y_inst_wire153/Z
+ wave_controller_y_inst__2261_/Z VDD VDD VSS VSS gf180mcu_fd_sc_mcu7t5v0__xor2_1
Xwave_controller_x_inst__2245_ wave_controller_x_inst__2245_/I wave_controller_x_inst__2246_/A2
+ VDD VDD VSS VSS gf180mcu_fd_sc_mcu7t5v0__clkinv_1
Xclkbuf_leaf_31_clk clkload0/I clkbuf_leaf_31_clk/Z VDD VDD VSS VSS gf180mcu_fd_sc_mcu7t5v0__clkbuf_8
XFILLER_138_849 VDD VDD VSS VSS gf180mcu_fd_sc_mcu7t5v0__fill_1
XFILLER_149_175 VDD VDD VSS VSS gf180mcu_fd_sc_mcu7t5v0__fill_2
XFILLER_149_197 VDD VDD VSS VSS gf180mcu_fd_sc_mcu7t5v0__fillcap_4
XFILLER_164_101 VDD VDD VSS VSS gf180mcu_fd_sc_mcu7t5v0__fillcap_4
XTAP_TAPCELL_ROW_7_1_384 VDD VSS gf180mcu_fd_sc_mcu7t5v0__filltie
XFILLER_22_69 VDD VDD VSS VSS gf180mcu_fd_sc_mcu7t5v0__fillcap_16
Xwave_controller_y_inst__2192_ wave_controller_y_inst__2223_/A1 wave_controller_y_inst__3566_/A1
+ wave_controller_y_inst__2192_/Z VDD VDD VSS VSS gf180mcu_fd_sc_mcu7t5v0__xor2_1
Xwave_controller_x_inst__2176_ wave_controller_x_inst__2176_/A1 wave_controller_x_inst__2221_/A1
+ wave_controller_x_inst__2181_/A2 VDD VDD VSS VSS gf180mcu_fd_sc_mcu7t5v0__nand2_1
XFILLER_146_871 VDD VDD VSS VSS gf180mcu_fd_sc_mcu7t5v0__fillcap_4
XFILLER_105_212 VDD VDD VSS VSS gf180mcu_fd_sc_mcu7t5v0__fillcap_16
XFILLER_78_107 VDD VDD VSS VSS gf180mcu_fd_sc_mcu7t5v0__fillcap_8
XFILLER_120_215 VDD VDD VSS VSS gf180mcu_fd_sc_mcu7t5v0__fill_2
XFILLER_154_79 VDD VDD VSS VSS gf180mcu_fd_sc_mcu7t5v0__fillcap_16
XFILLER_87_652 VDD VDD VSS VSS gf180mcu_fd_sc_mcu7t5v0__fill_2
Xwave_controller_y_inst__1976_ wave_controller_y_inst__1981_/A1 spi_regs_inst__1354_/A1
+ wave_controller_y_inst__1986_/A1 VDD VDD VSS VSS gf180mcu_fd_sc_mcu7t5v0__nor2_1
XFILLER_47_66 VDD VDD VSS VSS gf180mcu_fd_sc_mcu7t5v0__fillcap_4
XFILLER_47_88 VDD VDD VSS VSS gf180mcu_fd_sc_mcu7t5v0__fillcap_8
Xwave_controller_y_inst__3715_ wave_controller_y_inst__3715_/D fanout545/Z clkload2/I
+ wave_controller_y_inst__3715_/Q VDD VDD VSS VSS gf180mcu_fd_sc_mcu7t5v0__dffrnq_1
Xspi_regs_inst_load_slew306 spi_regs_inst__0835_/S spi_regs_inst__0834_/S VDD VDD
+ VSS VSS gf180mcu_fd_sc_mcu7t5v0__clkbuf_3
XPHY_EDGE_ROW_52_1_Left_219 VDD VSS gf180mcu_fd_sc_mcu7t5v0__endcap
Xwave_controller_y_inst__3646_ wave_controller_y_inst__3646_/D wave_controller_y_inst__3648_/RN
+ clkload14/I spi_regs_inst__1138_/B2 VDD VDD VSS VSS gf180mcu_fd_sc_mcu7t5v0__dffrnq_1
XFILLER_103_72 VDD VDD VSS VSS gf180mcu_fd_sc_mcu7t5v0__fill_1
XFILLER_27_273 VDD VDD VSS VSS gf180mcu_fd_sc_mcu7t5v0__fillcap_4
XFILLER_163_1116 VDD VDD VSS VSS gf180mcu_fd_sc_mcu7t5v0__fillcap_4
XFILLER_42_243 VDD VDD VSS VSS gf180mcu_fd_sc_mcu7t5v0__fill_2
XFILLER_70_552 VDD VDD VSS VSS gf180mcu_fd_sc_mcu7t5v0__fillcap_8
XFILLER_76_1157 VDD VDD VSS VSS gf180mcu_fd_sc_mcu7t5v0__fillcap_16
XTAP_TAPCELL_ROW_53_750 VDD VSS gf180mcu_fd_sc_mcu7t5v0__filltie
Xwave_controller_y_inst__3577_ wave_controller_y_inst_wire48/I wave_controller_y_inst__3606_/A2
+ wave_controller_y_inst__3577_/B wave_controller_y_inst__3658_/D VDD VDD VSS VSS
+ gf180mcu_fd_sc_mcu7t5v0__oai21_1
Xwave_controller_y_inst__2528_ spi_regs_inst__1275_/A1 wave_controller_y_inst__2523_/Z
+ wave_controller_y_inst__2528_/B wave_controller_y_inst__2542_/A1 VDD VDD VSS VSS
+ gf180mcu_fd_sc_mcu7t5v0__aoi21_1
Xsignal_processor_x_inst__236_ signal_processor_x_inst__236_/D fanout583/Z clkload10/I
+ signal_processor_x_inst__236_/Q VDD VDD VSS VSS gf180mcu_fd_sc_mcu7t5v0__dffrnq_1
XFILLER_30_449 VDD VDD VSS VSS gf180mcu_fd_sc_mcu7t5v0__fillcap_4
Xwave_controller_y_inst__2459_ max_cap429/I wave_controller_y_inst__3503_/B2 wave_controller_y_inst__2490_/A1
+ VDD VDD VSS VSS gf180mcu_fd_sc_mcu7t5v0__nand2_1
Xclkbuf_leaf_22_clk clkbuf_3_5__f_clk/Z clkbuf_leaf_22_clk/Z VDD VDD VSS VSS gf180mcu_fd_sc_mcu7t5v0__clkbuf_8
Xsignal_processor_x_inst__167_ signal_processor_x_inst__233_/Q signal_processor_x_inst__167_/A2
+ signal_processor_x_inst__209_/A2 VDD VDD VSS VSS gf180mcu_fd_sc_mcu7t5v0__xnor2_1
XFILLER_10_162 VDD VDD VSS VSS gf180mcu_fd_sc_mcu7t5v0__fillcap_8
XFILLER_128_348 VDD VDD VSS VSS gf180mcu_fd_sc_mcu7t5v0__fillcap_16
XFILLER_155_134 VDD VDD VSS VSS gf180mcu_fd_sc_mcu7t5v0__fillcap_4
Xspi_regs_inst__1120_ spi_regs_inst__1120_/A1 spi_regs_inst__1120_/A2 spi_regs_inst__1120_/A3
+ spi_regs_inst__1120_/A4 spi_regs_inst__1123_/A3 VDD VDD VSS VSS gf180mcu_fd_sc_mcu7t5v0__nand4_1
XFILLER_109_562 VDD VDD VSS VSS gf180mcu_fd_sc_mcu7t5v0__fillcap_16
XFILLER_12_80 VDD VDD VSS VSS gf180mcu_fd_sc_mcu7t5v0__fillcap_16
XFILLER_137_882 VDD VDD VSS VSS gf180mcu_fd_sc_mcu7t5v0__fillcap_16
XFILLER_6_177 VDD VDD VSS VSS gf180mcu_fd_sc_mcu7t5v0__fillcap_64
XTAP_TAPCELL_ROW_94_1432 VDD VSS gf180mcu_fd_sc_mcu7t5v0__filltie
XTAP_TAPCELL_ROW_94_1421 VDD VSS gf180mcu_fd_sc_mcu7t5v0__filltie
XFILLER_124_543 VDD VDD VSS VSS gf180mcu_fd_sc_mcu7t5v0__fillcap_16
Xspi_regs_inst__1051_ spi_regs_inst__1051_/A1 spi_regs_inst__1334_/B1 spi_regs_inst_wire218/Z
+ spi_regs_inst__1051_/B2 spi_regs_inst__1053_/A3 VDD VDD VSS VSS gf180mcu_fd_sc_mcu7t5v0__aoi22_1
XFILLER_98_939 VDD VDD VSS VSS gf180mcu_fd_sc_mcu7t5v0__fillcap_4
XFILLER_111_204 VDD VDD VSS VSS gf180mcu_fd_sc_mcu7t5v0__fillcap_4
XFILLER_88_84 VDD VDD VSS VSS gf180mcu_fd_sc_mcu7t5v0__fillcap_4
XFILLER_26_6 VDD VDD VSS VSS gf180mcu_fd_sc_mcu7t5v0__fillcap_16
XFILLER_78_641 VDD VDD VSS VSS gf180mcu_fd_sc_mcu7t5v0__fillcap_8
XFILLER_144_90 VDD VDD VSS VSS gf180mcu_fd_sc_mcu7t5v0__fillcap_8
XFILLER_38_505 VDD VDD VSS VSS gf180mcu_fd_sc_mcu7t5v0__fillcap_4
XFILLER_66_825 VDD VDD VSS VSS gf180mcu_fd_sc_mcu7t5v0__fill_1
XFILLER_66_836 VDD VDD VSS VSS gf180mcu_fd_sc_mcu7t5v0__fillcap_8
XFILLER_93_644 VDD VDD VSS VSS gf180mcu_fd_sc_mcu7t5v0__fill_2
Xspi_regs_inst__0904_ spi_regs_inst__1628_/Q spi_regs_inst__0916_/A1 spi_regs_inst__0904_/B
+ spi_regs_inst__1628_/D VDD VDD VSS VSS gf180mcu_fd_sc_mcu7t5v0__oai21_1
X_13_ _17_/B _15_/A2 _14_/A2 VDD VDD VSS VSS gf180mcu_fd_sc_mcu7t5v0__nand2_1
XFILLER_18_240 VDD VDD VSS VSS gf180mcu_fd_sc_mcu7t5v0__fillcap_4
XFILLER_18_251 VDD VDD VSS VSS gf180mcu_fd_sc_mcu7t5v0__fill_1
Xspi_regs_inst__0835_ spi_regs_inst__1577_/Q spi_regs_inst__1412_/I1 spi_regs_inst__0835_/S
+ spi_regs_inst__1577_/D VDD VDD VSS VSS gf180mcu_fd_sc_mcu7t5v0__mux2_2
Xspi_regs_inst__0766_ spi_regs_inst__1526_/Q spi_regs_inst__1411_/I1 spi_regs_inst__0766_/S
+ spi_regs_inst__1526_/D VDD VDD VSS VSS gf180mcu_fd_sc_mcu7t5v0__mux2_2
XTAP_TAPCELL_ROW_103_1572 VDD VSS gf180mcu_fd_sc_mcu7t5v0__filltie
XFILLER_14_490 VDD VDD VSS VSS gf180mcu_fd_sc_mcu7t5v0__fillcap_16
XTAP_TAPCELL_ROW_103_1583 VDD VSS gf180mcu_fd_sc_mcu7t5v0__filltie
Xclkbuf_leaf_13_clk clkbuf_3_4__f_clk/Z clkbuf_leaf_13_clk/Z VDD VDD VSS VSS gf180mcu_fd_sc_mcu7t5v0__clkbuf_8
XFILLER_88_1017 VDD VDD VSS VSS gf180mcu_fd_sc_mcu7t5v0__fillcap_64
Xwave_controller_x_inst__2030_ spi_regs_inst__1470_/Q spi_regs_inst__1128_/B2 spi_regs_inst__1144_/A1
+ VDD VDD VSS VSS gf180mcu_fd_sc_mcu7t5v0__xor2_1
Xspi_regs_inst__1318_ spi_regs_inst_wire91/Z spi_regs_inst__1340_/A2 spi_regs_inst__1352_/A2
+ spi_regs_inst__1597_/Q spi_regs_inst__1333_/B1 spi_regs_inst__1318_/C2 spi_regs_inst__1319_/A4
+ VDD VDD VSS VSS gf180mcu_fd_sc_mcu7t5v0__aoi222_1
XFILLER_115_510 VDD VDD VSS VSS gf180mcu_fd_sc_mcu7t5v0__fillcap_4
XFILLER_128_860 VDD VDD VSS VSS gf180mcu_fd_sc_mcu7t5v0__fill_2
XFILLER_146_189 VDD VDD VSS VSS gf180mcu_fd_sc_mcu7t5v0__fill_2
Xspi_regs_inst_wire102 spi_regs_inst_wire102/I spi_regs_inst_wire102/Z VDD VDD VSS
+ VSS gf180mcu_fd_sc_mcu7t5v0__buf_2
Xspi_regs_inst__1249_ spi_regs_inst__1249_/A1 spi_regs_inst__1249_/A2 spi_regs_inst_wire207/I
+ fanout527/Z spi_regs_inst__1253_/A1 VDD VDD VSS VSS gf180mcu_fd_sc_mcu7t5v0__aoi22_1
XFILLER_115_554 VDD VDD VSS VSS gf180mcu_fd_sc_mcu7t5v0__fillcap_4
XFILLER_130_524 VDD VDD VSS VSS gf180mcu_fd_sc_mcu7t5v0__fill_1
Xwave_controller_x_inst__2932_ wave_controller_x_inst__2929_/S wave_controller_x_inst__3593_/A1
+ wave_controller_x_inst__2932_/B wave_controller_x_inst__3690_/D VDD VDD VSS VSS
+ gf180mcu_fd_sc_mcu7t5v0__oai21_1
XFILLER_116_1151 VDD VDD VSS VSS gf180mcu_fd_sc_mcu7t5v0__fillcap_4
XFILLER_130_579 VDD VDD VSS VSS gf180mcu_fd_sc_mcu7t5v0__fill_1
XFILLER_68_140 VDD VDD VSS VSS gf180mcu_fd_sc_mcu7t5v0__fill_1
Xwave_controller_x_inst__2863_ wave_controller_x_inst__2885_/A1 wave_controller_x_inst__2885_/A2
+ wave_controller_x_inst__2867_/A1 VDD VDD VSS VSS gf180mcu_fd_sc_mcu7t5v0__nand2_1
XFILLER_56_302 VDD VDD VSS VSS gf180mcu_fd_sc_mcu7t5v0__fill_1
Xwave_controller_y_inst__1830_ spi_regs_inst__1598_/Q wave_controller_y_inst__3174_/B1
+ VDD VDD VSS VSS gf180mcu_fd_sc_mcu7t5v0__clkinv_1
Xwave_controller_x_inst__1814_ spi_regs_inst__1546_/Q wave_controller_x_inst__3273_/A2
+ VDD VDD VSS VSS gf180mcu_fd_sc_mcu7t5v0__clkinv_1
Xwave_controller_x_inst__2794_ wave_controller_x_inst__3290_/A1 wave_controller_x_inst__2793_/Z
+ wave_controller_x_inst__2809_/A2 VDD VDD VSS VSS gf180mcu_fd_sc_mcu7t5v0__nor2_1
XFILLER_72_839 VDD VDD VSS VSS gf180mcu_fd_sc_mcu7t5v0__fillcap_16
XTAP_TAPCELL_ROW_123_1904 VDD VSS gf180mcu_fd_sc_mcu7t5v0__filltie
Xwave_controller_y_inst__3500_ wave_controller_y_inst_wire144/Z wave_controller_y_inst__3500_/A2
+ wave_controller_y_inst__3500_/A3 wave_controller_y_inst_wire139/Z wave_controller_y_inst__3500_/B2
+ wave_controller_y_inst__3629_/D VDD VDD VSS VSS gf180mcu_fd_sc_mcu7t5v0__oai32_1
XFILLER_140_37 VDD VDD VSS VSS gf180mcu_fd_sc_mcu7t5v0__fill_2
Xwave_controller_x_inst_max_cap116 wave_controller_x_inst_wire117/Z wave_controller_x_inst__2412_/A2
+ VDD VDD VSS VSS gf180mcu_fd_sc_mcu7t5v0__clkbuf_1
XFILLER_52_552 VDD VDD VSS VSS gf180mcu_fd_sc_mcu7t5v0__fill_2
Xwave_controller_y_inst__3431_ wave_controller_y_inst__3441_/A1 wave_controller_y_inst__3429_/I
+ wave_controller_y_inst__3431_/B wave_controller_y_inst__3431_/C wave_controller_y_inst__3433_/B1
+ VDD VDD VSS VSS gf180mcu_fd_sc_mcu7t5v0__aoi211_1
Xwave_controller_x_inst__3415_ spi_regs_inst__1050_/B2 wave_controller_x_inst__3494_/A1
+ wave_controller_x_inst__3416_/B VDD VDD VSS VSS gf180mcu_fd_sc_mcu7t5v0__nand2_1
XFILLER_12_427 VDD VDD VSS VSS gf180mcu_fd_sc_mcu7t5v0__fillcap_16
XFILLER_24_287 VDD VDD VSS VSS gf180mcu_fd_sc_mcu7t5v0__fill_1
Xwave_controller_y_inst__3362_ wave_controller_y_inst__3391_/A1 wave_controller_y_inst__3361_/Z
+ wave_controller_y_inst__3392_/C VDD VDD VSS VSS gf180mcu_fd_sc_mcu7t5v0__nand2_1
XFILLER_33_68 VDD VDD VSS VSS gf180mcu_fd_sc_mcu7t5v0__fill_2
XFILLER_8_409 VDD VDD VSS VSS gf180mcu_fd_sc_mcu7t5v0__fill_2
XTAP_TAPCELL_ROW_156_2447 VDD VSS gf180mcu_fd_sc_mcu7t5v0__filltie
Xwave_controller_y_inst__2313_ wave_controller_y_inst__2346_/A1 wave_controller_y_inst__2313_/A2
+ wave_controller_y_inst__2313_/B wave_controller_y_inst__2313_/C wave_controller_y_inst__2315_/A2
+ VDD VDD VSS VSS gf180mcu_fd_sc_mcu7t5v0__aoi211_1
Xwave_controller_x_inst__3346_ wave_controller_x_inst__3402_/A1 wave_controller_x_inst__3346_/A2
+ wave_controller_x_inst__3346_/Z VDD VDD VSS VSS gf180mcu_fd_sc_mcu7t5v0__or2_1
XFILLER_123_1122 VDD VDD VSS VSS gf180mcu_fd_sc_mcu7t5v0__fillcap_32
XFILLER_130_6 VDD VDD VSS VSS gf180mcu_fd_sc_mcu7t5v0__fill_2
XFILLER_149_68 VDD VDD VSS VSS gf180mcu_fd_sc_mcu7t5v0__fill_2
XTAP_TAPCELL_ROW_156_2458 VDD VSS gf180mcu_fd_sc_mcu7t5v0__filltie
Xwave_controller_y_inst__3293_ wave_controller_y_inst__3274_/Z wave_controller_y_inst__3384_/A2
+ wave_controller_y_inst__3369_/A3 VDD VDD VSS VSS gf180mcu_fd_sc_mcu7t5v0__nor2_1
Xwave_controller_x_inst__3277_ wave_controller_x_inst__3277_/I wave_controller_x_inst__3373_/A1
+ VDD VDD VSS VSS gf180mcu_fd_sc_mcu7t5v0__clkinv_1
XTAP_TAPCELL_ROW_48_1_688 VDD VSS gf180mcu_fd_sc_mcu7t5v0__filltie
Xwave_controller_y_inst__2244_ wave_controller_y_inst__2521_/A1 wave_controller_y_inst__2242_/Z
+ wave_controller_y_inst__2245_/I VDD VDD VSS VSS gf180mcu_fd_sc_mcu7t5v0__xor2_1
Xwave_controller_x_inst__2228_ spi_regs_inst__1473_/Q wave_controller_x_inst__2226_/Z
+ wave_controller_x_inst__2228_/Z VDD VDD VSS VSS gf180mcu_fd_sc_mcu7t5v0__xor2_1
XFILLER_125_329 VDD VDD VSS VSS gf180mcu_fd_sc_mcu7t5v0__fill_1
Xwave_controller_y_inst__2175_ wave_controller_y_inst__2757_/B wave_controller_y_inst__2173_/Z
+ spi_regs_inst__1092_/A1 VDD VDD VSS VSS gf180mcu_fd_sc_mcu7t5v0__xnor2_1
Xwave_controller_x_inst__2159_ wire462/I spi_regs_inst__1112_/A1 wave_controller_x_inst__2163_/B
+ VDD VDD VSS VSS gf180mcu_fd_sc_mcu7t5v0__xnor2_1
XFILLER_134_874 VDD VDD VSS VSS gf180mcu_fd_sc_mcu7t5v0__fill_1
XFILLER_165_56 VDD VDD VSS VSS gf180mcu_fd_sc_mcu7t5v0__fillcap_8
XFILLER_3_136 VDD VDD VSS VSS gf180mcu_fd_sc_mcu7t5v0__fillcap_4
XTAP_TAPCELL_ROW_72_1059 VDD VSS gf180mcu_fd_sc_mcu7t5v0__filltie
XFILLER_121_557 VDD VDD VSS VSS gf180mcu_fd_sc_mcu7t5v0__fill_2
Xwave_controller_x_inst_fanout622 wave_controller_x_inst__3712_/RN wave_controller_x_inst__3710_/RN
+ VDD VDD VSS VSS gf180mcu_fd_sc_mcu7t5v0__dlyb_1
XFILLER_75_600 VDD VDD VSS VSS gf180mcu_fd_sc_mcu7t5v0__fillcap_8
XFILLER_75_644 VDD VDD VSS VSS gf180mcu_fd_sc_mcu7t5v0__fill_2
XTAP_TAPCELL_ROW_58_831 VDD VSS gf180mcu_fd_sc_mcu7t5v0__filltie
XTAP_TAPCELL_ROW_58_842 VDD VSS gf180mcu_fd_sc_mcu7t5v0__filltie
XFILLER_63_817 VDD VDD VSS VSS gf180mcu_fd_sc_mcu7t5v0__fillcap_4
XFILLER_63_839 VDD VDD VSS VSS gf180mcu_fd_sc_mcu7t5v0__fill_1
XFILLER_74_31 VDD VDD VSS VSS gf180mcu_fd_sc_mcu7t5v0__fillcap_4
Xwave_controller_y_inst__1959_ fanout507/Z spi_regs_inst__1226_/A1 wave_controller_y_inst__1960_/I
+ VDD VDD VSS VSS gf180mcu_fd_sc_mcu7t5v0__xnor2_1
XFILLER_74_53 VDD VDD VSS VSS gf180mcu_fd_sc_mcu7t5v0__fillcap_4
XFILLER_128_1011 VDD VDD VSS VSS gf180mcu_fd_sc_mcu7t5v0__fillcap_4
XFILLER_71_861 VDD VDD VSS VSS gf180mcu_fd_sc_mcu7t5v0__fill_2
Xwave_controller_y_inst__3629_ wave_controller_y_inst__3629_/D wave_controller_y_inst__3673_/RN
+ clkbuf_leaf_35_clk/Z spi_regs_inst__1097_/A1 VDD VDD VSS VSS gf180mcu_fd_sc_mcu7t5v0__dffrnq_1
XFILLER_15_298 VDD VDD VSS VSS gf180mcu_fd_sc_mcu7t5v0__fill_1
XFILLER_30_279 VDD VDD VSS VSS gf180mcu_fd_sc_mcu7t5v0__fill_2
Xsignal_processor_x_inst__219_ signal_processor_x_inst__219_/D signal_processor_x_inst__242_/RN
+ clkload23/I spi_regs_inst__1050_/A1 VDD VDD VSS VSS gf180mcu_fd_sc_mcu7t5v0__dffrnq_1
XTAP_TAPCELL_ROW_50_1_703 VDD VSS gf180mcu_fd_sc_mcu7t5v0__filltie
XFILLER_128_189 VDD VDD VSS VSS gf180mcu_fd_sc_mcu7t5v0__fill_2
XFILLER_99_72 VDD VDD VSS VSS gf180mcu_fd_sc_mcu7t5v0__fillcap_8
Xspi_regs_inst__1103_ spi_regs_inst__1537_/Q spi_regs_inst__1207_/B1 spi_regs_inst_wire233/Z
+ spi_regs_inst_wire134/Z spi_regs_inst__1103_/C1 spi_regs_inst__1308_/B1 spi_regs_inst__1104_/A4
+ VDD VDD VSS VSS gf180mcu_fd_sc_mcu7t5v0__aoi222_1
Xspi_regs_inst__1034_ spi_regs_inst__1034_/A1 spi_regs_inst_wire231/Z spi_regs_inst_wire226/Z
+ spi_regs_inst__1034_/B2 spi_regs_inst__1520_/Q spi_regs_inst__1315_/B1 spi_regs_inst__1035_/A2
+ VDD VDD VSS VSS gf180mcu_fd_sc_mcu7t5v0__aoi222_1
XFILLER_98_725 VDD VDD VSS VSS gf180mcu_fd_sc_mcu7t5v0__fillcap_8
XFILLER_140_877 VDD VDD VSS VSS gf180mcu_fd_sc_mcu7t5v0__fillcap_64
XFILLER_97_246 VDD VDD VSS VSS gf180mcu_fd_sc_mcu7t5v0__fill_2
XFILLER_97_279 VDD VDD VSS VSS gf180mcu_fd_sc_mcu7t5v0__fill_1
Xclkbuf_leaf_2_clk clkbuf_leaf_3_clk/I clkload2/I VDD VDD VSS VSS gf180mcu_fd_sc_mcu7t5v0__clkbuf_8
XFILLER_17_2 VDD VDD VSS VSS gf180mcu_fd_sc_mcu7t5v0__fillcap_64
XFILLER_94_942 VDD VDD VSS VSS gf180mcu_fd_sc_mcu7t5v0__fill_2
XPHY_EDGE_ROW_119_Right_119 VDD VSS gf180mcu_fd_sc_mcu7t5v0__endcap
XFILLER_38_368 VDD VDD VSS VSS gf180mcu_fd_sc_mcu7t5v0__fill_2
XFILLER_53_305 VDD VDD VSS VSS gf180mcu_fd_sc_mcu7t5v0__fill_1
XFILLER_65_154 VDD VDD VSS VSS gf180mcu_fd_sc_mcu7t5v0__fill_1
XFILLER_81_614 VDD VDD VSS VSS gf180mcu_fd_sc_mcu7t5v0__fill_1
XFILLER_93_496 VDD VDD VSS VSS gf180mcu_fd_sc_mcu7t5v0__fill_1
XTAP_TAPCELL_ROW_105_1612 VDD VSS gf180mcu_fd_sc_mcu7t5v0__filltie
XFILLER_34_552 VDD VDD VSS VSS gf180mcu_fd_sc_mcu7t5v0__fill_2
Xspi_regs_inst__0818_ spi_regs_inst__0818_/A1 spi_regs_inst__0818_/A2 spi_regs_inst__0852_/A2
+ spi_regs_inst_wire308/I VDD VDD VSS VSS gf180mcu_fd_sc_mcu7t5v0__nand3_1
XFILLER_110_18 VDD VDD VSS VSS gf180mcu_fd_sc_mcu7t5v0__fillcap_4
XFILLER_94_1087 VDD VDD VSS VSS gf180mcu_fd_sc_mcu7t5v0__fillcap_64
Xwave_controller_x_inst__3200_ wave_controller_x_inst__3166_/B wave_controller_x_inst__3165_/Z
+ wave_controller_x_inst__3244_/A2 VDD VDD VSS VSS gf180mcu_fd_sc_mcu7t5v0__xnor2_1
Xspi_regs_inst__0749_ spi_regs_inst__1626_/Q spi_regs_inst__0748_/Z spi_regs_inst__0749_/Z
+ VDD VDD VSS VSS gf180mcu_fd_sc_mcu7t5v0__and2_1
XFILLER_21_257 VDD VDD VSS VSS gf180mcu_fd_sc_mcu7t5v0__fillcap_8
XTAP_TAPCELL_ROW_138_2155 VDD VSS gf180mcu_fd_sc_mcu7t5v0__filltie
Xwave_controller_x_inst__3131_ wave_controller_x_inst__3702_/Q spi_regs_inst__1521_/Q
+ wave_controller_x_inst__3134_/B VDD VDD VSS VSS gf180mcu_fd_sc_mcu7t5v0__xnor2_1
XTAP_TAPCELL_ROW_36_1_604 VDD VSS gf180mcu_fd_sc_mcu7t5v0__filltie
Xwave_controller_x_inst__3062_ wave_controller_x_inst__3091_/A1 wave_controller_x_inst__2979_/B
+ wave_controller_x_inst__3063_/B2 VDD VDD VSS VSS gf180mcu_fd_sc_mcu7t5v0__nand2_1
XFILLER_107_307 VDD VDD VSS VSS gf180mcu_fd_sc_mcu7t5v0__fill_2
XFILLER_135_616 VDD VDD VSS VSS gf180mcu_fd_sc_mcu7t5v0__fill_1
XFILLER_162_413 VDD VDD VSS VSS gf180mcu_fd_sc_mcu7t5v0__fill_1
Xwave_controller_x_inst__2013_ fanout535/Z wave_controller_x_inst__2380_/A1 wave_controller_x_inst__2013_/A3
+ spi_regs_inst__1341_/B2 VDD VDD VSS VSS gf180mcu_fd_sc_mcu7t5v0__xor3_1
XTAP_TAPCELL_ROW_151_2366 VDD VSS gf180mcu_fd_sc_mcu7t5v0__filltie
XTAP_TAPCELL_ROW_44_1_661 VDD VSS gf180mcu_fd_sc_mcu7t5v0__filltie
XFILLER_162_457 VDD VDD VSS VSS gf180mcu_fd_sc_mcu7t5v0__fillcap_16
XTAP_TAPCELL_ROW_116_1785 VDD VSS gf180mcu_fd_sc_mcu7t5v0__filltie
XFILLER_103_535 VDD VDD VSS VSS gf180mcu_fd_sc_mcu7t5v0__fillcap_4
XTAP_TAPCELL_ROW_116_1796 VDD VSS gf180mcu_fd_sc_mcu7t5v0__filltie
XFILLER_130_321 VDD VDD VSS VSS gf180mcu_fd_sc_mcu7t5v0__fillcap_8
XFILLER_131_855 VDD VDD VSS VSS gf180mcu_fd_sc_mcu7t5v0__fill_1
XFILLER_88_235 VDD VDD VSS VSS gf180mcu_fd_sc_mcu7t5v0__fillcap_4
XTAP_TAPCELL_ROW_10_1_406 VDD VSS gf180mcu_fd_sc_mcu7t5v0__filltie
Xwave_controller_y_inst__2931_ spi_regs_inst__1254_/A1 wave_controller_y_inst__2923_/S
+ wave_controller_y_inst__2932_/B VDD VDD VSS VSS gf180mcu_fd_sc_mcu7t5v0__nand2_1
Xwave_controller_x_inst__2915_ wave_controller_x_inst__3265_/A1 wave_controller_x_inst_wire333/Z
+ wave_controller_x_inst__3584_/I0 VDD VDD VSS VSS gf180mcu_fd_sc_mcu7t5v0__nor2_1
XFILLER_130_387 VDD VDD VSS VSS gf180mcu_fd_sc_mcu7t5v0__fillcap_8
XFILLER_57_600 VDD VDD VSS VSS gf180mcu_fd_sc_mcu7t5v0__fill_1
XFILLER_97_780 VDD VDD VSS VSS gf180mcu_fd_sc_mcu7t5v0__fill_1
Xwave_controller_y_inst__2862_ wave_controller_y_inst__2882_/A1 wave_controller_y_inst__2861_/Z
+ wave_controller_y_inst__2885_/A2 VDD VDD VSS VSS gf180mcu_fd_sc_mcu7t5v0__nand2_1
Xwave_controller_x_inst__2846_ wave_controller_x_inst__3718_/Q wave_controller_x_inst__2846_/A2
+ wave_controller_x_inst__2851_/A1 VDD VDD VSS VSS gf180mcu_fd_sc_mcu7t5v0__nand2_1
Xwave_controller_y_inst__2793_ wave_controller_y_inst__3566_/A1 max_cap433/Z wave_controller_y_inst__2805_/S
+ wave_controller_y_inst__2793_/Z VDD VDD VSS VSS gf180mcu_fd_sc_mcu7t5v0__mux2_2
Xwave_controller_y_inst__1813_ spi_regs_inst__1606_/Q wave_controller_y_inst__3365_/A2
+ VDD VDD VSS VSS gf180mcu_fd_sc_mcu7t5v0__clkinv_1
Xwave_controller_x_inst__2777_ wave_controller_x_inst__3551_/B2 wave_controller_x_inst__1902_/I
+ wave_controller_x_inst__2778_/B VDD VDD VSS VSS gf180mcu_fd_sc_mcu7t5v0__nand2_1
XFILLER_72_636 VDD VDD VSS VSS gf180mcu_fd_sc_mcu7t5v0__fillcap_4
XFILLER_25_552 VDD VDD VSS VSS gf180mcu_fd_sc_mcu7t5v0__fill_2
XFILLER_44_34 VDD VDD VSS VSS gf180mcu_fd_sc_mcu7t5v0__fill_1
XFILLER_71_146 VDD VDD VSS VSS gf180mcu_fd_sc_mcu7t5v0__fill_1
XFILLER_73_1116 VDD VDD VSS VSS gf180mcu_fd_sc_mcu7t5v0__fillcap_4
Xwave_controller_y_inst__3414_ wave_controller_y_inst__3454_/B wave_controller_y_inst__3414_/A2
+ wave_controller_y_inst__3414_/A3 wave_controller_y_inst__3465_/B wave_controller_y_inst__3421_/C
+ VDD VDD VSS VSS gf180mcu_fd_sc_mcu7t5v0__oai31_1
XFILLER_158_708 VDD VDD VSS VSS gf180mcu_fd_sc_mcu7t5v0__fillcap_16
XFILLER_40_522 VDD VDD VSS VSS gf180mcu_fd_sc_mcu7t5v0__fill_2
XFILLER_40_544 VDD VDD VSS VSS gf180mcu_fd_sc_mcu7t5v0__fill_1
Xanalog_block_inst_analog_comp_x_inst__0_ analog[2] clkload24/I wave_controller_x_inst__1952_/A2
+ VDD VDD VSS VSS gf180mcu_fd_sc_mcu7t5v0__dffq_1
Xwave_controller_y_inst__3345_ wave_controller_y_inst__3341_/C wave_controller_y_inst__3345_/A2
+ wave_controller_y_inst__3345_/A3 wave_controller_y_inst__3346_/A2 VDD VDD VSS VSS
+ gf180mcu_fd_sc_mcu7t5v0__nor3_1
Xwave_controller_x_inst__3329_ wave_controller_x_inst__3336_/A1 wave_controller_x_inst__3328_/Z
+ wave_controller_x_inst__3398_/A2 VDD VDD VSS VSS gf180mcu_fd_sc_mcu7t5v0__nand2_1
XFILLER_138_432 VDD VDD VSS VSS gf180mcu_fd_sc_mcu7t5v0__fill_1
Xwave_controller_y_inst__3276_ wave_controller_y_inst__3562_/A1 spi_regs_inst__1601_/Q
+ wave_controller_y_inst__3277_/I VDD VDD VSS VSS gf180mcu_fd_sc_mcu7t5v0__nand2_1
XFILLER_126_605 VDD VDD VSS VSS gf180mcu_fd_sc_mcu7t5v0__fillcap_4
XFILLER_153_413 VDD VDD VSS VSS gf180mcu_fd_sc_mcu7t5v0__fillcap_4
Xwave_controller_y_inst__2227_ wave_controller_y_inst__1826_/I wave_controller_y_inst__2226_/Z
+ wave_controller_y_inst__2233_/B VDD VDD VSS VSS gf180mcu_fd_sc_mcu7t5v0__nor2_1
XFILLER_154_947 VDD VDD VSS VSS gf180mcu_fd_sc_mcu7t5v0__fillcap_64
XFILLER_153_457 VDD VDD VSS VSS gf180mcu_fd_sc_mcu7t5v0__fillcap_8
XFILLER_4_467 VDD VDD VSS VSS gf180mcu_fd_sc_mcu7t5v0__fillcap_16
Xwave_controller_y_inst__2158_ wave_controller_y_inst__2451_/A1 spi_regs_inst__1090_/B2
+ wave_controller_y_inst__2168_/A1 VDD VDD VSS VSS gf180mcu_fd_sc_mcu7t5v0__nand2_1
XFILLER_106_373 VDD VDD VSS VSS gf180mcu_fd_sc_mcu7t5v0__fillcap_8
XFILLER_121_310 VDD VDD VSS VSS gf180mcu_fd_sc_mcu7t5v0__fill_2
XFILLER_140_107 VDD VDD VSS VSS gf180mcu_fd_sc_mcu7t5v0__fillcap_4
Xwave_controller_y_inst__2089_ wave_controller_y_inst__2104_/A1 wave_controller_y_inst__2104_/A2
+ wave_controller_y_inst__2105_/A1 VDD VDD VSS VSS gf180mcu_fd_sc_mcu7t5v0__nand2_1
XFILLER_121_332 VDD VDD VSS VSS gf180mcu_fd_sc_mcu7t5v0__fillcap_4
XFILLER_79_235 VDD VDD VSS VSS gf180mcu_fd_sc_mcu7t5v0__fill_2
XFILLER_79_279 VDD VDD VSS VSS gf180mcu_fd_sc_mcu7t5v0__fill_1
Xwave_controller_x_inst_fanout441 wave_controller_x_inst__2052_/A2 wave_controller_x_inst__3089_/B
+ VDD VDD VSS VSS gf180mcu_fd_sc_mcu7t5v0__dlyb_1
XFILLER_134_1081 VDD VDD VSS VSS gf180mcu_fd_sc_mcu7t5v0__fillcap_4
Xwave_controller_y_inst_max_cap43 wave_controller_y_inst__3016_/A3 wave_controller_y_inst__3034_/B1
+ VDD VDD VSS VSS gf180mcu_fd_sc_mcu7t5v0__buf_2
XFILLER_47_154 VDD VDD VSS VSS gf180mcu_fd_sc_mcu7t5v0__fillcap_4
XFILLER_91_912 VDD VDD VSS VSS gf180mcu_fd_sc_mcu7t5v0__fillcap_16
XTAP_TAPCELL_ROW_89_1342 VDD VSS gf180mcu_fd_sc_mcu7t5v0__filltie
XTAP_TAPCELL_ROW_89_1353 VDD VSS gf180mcu_fd_sc_mcu7t5v0__filltie
XFILLER_35_316 VDD VDD VSS VSS gf180mcu_fd_sc_mcu7t5v0__fillcap_4
XFILLER_16_552 VDD VDD VSS VSS gf180mcu_fd_sc_mcu7t5v0__fill_2
XFILLER_63_669 VDD VDD VSS VSS gf180mcu_fd_sc_mcu7t5v0__fillcap_4
XFILLER_91_978 VDD VDD VSS VSS gf180mcu_fd_sc_mcu7t5v0__fill_2
Xspi_regs_inst__1652_ spi_regs_inst__1652_/D wire594/Z clkbuf_leaf_11_clk/Z spi_regs_inst__1652_/Q
+ VDD VDD VSS VSS gf180mcu_fd_sc_mcu7t5v0__dffrnq_1
XFILLER_43_371 VDD VDD VSS VSS gf180mcu_fd_sc_mcu7t5v0__fillcap_32
Xspi_regs_inst__1583_ spi_regs_inst__1583_/D fanout578/Z clkload19/I spi_regs_inst__1583_/Q
+ VDD VDD VSS VSS gf180mcu_fd_sc_mcu7t5v0__dffrnq_1
XTAP_TAPCELL_ROW_100_1520 VDD VSS gf180mcu_fd_sc_mcu7t5v0__filltie
XTAP_TAPCELL_ROW_100_1531 VDD VSS gf180mcu_fd_sc_mcu7t5v0__filltie
XFILLER_141_1052 VDD VDD VSS VSS gf180mcu_fd_sc_mcu7t5v0__fillcap_64
XTAP_TAPCELL_ROW_9_1_398 VDD VSS gf180mcu_fd_sc_mcu7t5v0__filltie
XFILLER_116_104 VDD VDD VSS VSS gf180mcu_fd_sc_mcu7t5v0__fill_1
XFILLER_156_295 VDD VDD VSS VSS gf180mcu_fd_sc_mcu7t5v0__fillcap_8
XFILLER_144_457 VDD VDD VSS VSS gf180mcu_fd_sc_mcu7t5v0__fillcap_4
XTAP_TAPCELL_ROW_133_2074 VDD VSS gf180mcu_fd_sc_mcu7t5v0__filltie
Xspi_regs_inst__1017_ spi_regs_inst__1028_/A1 spi_regs_inst__1025_/A2 spi_regs_inst__1036_/B1
+ VDD VDD VSS VSS gf180mcu_fd_sc_mcu7t5v0__nor2_1
XFILLER_79_780 VDD VDD VSS VSS gf180mcu_fd_sc_mcu7t5v0__fillcap_4
XFILLER_85_205 VDD VDD VSS VSS gf180mcu_fd_sc_mcu7t5v0__fillcap_4
XFILLER_85_216 VDD VDD VSS VSS gf180mcu_fd_sc_mcu7t5v0__fill_1
XFILLER_98_588 VDD VDD VSS VSS gf180mcu_fd_sc_mcu7t5v0__fillcap_4
Xwave_controller_y_inst_fanout22 wave_controller_y_inst__3520_/A2 wave_controller_y_inst__3529_/A2
+ VDD VDD VSS VSS gf180mcu_fd_sc_mcu7t5v0__dlyb_1
XFILLER_112_387 VDD VDD VSS VSS gf180mcu_fd_sc_mcu7t5v0__fillcap_8
XFILLER_85_227 VDD VDD VSS VSS gf180mcu_fd_sc_mcu7t5v0__fillcap_8
Xwave_controller_x_inst__3680_ wave_controller_x_inst__3680_/D wave_controller_x_inst__3682_/RN
+ clkload34/I spi_regs_inst__1140_/B2 VDD VDD VSS VSS gf180mcu_fd_sc_mcu7t5v0__dffrnq_1
Xwave_controller_x_inst__2700_ wave_controller_x_inst__2717_/B1 wave_controller_x_inst_wire113/Z
+ wave_controller_x_inst__2717_/C wave_controller_x_inst__2702_/A3 VDD VDD VSS VSS
+ gf180mcu_fd_sc_mcu7t5v0__aoi21_1
XFILLER_113_1154 VDD VDD VSS VSS gf180mcu_fd_sc_mcu7t5v0__fillcap_16
XTAP_TAPCELL_ROW_47_1_687 VDD VSS gf180mcu_fd_sc_mcu7t5v0__filltie
Xwave_controller_x_inst__2631_ wave_controller_x_inst__2601_/Z wave_controller_x_inst__2631_/A2
+ wave_controller_x_inst__2627_/Z wave_controller_x_inst__2634_/B VDD VDD VSS VSS
+ gf180mcu_fd_sc_mcu7t5v0__nand3_1
XFILLER_66_496 VDD VDD VSS VSS gf180mcu_fd_sc_mcu7t5v0__fillcap_16
XFILLER_81_400 VDD VDD VSS VSS gf180mcu_fd_sc_mcu7t5v0__fill_2
XFILLER_81_422 VDD VDD VSS VSS gf180mcu_fd_sc_mcu7t5v0__fillcap_4
XFILLER_93_282 VDD VDD VSS VSS gf180mcu_fd_sc_mcu7t5v0__fill_2
XFILLER_26_349 VDD VDD VSS VSS gf180mcu_fd_sc_mcu7t5v0__fill_2
XFILLER_53_135 VDD VDD VSS VSS gf180mcu_fd_sc_mcu7t5v0__fill_1
XFILLER_54_669 VDD VDD VSS VSS gf180mcu_fd_sc_mcu7t5v0__fill_1
Xwave_controller_x_inst__2562_ wave_controller_x_inst__2562_/A1 wave_controller_x_inst__2561_/B
+ wave_controller_x_inst__2563_/B VDD VDD VSS VSS gf180mcu_fd_sc_mcu7t5v0__xnor2_1
XFILLER_41_308 VDD VDD VSS VSS gf180mcu_fd_sc_mcu7t5v0__fill_1
XFILLER_53_168 VDD VDD VSS VSS gf180mcu_fd_sc_mcu7t5v0__fill_2
XFILLER_81_488 VDD VDD VSS VSS gf180mcu_fd_sc_mcu7t5v0__fill_2
Xwave_controller_x_inst__2493_ fanout530/Z wave_controller_x_inst__2488_/Z wave_controller_x_inst__2501_/A2
+ wave_controller_x_inst__2493_/Z VDD VDD VSS VSS gf180mcu_fd_sc_mcu7t5v0__xor3_1
XFILLER_14_26 VDD VDD VSS VSS gf180mcu_fd_sc_mcu7t5v0__fill_1
XFILLER_14_37 VDD VDD VSS VSS gf180mcu_fd_sc_mcu7t5v0__fillcap_64
XTAP_TAPCELL_ROW_21_1_489 VDD VSS gf180mcu_fd_sc_mcu7t5v0__filltie
XTAP_TAPCELL_ROW_153_2406 VDD VSS gf180mcu_fd_sc_mcu7t5v0__filltie
XTAP_TAPCELL_ROW_60_870 VDD VSS gf180mcu_fd_sc_mcu7t5v0__filltie
Xwave_controller_y_inst__3130_ wave_controller_y_inst__3279_/A1 spi_regs_inst__1584_/Q
+ wave_controller_y_inst__3227_/A1 VDD VDD VSS VSS gf180mcu_fd_sc_mcu7t5v0__nand2_1
Xwave_controller_x_inst__3114_ wave_controller_x_inst__3305_/A1 spi_regs_inst__1529_/Q
+ wave_controller_x_inst__3156_/B VDD VDD VSS VSS gf180mcu_fd_sc_mcu7t5v0__nand2_1
XTAP_TAPCELL_ROW_118_1825 VDD VSS gf180mcu_fd_sc_mcu7t5v0__filltie
Xwave_controller_y_inst__3061_ wave_controller_y_inst__3061_/A1 wave_controller_y_inst__2977_/Z
+ wave_controller_y_inst__3063_/B1 VDD VDD VSS VSS gf180mcu_fd_sc_mcu7t5v0__nor2_1
XFILLER_135_446 VDD VDD VSS VSS gf180mcu_fd_sc_mcu7t5v0__fill_2
XFILLER_136_947 VDD VDD VSS VSS gf180mcu_fd_sc_mcu7t5v0__fillcap_64
XFILLER_147_284 VDD VDD VSS VSS gf180mcu_fd_sc_mcu7t5v0__fill_1
Xwave_controller_y_inst__2012_ fanout513/I wave_controller_y_inst__2380_/A1 wave_controller_y_inst__2018_/A1
+ VDD VDD VSS VSS gf180mcu_fd_sc_mcu7t5v0__nand2_1
Xwave_controller_x_inst__3045_ wave_controller_x_inst__2960_/I wave_controller_x_inst__2961_/Z
+ wave_controller_x_inst__3045_/B wave_controller_x_inst__3046_/A3 VDD VDD VSS VSS
+ gf180mcu_fd_sc_mcu7t5v0__aoi21_1
XFILLER_151_906 VDD VDD VSS VSS gf180mcu_fd_sc_mcu7t5v0__fillcap_4
XFILLER_163_766 VDD VDD VSS VSS gf180mcu_fd_sc_mcu7t5v0__fillcap_4
XFILLER_122_107 VDD VDD VSS VSS gf180mcu_fd_sc_mcu7t5v0__fillcap_16
XFILLER_162_276 VDD VDD VSS VSS gf180mcu_fd_sc_mcu7t5v0__fill_2
XFILLER_89_500 VDD VDD VSS VSS gf180mcu_fd_sc_mcu7t5v0__fillcap_4
XFILLER_89_511 VDD VDD VSS VSS gf180mcu_fd_sc_mcu7t5v0__fillcap_8
XFILLER_89_555 VDD VDD VSS VSS gf180mcu_fd_sc_mcu7t5v0__fillcap_4
XFILLER_104_877 VDD VDD VSS VSS gf180mcu_fd_sc_mcu7t5v0__fillcap_16
XFILLER_118_1087 VDD VDD VSS VSS gf180mcu_fd_sc_mcu7t5v0__fillcap_64
XFILLER_131_674 VDD VDD VSS VSS gf180mcu_fd_sc_mcu7t5v0__fill_2
XFILLER_131_696 VDD VDD VSS VSS gf180mcu_fd_sc_mcu7t5v0__fillcap_4
Xwave_controller_y_inst__2914_ wave_controller_y_inst__2923_/S wave_controller_y_inst__3583_/A1
+ wave_controller_y_inst__2914_/B wave_controller_y_inst__3682_/D VDD VDD VSS VSS
+ gf180mcu_fd_sc_mcu7t5v0__oai21_1
XFILLER_69_290 VDD VDD VSS VSS gf180mcu_fd_sc_mcu7t5v0__fill_2
XFILLER_73_901 VDD VDD VSS VSS gf180mcu_fd_sc_mcu7t5v0__fill_1
XFILLER_73_912 VDD VDD VSS VSS gf180mcu_fd_sc_mcu7t5v0__fillcap_8
XFILLER_85_772 VDD VDD VSS VSS gf180mcu_fd_sc_mcu7t5v0__fillcap_16
XTAP_TAPCELL_ROW_164_2579 VDD VSS gf180mcu_fd_sc_mcu7t5v0__filltie
Xwave_controller_y_inst__2845_ wave_controller_y_inst__3718_/Q wave_controller_y_inst__2846_/A2
+ wave_controller_y_inst__2845_/Z VDD VDD VSS VSS gf180mcu_fd_sc_mcu7t5v0__or2_1
Xwave_controller_x_inst__2829_ wave_controller_x_inst__2829_/A1 wave_controller_x_inst__2831_/A2
+ wave_controller_x_inst__2829_/B wave_controller_x_inst__2834_/A2 VDD VDD VSS VSS
+ gf180mcu_fd_sc_mcu7t5v0__oai21_1
XFILLER_17_316 VDD VDD VSS VSS gf180mcu_fd_sc_mcu7t5v0__fill_1
XFILLER_17_327 VDD VDD VSS VSS gf180mcu_fd_sc_mcu7t5v0__fill_1
XTAP_TAPCELL_ROW_129_1998 VDD VSS gf180mcu_fd_sc_mcu7t5v0__filltie
XTAP_TAPCELL_ROW_68_992 VDD VSS gf180mcu_fd_sc_mcu7t5v0__filltie
Xwave_controller_y_inst__2776_ wave_controller_y_inst__3189_/A1 wave_controller_y_inst__2898_/A2
+ wave_controller_y_inst__2854_/B VDD VDD VSS VSS gf180mcu_fd_sc_mcu7t5v0__or2_1
XTAP_TAPCELL_ROW_84_1261 VDD VSS gf180mcu_fd_sc_mcu7t5v0__filltie
XFILLER_111_72 VDD VDD VSS VSS gf180mcu_fd_sc_mcu7t5v0__fillcap_4
XFILLER_158_505 VDD VDD VSS VSS gf180mcu_fd_sc_mcu7t5v0__fillcap_16
XFILLER_158_527 VDD VDD VSS VSS gf180mcu_fd_sc_mcu7t5v0__fillcap_32
XFILLER_40_352 VDD VDD VSS VSS gf180mcu_fd_sc_mcu7t5v0__fillcap_16
XFILLER_71_54 VDD VDD VSS VSS gf180mcu_fd_sc_mcu7t5v0__fill_1
XFILLER_139_752 VDD VDD VSS VSS gf180mcu_fd_sc_mcu7t5v0__fill_1
Xwave_controller_y_inst__3328_ wave_controller_y_inst__3004_/B spi_regs_inst__1616_/Q
+ wave_controller_y_inst__3328_/Z VDD VDD VSS VSS gf180mcu_fd_sc_mcu7t5v0__or2_1
XTAP_TAPCELL_ROW_5_1_371 VDD VSS gf180mcu_fd_sc_mcu7t5v0__filltie
XFILLER_126_413 VDD VDD VSS VSS gf180mcu_fd_sc_mcu7t5v0__fill_1
Xwave_controller_y_inst__3259_ wave_controller_y_inst__1806_/I wave_controller_y_inst__3338_/A2
+ wave_controller_y_inst__3402_/C VDD VDD VSS VSS gf180mcu_fd_sc_mcu7t5v0__nand2_1
XFILLER_126_457 VDD VDD VSS VSS gf180mcu_fd_sc_mcu7t5v0__fillcap_16
XFILLER_154_766 VDD VDD VSS VSS gf180mcu_fd_sc_mcu7t5v0__fillcap_8
XFILLER_107_693 VDD VDD VSS VSS gf180mcu_fd_sc_mcu7t5v0__fill_1
Xsignal_processor_y_inst__180_ signal_processor_y_inst__129_/Z signal_processor_y_inst__212_/A2
+ signal_processor_y_inst__191_/A2 VDD VDD VSS VSS gf180mcu_fd_sc_mcu7t5v0__nand2_1
XFILLER_110_803 VDD VDD VSS VSS gf180mcu_fd_sc_mcu7t5v0__fill_2
XFILLER_110_825 VDD VDD VSS VSS gf180mcu_fd_sc_mcu7t5v0__fill_2
XFILLER_136_91 VDD VDD VSS VSS gf180mcu_fd_sc_mcu7t5v0__fill_2
XFILLER_95_514 VDD VDD VSS VSS gf180mcu_fd_sc_mcu7t5v0__fillcap_16
XFILLER_110_858 VDD VDD VSS VSS gf180mcu_fd_sc_mcu7t5v0__fillcap_16
XFILLER_121_184 VDD VDD VSS VSS gf180mcu_fd_sc_mcu7t5v0__fill_2
XFILLER_48_452 VDD VDD VSS VSS gf180mcu_fd_sc_mcu7t5v0__fill_2
XFILLER_76_761 VDD VDD VSS VSS gf180mcu_fd_sc_mcu7t5v0__fill_1
XFILLER_152_90 VDD VDD VSS VSS gf180mcu_fd_sc_mcu7t5v0__fillcap_4
XFILLER_75_282 VDD VDD VSS VSS gf180mcu_fd_sc_mcu7t5v0__fillcap_8
XFILLER_63_455 VDD VDD VSS VSS gf180mcu_fd_sc_mcu7t5v0__fill_2
XFILLER_35_179 VDD VDD VSS VSS gf180mcu_fd_sc_mcu7t5v0__fillcap_16
XFILLER_90_252 VDD VDD VSS VSS gf180mcu_fd_sc_mcu7t5v0__fillcap_8
Xspi_regs_inst__1635_ spi_regs_inst__1635_/D fanout582/Z clkload10/I spi_regs_inst__1635_/Q
+ VDD VDD VSS VSS gf180mcu_fd_sc_mcu7t5v0__dffrnq_1
XFILLER_31_352 VDD VDD VSS VSS gf180mcu_fd_sc_mcu7t5v0__fill_1
XFILLER_91_1046 VDD VDD VSS VSS gf180mcu_fd_sc_mcu7t5v0__fillcap_4
Xspi_regs_inst__1566_ spi_regs_inst__1566_/D spi_regs_inst__1647_/RN clkbuf_leaf_39_clk/Z
+ spi_regs_inst__1566_/Q VDD VDD VSS VSS gf180mcu_fd_sc_mcu7t5v0__dffrnq_1
XFILLER_149_549 VDD VDD VSS VSS gf180mcu_fd_sc_mcu7t5v0__fillcap_4
XTAP_TAPCELL_ROW_135_2103 VDD VSS gf180mcu_fd_sc_mcu7t5v0__filltie
Xspi_regs_inst__1497_ spi_regs_inst__1497_/D fanout589/Z clkload25/I spi_regs_inst__1497_/Q
+ VDD VDD VSS VSS gf180mcu_fd_sc_mcu7t5v0__dffrnq_1
XFILLER_118_947 VDD VDD VSS VSS gf180mcu_fd_sc_mcu7t5v0__fillcap_64
XFILLER_144_210 VDD VDD VSS VSS gf180mcu_fd_sc_mcu7t5v0__fill_2
XFILLER_117_446 VDD VDD VSS VSS gf180mcu_fd_sc_mcu7t5v0__fill_2
XFILLER_144_232 VDD VDD VSS VSS gf180mcu_fd_sc_mcu7t5v0__fillcap_4
XFILLER_145_766 VDD VDD VSS VSS gf180mcu_fd_sc_mcu7t5v0__fillcap_4
XFILLER_104_107 VDD VDD VSS VSS gf180mcu_fd_sc_mcu7t5v0__fillcap_64
XTAP_TAPCELL_ROW_113_1744 VDD VSS gf180mcu_fd_sc_mcu7t5v0__filltie
Xfanout505 fanout505/I fanout505/Z VDD VDD VSS VSS gf180mcu_fd_sc_mcu7t5v0__dlyb_1
XFILLER_113_663 VDD VDD VSS VSS gf180mcu_fd_sc_mcu7t5v0__fill_1
XFILLER_98_352 VDD VDD VSS VSS gf180mcu_fd_sc_mcu7t5v0__fill_1
Xwave_controller_x_inst__1993_ wave_controller_x_inst__1999_/B1 wave_controller_x_inst__1999_/B2
+ spi_regs_inst__1145_/B2 VDD VDD VSS VSS gf180mcu_fd_sc_mcu7t5v0__xor2_1
Xfanout527 fanout527/I fanout527/Z VDD VDD VSS VSS gf180mcu_fd_sc_mcu7t5v0__dlyb_1
Xfanout516 fanout516/I fanout516/Z VDD VDD VSS VSS gf180mcu_fd_sc_mcu7t5v0__dlyb_1
XFILLER_100_313 VDD VDD VSS VSS gf180mcu_fd_sc_mcu7t5v0__fill_2
XFILLER_58_216 VDD VDD VSS VSS gf180mcu_fd_sc_mcu7t5v0__fillcap_4
XFILLER_58_227 VDD VDD VSS VSS gf180mcu_fd_sc_mcu7t5v0__fill_2
Xwave_controller_x_inst__3732_ wave_controller_x_inst__3732_/D fanout597/Z clkbuf_leaf_20_clk/Z
+ wave_controller_x_inst__3732_/Q VDD VDD VSS VSS gf180mcu_fd_sc_mcu7t5v0__dffrnq_1
XFILLER_67_761 VDD VDD VSS VSS gf180mcu_fd_sc_mcu7t5v0__fillcap_8
XFILLER_74_709 VDD VDD VSS VSS gf180mcu_fd_sc_mcu7t5v0__fillcap_4
XFILLER_100_379 VDD VDD VSS VSS gf180mcu_fd_sc_mcu7t5v0__fillcap_4
XFILLER_26_102 VDD VDD VSS VSS gf180mcu_fd_sc_mcu7t5v0__fill_2
XFILLER_54_411 VDD VDD VSS VSS gf180mcu_fd_sc_mcu7t5v0__fillcap_8
XFILLER_55_912 VDD VDD VSS VSS gf180mcu_fd_sc_mcu7t5v0__fillcap_64
XTAP_TAPCELL_ROW_146_2287 VDD VSS gf180mcu_fd_sc_mcu7t5v0__filltie
XTAP_TAPCELL_ROW_29_1_550 VDD VSS gf180mcu_fd_sc_mcu7t5v0__filltie
Xwave_controller_y_inst__2630_ wave_controller_y_inst__2630_/A1 wave_controller_y_inst__2630_/A2
+ spi_regs_inst__1200_/A1 VDD VDD VSS VSS gf180mcu_fd_sc_mcu7t5v0__xor2_1
Xwave_controller_x_inst__3663_ wave_controller_x_inst__3663_/D fanout592/Z clkbuf_leaf_26_clk/Z
+ spi_regs_inst__1306_/A1 VDD VDD VSS VSS gf180mcu_fd_sc_mcu7t5v0__dffrnq_1
XTAP_TAPCELL_ROW_65_951 VDD VSS gf180mcu_fd_sc_mcu7t5v0__filltie
Xwave_controller_y_inst_wire412 wave_controller_y_inst_wire412/I wave_controller_y_inst__2800_/S
+ VDD VDD VSS VSS gf180mcu_fd_sc_mcu7t5v0__buf_4
Xwave_controller_x_inst__3594_ wave_controller_x_inst__3594_/I0 spi_regs_inst__1033_/B2
+ wave_controller_x_inst__3601_/S wave_controller_x_inst__3670_/D VDD VDD VSS VSS
+ gf180mcu_fd_sc_mcu7t5v0__mux2_2
Xwave_controller_x_inst__2614_ max_cap453/Z max_cap463/Z wave_controller_x_inst__2615_/I
+ VDD VDD VSS VSS gf180mcu_fd_sc_mcu7t5v0__xor2_1
XFILLER_26_179 VDD VDD VSS VSS gf180mcu_fd_sc_mcu7t5v0__fill_1
Xwave_controller_y_inst__2561_ wave_controller_y_inst__2561_/A1 wave_controller_y_inst__2561_/A2
+ wave_controller_y_inst__2561_/B wave_controller_y_inst_wire99/I VDD VDD VSS VSS
+ gf180mcu_fd_sc_mcu7t5v0__oai21_1
Xwave_controller_x_inst__2545_ wave_controller_x_inst__2545_/A1 wave_controller_x_inst__2545_/A2
+ wave_controller_x_inst__2545_/B wave_controller_x_inst__2546_/A2 VDD VDD VSS VSS
+ gf180mcu_fd_sc_mcu7t5v0__aoi21_1
Xwave_controller_y_inst__2492_ wave_controller_y_inst__2488_/Z wave_controller_y_inst__2501_/A2
+ wave_controller_y_inst__2492_/Z VDD VDD VSS VSS gf180mcu_fd_sc_mcu7t5v0__xor2_1
XFILLER_22_341 VDD VDD VSS VSS gf180mcu_fd_sc_mcu7t5v0__fill_2
Xwave_controller_x_inst__2476_ wave_controller_x_inst__3376_/B wave_controller_x_inst__2470_/Z
+ wave_controller_x_inst__2476_/A3 wave_controller_x_inst__2476_/Z VDD VDD VSS VSS
+ gf180mcu_fd_sc_mcu7t5v0__xor3_1
XFILLER_10_514 VDD VDD VSS VSS gf180mcu_fd_sc_mcu7t5v0__fill_1
Xwave_controller_y_inst__3113_ wave_controller_y_inst__3163_/C spi_regs_inst__1593_/Q
+ wave_controller_y_inst__3203_/A1 VDD VDD VSS VSS gf180mcu_fd_sc_mcu7t5v0__nand2_1
XFILLER_159_1154 VDD VDD VSS VSS gf180mcu_fd_sc_mcu7t5v0__fillcap_16
Xwave_controller_y_inst__3044_ wave_controller_y_inst__3279_/A1 wave_controller_y_inst__3059_/A2
+ wave_controller_y_inst__3043_/Z wave_controller_y_inst__2762_/I wave_controller_y_inst__3702_/D
+ VDD VDD VSS VSS gf180mcu_fd_sc_mcu7t5v0__oai22_1
Xwave_controller_x_inst__3028_ wave_controller_x_inst_wire60/Z wave_controller_x_inst__3029_/B1
+ wave_controller_x_inst__3030_/A2 VDD VDD VSS VSS gf180mcu_fd_sc_mcu7t5v0__nand2_1
XFILLER_151_736 VDD VDD VSS VSS gf180mcu_fd_sc_mcu7t5v0__fillcap_8
XFILLER_1_212 VDD VDD VSS VSS gf180mcu_fd_sc_mcu7t5v0__fillcap_64
XTAP_TAPCELL_ROW_166_2608 VDD VSS gf180mcu_fd_sc_mcu7t5v0__filltie
XFILLER_104_663 VDD VDD VSS VSS gf180mcu_fd_sc_mcu7t5v0__fill_2
XFILLER_49_205 VDD VDD VSS VSS gf180mcu_fd_sc_mcu7t5v0__fillcap_4
XFILLER_89_352 VDD VDD VSS VSS gf180mcu_fd_sc_mcu7t5v0__fillcap_8
XFILLER_89_374 VDD VDD VSS VSS gf180mcu_fd_sc_mcu7t5v0__fill_1
XTAP_TAPCELL_ROW_166_2619 VDD VSS gf180mcu_fd_sc_mcu7t5v0__filltie
XFILLER_103_184 VDD VDD VSS VSS gf180mcu_fd_sc_mcu7t5v0__fillcap_4
XFILLER_49_238 VDD VDD VSS VSS gf180mcu_fd_sc_mcu7t5v0__fillcap_8
XFILLER_89_385 VDD VDD VSS VSS gf180mcu_fd_sc_mcu7t5v0__fill_2
XFILLER_58_761 VDD VDD VSS VSS gf180mcu_fd_sc_mcu7t5v0__fill_1
XFILLER_66_32 VDD VDD VSS VSS gf180mcu_fd_sc_mcu7t5v0__fill_2
XTAP_TAPCELL_ROW_69_1009 VDD VSS gf180mcu_fd_sc_mcu7t5v0__filltie
XFILLER_45_411 VDD VDD VSS VSS gf180mcu_fd_sc_mcu7t5v0__fillcap_8
XFILLER_79_1122 VDD VDD VSS VSS gf180mcu_fd_sc_mcu7t5v0__fillcap_32
XTAP_TAPCELL_ROW_86_1301 VDD VSS gf180mcu_fd_sc_mcu7t5v0__filltie
XFILLER_45_422 VDD VDD VSS VSS gf180mcu_fd_sc_mcu7t5v0__fill_2
XFILLER_57_282 VDD VDD VSS VSS gf180mcu_fd_sc_mcu7t5v0__fillcap_16
XFILLER_61_904 VDD VDD VSS VSS gf180mcu_fd_sc_mcu7t5v0__fillcap_4
Xwave_controller_y_inst__2828_ spi_regs_inst__1256_/A1 wave_controller_y_inst__1902_/I
+ wave_controller_y_inst__2829_/B VDD VDD VSS VSS gf180mcu_fd_sc_mcu7t5v0__nand2_1
XFILLER_73_786 VDD VDD VSS VSS gf180mcu_fd_sc_mcu7t5v0__fill_1
XFILLER_82_31 VDD VDD VSS VSS gf180mcu_fd_sc_mcu7t5v0__fillcap_4
Xwave_controller_y_inst__2759_ wave_controller_y_inst__3100_/B fanout499/Z wave_controller_y_inst__3081_/C
+ VDD VDD VSS VSS gf180mcu_fd_sc_mcu7t5v0__nor2_1
XFILLER_61_959 VDD VDD VSS VSS gf180mcu_fd_sc_mcu7t5v0__fillcap_16
XFILLER_82_53 VDD VDD VSS VSS gf180mcu_fd_sc_mcu7t5v0__fillcap_4
XFILLER_13_352 VDD VDD VSS VSS gf180mcu_fd_sc_mcu7t5v0__fillcap_4
XFILLER_159_836 VDD VDD VSS VSS gf180mcu_fd_sc_mcu7t5v0__fillcap_4
XFILLER_60_469 VDD VDD VSS VSS gf180mcu_fd_sc_mcu7t5v0__fillcap_4
Xspi_regs_inst__1420_ spi_regs_inst__1444_/I1 fanout502/I spi_regs_inst__1421_/S spi_regs_inst__1492_/D
+ VDD VDD VSS VSS gf180mcu_fd_sc_mcu7t5v0__mux2_2
XTAP_TAPCELL_ROW_38_1_618 VDD VSS gf180mcu_fd_sc_mcu7t5v0__filltie
Xspi_regs_inst__1351_ spi_regs_inst__1351_/A1 spi_regs_inst__1351_/A2 spi_regs_inst__1351_/A3
+ spi_regs_inst__1351_/A4 spi_regs_inst__1359_/A2 VDD VDD VSS VSS gf180mcu_fd_sc_mcu7t5v0__nand4_1
XFILLER_40_193 VDD VDD VSS VSS gf180mcu_fd_sc_mcu7t5v0__fillcap_8
XFILLER_127_744 VDD VDD VSS VSS gf180mcu_fd_sc_mcu7t5v0__fillcap_4
XFILLER_9_389 VDD VDD VSS VSS gf180mcu_fd_sc_mcu7t5v0__fillcap_8
XTAP_TAPCELL_ROW_46_1_675 VDD VSS gf180mcu_fd_sc_mcu7t5v0__filltie
Xspi_regs_inst__1282_ spi_regs_inst__1546_/Q spi_regs_inst_wire252/Z spi_regs_inst__1354_/B1
+ spi_regs_inst__1282_/B2 spi_regs_inst__1294_/A1 VDD VDD VSS VSS gf180mcu_fd_sc_mcu7t5v0__aoi22_1
XFILLER_154_541 VDD VDD VSS VSS gf180mcu_fd_sc_mcu7t5v0__fill_2
XTAP_TAPCELL_ROW_97_1485 VDD VSS gf180mcu_fd_sc_mcu7t5v0__filltie
XTAP_TAPCELL_ROW_97_1474 VDD VSS gf180mcu_fd_sc_mcu7t5v0__filltie
XFILLER_142_714 VDD VDD VSS VSS gf180mcu_fd_sc_mcu7t5v0__fill_1
XPHY_EDGE_ROW_8_1_Right_7 VDD VSS gf180mcu_fd_sc_mcu7t5v0__endcap
XTAP_TAPCELL_ROW_130_2022 VDD VSS gf180mcu_fd_sc_mcu7t5v0__filltie
XFILLER_114_449 VDD VDD VSS VSS gf180mcu_fd_sc_mcu7t5v0__fillcap_4
XFILLER_123_950 VDD VDD VSS VSS gf180mcu_fd_sc_mcu7t5v0__fillcap_16
XFILLER_141_279 VDD VDD VSS VSS gf180mcu_fd_sc_mcu7t5v0__fill_1
Xsignal_processor_y_inst__232_ signal_processor_y_inst__232_/D fanout556/Z _21_/CLK
+ signal_processor_y_inst__232_/Q VDD VDD VSS VSS gf180mcu_fd_sc_mcu7t5v0__dffrnq_1
XFILLER_150_791 VDD VDD VSS VSS gf180mcu_fd_sc_mcu7t5v0__fillcap_8
Xsignal_processor_y_inst__163_ signal_processor_y_inst__232_/Q signal_processor_y_inst__163_/A2
+ signal_processor_y_inst__163_/Z VDD VDD VSS VSS gf180mcu_fd_sc_mcu7t5v0__xor2_1
XFILLER_110_688 VDD VDD VSS VSS gf180mcu_fd_sc_mcu7t5v0__fill_2
XFILLER_36_400 VDD VDD VSS VSS gf180mcu_fd_sc_mcu7t5v0__fill_2
XFILLER_48_271 VDD VDD VSS VSS gf180mcu_fd_sc_mcu7t5v0__fill_1
Xspi_regs_inst__0997_ spi_regs_inst__1028_/A1 spi_regs_inst__1019_/A1 spi_regs_inst_wire247/I
+ VDD VDD VSS VSS gf180mcu_fd_sc_mcu7t5v0__nor2_1
XFILLER_110_1157 VDD VDD VSS VSS gf180mcu_fd_sc_mcu7t5v0__fillcap_16
Xwave_controller_x_inst__2330_ wave_controller_x_inst__2304_/Z wave_controller_x_inst__2342_/A2
+ wave_controller_x_inst__2330_/B wave_controller_x_inst__2331_/A2 VDD VDD VSS VSS
+ gf180mcu_fd_sc_mcu7t5v0__aoi21_1
XFILLER_51_458 VDD VDD VSS VSS gf180mcu_fd_sc_mcu7t5v0__fillcap_8
Xspi_regs_inst__1618_ spi_regs_inst__1618_/D fanout561/Z clkbuf_leaf_6_clk/Z spi_regs_inst__1618_/Q
+ VDD VDD VSS VSS gf180mcu_fd_sc_mcu7t5v0__dffrnq_1
XFILLER_149_324 VDD VDD VSS VSS gf180mcu_fd_sc_mcu7t5v0__fillcap_16
Xwave_controller_x_inst__2261_ wave_controller_x_inst__2254_/Z wave_controller_x_inst_wire170/Z
+ wave_controller_x_inst__2261_/Z VDD VDD VSS VSS gf180mcu_fd_sc_mcu7t5v0__xor2_1
XFILLER_137_508 VDD VDD VSS VSS gf180mcu_fd_sc_mcu7t5v0__fillcap_4
XFILLER_31_171 VDD VDD VSS VSS gf180mcu_fd_sc_mcu7t5v0__fillcap_4
Xwave_controller_x_inst__2192_ wave_controller_x_inst__2223_/A1 wave_controller_x_inst__2793_/I0
+ wave_controller_x_inst__2192_/Z VDD VDD VSS VSS gf180mcu_fd_sc_mcu7t5v0__xor2_1
Xspi_regs_inst__1549_ spi_regs_inst__1549_/D spi_regs_inst__1648_/RN clkload30/I spi_regs_inst__1549_/Q
+ VDD VDD VSS VSS gf180mcu_fd_sc_mcu7t5v0__dffrnq_1
XFILLER_118_733 VDD VDD VSS VSS gf180mcu_fd_sc_mcu7t5v0__fill_2
XFILLER_118_744 VDD VDD VSS VSS gf180mcu_fd_sc_mcu7t5v0__fillcap_4
XFILLER_145_574 VDD VDD VSS VSS gf180mcu_fd_sc_mcu7t5v0__fill_2
Xwave_controller_y_inst_fanout418 wave_controller_y_inst__3716_/Q wave_controller_y_inst__1781_/I
+ VDD VDD VSS VSS gf180mcu_fd_sc_mcu7t5v0__dlyb_1
Xwave_controller_y_inst_fanout407 wave_controller_y_inst__2800_/S wave_controller_y_inst__2831_/A2
+ VDD VDD VSS VSS gf180mcu_fd_sc_mcu7t5v0__dlyb_1
XFILLER_105_438 VDD VDD VSS VSS gf180mcu_fd_sc_mcu7t5v0__fillcap_4
XFILLER_117_298 VDD VDD VSS VSS gf180mcu_fd_sc_mcu7t5v0__fillcap_4
XFILLER_160_533 VDD VDD VSS VSS gf180mcu_fd_sc_mcu7t5v0__fill_1
XFILLER_160_588 VDD VDD VSS VSS gf180mcu_fd_sc_mcu7t5v0__fillcap_4
XFILLER_99_672 VDD VDD VSS VSS gf180mcu_fd_sc_mcu7t5v0__fill_2
XTAP_TAPCELL_ROW_148_2316 VDD VSS gf180mcu_fd_sc_mcu7t5v0__filltie
XTAP_TAPCELL_ROW_148_2327 VDD VSS gf180mcu_fd_sc_mcu7t5v0__filltie
XFILLER_141_780 VDD VDD VSS VSS gf180mcu_fd_sc_mcu7t5v0__fillcap_4
XFILLER_115_1046 VDD VDD VSS VSS gf180mcu_fd_sc_mcu7t5v0__fillcap_4
Xwave_controller_y_inst__3731_ wave_controller_y_inst__3731_/D fanout544/Z clkload6/I
+ wave_controller_y_inst__3731_/Q VDD VDD VSS VSS gf180mcu_fd_sc_mcu7t5v0__dffrnq_1
Xwave_controller_y_inst__1992_ wave_controller_y_inst__3387_/A1 spi_regs_inst__1109_/A1
+ wave_controller_y_inst__1992_/B wave_controller_y_inst__1999_/B2 VDD VDD VSS VSS
+ gf180mcu_fd_sc_mcu7t5v0__aoi21_1
Xwave_controller_x_inst__1976_ wave_controller_x_inst__1981_/A1 spi_regs_inst__1343_/B2
+ wave_controller_x_inst__1986_/A1 VDD VDD VSS VSS gf180mcu_fd_sc_mcu7t5v0__nor2_1
XTAP_TAPCELL_ROW_161_2527 VDD VSS gf180mcu_fd_sc_mcu7t5v0__filltie
XTAP_TAPCELL_ROW_161_2538 VDD VSS gf180mcu_fd_sc_mcu7t5v0__filltie
Xwave_controller_x_inst__3715_ wave_controller_x_inst__3715_/D wave_controller_x_inst__3715_/RN
+ clkload28/I wave_controller_x_inst__3715_/Q VDD VDD VSS VSS gf180mcu_fd_sc_mcu7t5v0__dffrnq_1
XFILLER_27_422 VDD VDD VSS VSS gf180mcu_fd_sc_mcu7t5v0__fillcap_16
Xwave_controller_y_inst_max_cap357 wave_controller_y_inst__2125_/A2 wave_controller_y_inst__2092_/A2
+ VDD VDD VSS VSS gf180mcu_fd_sc_mcu7t5v0__buf_2
Xwave_controller_y_inst__3662_ wave_controller_y_inst__3662_/D wave_controller_y_inst__3683_/RN
+ clkbuf_leaf_46_clk/Z spi_regs_inst__1275_/B2 VDD VDD VSS VSS gf180mcu_fd_sc_mcu7t5v0__dffrnq_1
Xwave_controller_x_inst__3646_ wave_controller_x_inst__3646_/D wave_controller_x_inst__3686_/RN
+ clkbuf_leaf_26_clk/Z spi_regs_inst__1169_/B2 VDD VDD VSS VSS gf180mcu_fd_sc_mcu7t5v0__dffrnq_1
XFILLER_36_79 VDD VDD VSS VSS gf180mcu_fd_sc_mcu7t5v0__fillcap_4
XTAP_TAPCELL_ROW_126_1957 VDD VSS gf180mcu_fd_sc_mcu7t5v0__filltie
Xwave_controller_y_inst__2613_ wave_controller_y_inst__2829_/A1 spi_regs_inst__1256_/A1
+ wave_controller_y_inst__2650_/B VDD VDD VSS VSS gf180mcu_fd_sc_mcu7t5v0__nor2_1
Xwave_controller_y_inst__3593_ wave_controller_y_inst__3593_/A1 wave_controller_y_inst__3588_/S
+ wave_controller_y_inst__3593_/B wave_controller_y_inst__3669_/D VDD VDD VSS VSS
+ gf180mcu_fd_sc_mcu7t5v0__oai21_1
Xspi_regs_inst_max_cap217 spi_regs_inst__1038_/B1 spi_regs_inst__1178_/A2 VDD VDD
+ VSS VSS gf180mcu_fd_sc_mcu7t5v0__buf_2
Xspi_regs_inst_max_cap206 spi_regs_inst_wire207/Z spi_regs_inst__1332_/B1 VDD VDD
+ VSS VSS gf180mcu_fd_sc_mcu7t5v0__buf_2
XFILLER_82_594 VDD VDD VSS VSS gf180mcu_fd_sc_mcu7t5v0__fill_1
Xwave_controller_y_inst__2544_ wave_controller_y_inst__2545_/A1 wave_controller_y_inst__2545_/B
+ wave_controller_y_inst__2545_/A2 wave_controller_y_inst__2544_/Z VDD VDD VSS VSS
+ gf180mcu_fd_sc_mcu7t5v0__and3_1
Xwave_controller_x_inst__3577_ wave_controller_x_inst__3581_/A1 wave_controller_x_inst__3606_/A2
+ wave_controller_x_inst__3577_/B wave_controller_x_inst__3658_/D VDD VDD VSS VSS
+ gf180mcu_fd_sc_mcu7t5v0__oai21_1
Xspi_regs_inst_max_cap239 spi_regs_inst__1247_/B1 spi_regs_inst__1301_/B1 VDD VDD
+ VSS VSS gf180mcu_fd_sc_mcu7t5v0__buf_2
XFILLER_70_789 VDD VDD VSS VSS gf180mcu_fd_sc_mcu7t5v0__fill_1
XTAP_TAPCELL_ROW_81_1220 VDD VSS gf180mcu_fd_sc_mcu7t5v0__filltie
Xwave_controller_x_inst__2528_ spi_regs_inst__1286_/B2 wave_controller_x_inst__2523_/Z
+ wave_controller_x_inst__2528_/B wave_controller_x_inst__2542_/A1 VDD VDD VSS VSS
+ gf180mcu_fd_sc_mcu7t5v0__aoi21_1
Xsignal_processor_x_inst__252_ signal_processor_x_inst__252_/D fanout587/Z clkload24/I
+ signal_processor_x_inst__252_/Q VDD VDD VSS VSS gf180mcu_fd_sc_mcu7t5v0__dffrnq_1
Xwave_controller_y_inst__2475_ wave_controller_y_inst__3376_/B wave_controller_y_inst__2474_/Z
+ wave_controller_y_inst__2497_/A1 VDD VDD VSS VSS gf180mcu_fd_sc_mcu7t5v0__nand2_1
Xwave_controller_x_inst__2459_ max_cap461/I wave_controller_x_inst__3503_/B2 wave_controller_x_inst__2490_/A1
+ VDD VDD VSS VSS gf180mcu_fd_sc_mcu7t5v0__nand2_1
Xsignal_processor_x_inst__183_ signal_processor_x_inst__183_/A1 signal_processor_x_inst__187_/B
+ signal_processor_x_inst__191_/A2 signal_processor_x_inst__182_/Z signal_processor_x_inst__240_/D
+ VDD VDD VSS VSS gf180mcu_fd_sc_mcu7t5v0__oai22_1
XFILLER_10_311 VDD VDD VSS VSS gf180mcu_fd_sc_mcu7t5v0__fillcap_4
XFILLER_122_1017 VDD VDD VSS VSS gf180mcu_fd_sc_mcu7t5v0__fillcap_64
XFILLER_109_755 VDD VDD VSS VSS gf180mcu_fd_sc_mcu7t5v0__fillcap_4
XFILLER_155_349 VDD VDD VSS VSS gf180mcu_fd_sc_mcu7t5v0__fill_1
XFILLER_6_359 VDD VDD VSS VSS gf180mcu_fd_sc_mcu7t5v0__fillcap_4
XFILLER_123_202 VDD VDD VSS VSS gf180mcu_fd_sc_mcu7t5v0__fillcap_8
XFILLER_163_360 VDD VDD VSS VSS gf180mcu_fd_sc_mcu7t5v0__fillcap_4
XTAP_TAPCELL_ROW_79_1182 VDD VSS gf180mcu_fd_sc_mcu7t5v0__filltie
XFILLER_123_224 VDD VDD VSS VSS gf180mcu_fd_sc_mcu7t5v0__fill_1
XFILLER_151_522 VDD VDD VSS VSS gf180mcu_fd_sc_mcu7t5v0__fill_1
Xwave_controller_y_inst__3027_ wave_controller_y_inst__3408_/A1 wave_controller_y_inst__3032_/A3
+ wave_controller_y_inst__3029_/B1 VDD VDD VSS VSS gf180mcu_fd_sc_mcu7t5v0__nand2_1
XFILLER_111_419 VDD VDD VSS VSS gf180mcu_fd_sc_mcu7t5v0__fill_1
XFILLER_117_60 VDD VDD VSS VSS gf180mcu_fd_sc_mcu7t5v0__fill_2
XFILLER_2_543 VDD VDD VSS VSS gf180mcu_fd_sc_mcu7t5v0__fillcap_8
XFILLER_85_1170 VDD VDD VSS VSS gf180mcu_fd_sc_mcu7t5v0__fillcap_4
XFILLER_104_482 VDD VDD VSS VSS gf180mcu_fd_sc_mcu7t5v0__fill_1
XFILLER_77_64 VDD VDD VSS VSS gf180mcu_fd_sc_mcu7t5v0__fill_1
XFILLER_78_823 VDD VDD VSS VSS gf180mcu_fd_sc_mcu7t5v0__fillcap_4
XFILLER_78_845 VDD VDD VSS VSS gf180mcu_fd_sc_mcu7t5v0__fillcap_16
XTAP_TAPCELL_ROW_92_1393 VDD VSS gf180mcu_fd_sc_mcu7t5v0__filltie
XFILLER_65_506 VDD VDD VSS VSS gf180mcu_fd_sc_mcu7t5v0__fill_1
Xspi_regs_inst__0920_ spi_regs_inst__0889_/B spi_regs_inst__1013_/A1 spi_regs_inst__0925_/A4
+ VDD VDD VSS VSS gf180mcu_fd_sc_mcu7t5v0__nor2_1
XFILLER_65_539 VDD VDD VSS VSS gf180mcu_fd_sc_mcu7t5v0__fill_2
XFILLER_18_411 VDD VDD VSS VSS gf180mcu_fd_sc_mcu7t5v0__fill_1
Xspi_regs_inst__0851_ spi_regs_inst__1590_/Q spi_regs_inst__1445_/I1 spi_regs_inst__0851_/S
+ spi_regs_inst__1590_/D VDD VDD VSS VSS gf180mcu_fd_sc_mcu7t5v0__mux2_2
XFILLER_93_52 VDD VDD VSS VSS gf180mcu_fd_sc_mcu7t5v0__fill_1
Xspi_regs_inst__0782_ spi_regs_inst__1385_/A2 spi_regs_inst__0842_/A1 spi_regs_inst__0818_/A2
+ spi_regs_inst_wire311/I VDD VDD VSS VSS gf180mcu_fd_sc_mcu7t5v0__nand3_1
XFILLER_93_96 VDD VDD VSS VSS gf180mcu_fd_sc_mcu7t5v0__fill_2
XFILLER_26_90 VDD VDD VSS VSS gf180mcu_fd_sc_mcu7t5v0__fillcap_8
XFILLER_60_244 VDD VDD VSS VSS gf180mcu_fd_sc_mcu7t5v0__fill_1
XFILLER_61_767 VDD VDD VSS VSS gf180mcu_fd_sc_mcu7t5v0__fill_2
XFILLER_159_644 VDD VDD VSS VSS gf180mcu_fd_sc_mcu7t5v0__fillcap_32
Xspi_regs_inst__1403_ fanout521/Z spi_regs_inst__1445_/I1 spi_regs_inst__1403_/S spi_regs_inst__1477_/D
+ VDD VDD VSS VSS gf180mcu_fd_sc_mcu7t5v0__mux2_2
XFILLER_53_1158 VDD VDD VSS VSS gf180mcu_fd_sc_mcu7t5v0__fillcap_16
XFILLER_9_142 VDD VDD VSS VSS gf180mcu_fd_sc_mcu7t5v0__fillcap_64
XTAP_TAPCELL_ROW_99_1514 VDD VSS gf180mcu_fd_sc_mcu7t5v0__filltie
XTAP_TAPCELL_ROW_99_1503 VDD VSS gf180mcu_fd_sc_mcu7t5v0__filltie
Xspi_regs_inst__1334_ spi_regs_inst__1334_/A1 spi_regs_inst_wire284/Z spi_regs_inst__1334_/B1
+ spi_regs_inst__1334_/B2 spi_regs_inst__1351_/A1 VDD VDD VSS VSS gf180mcu_fd_sc_mcu7t5v0__aoi22_1
XFILLER_127_552 VDD VDD VSS VSS gf180mcu_fd_sc_mcu7t5v0__fillcap_8
XFILLER_61_4 VDD VDD VSS VSS gf180mcu_fd_sc_mcu7t5v0__fill_1
Xspi_regs_inst__1265_ spi_regs_inst__1265_/A1 spi_regs_inst__1357_/B spi_regs_inst__1265_/B1
+ spi_regs_inst__1265_/B2 spi_regs_inst__1266_/I0 VDD VDD VSS VSS gf180mcu_fd_sc_mcu7t5v0__aoi22_1
Xspi_regs_inst__1196_ spi_regs_inst__1196_/A1 spi_regs_inst__1196_/A2 spi_regs_inst__1196_/A3
+ spi_regs_inst__1197_/C VDD VDD VSS VSS gf180mcu_fd_sc_mcu7t5v0__nand3_1
XFILLER_130_728 VDD VDD VSS VSS gf180mcu_fd_sc_mcu7t5v0__fillcap_4
Xsignal_processor_y_inst__215_ signal_processor_y_inst__215_/A1 signal_processor_y_inst__175_/Z
+ signal_processor_y_inst__215_/B signal_processor_y_inst__226_/D VDD VDD VSS VSS
+ gf180mcu_fd_sc_mcu7t5v0__oai21_1
XFILLER_3_72 VDD VDD VSS VSS gf180mcu_fd_sc_mcu7t5v0__fillcap_64
XFILLER_69_889 VDD VDD VSS VSS gf180mcu_fd_sc_mcu7t5v0__fill_2
Xwave_controller_x_inst__1830_ spi_regs_inst__1535_/Q wave_controller_x_inst__3174_/B1
+ VDD VDD VSS VSS gf180mcu_fd_sc_mcu7t5v0__clkinv_1
XFILLER_56_506 VDD VDD VSS VSS gf180mcu_fd_sc_mcu7t5v0__fillcap_8
XFILLER_68_366 VDD VDD VSS VSS gf180mcu_fd_sc_mcu7t5v0__fill_2
XFILLER_68_399 VDD VDD VSS VSS gf180mcu_fd_sc_mcu7t5v0__fill_1
XFILLER_84_826 VDD VDD VSS VSS gf180mcu_fd_sc_mcu7t5v0__fill_2
XFILLER_96_675 VDD VDD VSS VSS gf180mcu_fd_sc_mcu7t5v0__fillcap_4
Xsignal_processor_y_inst__146_ signal_processor_y_inst__238_/Q signal_processor_y_inst__146_/A2
+ signal_processor_y_inst__146_/Z VDD VDD VSS VSS gf180mcu_fd_sc_mcu7t5v0__xor2_1
XFILLER_83_336 VDD VDD VSS VSS gf180mcu_fd_sc_mcu7t5v0__fillcap_4
XTAP_TAPCELL_ROW_143_2235 VDD VSS gf180mcu_fd_sc_mcu7t5v0__filltie
XTAP_TAPCELL_ROW_51_1_716 VDD VSS gf180mcu_fd_sc_mcu7t5v0__filltie
Xwave_controller_x_inst__3500_ wave_controller_x_inst__3539_/A1 wave_controller_x_inst__3500_/A2
+ wave_controller_x_inst__3500_/A3 wave_controller_x_inst__3530_/B1 wave_controller_x_inst__3500_/B2
+ wave_controller_x_inst__3629_/D VDD VDD VSS VSS gf180mcu_fd_sc_mcu7t5v0__oai32_1
XFILLER_24_403 VDD VDD VSS VSS gf180mcu_fd_sc_mcu7t5v0__fill_1
XFILLER_97_1052 VDD VDD VSS VSS gf180mcu_fd_sc_mcu7t5v0__fillcap_64
XTAP_TAPCELL_ROW_108_1654 VDD VSS gf180mcu_fd_sc_mcu7t5v0__filltie
XTAP_TAPCELL_ROW_108_1665 VDD VSS gf180mcu_fd_sc_mcu7t5v0__filltie
Xwave_controller_x_inst__3431_ wave_controller_x_inst__3441_/A1 wave_controller_x_inst__3429_/I
+ wave_controller_x_inst__3431_/B wave_controller_x_inst__3431_/C wave_controller_x_inst__3433_/B1
+ VDD VDD VSS VSS gf180mcu_fd_sc_mcu7t5v0__aoi211_1
X_89_ _89_/I _89_/Z VDD VDD VSS VSS gf180mcu_fd_sc_mcu7t5v0__buf_1
XFILLER_24_436 VDD VDD VSS VSS gf180mcu_fd_sc_mcu7t5v0__fill_1
XFILLER_51_200 VDD VDD VSS VSS gf180mcu_fd_sc_mcu7t5v0__fillcap_8
XFILLER_64_594 VDD VDD VSS VSS gf180mcu_fd_sc_mcu7t5v0__fill_1
XFILLER_92_892 VDD VDD VSS VSS gf180mcu_fd_sc_mcu7t5v0__fillcap_16
Xwave_controller_x_inst__3362_ wave_controller_x_inst__3391_/A1 wave_controller_x_inst__3361_/Z
+ wave_controller_x_inst__3392_/C VDD VDD VSS VSS gf180mcu_fd_sc_mcu7t5v0__nand2_1
XFILLER_51_277 VDD VDD VSS VSS gf180mcu_fd_sc_mcu7t5v0__fill_2
XTAP_TAPCELL_ROW_121_1876 VDD VSS gf180mcu_fd_sc_mcu7t5v0__filltie
Xwave_controller_x_inst__3293_ wave_controller_x_inst__3274_/Z wave_controller_x_inst__3384_/A2
+ wave_controller_x_inst__3369_/A3 VDD VDD VSS VSS gf180mcu_fd_sc_mcu7t5v0__nor2_1
Xwave_controller_x_inst__2313_ wave_controller_x_inst__2346_/A1 wave_controller_x_inst__2313_/A2
+ wave_controller_x_inst__2313_/B wave_controller_x_inst__2313_/C wave_controller_x_inst__2315_/A2
+ VDD VDD VSS VSS gf180mcu_fd_sc_mcu7t5v0__aoi211_1
XFILLER_165_603 VDD VDD VSS VSS gf180mcu_fd_sc_mcu7t5v0__fill_1
Xwave_controller_y_inst__2260_ wave_controller_y_inst__2260_/A1 wave_controller_y_inst__2256_/Z
+ wave_controller_y_inst__2260_/B wave_controller_y_inst__2260_/C wave_controller_y_inst__2272_/A2
+ VDD VDD VSS VSS gf180mcu_fd_sc_mcu7t5v0__aoi211_1
Xwave_controller_x_inst__2244_ wave_controller_x_inst__2521_/A1 wave_controller_x_inst__2242_/Z
+ wave_controller_x_inst__2245_/I VDD VDD VSS VSS gf180mcu_fd_sc_mcu7t5v0__xor2_1
XFILLER_165_625 VDD VDD VSS VSS gf180mcu_fd_sc_mcu7t5v0__fillcap_4
XFILLER_22_37 VDD VDD VSS VSS gf180mcu_fd_sc_mcu7t5v0__fillcap_32
XTAP_TAPCELL_ROW_7_1_385 VDD VSS gf180mcu_fd_sc_mcu7t5v0__filltie
Xwave_controller_y_inst__2191_ wave_controller_y_inst__2223_/A1 wave_controller_y_inst__3566_/A1
+ wave_controller_y_inst__2204_/B VDD VDD VSS VSS gf180mcu_fd_sc_mcu7t5v0__nor2_1
Xwave_controller_x_inst__2175_ wave_controller_x_inst__2757_/B wave_controller_x_inst__2173_/Z
+ spi_regs_inst_wire134/I VDD VDD VSS VSS gf180mcu_fd_sc_mcu7t5v0__xnor2_1
XFILLER_133_500 VDD VDD VSS VSS gf180mcu_fd_sc_mcu7t5v0__fill_2
XFILLER_133_511 VDD VDD VSS VSS gf180mcu_fd_sc_mcu7t5v0__fillcap_4
XFILLER_152_308 VDD VDD VSS VSS gf180mcu_fd_sc_mcu7t5v0__fillcap_4
XFILLER_161_842 VDD VDD VSS VSS gf180mcu_fd_sc_mcu7t5v0__fillcap_64
XFILLER_69_1154 VDD VDD VSS VSS gf180mcu_fd_sc_mcu7t5v0__fillcap_16
XFILLER_133_566 VDD VDD VSS VSS gf180mcu_fd_sc_mcu7t5v0__fill_2
XFILLER_156_1157 VDD VDD VSS VSS gf180mcu_fd_sc_mcu7t5v0__fillcap_16
XFILLER_105_279 VDD VDD VSS VSS gf180mcu_fd_sc_mcu7t5v0__fill_1
XTAP_TAPCELL_ROW_74_1090 VDD VSS gf180mcu_fd_sc_mcu7t5v0__filltie
XFILLER_102_942 VDD VDD VSS VSS gf180mcu_fd_sc_mcu7t5v0__fill_2
XFILLER_59_333 VDD VDD VSS VSS gf180mcu_fd_sc_mcu7t5v0__fillcap_16
XTAP_TAPCELL_ROW_37_1_606 VDD VSS gf180mcu_fd_sc_mcu7t5v0__filltie
XFILLER_86_174 VDD VDD VSS VSS gf180mcu_fd_sc_mcu7t5v0__fill_1
Xwave_controller_y_inst_max_cap110 wave_controller_y_inst__2383_/A2 wave_controller_y_inst__2412_/A2
+ VDD VDD VSS VSS gf180mcu_fd_sc_mcu7t5v0__clkbuf_1
Xwave_controller_y_inst__1975_ wave_controller_y_inst__1981_/B wave_controller_y_inst__1981_/C
+ wave_controller_y_inst__1977_/A3 VDD VDD VSS VSS gf180mcu_fd_sc_mcu7t5v0__nor2_1
Xwave_controller_x_inst__1959_ fanout528/Z spi_regs_inst__1254_/B2 wave_controller_x_inst__1960_/I
+ VDD VDD VSS VSS gf180mcu_fd_sc_mcu7t5v0__xnor2_1
XFILLER_47_56 VDD VDD VSS VSS gf180mcu_fd_sc_mcu7t5v0__fill_1
Xwave_controller_y_inst__3714_ wave_controller_y_inst__3714_/D wave_controller_y_inst__3717_/RN
+ clkload14/I wave_controller_y_inst__3714_/Q VDD VDD VSS VSS gf180mcu_fd_sc_mcu7t5v0__dffrnq_1
XFILLER_55_550 VDD VDD VSS VSS gf180mcu_fd_sc_mcu7t5v0__fillcap_4
Xwave_controller_y_inst__3645_ wave_controller_y_inst__3645_/D wave_controller_y_inst__3648_/RN
+ clkload14/I spi_regs_inst__1121_/A1 VDD VDD VSS VSS gf180mcu_fd_sc_mcu7t5v0__dffrnq_1
XFILLER_15_403 VDD VDD VSS VSS gf180mcu_fd_sc_mcu7t5v0__fill_2
Xwave_controller_x_inst__3629_ wave_controller_x_inst__3629_/D wave_controller_x_inst__3706_/RN
+ clkload36/I max_cap467/I VDD VDD VSS VSS gf180mcu_fd_sc_mcu7t5v0__dffrnq_1
XFILLER_70_564 VDD VDD VSS VSS gf180mcu_fd_sc_mcu7t5v0__fill_2
XTAP_TAPCELL_ROW_53_740 VDD VSS gf180mcu_fd_sc_mcu7t5v0__filltie
XTAP_TAPCELL_ROW_53_751 VDD VSS gf180mcu_fd_sc_mcu7t5v0__filltie
Xwave_controller_y_inst__3576_ spi_regs_inst__1109_/B2 wave_controller_y_inst_wire48/I
+ wave_controller_y_inst__3577_/B VDD VDD VSS VSS gf180mcu_fd_sc_mcu7t5v0__nand2_1
XFILLER_42_266 VDD VDD VSS VSS gf180mcu_fd_sc_mcu7t5v0__fillcap_4
XFILLER_70_586 VDD VDD VSS VSS gf180mcu_fd_sc_mcu7t5v0__fillcap_4
XFILLER_70_597 VDD VDD VSS VSS gf180mcu_fd_sc_mcu7t5v0__fillcap_4
Xwave_controller_y_inst__2527_ wave_controller_y_inst__2543_/B1 wave_controller_y_inst__2524_/Z
+ wave_controller_y_inst__2527_/A3 spi_regs_inst__1288_/B2 VDD VDD VSS VSS gf180mcu_fd_sc_mcu7t5v0__xor3_1
Xsignal_processor_x_inst__235_ signal_processor_x_inst__235_/D fanout583/Z clkbuf_leaf_14_clk/Z
+ signal_processor_x_inst__235_/Q VDD VDD VSS VSS gf180mcu_fd_sc_mcu7t5v0__dffrnq_1
XFILLER_129_817 VDD VDD VSS VSS gf180mcu_fd_sc_mcu7t5v0__fillcap_16
XFILLER_156_603 VDD VDD VSS VSS gf180mcu_fd_sc_mcu7t5v0__fill_1
Xwave_controller_y_inst__2458_ wave_controller_y_inst__2757_/A1 wave_controller_y_inst__2455_/B
+ wave_controller_y_inst__2458_/B wave_controller_y_inst__2758_/B VDD VDD VSS VSS
+ gf180mcu_fd_sc_mcu7t5v0__aoi21_1
XFILLER_129_839 VDD VDD VSS VSS gf180mcu_fd_sc_mcu7t5v0__fill_1
XFILLER_6_101 VDD VDD VSS VSS gf180mcu_fd_sc_mcu7t5v0__fillcap_4
Xsignal_processor_x_inst__166_ signal_processor_x_inst__233_/Q signal_processor_x_inst__166_/A2
+ signal_processor_x_inst__192_/B VDD VDD VSS VSS gf180mcu_fd_sc_mcu7t5v0__xor2_1
XFILLER_10_174 VDD VDD VSS VSS gf180mcu_fd_sc_mcu7t5v0__fill_1
Xwave_controller_y_inst__2389_ wave_controller_y_inst__2389_/A1 wave_controller_y_inst__2389_/A2
+ wave_controller_y_inst__2388_/B wave_controller_y_inst__2389_/Z VDD VDD VSS VSS
+ gf180mcu_fd_sc_mcu7t5v0__and3_1
Xspi_regs_inst__1050_ spi_regs_inst__1050_/A1 spi_regs_inst__1184_/A2 spi_regs_inst_wire288/Z
+ spi_regs_inst__1050_/B2 spi_regs_inst__1050_/C1 spi_regs_inst__1050_/C2 spi_regs_inst__1053_/A2
+ VDD VDD VSS VSS gf180mcu_fd_sc_mcu7t5v0__aoi222_1
XTAP_TAPCELL_ROW_94_1422 VDD VSS gf180mcu_fd_sc_mcu7t5v0__filltie
XTAP_TAPCELL_ROW_94_1433 VDD VSS gf180mcu_fd_sc_mcu7t5v0__filltie
XFILLER_128_92 VDD VDD VSS VSS gf180mcu_fd_sc_mcu7t5v0__fill_2
XFILLER_151_352 VDD VDD VSS VSS gf180mcu_fd_sc_mcu7t5v0__fill_2
XFILLER_111_216 VDD VDD VSS VSS gf180mcu_fd_sc_mcu7t5v0__fill_1
XFILLER_2_373 VDD VDD VSS VSS gf180mcu_fd_sc_mcu7t5v0__fillcap_4
XFILLER_66_804 VDD VDD VSS VSS gf180mcu_fd_sc_mcu7t5v0__fill_1
XFILLER_78_653 VDD VDD VSS VSS gf180mcu_fd_sc_mcu7t5v0__fill_2
X_12_ _19_/Q _18_/A2 _20_/Q _15_/A2 VDD VDD VSS VSS gf180mcu_fd_sc_mcu7t5v0__nand3_1
XPHY_EDGE_ROW_69_Left_236 VDD VSS gf180mcu_fd_sc_mcu7t5v0__endcap
Xspi_regs_inst__0903_ spi_regs_inst__1628_/Q spi_regs_inst__0889_/B spi_regs_inst__0911_/B
+ spi_regs_inst__1461_/Q spi_regs_inst__0904_/B VDD VDD VSS VSS gf180mcu_fd_sc_mcu7t5v0__aoi22_1
XFILLER_53_509 VDD VDD VSS VSS gf180mcu_fd_sc_mcu7t5v0__fill_1
XFILLER_93_678 VDD VDD VSS VSS gf180mcu_fd_sc_mcu7t5v0__fillcap_4
Xspi_regs_inst__0834_ spi_regs_inst__1576_/Q spi_regs_inst__1411_/I1 spi_regs_inst__0834_/S
+ spi_regs_inst__1576_/D VDD VDD VSS VSS gf180mcu_fd_sc_mcu7t5v0__mux2_2
XFILLER_80_317 VDD VDD VSS VSS gf180mcu_fd_sc_mcu7t5v0__fillcap_8
Xspi_regs_inst__0765_ spi_regs_inst__1525_/Q spi_regs_inst__1410_/I1 spi_regs_inst__0766_/S
+ spi_regs_inst__1525_/D VDD VDD VSS VSS gf180mcu_fd_sc_mcu7t5v0__mux2_2
XFILLER_109_1170 VDD VDD VSS VSS gf180mcu_fd_sc_mcu7t5v0__fillcap_4
XFILLER_14_480 VDD VDD VSS VSS gf180mcu_fd_sc_mcu7t5v0__fillcap_4
XTAP_TAPCELL_ROW_103_1573 VDD VSS gf180mcu_fd_sc_mcu7t5v0__filltie
XTAP_TAPCELL_ROW_103_1584 VDD VSS gf180mcu_fd_sc_mcu7t5v0__filltie
XFILLER_119_327 VDD VDD VSS VSS gf180mcu_fd_sc_mcu7t5v0__fillcap_8
XFILLER_147_625 VDD VDD VSS VSS gf180mcu_fd_sc_mcu7t5v0__fillcap_4
XPHY_EDGE_ROW_78_Left_245 VDD VSS gf180mcu_fd_sc_mcu7t5v0__endcap
Xspi_regs_inst__1317_ spi_regs_inst__1576_/Q spi_regs_inst__1317_/A2 spi_regs_inst_wire249/I
+ fanout534/Z spi_regs_inst__1319_/A3 VDD VDD VSS VSS gf180mcu_fd_sc_mcu7t5v0__aoi22_1
XFILLER_115_500 VDD VDD VSS VSS gf180mcu_fd_sc_mcu7t5v0__fill_1
XFILLER_128_872 VDD VDD VSS VSS gf180mcu_fd_sc_mcu7t5v0__fill_2
XFILLER_108_18 VDD VDD VSS VSS gf180mcu_fd_sc_mcu7t5v0__fill_2
Xspi_regs_inst_wire103 spi_regs_inst_wire103/I spi_regs_inst_wire103/Z VDD VDD VSS
+ VSS gf180mcu_fd_sc_mcu7t5v0__buf_2
Xspi_regs_inst__1248_ spi_regs_inst__1248_/A1 spi_regs_inst__1248_/A2 spi_regs_inst__1248_/A3
+ spi_regs_inst__1248_/A4 spi_regs_inst__1264_/A1 VDD VDD VSS VSS gf180mcu_fd_sc_mcu7t5v0__nand4_1
XFILLER_89_907 VDD VDD VSS VSS gf180mcu_fd_sc_mcu7t5v0__fill_2
Xspi_regs_inst__1179_ spi_regs_inst__1179_/A1 spi_regs_inst__1278_/A2 spi_regs_inst_wire210/Z
+ spi_regs_inst__1179_/B2 spi_regs_inst__1210_/A1 VDD VDD VSS VSS gf180mcu_fd_sc_mcu7t5v0__aoi22_1
XFILLER_88_417 VDD VDD VSS VSS gf180mcu_fd_sc_mcu7t5v0__fillcap_4
Xwave_controller_x_inst__2931_ spi_regs_inst__1252_/B2 wave_controller_x_inst__2929_/S
+ wave_controller_x_inst__2932_/B VDD VDD VSS VSS gf180mcu_fd_sc_mcu7t5v0__nand2_1
XFILLER_102_249 VDD VDD VSS VSS gf180mcu_fd_sc_mcu7t5v0__fill_1
XFILLER_57_804 VDD VDD VSS VSS gf180mcu_fd_sc_mcu7t5v0__fillcap_4
Xwave_controller_x_inst__2862_ wave_controller_x_inst__2882_/A1 wave_controller_x_inst__2861_/Z
+ wave_controller_x_inst__2885_/A2 VDD VDD VSS VSS gf180mcu_fd_sc_mcu7t5v0__nand2_1
XFILLER_69_664 VDD VDD VSS VSS gf180mcu_fd_sc_mcu7t5v0__fillcap_4
XPHY_EDGE_ROW_87_Left_254 VDD VSS gf180mcu_fd_sc_mcu7t5v0__endcap
Xwave_controller_x_inst__1813_ spi_regs_inst__1548_/Q wave_controller_x_inst__3365_/A2
+ VDD VDD VSS VSS gf180mcu_fd_sc_mcu7t5v0__clkinv_1
XFILLER_110_293 VDD VDD VSS VSS gf180mcu_fd_sc_mcu7t5v0__fill_1
XFILLER_111_794 VDD VDD VSS VSS gf180mcu_fd_sc_mcu7t5v0__fillcap_4
XFILLER_68_185 VDD VDD VSS VSS gf180mcu_fd_sc_mcu7t5v0__fill_2
Xwave_controller_x_inst__2793_ wave_controller_x_inst__2793_/I0 spi_regs_inst__1259_/B2
+ wave_controller_x_inst__2793_/S wave_controller_x_inst__2793_/Z VDD VDD VSS VSS
+ gf180mcu_fd_sc_mcu7t5v0__mux2_2
Xsignal_processor_y_inst__129_ signal_processor_y_inst__230_/Q signal_processor_y_inst__256_/Q
+ signal_processor_y_inst__129_/Z VDD VDD VSS VSS gf180mcu_fd_sc_mcu7t5v0__and2_1
XFILLER_72_807 VDD VDD VSS VSS gf180mcu_fd_sc_mcu7t5v0__fillcap_16
XTAP_TAPCELL_ROW_123_1905 VDD VSS gf180mcu_fd_sc_mcu7t5v0__filltie
XFILLER_64_391 VDD VDD VSS VSS gf180mcu_fd_sc_mcu7t5v0__fill_2
XFILLER_80_851 VDD VDD VSS VSS gf180mcu_fd_sc_mcu7t5v0__fill_2
Xwave_controller_y_inst__3430_ wave_controller_y_inst__3430_/A1 wave_controller_y_inst__3419_/C
+ wave_controller_y_inst__3494_/A2 wave_controller_y_inst__3430_/B2 wave_controller_y_inst__3489_/C
+ wave_controller_y_inst__3431_/B VDD VDD VSS VSS gf180mcu_fd_sc_mcu7t5v0__aoi221_1
Xwave_controller_x_inst__3414_ wave_controller_x_inst__3454_/B wave_controller_x_inst__3414_/A2
+ wave_controller_x_inst__3414_/A3 wave_controller_x_inst__3465_/B wave_controller_x_inst__3421_/C
+ VDD VDD VSS VSS gf180mcu_fd_sc_mcu7t5v0__oai31_1
Xwave_controller_y_inst__3361_ wave_controller_y_inst__3306_/Z wave_controller_y_inst__3310_/B
+ wave_controller_y_inst__3361_/Z VDD VDD VSS VSS gf180mcu_fd_sc_mcu7t5v0__xor2_1
Xwave_controller_x_inst__3345_ wave_controller_x_inst__3341_/C wave_controller_x_inst__3345_/A2
+ wave_controller_x_inst__3345_/A3 wave_controller_x_inst__3346_/A2 VDD VDD VSS VSS
+ gf180mcu_fd_sc_mcu7t5v0__nor3_1
XPHY_EDGE_ROW_96_Left_263 VDD VSS gf180mcu_fd_sc_mcu7t5v0__endcap
Xwave_controller_y_inst__2312_ wave_controller_y_inst__2313_/C wave_controller_y_inst__2313_/B
+ wave_controller_y_inst__2345_/A1 VDD VDD VSS VSS gf180mcu_fd_sc_mcu7t5v0__nor2_1
XFILLER_138_625 VDD VDD VSS VSS gf180mcu_fd_sc_mcu7t5v0__fillcap_4
XTAP_TAPCELL_ROW_156_2448 VDD VSS gf180mcu_fd_sc_mcu7t5v0__filltie
XTAP_TAPCELL_ROW_156_2459 VDD VSS gf180mcu_fd_sc_mcu7t5v0__filltie
Xwave_controller_y_inst__3292_ wave_controller_y_inst__3371_/A1 wave_controller_y_inst__3375_/A2
+ wave_controller_y_inst__3292_/B wave_controller_y_inst__3384_/A2 VDD VDD VSS VSS
+ gf180mcu_fd_sc_mcu7t5v0__aoi21_1
Xwave_controller_x_inst__3276_ wave_controller_x_inst__3562_/A1 spi_regs_inst__1543_/Q
+ wave_controller_x_inst__3277_/I VDD VDD VSS VSS gf180mcu_fd_sc_mcu7t5v0__nand2_1
XFILLER_123_6 VDD VDD VSS VSS gf180mcu_fd_sc_mcu7t5v0__fill_2
XFILLER_165_444 VDD VDD VSS VSS gf180mcu_fd_sc_mcu7t5v0__fillcap_8
XTAP_TAPCELL_ROW_48_1_689 VDD VSS gf180mcu_fd_sc_mcu7t5v0__filltie
Xwave_controller_y_inst__2243_ wave_controller_y_inst__2521_/A1 wave_controller_y_inst__2242_/Z
+ wave_controller_y_inst__2265_/A2 VDD VDD VSS VSS gf180mcu_fd_sc_mcu7t5v0__nor2_1
Xwave_controller_x_inst__2227_ spi_regs_inst__1473_/Q wave_controller_x_inst__2226_/Z
+ wave_controller_x_inst__2233_/B VDD VDD VSS VSS gf180mcu_fd_sc_mcu7t5v0__nor2_1
XFILLER_153_606 VDD VDD VSS VSS gf180mcu_fd_sc_mcu7t5v0__fill_1
Xwave_controller_y_inst__2174_ wave_controller_y_inst__2757_/B wave_controller_y_inst__2173_/Z
+ wave_controller_y_inst__2187_/B VDD VDD VSS VSS gf180mcu_fd_sc_mcu7t5v0__nor2_1
Xwave_controller_x_inst__2158_ wave_controller_x_inst__2451_/A1 spi_regs_inst__1112_/A1
+ wave_controller_x_inst__2168_/A1 VDD VDD VSS VSS gf180mcu_fd_sc_mcu7t5v0__nand2_1
XFILLER_106_511 VDD VDD VSS VSS gf180mcu_fd_sc_mcu7t5v0__fillcap_8
XTAP_TAPCELL_ROW_76_1130 VDD VSS gf180mcu_fd_sc_mcu7t5v0__filltie
XFILLER_133_352 VDD VDD VSS VSS gf180mcu_fd_sc_mcu7t5v0__fillcap_8
XFILLER_165_68 VDD VDD VSS VSS gf180mcu_fd_sc_mcu7t5v0__fill_2
Xwave_controller_x_inst__2089_ wave_controller_x_inst__2104_/A1 wave_controller_x_inst__2104_/A2
+ wave_controller_x_inst__2105_/A1 VDD VDD VSS VSS gf180mcu_fd_sc_mcu7t5v0__nand2_1
XFILLER_106_588 VDD VDD VSS VSS gf180mcu_fd_sc_mcu7t5v0__fillcap_4
XFILLER_160_171 VDD VDD VSS VSS gf180mcu_fd_sc_mcu7t5v0__fillcap_4
XFILLER_161_694 VDD VDD VSS VSS gf180mcu_fd_sc_mcu7t5v0__fillcap_4
XFILLER_82_1151 VDD VDD VSS VSS gf180mcu_fd_sc_mcu7t5v0__fillcap_4
Xwave_controller_x_inst_fanout623 wire628/Z wave_controller_x_inst__3712_/RN VDD VDD
+ VSS VSS gf180mcu_fd_sc_mcu7t5v0__dlyb_1
XFILLER_101_282 VDD VDD VSS VSS gf180mcu_fd_sc_mcu7t5v0__fill_2
XFILLER_102_794 VDD VDD VSS VSS gf180mcu_fd_sc_mcu7t5v0__fillcap_8
XFILLER_59_174 VDD VDD VSS VSS gf180mcu_fd_sc_mcu7t5v0__fillcap_4
XFILLER_74_111 VDD VDD VSS VSS gf180mcu_fd_sc_mcu7t5v0__fill_2
XTAP_TAPCELL_ROW_58_832 VDD VSS gf180mcu_fd_sc_mcu7t5v0__filltie
XFILLER_28_550 VDD VDD VSS VSS gf180mcu_fd_sc_mcu7t5v0__fillcap_4
XFILLER_62_306 VDD VDD VSS VSS gf180mcu_fd_sc_mcu7t5v0__fill_1
XFILLER_63_807 VDD VDD VSS VSS gf180mcu_fd_sc_mcu7t5v0__fill_1
XFILLER_74_10 VDD VDD VSS VSS gf180mcu_fd_sc_mcu7t5v0__fill_1
XFILLER_74_166 VDD VDD VSS VSS gf180mcu_fd_sc_mcu7t5v0__fillcap_8
Xwave_controller_y_inst__1958_ fanout507/Z wave_controller_y_inst__2223_/A1 wave_controller_y_inst__1967_/A1
+ VDD VDD VSS VSS gf180mcu_fd_sc_mcu7t5v0__nor2_1
XFILLER_62_317 VDD VDD VSS VSS gf180mcu_fd_sc_mcu7t5v0__fillcap_16
XFILLER_74_177 VDD VDD VSS VSS gf180mcu_fd_sc_mcu7t5v0__fillcap_8
Xwave_controller_y_inst__1889_ spi_regs_inst__1261_/B2 wave_controller_y_inst__3557_/B2
+ VDD VDD VSS VSS gf180mcu_fd_sc_mcu7t5v0__clkinv_1
Xwave_controller_y_inst__3628_ wave_controller_y_inst__3628_/D wave_controller_y_inst__3673_/RN
+ clkbuf_leaf_35_clk/Z spi_regs_inst__1063_/B2 VDD VDD VSS VSS gf180mcu_fd_sc_mcu7t5v0__dffrnq_1
XFILLER_15_255 VDD VDD VSS VSS gf180mcu_fd_sc_mcu7t5v0__fillcap_16
XFILLER_70_372 VDD VDD VSS VSS gf180mcu_fd_sc_mcu7t5v0__fillcap_4
XFILLER_71_884 VDD VDD VSS VSS gf180mcu_fd_sc_mcu7t5v0__fillcap_4
Xwave_controller_y_inst__3559_ wave_controller_y_inst__3594_/I0 spi_regs_inst__0967_/A1
+ wave_controller_y_inst_wire48/Z wave_controller_y_inst__3649_/D VDD VDD VSS VSS
+ gf180mcu_fd_sc_mcu7t5v0__mux2_2
XFILLER_128_102 VDD VDD VSS VSS gf180mcu_fd_sc_mcu7t5v0__fill_2
XFILLER_157_912 VDD VDD VSS VSS gf180mcu_fd_sc_mcu7t5v0__fillcap_64
XFILLER_30_247 VDD VDD VSS VSS gf180mcu_fd_sc_mcu7t5v0__fill_1
Xsignal_processor_x_inst__218_ signal_processor_x_inst__218_/D signal_processor_x_inst__242_/RN
+ clkload23/I spi_regs_inst__1044_/C2 VDD VDD VSS VSS gf180mcu_fd_sc_mcu7t5v0__dffrnq_1
XFILLER_7_410 VDD VDD VSS VSS gf180mcu_fd_sc_mcu7t5v0__fill_1
Xsignal_processor_x_inst__149_ signal_processor_x_inst__252_/Q signal_processor_x_inst__108_/I
+ signal_processor_x_inst__248_/Q signal_processor_x_inst__151_/B VDD VDD VSS VSS
+ gf180mcu_fd_sc_mcu7t5v0__nand3_1
XFILLER_128_157 VDD VDD VSS VSS gf180mcu_fd_sc_mcu7t5v0__fillcap_4
XFILLER_144_617 VDD VDD VSS VSS gf180mcu_fd_sc_mcu7t5v0__fillcap_4
XTAP_TAPCELL_ROW_50_1_704 VDD VSS gf180mcu_fd_sc_mcu7t5v0__filltie
XFILLER_109_371 VDD VDD VSS VSS gf180mcu_fd_sc_mcu7t5v0__fill_2
XFILLER_109_382 VDD VDD VSS VSS gf180mcu_fd_sc_mcu7t5v0__fill_2
XFILLER_125_842 VDD VDD VSS VSS gf180mcu_fd_sc_mcu7t5v0__fill_1
XFILLER_143_116 VDD VDD VSS VSS gf180mcu_fd_sc_mcu7t5v0__fillcap_16
Xspi_regs_inst__1102_ spi_regs_inst__1102_/A1 spi_regs_inst__1251_/B1 spi_regs_inst_wire241/I
+ wire462/Z spi_regs_inst__1104_/A3 VDD VDD VSS VSS gf180mcu_fd_sc_mcu7t5v0__aoi22_1
XFILLER_140_801 VDD VDD VSS VSS gf180mcu_fd_sc_mcu7t5v0__fillcap_4
XFILLER_99_84 VDD VDD VSS VSS gf180mcu_fd_sc_mcu7t5v0__fill_1
Xspi_regs_inst__1033_ spi_regs_inst_wire167/Z spi_regs_inst__1354_/B1 spi_regs_inst__1324_/B1
+ spi_regs_inst__1033_/B2 spi_regs_inst__1232_/B1 spi_regs_inst__1033_/C2 spi_regs_inst__1035_/A1
+ VDD VDD VSS VSS gf180mcu_fd_sc_mcu7t5v0__aoi222_1
XFILLER_112_503 VDD VDD VSS VSS gf180mcu_fd_sc_mcu7t5v0__fillcap_4
XFILLER_152_683 VDD VDD VSS VSS gf180mcu_fd_sc_mcu7t5v0__fillcap_8
XFILLER_151_193 VDD VDD VSS VSS gf180mcu_fd_sc_mcu7t5v0__fill_1
XFILLER_66_601 VDD VDD VSS VSS gf180mcu_fd_sc_mcu7t5v0__fill_1
XFILLER_79_973 VDD VDD VSS VSS gf180mcu_fd_sc_mcu7t5v0__fillcap_4
XFILLER_66_634 VDD VDD VSS VSS gf180mcu_fd_sc_mcu7t5v0__fill_2
XTAP_TAPCELL_ROW_6_1_373 VDD VSS gf180mcu_fd_sc_mcu7t5v0__filltie
XFILLER_66_667 VDD VDD VSS VSS gf180mcu_fd_sc_mcu7t5v0__fill_1
XFILLER_53_317 VDD VDD VSS VSS gf180mcu_fd_sc_mcu7t5v0__fillcap_8
XFILLER_81_648 VDD VDD VSS VSS gf180mcu_fd_sc_mcu7t5v0__fill_2
XFILLER_93_475 VDD VDD VSS VSS gf180mcu_fd_sc_mcu7t5v0__fillcap_4
XFILLER_94_1011 VDD VDD VSS VSS gf180mcu_fd_sc_mcu7t5v0__fillcap_4
XTAP_TAPCELL_ROW_105_1602 VDD VSS gf180mcu_fd_sc_mcu7t5v0__filltie
XTAP_TAPCELL_ROW_105_1613 VDD VSS gf180mcu_fd_sc_mcu7t5v0__filltie
Xspi_regs_inst__0817_ spi_regs_inst__0818_/A1 spi_regs_inst__0852_/A2 spi_regs_inst__1446_/A2
+ VDD VDD VSS VSS gf180mcu_fd_sc_mcu7t5v0__nand2_1
XFILLER_62_873 VDD VDD VSS VSS gf180mcu_fd_sc_mcu7t5v0__fill_2
Xspi_regs_inst__0748_ spi_regs_inst__1624_/Q spi_regs_inst__1625_/Q spi_regs_inst__0748_/Z
+ VDD VDD VSS VSS gf180mcu_fd_sc_mcu7t5v0__and2_1
XFILLER_159_271 VDD VDD VSS VSS gf180mcu_fd_sc_mcu7t5v0__fill_1
XTAP_TAPCELL_ROW_138_2156 VDD VSS gf180mcu_fd_sc_mcu7t5v0__filltie
Xwave_controller_x_inst__3130_ wave_controller_x_inst__3279_/A1 spi_regs_inst__1521_/Q
+ wave_controller_x_inst__3227_/A1 VDD VDD VSS VSS gf180mcu_fd_sc_mcu7t5v0__nand2_1
XFILLER_147_422 VDD VDD VSS VSS gf180mcu_fd_sc_mcu7t5v0__fillcap_8
XTAP_TAPCELL_ROW_36_1_605 VDD VSS gf180mcu_fd_sc_mcu7t5v0__filltie
Xwave_controller_x_inst__3061_ wave_controller_x_inst__3061_/A1 wave_controller_x_inst__2977_/Z
+ wave_controller_x_inst__3063_/B1 VDD VDD VSS VSS gf180mcu_fd_sc_mcu7t5v0__nor2_1
XFILLER_162_403 VDD VDD VSS VSS gf180mcu_fd_sc_mcu7t5v0__fillcap_8
Xwave_controller_x_inst__2012_ fanout535/Z wave_controller_x_inst__2380_/A1 wave_controller_x_inst__2018_/A1
+ VDD VDD VSS VSS gf180mcu_fd_sc_mcu7t5v0__nand2_1
XTAP_TAPCELL_ROW_151_2367 VDD VSS gf180mcu_fd_sc_mcu7t5v0__filltie
XTAP_TAPCELL_ROW_44_1_662 VDD VSS gf180mcu_fd_sc_mcu7t5v0__filltie
XFILLER_115_352 VDD VDD VSS VSS gf180mcu_fd_sc_mcu7t5v0__fillcap_64
XTAP_TAPCELL_ROW_116_1786 VDD VSS gf180mcu_fd_sc_mcu7t5v0__filltie
XFILLER_130_300 VDD VDD VSS VSS gf180mcu_fd_sc_mcu7t5v0__fill_2
XFILLER_153_1116 VDD VDD VSS VSS gf180mcu_fd_sc_mcu7t5v0__fillcap_4
XFILLER_66_1157 VDD VDD VSS VSS gf180mcu_fd_sc_mcu7t5v0__fillcap_16
XTAP_TAPCELL_ROW_116_1797 VDD VSS gf180mcu_fd_sc_mcu7t5v0__filltie
XFILLER_103_558 VDD VDD VSS VSS gf180mcu_fd_sc_mcu7t5v0__fill_2
XFILLER_130_333 VDD VDD VSS VSS gf180mcu_fd_sc_mcu7t5v0__fill_1
XFILLER_88_247 VDD VDD VSS VSS gf180mcu_fd_sc_mcu7t5v0__fillcap_16
XTAP_TAPCELL_ROW_10_1_407 VDD VSS gf180mcu_fd_sc_mcu7t5v0__filltie
Xwave_controller_y_inst__2930_ wave_controller_y_inst__2124_/B wave_controller_y_inst__3039_/A1
+ wave_controller_y_inst__3593_/A1 VDD VDD VSS VSS gf180mcu_fd_sc_mcu7t5v0__nand2_1
Xwave_controller_x_inst__2914_ wave_controller_x_inst__2918_/S wave_controller_x_inst__3583_/A1
+ wave_controller_x_inst__2914_/B wave_controller_x_inst__3682_/D VDD VDD VSS VSS
+ gf180mcu_fd_sc_mcu7t5v0__oai21_1
XFILLER_130_355 VDD VDD VSS VSS gf180mcu_fd_sc_mcu7t5v0__fillcap_8
XFILLER_76_409 VDD VDD VSS VSS gf180mcu_fd_sc_mcu7t5v0__fill_1
XFILLER_88_269 VDD VDD VSS VSS gf180mcu_fd_sc_mcu7t5v0__fill_1
Xwave_controller_y_inst__2861_ wave_controller_y_inst__3430_/A1 spi_regs_inst__1091_/A1
+ wave_controller_y_inst__2861_/Z VDD VDD VSS VSS gf180mcu_fd_sc_mcu7t5v0__xor2_1
XFILLER_130_399 VDD VDD VSS VSS gf180mcu_fd_sc_mcu7t5v0__fill_2
XFILLER_29_314 VDD VDD VSS VSS gf180mcu_fd_sc_mcu7t5v0__fill_2
XFILLER_29_336 VDD VDD VSS VSS gf180mcu_fd_sc_mcu7t5v0__fillcap_8
XFILLER_69_483 VDD VDD VSS VSS gf180mcu_fd_sc_mcu7t5v0__fill_1
Xwave_controller_y_inst__1812_ spi_regs_inst__1607_/Q wave_controller_y_inst__3304_/B
+ VDD VDD VSS VSS gf180mcu_fd_sc_mcu7t5v0__clkinv_1
Xwave_controller_x_inst__2845_ wave_controller_x_inst__3718_/Q wave_controller_x_inst__2846_/A2
+ wave_controller_x_inst__2845_/Z VDD VDD VSS VSS gf180mcu_fd_sc_mcu7t5v0__or2_1
XFILLER_151_48 VDD VDD VSS VSS gf180mcu_fd_sc_mcu7t5v0__fillcap_8
Xwave_controller_y_inst__2792_ wave_controller_y_inst__3568_/A1 wave_controller_y_inst__2791_/Z
+ wave_controller_y_inst__2809_/A1 VDD VDD VSS VSS gf180mcu_fd_sc_mcu7t5v0__nand2_1
Xwave_controller_x_inst__2776_ wave_controller_x_inst__3340_/A1 wave_controller_x_inst__2898_/A2
+ wave_controller_x_inst__2854_/B VDD VDD VSS VSS gf180mcu_fd_sc_mcu7t5v0__or2_1
XFILLER_56_177 VDD VDD VSS VSS gf180mcu_fd_sc_mcu7t5v0__fillcap_16
XPHY_EDGE_ROW_14_1_Left_181 VDD VSS gf180mcu_fd_sc_mcu7t5v0__endcap
Xwave_controller_y_inst__3413_ spi_regs_inst__1054_/B2 wave_controller_y_inst__3454_/A2
+ wave_controller_y_inst__3414_/A3 VDD VDD VSS VSS gf180mcu_fd_sc_mcu7t5v0__nor2_1
XFILLER_139_912 VDD VDD VSS VSS gf180mcu_fd_sc_mcu7t5v0__fillcap_64
Xwave_controller_y_inst__3344_ wave_controller_y_inst__3344_/A1 wave_controller_y_inst__3344_/A2
+ wave_controller_y_inst__3343_/Z wave_controller_y_inst__3403_/A1 VDD VDD VSS VSS
+ gf180mcu_fd_sc_mcu7t5v0__nand3_1
Xwave_controller_x_inst__3328_ wave_controller_x_inst__3004_/B spi_regs_inst__1537_/Q
+ wave_controller_x_inst__3328_/Z VDD VDD VSS VSS gf180mcu_fd_sc_mcu7t5v0__or2_1
XFILLER_166_731 VDD VDD VSS VSS gf180mcu_fd_sc_mcu7t5v0__fillcap_4
Xwave_controller_y_inst__3275_ wave_controller_y_inst__3564_/A1 spi_regs_inst__1602_/Q
+ wave_controller_y_inst__3371_/A1 VDD VDD VSS VSS gf180mcu_fd_sc_mcu7t5v0__nand2_1
Xwave_controller_x_inst__3259_ wave_controller_x_inst__1806_/I wave_controller_x_inst__3338_/A2
+ wave_controller_x_inst__3402_/C VDD VDD VSS VSS gf180mcu_fd_sc_mcu7t5v0__nand2_1
XFILLER_126_628 VDD VDD VSS VSS gf180mcu_fd_sc_mcu7t5v0__fillcap_4
Xwave_controller_y_inst__2226_ wave_controller_y_inst__2226_/A1 wave_controller_y_inst__2521_/A1
+ wave_controller_y_inst__2239_/A2 wave_controller_y_inst__2226_/Z VDD VDD VSS VSS
+ gf180mcu_fd_sc_mcu7t5v0__xor3_1
XFILLER_114_2 VDD VDD VSS VSS gf180mcu_fd_sc_mcu7t5v0__fillcap_16
XFILLER_165_296 VDD VDD VSS VSS gf180mcu_fd_sc_mcu7t5v0__fill_1
XFILLER_106_330 VDD VDD VSS VSS gf180mcu_fd_sc_mcu7t5v0__fill_2
XFILLER_109_72 VDD VDD VSS VSS gf180mcu_fd_sc_mcu7t5v0__fillcap_16
XFILLER_125_149 VDD VDD VSS VSS gf180mcu_fd_sc_mcu7t5v0__fillcap_4
XFILLER_4_457 VDD VDD VSS VSS gf180mcu_fd_sc_mcu7t5v0__fill_2
Xwave_controller_y_inst__2157_ wave_controller_y_inst__2451_/A1 spi_regs_inst__1090_/B2
+ wave_controller_y_inst__2157_/Z VDD VDD VSS VSS gf180mcu_fd_sc_mcu7t5v0__and2_1
XFILLER_134_683 VDD VDD VSS VSS gf180mcu_fd_sc_mcu7t5v0__fillcap_8
XFILLER_140_119 VDD VDD VSS VSS gf180mcu_fd_sc_mcu7t5v0__fillcap_4
XFILLER_79_203 VDD VDD VSS VSS gf180mcu_fd_sc_mcu7t5v0__fillcap_4
Xwave_controller_y_inst__2088_ wave_controller_y_inst__2755_/A1 wave_controller_y_inst__2086_/Z
+ wave_controller_y_inst__3727_/D VDD VDD VSS VSS gf180mcu_fd_sc_mcu7t5v0__xor2_1
XFILLER_106_396 VDD VDD VSS VSS gf180mcu_fd_sc_mcu7t5v0__fillcap_16
XFILLER_133_182 VDD VDD VSS VSS gf180mcu_fd_sc_mcu7t5v0__fillcap_4
XFILLER_161_480 VDD VDD VSS VSS gf180mcu_fd_sc_mcu7t5v0__fillcap_8
XFILLER_94_217 VDD VDD VSS VSS gf180mcu_fd_sc_mcu7t5v0__fill_2
Xwave_controller_x_inst_fanout442 wave_controller_x_inst__1806_/I wave_controller_x_inst__2052_/A2
+ VDD VDD VSS VSS gf180mcu_fd_sc_mcu7t5v0__dlyb_1
XFILLER_125_82 VDD VDD VSS VSS gf180mcu_fd_sc_mcu7t5v0__fill_1
XTAP_TAPCELL_ROW_89_1343 VDD VSS gf180mcu_fd_sc_mcu7t5v0__filltie
Xwave_controller_y_inst_max_cap44 wave_controller_y_inst__3036_/A2 wave_controller_y_inst__3016_/A3
+ VDD VDD VSS VSS gf180mcu_fd_sc_mcu7t5v0__buf_2
XFILLER_78_1017 VDD VDD VSS VSS gf180mcu_fd_sc_mcu7t5v0__fillcap_64
XFILLER_16_531 VDD VDD VSS VSS gf180mcu_fd_sc_mcu7t5v0__fill_1
Xspi_regs_inst__1651_ spi_regs_inst__1651_/D fanout584/Z clkbuf_leaf_13_clk/Z spi_regs_inst__1651_/Q
+ VDD VDD VSS VSS gf180mcu_fd_sc_mcu7t5v0__dffrnq_1
Xspi_regs_inst__1582_ spi_regs_inst__1582_/D spi_regs_inst__1662_/RN clkbuf_leaf_7_clk/Z
+ spi_regs_inst__1582_/Q VDD VDD VSS VSS gf180mcu_fd_sc_mcu7t5v0__dffrnq_1
XTAP_TAPCELL_ROW_100_1521 VDD VSS gf180mcu_fd_sc_mcu7t5v0__filltie
XTAP_TAPCELL_ROW_100_1532 VDD VSS gf180mcu_fd_sc_mcu7t5v0__filltie
XFILLER_106_1151 VDD VDD VSS VSS gf180mcu_fd_sc_mcu7t5v0__fillcap_4
XFILLER_129_422 VDD VDD VSS VSS gf180mcu_fd_sc_mcu7t5v0__fillcap_4
XTAP_TAPCELL_ROW_9_1_399 VDD VSS gf180mcu_fd_sc_mcu7t5v0__filltie
XFILLER_106_1173 VDD VDD VSS VSS gf180mcu_fd_sc_mcu7t5v0__fill_1
XFILLER_129_477 VDD VDD VSS VSS gf180mcu_fd_sc_mcu7t5v0__fillcap_4
XPHY_EDGE_ROW_152_Right_152 VDD VSS gf180mcu_fd_sc_mcu7t5v0__endcap
XTAP_TAPCELL_ROW_133_2064 VDD VSS gf180mcu_fd_sc_mcu7t5v0__filltie
XTAP_TAPCELL_ROW_133_2075 VDD VSS gf180mcu_fd_sc_mcu7t5v0__filltie
XFILLER_112_333 VDD VDD VSS VSS gf180mcu_fd_sc_mcu7t5v0__fillcap_4
Xspi_regs_inst__1016_ spi_regs_inst__1029_/A1 spi_regs_inst__1016_/A2 spi_regs_inst__1189_/A2
+ VDD VDD VSS VSS gf180mcu_fd_sc_mcu7t5v0__nor2_1
XFILLER_100_506 VDD VDD VSS VSS gf180mcu_fd_sc_mcu7t5v0__fillcap_16
XFILLER_86_718 VDD VDD VSS VSS gf180mcu_fd_sc_mcu7t5v0__fillcap_4
XFILLER_113_1122 VDD VDD VSS VSS gf180mcu_fd_sc_mcu7t5v0__fillcap_32
XFILLER_85_239 VDD VDD VSS VSS gf180mcu_fd_sc_mcu7t5v0__fill_2
Xwave_controller_y_inst_fanout56 wave_controller_y_inst__2911_/ZN wave_controller_y_inst__3602_/S
+ VDD VDD VSS VSS gf180mcu_fd_sc_mcu7t5v0__dlyb_1
Xwave_controller_y_inst_fanout45 wave_controller_y_inst__3591_/S wave_controller_y_inst__3588_/S
+ VDD VDD VSS VSS gf180mcu_fd_sc_mcu7t5v0__dlyb_1
Xwave_controller_y_inst_fanout23 wave_controller_y_inst__3528_/A2 wave_controller_y_inst__3555_/A2
+ VDD VDD VSS VSS gf180mcu_fd_sc_mcu7t5v0__dlyb_1
Xwave_controller_x_inst__2630_ wave_controller_x_inst__2630_/A1 wave_controller_x_inst__2630_/A2
+ spi_regs_inst__1177_/B2 VDD VDD VSS VSS gf180mcu_fd_sc_mcu7t5v0__xor2_1
XFILLER_26_317 VDD VDD VSS VSS gf180mcu_fd_sc_mcu7t5v0__fillcap_4
Xwave_controller_x_inst__2561_ wave_controller_x_inst__2561_/A1 wave_controller_x_inst__2561_/A2
+ wave_controller_x_inst__2561_/B wave_controller_x_inst__2633_/A1 VDD VDD VSS VSS
+ gf180mcu_fd_sc_mcu7t5v0__oai21_1
Xwave_controller_x_inst__2492_ wave_controller_x_inst__2488_/Z wave_controller_x_inst__2501_/A2
+ wave_controller_x_inst__2492_/Z VDD VDD VSS VSS gf180mcu_fd_sc_mcu7t5v0__xor2_1
Xclkbuf_3_5__f_clk clkbuf_0_clk/Z clkbuf_3_5__f_clk/Z VDD VDD VSS VSS gf180mcu_fd_sc_mcu7t5v0__clkbuf_16
XFILLER_61_191 VDD VDD VSS VSS gf180mcu_fd_sc_mcu7t5v0__fillcap_4
XTAP_TAPCELL_ROW_153_2407 VDD VSS gf180mcu_fd_sc_mcu7t5v0__filltie
XTAP_TAPCELL_ROW_60_860 VDD VSS gf180mcu_fd_sc_mcu7t5v0__filltie
XTAP_TAPCELL_ROW_60_871 VDD VSS gf180mcu_fd_sc_mcu7t5v0__filltie
Xwave_controller_x_inst__3113_ wave_controller_x_inst__3163_/C spi_regs_inst__1530_/Q
+ wave_controller_x_inst__3203_/A1 VDD VDD VSS VSS gf180mcu_fd_sc_mcu7t5v0__nand2_1
XFILLER_147_241 VDD VDD VSS VSS gf180mcu_fd_sc_mcu7t5v0__fillcap_8
XFILLER_147_263 VDD VDD VSS VSS gf180mcu_fd_sc_mcu7t5v0__fill_1
XTAP_TAPCELL_ROW_118_1826 VDD VSS gf180mcu_fd_sc_mcu7t5v0__filltie
Xwave_controller_y_inst__3060_ wave_controller_y_inst__3709_/Q wave_controller_y_inst__3408_/A1
+ wave_controller_y_inst__3604_/A2 VDD VDD VSS VSS gf180mcu_fd_sc_mcu7t5v0__nand2_1
XFILLER_30_37 VDD VDD VSS VSS gf180mcu_fd_sc_mcu7t5v0__fillcap_16
Xwave_controller_y_inst__2011_ wave_controller_y_inst__2008_/Z wave_controller_y_inst_wire82/Z
+ wave_controller_y_inst__2016_/C wave_controller_y_inst__2013_/A3 VDD VDD VSS VSS
+ gf180mcu_fd_sc_mcu7t5v0__oai21_1
Xwave_controller_x_inst__3044_ wave_controller_x_inst__3279_/A1 wave_controller_x_inst__3069_/B1
+ wave_controller_x_inst__3043_/Z wave_controller_x_inst__2762_/I wave_controller_x_inst__3702_/D
+ VDD VDD VSS VSS gf180mcu_fd_sc_mcu7t5v0__oai22_1
XFILLER_100_8 VDD VDD VSS VSS gf180mcu_fd_sc_mcu7t5v0__fill_1
XFILLER_118_1011 VDD VDD VSS VSS gf180mcu_fd_sc_mcu7t5v0__fillcap_4
XFILLER_150_417 VDD VDD VSS VSS gf180mcu_fd_sc_mcu7t5v0__fillcap_4
Xmax_cap460 max_cap460/I max_cap460/Z VDD VDD VSS VSS gf180mcu_fd_sc_mcu7t5v0__buf_4
XFILLER_89_589 VDD VDD VSS VSS gf180mcu_fd_sc_mcu7t5v0__fill_1
Xwave_controller_y_inst__2913_ spi_regs_inst__1232_/B2 wave_controller_y_inst__2923_/S
+ wave_controller_y_inst__2914_/B VDD VDD VSS VSS gf180mcu_fd_sc_mcu7t5v0__nand2_1
XFILLER_130_185 VDD VDD VSS VSS gf180mcu_fd_sc_mcu7t5v0__fill_2
XFILLER_76_239 VDD VDD VSS VSS gf180mcu_fd_sc_mcu7t5v0__fillcap_4
XFILLER_57_453 VDD VDD VSS VSS gf180mcu_fd_sc_mcu7t5v0__fillcap_4
XFILLER_85_740 VDD VDD VSS VSS gf180mcu_fd_sc_mcu7t5v0__fillcap_4
Xwave_controller_y_inst__2844_ wave_controller_y_inst__2844_/A1 wave_controller_y_inst__2844_/A2
+ wave_controller_y_inst__2844_/B wave_controller_y_inst__2846_/A2 VDD VDD VSS VSS
+ gf180mcu_fd_sc_mcu7t5v0__oai21_1
Xwave_controller_x_inst__2828_ max_cap463/Z wave_controller_x_inst__3446_/A2 wave_controller_x_inst__2829_/B
+ VDD VDD VSS VSS gf180mcu_fd_sc_mcu7t5v0__nand2_1
XFILLER_84_261 VDD VDD VSS VSS gf180mcu_fd_sc_mcu7t5v0__fill_1
XTAP_TAPCELL_ROW_129_1999 VDD VSS gf180mcu_fd_sc_mcu7t5v0__filltie
XTAP_TAPCELL_ROW_68_993 VDD VSS gf180mcu_fd_sc_mcu7t5v0__filltie
Xwave_controller_y_inst__2775_ wave_controller_y_inst__3189_/A1 wave_controller_y_inst__2898_/A2
+ wave_controller_y_inst__2775_/Z VDD VDD VSS VSS gf180mcu_fd_sc_mcu7t5v0__and2_1
XFILLER_73_979 VDD VDD VSS VSS gf180mcu_fd_sc_mcu7t5v0__fill_1
Xwave_controller_x_inst__2759_ state_machine_inst__34_/A1 fanout498/Z wave_controller_x_inst__3081_/C
+ VDD VDD VSS VSS gf180mcu_fd_sc_mcu7t5v0__nor2_1
XFILLER_72_489 VDD VDD VSS VSS gf180mcu_fd_sc_mcu7t5v0__fillcap_8
XTAP_TAPCELL_ROW_84_1262 VDD VSS gf180mcu_fd_sc_mcu7t5v0__filltie
XFILLER_9_516 VDD VDD VSS VSS gf180mcu_fd_sc_mcu7t5v0__fillcap_8
XFILLER_9_549 VDD VDD VSS VSS gf180mcu_fd_sc_mcu7t5v0__fillcap_4
XPHY_EDGE_ROW_50_1_Right_49 VDD VSS gf180mcu_fd_sc_mcu7t5v0__endcap
Xwave_controller_y_inst__3327_ wave_controller_y_inst__3004_/B spi_regs_inst__1616_/Q
+ wave_controller_y_inst__3336_/A1 VDD VDD VSS VSS gf180mcu_fd_sc_mcu7t5v0__nand2_1
XFILLER_154_734 VDD VDD VSS VSS gf180mcu_fd_sc_mcu7t5v0__fill_1
XFILLER_154_745 VDD VDD VSS VSS gf180mcu_fd_sc_mcu7t5v0__fill_2
XTAP_TAPCELL_ROW_5_1_372 VDD VSS gf180mcu_fd_sc_mcu7t5v0__filltie
Xwave_controller_y_inst__3258_ wave_controller_y_inst__3616_/Q wave_controller_y_inst__3258_/A2
+ wave_controller_y_inst__3404_/A1 VDD VDD VSS VSS gf180mcu_fd_sc_mcu7t5v0__nand2_1
Xwave_controller_y_inst__3189_ wave_controller_y_inst__3189_/A1 spi_regs_inst__1581_/Q
+ spi_regs_inst__1580_/Q wave_controller_y_inst__3189_/C wave_controller_y_inst__3190_/A2
+ VDD VDD VSS VSS gf180mcu_fd_sc_mcu7t5v0__oai211_1
Xwave_controller_y_inst__2209_ wave_controller_y_inst__2209_/I wave_controller_y_inst__2248_/A1
+ VDD VDD VSS VSS gf180mcu_fd_sc_mcu7t5v0__clkinv_1
XFILLER_141_417 VDD VDD VSS VSS gf180mcu_fd_sc_mcu7t5v0__fill_2
XFILLER_106_193 VDD VDD VSS VSS gf180mcu_fd_sc_mcu7t5v0__fill_1
XFILLER_122_642 VDD VDD VSS VSS gf180mcu_fd_sc_mcu7t5v0__fillcap_4
XFILLER_122_664 VDD VDD VSS VSS gf180mcu_fd_sc_mcu7t5v0__fill_1
XFILLER_122_675 VDD VDD VSS VSS gf180mcu_fd_sc_mcu7t5v0__fillcap_4
XFILLER_84_1087 VDD VDD VSS VSS gf180mcu_fd_sc_mcu7t5v0__fillcap_64
XFILLER_95_504 VDD VDD VSS VSS gf180mcu_fd_sc_mcu7t5v0__fill_1
XFILLER_96_30 VDD VDD VSS VSS gf180mcu_fd_sc_mcu7t5v0__fillcap_4
XFILLER_96_85 VDD VDD VSS VSS gf180mcu_fd_sc_mcu7t5v0__fill_2
XFILLER_96_96 VDD VDD VSS VSS gf180mcu_fd_sc_mcu7t5v0__fillcap_4
XFILLER_76_751 VDD VDD VSS VSS gf180mcu_fd_sc_mcu7t5v0__fill_2
XFILLER_91_710 VDD VDD VSS VSS gf180mcu_fd_sc_mcu7t5v0__fillcap_4
XFILLER_35_147 VDD VDD VSS VSS gf180mcu_fd_sc_mcu7t5v0__fillcap_32
XFILLER_63_478 VDD VDD VSS VSS gf180mcu_fd_sc_mcu7t5v0__fill_2
XFILLER_91_787 VDD VDD VSS VSS gf180mcu_fd_sc_mcu7t5v0__fillcap_8
Xspi_regs_inst__1634_ spi_regs_inst__1634_/D spi_regs_inst__1662_/RN clkbuf_leaf_7_clk/Z
+ spi_regs_inst__1634_/Q VDD VDD VSS VSS gf180mcu_fd_sc_mcu7t5v0__dffrnq_1
XFILLER_50_117 VDD VDD VSS VSS gf180mcu_fd_sc_mcu7t5v0__fill_2
XFILLER_31_342 VDD VDD VSS VSS gf180mcu_fd_sc_mcu7t5v0__fillcap_8
Xspi_regs_inst__1565_ spi_regs_inst__1565_/D spi_regs_inst__1647_/RN clkbuf_leaf_39_clk/Z
+ spi_regs_inst__1565_/Q VDD VDD VSS VSS gf180mcu_fd_sc_mcu7t5v0__dffrnq_1
XFILLER_31_375 VDD VDD VSS VSS gf180mcu_fd_sc_mcu7t5v0__fill_2
XTAP_TAPCELL_ROW_135_2104 VDD VSS gf180mcu_fd_sc_mcu7t5v0__filltie
Xspi_regs_inst__1496_ spi_regs_inst__1496_/D fanout589/Z clkload25/I spi_regs_inst__1496_/Q
+ VDD VDD VSS VSS gf180mcu_fd_sc_mcu7t5v0__dffrnq_1
XFILLER_118_926 VDD VDD VSS VSS gf180mcu_fd_sc_mcu7t5v0__fillcap_16
XFILLER_129_230 VDD VDD VSS VSS gf180mcu_fd_sc_mcu7t5v0__fill_1
XFILLER_129_263 VDD VDD VSS VSS gf180mcu_fd_sc_mcu7t5v0__fillcap_8
XFILLER_145_723 VDD VDD VSS VSS gf180mcu_fd_sc_mcu7t5v0__fill_1
XFILLER_144_255 VDD VDD VSS VSS gf180mcu_fd_sc_mcu7t5v0__fillcap_8
XFILLER_145_789 VDD VDD VSS VSS gf180mcu_fd_sc_mcu7t5v0__fill_1
XFILLER_160_737 VDD VDD VSS VSS gf180mcu_fd_sc_mcu7t5v0__fillcap_64
XFILLER_116_18 VDD VDD VSS VSS gf180mcu_fd_sc_mcu7t5v0__fill_2
XFILLER_63_1116 VDD VDD VSS VSS gf180mcu_fd_sc_mcu7t5v0__fillcap_4
XTAP_TAPCELL_ROW_113_1734 VDD VSS gf180mcu_fd_sc_mcu7t5v0__filltie
XTAP_TAPCELL_ROW_113_1745 VDD VSS gf180mcu_fd_sc_mcu7t5v0__filltie
XFILLER_99_898 VDD VDD VSS VSS gf180mcu_fd_sc_mcu7t5v0__fillcap_8
Xwave_controller_x_inst__1992_ wave_controller_x_inst__3387_/A1 spi_regs_inst__1100_/B2
+ wave_controller_x_inst__1992_/B wave_controller_x_inst__1999_/B2 VDD VDD VSS VSS
+ gf180mcu_fd_sc_mcu7t5v0__aoi21_1
Xstate_machine_inst__29_ state_machine_inst__26_/Z state_machine_inst__29_/A2 state_machine_inst__28_/Z
+ state_machine_inst__29_/B2 state_machine_inst__37_/A1 VDD VDD VSS VSS gf180mcu_fd_sc_mcu7t5v0__aoi22_1
Xfanout539 fanout539/I fanout539/Z VDD VDD VSS VSS gf180mcu_fd_sc_mcu7t5v0__dlyb_1
Xfanout528 fanout529/Z fanout528/Z VDD VDD VSS VSS gf180mcu_fd_sc_mcu7t5v0__dlyb_1
Xfanout517 fanout517/I fanout517/Z VDD VDD VSS VSS gf180mcu_fd_sc_mcu7t5v0__dlyb_1
XFILLER_112_174 VDD VDD VSS VSS gf180mcu_fd_sc_mcu7t5v0__fill_1
Xwave_controller_x_inst__3731_ wave_controller_x_inst__3731_/D fanout597/Z clkload26/I
+ wave_controller_x_inst__3731_/Q VDD VDD VSS VSS gf180mcu_fd_sc_mcu7t5v0__dffrnq_1
Xwave_controller_y_inst_max_cap506 spi_regs_inst__1489_/Q wave_controller_y_inst__1826_/I
+ VDD VDD VSS VSS gf180mcu_fd_sc_mcu7t5v0__buf_4
Xwave_controller_x_inst__3662_ wave_controller_x_inst__3662_/D wave_controller_x_inst__3682_/RN
+ clkload33/I max_cap452/I VDD VDD VSS VSS gf180mcu_fd_sc_mcu7t5v0__dffrnq_1
XTAP_TAPCELL_ROW_146_2288 VDD VSS gf180mcu_fd_sc_mcu7t5v0__filltie
XTAP_TAPCELL_ROW_29_1_551 VDD VSS gf180mcu_fd_sc_mcu7t5v0__filltie
Xwave_controller_x_inst__2613_ wave_controller_x_inst__2829_/A1 max_cap463/Z wave_controller_x_inst__2650_/B
+ VDD VDD VSS VSS gf180mcu_fd_sc_mcu7t5v0__nor2_1
XFILLER_66_283 VDD VDD VSS VSS gf180mcu_fd_sc_mcu7t5v0__fillcap_8
Xwave_controller_x_inst__3593_ wave_controller_x_inst__3593_/A1 wave_controller_x_inst__3591_/S
+ wave_controller_x_inst__3593_/B wave_controller_x_inst__3669_/D VDD VDD VSS VSS
+ gf180mcu_fd_sc_mcu7t5v0__oai21_1
XTAP_TAPCELL_ROW_65_952 VDD VSS gf180mcu_fd_sc_mcu7t5v0__filltie
Xwave_controller_y_inst__2560_ spi_regs_inst__1343_/A1 wave_controller_y_inst__2558_/Z
+ wave_controller_y_inst__2561_/B VDD VDD VSS VSS gf180mcu_fd_sc_mcu7t5v0__xor2_1
Xwave_controller_x_inst__2544_ wave_controller_x_inst__2545_/A1 wave_controller_x_inst__2545_/B
+ wave_controller_x_inst__2545_/A2 wave_controller_x_inst__2544_/Z VDD VDD VSS VSS
+ gf180mcu_fd_sc_mcu7t5v0__and3_1
XFILLER_81_286 VDD VDD VSS VSS gf180mcu_fd_sc_mcu7t5v0__fill_2
Xwave_controller_y_inst__2491_ wave_controller_y_inst__2517_/A1 wave_controller_y_inst__2517_/A2
+ wave_controller_y_inst__2517_/C wave_controller_y_inst__2501_/A2 VDD VDD VSS VSS
+ gf180mcu_fd_sc_mcu7t5v0__oai21_1
Xwave_controller_x_inst__2475_ wave_controller_x_inst__3376_/B wave_controller_x_inst__2474_/Z
+ wave_controller_x_inst__2497_/A1 VDD VDD VSS VSS gf180mcu_fd_sc_mcu7t5v0__nand2_1
XPHY_EDGE_ROW_2_1_Left_169 VDD VSS gf180mcu_fd_sc_mcu7t5v0__endcap
XFILLER_41_36 VDD VDD VSS VSS gf180mcu_fd_sc_mcu7t5v0__fill_2
Xwave_controller_y_inst__3112_ wave_controller_y_inst__3312_/A1 spi_regs_inst__1594_/Q
+ wave_controller_y_inst__3164_/A1 VDD VDD VSS VSS gf180mcu_fd_sc_mcu7t5v0__nand2_1
XFILLER_124_1081 VDD VDD VSS VSS gf180mcu_fd_sc_mcu7t5v0__fillcap_4
XFILLER_136_723 VDD VDD VSS VSS gf180mcu_fd_sc_mcu7t5v0__fill_1
XFILLER_148_594 VDD VDD VSS VSS gf180mcu_fd_sc_mcu7t5v0__fill_1
XTAP_TAPCELL_ROW_52_1_718 VDD VSS gf180mcu_fd_sc_mcu7t5v0__filltie
XFILLER_124_918 VDD VDD VSS VSS gf180mcu_fd_sc_mcu7t5v0__fillcap_16
XFILLER_159_1122 VDD VDD VSS VSS gf180mcu_fd_sc_mcu7t5v0__fillcap_32
Xwave_controller_y_inst__3043_ wave_controller_y_inst__3279_/A1 wave_controller_y_inst__3043_/A2
+ wave_controller_y_inst__3043_/A3 wave_controller_y_inst__3043_/Z VDD VDD VSS VSS
+ gf180mcu_fd_sc_mcu7t5v0__xor3_1
Xwave_controller_x_inst__3027_ wave_controller_x_inst__2910_/B wave_controller_x_inst__3032_/A3
+ wave_controller_x_inst__3029_/B1 VDD VDD VSS VSS gf180mcu_fd_sc_mcu7t5v0__nand2_1
XFILLER_135_277 VDD VDD VSS VSS gf180mcu_fd_sc_mcu7t5v0__fill_2
XFILLER_135_288 VDD VDD VSS VSS gf180mcu_fd_sc_mcu7t5v0__fillcap_4
XFILLER_151_726 VDD VDD VSS VSS gf180mcu_fd_sc_mcu7t5v0__fillcap_4
XFILLER_135_299 VDD VDD VSS VSS gf180mcu_fd_sc_mcu7t5v0__fillcap_4
XTAP_TAPCELL_ROW_166_2609 VDD VSS gf180mcu_fd_sc_mcu7t5v0__filltie
XFILLER_77_548 VDD VDD VSS VSS gf180mcu_fd_sc_mcu7t5v0__fill_2
XFILLER_131_1052 VDD VDD VSS VSS gf180mcu_fd_sc_mcu7t5v0__fillcap_64
XTAP_TAPCELL_ROW_86_1302 VDD VSS gf180mcu_fd_sc_mcu7t5v0__filltie
Xwave_controller_y_inst__2827_ wave_controller_y_inst__2838_/A1 wave_controller_y_inst__2826_/Z
+ wave_controller_y_inst__2834_/C VDD VDD VSS VSS gf180mcu_fd_sc_mcu7t5v0__nand2_1
XFILLER_17_136 VDD VDD VSS VSS gf180mcu_fd_sc_mcu7t5v0__fillcap_4
XFILLER_17_158 VDD VDD VSS VSS gf180mcu_fd_sc_mcu7t5v0__fill_1
XFILLER_17_169 VDD VDD VSS VSS gf180mcu_fd_sc_mcu7t5v0__fill_2
XFILLER_45_478 VDD VDD VSS VSS gf180mcu_fd_sc_mcu7t5v0__fillcap_8
XFILLER_61_927 VDD VDD VSS VSS gf180mcu_fd_sc_mcu7t5v0__fillcap_32
XFILLER_82_10 VDD VDD VSS VSS gf180mcu_fd_sc_mcu7t5v0__fillcap_4
Xwave_controller_y_inst__2758_ wave_controller_y_inst__3497_/A1 wave_controller_y_inst__2456_/B
+ wave_controller_y_inst__2758_/B spi_regs_inst_wire148/I VDD VDD VSS VSS gf180mcu_fd_sc_mcu7t5v0__aoi21_1
XFILLER_60_415 VDD VDD VSS VSS gf180mcu_fd_sc_mcu7t5v0__fill_2
XFILLER_72_297 VDD VDD VSS VSS gf180mcu_fd_sc_mcu7t5v0__fillcap_4
Xwave_controller_y_inst__2689_ spi_regs_inst__1045_/A1 wave_controller_y_inst__3545_/B2
+ wave_controller_y_inst__2717_/B2 wave_controller_y_inst__2689_/Z VDD VDD VSS VSS
+ gf180mcu_fd_sc_mcu7t5v0__xor3_1
XTAP_TAPCELL_ROW_38_1_619 VDD VSS gf180mcu_fd_sc_mcu7t5v0__filltie
Xspi_regs_inst__1350_ _09_/A1 spi_regs_inst_wire263/Z spi_regs_inst_wire241/Z max_cap457/Z
+ spi_regs_inst__1351_/A4 VDD VDD VSS VSS gf180mcu_fd_sc_mcu7t5v0__aoi22_1
XFILLER_139_572 VDD VDD VSS VSS gf180mcu_fd_sc_mcu7t5v0__fillcap_32
Xspi_regs_inst__1281_ spi_regs_inst__1281_/A1 spi_regs_inst_wire290/I spi_regs_inst__1281_/B1
+ spi_regs_inst__1575_/Q spi_regs_inst__1281_/C spi_regs_inst__1296_/A3 VDD VDD VSS
+ VSS gf180mcu_fd_sc_mcu7t5v0__aoi221_1
XFILLER_103_1154 VDD VDD VSS VSS gf180mcu_fd_sc_mcu7t5v0__fillcap_16
XFILLER_166_391 VDD VDD VSS VSS gf180mcu_fd_sc_mcu7t5v0__fill_2
XTAP_TAPCELL_ROW_46_1_676 VDD VSS gf180mcu_fd_sc_mcu7t5v0__filltie
XTAP_TAPCELL_ROW_97_1475 VDD VSS gf180mcu_fd_sc_mcu7t5v0__filltie
XFILLER_114_406 VDD VDD VSS VSS gf180mcu_fd_sc_mcu7t5v0__fill_1
XFILLER_147_80 VDD VDD VSS VSS gf180mcu_fd_sc_mcu7t5v0__fillcap_16
XTAP_TAPCELL_ROW_130_2023 VDD VSS gf180mcu_fd_sc_mcu7t5v0__filltie
XFILLER_142_737 VDD VDD VSS VSS gf180mcu_fd_sc_mcu7t5v0__fillcap_8
XFILLER_154_597 VDD VDD VSS VSS gf180mcu_fd_sc_mcu7t5v0__fillcap_8
XFILLER_99_139 VDD VDD VSS VSS gf180mcu_fd_sc_mcu7t5v0__fill_1
Xsignal_processor_y_inst__231_ signal_processor_y_inst__231_/D fanout556/Z _21_/CLK
+ signal_processor_y_inst__231_/Q VDD VDD VSS VSS gf180mcu_fd_sc_mcu7t5v0__dffrnq_1
XFILLER_68_504 VDD VDD VSS VSS gf180mcu_fd_sc_mcu7t5v0__fillcap_16
XTAP_TAPCELL_ROW_20_1_478 VDD VSS gf180mcu_fd_sc_mcu7t5v0__filltie
Xsignal_processor_y_inst__162_ signal_processor_y_inst__232_/Q signal_processor_y_inst__163_/A2
+ signal_processor_y_inst__192_/A2 VDD VDD VSS VSS gf180mcu_fd_sc_mcu7t5v0__xnor2_1
XFILLER_95_356 VDD VDD VSS VSS gf180mcu_fd_sc_mcu7t5v0__fill_2
XFILLER_55_209 VDD VDD VSS VSS gf180mcu_fd_sc_mcu7t5v0__fill_1
XFILLER_36_434 VDD VDD VSS VSS gf180mcu_fd_sc_mcu7t5v0__fillcap_4
XFILLER_36_445 VDD VDD VSS VSS gf180mcu_fd_sc_mcu7t5v0__fill_1
XFILLER_63_220 VDD VDD VSS VSS gf180mcu_fd_sc_mcu7t5v0__fill_2
XFILLER_64_721 VDD VDD VSS VSS gf180mcu_fd_sc_mcu7t5v0__fillcap_8
Xspi_regs_inst__0996_ spi_regs_inst__1032_/A1 spi_regs_inst__1027_/A2 spi_regs_inst_wire249/I
+ VDD VDD VSS VSS gf180mcu_fd_sc_mcu7t5v0__nor2_1
XFILLER_91_562 VDD VDD VSS VSS gf180mcu_fd_sc_mcu7t5v0__fill_2
XFILLER_91_573 VDD VDD VSS VSS gf180mcu_fd_sc_mcu7t5v0__fillcap_32
XTAP_TAPCELL_ROW_62_900 VDD VSS gf180mcu_fd_sc_mcu7t5v0__filltie
XTAP_TAPCELL_ROW_141_2196 VDD VSS gf180mcu_fd_sc_mcu7t5v0__filltie
Xspi_regs_inst__1617_ spi_regs_inst__1617_/D fanout561/Z clkload9/I spi_regs_inst__1617_/Q
+ VDD VDD VSS VSS gf180mcu_fd_sc_mcu7t5v0__dffrnq_1
Xwave_controller_x_inst__2260_ wave_controller_x_inst_wire183/Z wave_controller_x_inst__2256_/Z
+ wave_controller_x_inst__2260_/B wave_controller_x_inst__2260_/C wave_controller_x_inst__2272_/A2
+ VDD VDD VSS VSS gf180mcu_fd_sc_mcu7t5v0__aoi211_1
Xspi_regs_inst__1548_ spi_regs_inst__1548_/D spi_regs_inst__1648_/RN clkload30/I spi_regs_inst__1548_/Q
+ VDD VDD VSS VSS gf180mcu_fd_sc_mcu7t5v0__dffrnq_1
XFILLER_108_1087 VDD VDD VSS VSS gf180mcu_fd_sc_mcu7t5v0__fillcap_64
Xwave_controller_x_inst__2191_ wave_controller_x_inst__2223_/A1 wave_controller_x_inst__2793_/I0
+ wave_controller_x_inst__2204_/B VDD VDD VSS VSS gf180mcu_fd_sc_mcu7t5v0__nor2_1
XFILLER_118_701 VDD VDD VSS VSS gf180mcu_fd_sc_mcu7t5v0__fill_2
XFILLER_164_317 VDD VDD VSS VSS gf180mcu_fd_sc_mcu7t5v0__fillcap_4
Xspi_regs_inst__1479_ spi_regs_inst__1479_/D spi_regs_inst__1610_/RN clkload13/I fanout519/I
+ VDD VDD VSS VSS gf180mcu_fd_sc_mcu7t5v0__dffrnq_1
XFILLER_157_380 VDD VDD VSS VSS gf180mcu_fd_sc_mcu7t5v0__fill_1
XFILLER_117_277 VDD VDD VSS VSS gf180mcu_fd_sc_mcu7t5v0__fill_2
XFILLER_118_778 VDD VDD VSS VSS gf180mcu_fd_sc_mcu7t5v0__fill_2
XFILLER_118_789 VDD VDD VSS VSS gf180mcu_fd_sc_mcu7t5v0__fill_1
XPHY_EDGE_ROW_23_1_Left_190 VDD VSS gf180mcu_fd_sc_mcu7t5v0__endcap
Xwave_controller_y_inst_fanout408 wave_controller_y_inst_wire412/I wave_controller_y_inst__1902_/I
+ VDD VDD VSS VSS gf180mcu_fd_sc_mcu7t5v0__dlyb_1
XFILLER_132_236 VDD VDD VSS VSS gf180mcu_fd_sc_mcu7t5v0__fillcap_8
XFILLER_133_748 VDD VDD VSS VSS gf180mcu_fd_sc_mcu7t5v0__fillcap_4
Xwave_controller_y_inst_fanout419 wave_controller_y_inst__3715_/Q wave_controller_y_inst__1783_/I
+ VDD VDD VSS VSS gf180mcu_fd_sc_mcu7t5v0__dlyb_1
XFILLER_132_247 VDD VDD VSS VSS gf180mcu_fd_sc_mcu7t5v0__fillcap_16
XTAP_TAPCELL_ROW_148_2317 VDD VSS gf180mcu_fd_sc_mcu7t5v0__filltie
XFILLER_100_100 VDD VDD VSS VSS gf180mcu_fd_sc_mcu7t5v0__fillcap_4
XFILLER_101_623 VDD VDD VSS VSS gf180mcu_fd_sc_mcu7t5v0__fillcap_4
Xwave_controller_y_inst__1991_ wave_controller_y_inst__1991_/A1 wave_controller_y_inst__1999_/C
+ wave_controller_y_inst__1999_/B1 VDD VDD VSS VSS gf180mcu_fd_sc_mcu7t5v0__nand2_1
XFILLER_100_111 VDD VDD VSS VSS gf180mcu_fd_sc_mcu7t5v0__fill_1
Xwave_controller_y_inst__3730_ wave_controller_y_inst__3730_/D fanout547/Z clkload6/I
+ wave_controller_y_inst__3730_/Q VDD VDD VSS VSS gf180mcu_fd_sc_mcu7t5v0__dffrnq_1
Xwave_controller_x_inst__1975_ wave_controller_x_inst__1981_/B wave_controller_x_inst__1981_/C
+ wave_controller_x_inst__1977_/A3 VDD VDD VSS VSS gf180mcu_fd_sc_mcu7t5v0__nor2_1
XFILLER_27_401 VDD VDD VSS VSS gf180mcu_fd_sc_mcu7t5v0__fillcap_4
XFILLER_39_250 VDD VDD VSS VSS gf180mcu_fd_sc_mcu7t5v0__fillcap_4
XFILLER_55_710 VDD VDD VSS VSS gf180mcu_fd_sc_mcu7t5v0__fill_1
XTAP_TAPCELL_ROW_161_2528 VDD VSS gf180mcu_fd_sc_mcu7t5v0__filltie
XTAP_TAPCELL_ROW_161_2539 VDD VSS gf180mcu_fd_sc_mcu7t5v0__filltie
Xwave_controller_x_inst__3714_ wave_controller_x_inst__3714_/D wave_controller_x_inst__3715_/RN
+ clkbuf_leaf_25_clk/Z wave_controller_x_inst__3714_/Q VDD VDD VSS VSS gf180mcu_fd_sc_mcu7t5v0__dffrnq_1
XPHY_EDGE_ROW_42_1_Left_209 VDD VSS gf180mcu_fd_sc_mcu7t5v0__endcap
XTAP_TAPCELL_ROW_4_1_360 VDD VSS gf180mcu_fd_sc_mcu7t5v0__filltie
Xwave_controller_y_inst__3661_ wave_controller_y_inst__3661_/D wave_controller_y_inst__3683_/RN
+ clkbuf_leaf_46_clk/Z max_cap426/I VDD VDD VSS VSS gf180mcu_fd_sc_mcu7t5v0__dffrnq_1
Xwave_controller_x_inst__3645_ wave_controller_x_inst__3645_/D wave_controller_x_inst__3686_/RN
+ clkload27/I spi_regs_inst__1119_/A1 VDD VDD VSS VSS gf180mcu_fd_sc_mcu7t5v0__dffrnq_1
XFILLER_27_467 VDD VDD VSS VSS gf180mcu_fd_sc_mcu7t5v0__fillcap_8
XFILLER_54_231 VDD VDD VSS VSS gf180mcu_fd_sc_mcu7t5v0__fill_1
XFILLER_55_776 VDD VDD VSS VSS gf180mcu_fd_sc_mcu7t5v0__fill_1
XTAP_TAPCELL_ROW_126_1958 VDD VSS gf180mcu_fd_sc_mcu7t5v0__filltie
Xwave_controller_y_inst__2612_ wave_controller_y_inst__2612_/A1 wave_controller_y_inst__2610_/Z
+ spi_regs_inst_wire29/I VDD VDD VSS VSS gf180mcu_fd_sc_mcu7t5v0__xor2_1
Xwave_controller_y_inst__3592_ spi_regs_inst__1234_/A1 wave_controller_y_inst__3588_/S
+ wave_controller_y_inst__3593_/B VDD VDD VSS VSS gf180mcu_fd_sc_mcu7t5v0__nand2_1
Xwave_controller_x_inst__3576_ spi_regs_inst__1090_/A1 wave_controller_x_inst__3581_/A1
+ wave_controller_x_inst__3577_/B VDD VDD VSS VSS gf180mcu_fd_sc_mcu7t5v0__nand2_1
XFILLER_14_128 VDD VDD VSS VSS gf180mcu_fd_sc_mcu7t5v0__fill_1
XFILLER_27_489 VDD VDD VSS VSS gf180mcu_fd_sc_mcu7t5v0__fill_1
XFILLER_70_724 VDD VDD VSS VSS gf180mcu_fd_sc_mcu7t5v0__fill_1
Xwave_controller_y_inst__2543_ wave_controller_y_inst__2543_/A1 wave_controller_y_inst__2543_/A2
+ wave_controller_y_inst__2543_/B1 wave_controller_y_inst__2524_/Z wave_controller_y_inst__2543_/C
+ wave_controller_y_inst__2545_/A2 VDD VDD VSS VSS gf180mcu_fd_sc_mcu7t5v0__oai221_1
Xspi_regs_inst_max_cap229 spi_regs_inst_wire228/I spi_regs_inst__1250_/B1 VDD VDD
+ VSS VSS gf180mcu_fd_sc_mcu7t5v0__buf_2
Xsignal_processor_x_inst__251_ signal_processor_x_inst__251_/D fanout595/Z clkbuf_leaf_19_clk/Z
+ signal_processor_x_inst__251_/Q VDD VDD VSS VSS gf180mcu_fd_sc_mcu7t5v0__dffrnq_1
XTAP_TAPCELL_ROW_81_1210 VDD VSS gf180mcu_fd_sc_mcu7t5v0__filltie
XTAP_TAPCELL_ROW_81_1221 VDD VSS gf180mcu_fd_sc_mcu7t5v0__filltie
Xwave_controller_x_inst__2527_ wave_controller_x_inst__2543_/B1 wave_controller_x_inst__2524_/Z
+ wave_controller_x_inst__2527_/A3 spi_regs_inst__1282_/B2 VDD VDD VSS VSS gf180mcu_fd_sc_mcu7t5v0__xor3_1
XFILLER_167_122 VDD VDD VSS VSS gf180mcu_fd_sc_mcu7t5v0__fill_1
Xwave_controller_y_inst__2474_ wave_controller_y_inst__2470_/Z wave_controller_y_inst__2476_/A3
+ wave_controller_y_inst__2474_/Z VDD VDD VSS VSS gf180mcu_fd_sc_mcu7t5v0__xor2_1
Xwave_controller_x_inst__2458_ wave_controller_x_inst__2757_/A1 wave_controller_x_inst__2455_/B
+ wave_controller_x_inst__2458_/B wave_controller_x_inst__2758_/B VDD VDD VSS VSS
+ gf180mcu_fd_sc_mcu7t5v0__aoi21_1
Xsignal_processor_x_inst__182_ signal_processor_x_inst__239_/Q signal_processor_x_inst__183_/A1
+ signal_processor_x_inst__182_/Z VDD VDD VSS VSS gf180mcu_fd_sc_mcu7t5v0__xor2_1
XFILLER_126_1165 VDD VDD VSS VSS gf180mcu_fd_sc_mcu7t5v0__fillcap_4
XFILLER_156_807 VDD VDD VSS VSS gf180mcu_fd_sc_mcu7t5v0__fillcap_64
XFILLER_22_172 VDD VDD VSS VSS gf180mcu_fd_sc_mcu7t5v0__fill_2
XFILLER_52_79 VDD VDD VSS VSS gf180mcu_fd_sc_mcu7t5v0__fill_2
Xwave_controller_x_inst__2389_ wave_controller_x_inst__2389_/A1 wave_controller_x_inst__2389_/A2
+ wave_controller_x_inst__2388_/B wave_controller_x_inst__2389_/Z VDD VDD VSS VSS
+ gf180mcu_fd_sc_mcu7t5v0__and3_1
XFILLER_155_339 VDD VDD VSS VSS gf180mcu_fd_sc_mcu7t5v0__fillcap_8
XFILLER_148_391 VDD VDD VSS VSS gf180mcu_fd_sc_mcu7t5v0__fill_2
XFILLER_108_244 VDD VDD VSS VSS gf180mcu_fd_sc_mcu7t5v0__fill_1
XFILLER_108_255 VDD VDD VSS VSS gf180mcu_fd_sc_mcu7t5v0__fill_2
XFILLER_109_778 VDD VDD VSS VSS gf180mcu_fd_sc_mcu7t5v0__fill_1
XFILLER_151_512 VDD VDD VSS VSS gf180mcu_fd_sc_mcu7t5v0__fill_2
XTAP_TAPCELL_ROW_79_1183 VDD VSS gf180mcu_fd_sc_mcu7t5v0__filltie
Xwave_controller_y_inst__3026_ wave_controller_y_inst__3695_/Q wave_controller_y_inst__3696_/Q
+ wave_controller_y_inst__3026_/A3 wave_controller_y_inst__3032_/A3 VDD VDD VSS VSS
+ gf180mcu_fd_sc_mcu7t5v0__nand3_1
XFILLER_124_737 VDD VDD VSS VSS gf180mcu_fd_sc_mcu7t5v0__fillcap_16
XFILLER_136_597 VDD VDD VSS VSS gf180mcu_fd_sc_mcu7t5v0__fillcap_8
XFILLER_2_522 VDD VDD VSS VSS gf180mcu_fd_sc_mcu7t5v0__fill_2
XPHY_EDGE_ROW_107_Left_274 VDD VSS gf180mcu_fd_sc_mcu7t5v0__endcap
XFILLER_123_247 VDD VDD VSS VSS gf180mcu_fd_sc_mcu7t5v0__fillcap_8
XFILLER_78_802 VDD VDD VSS VSS gf180mcu_fd_sc_mcu7t5v0__fill_2
XFILLER_7_2 VDD VDD VSS VSS gf180mcu_fd_sc_mcu7t5v0__fillcap_64
XFILLER_132_781 VDD VDD VSS VSS gf180mcu_fd_sc_mcu7t5v0__fill_1
XFILLER_81_1046 VDD VDD VSS VSS gf180mcu_fd_sc_mcu7t5v0__fillcap_4
XTAP_TAPCELL_ROW_92_1394 VDD VSS gf180mcu_fd_sc_mcu7t5v0__filltie
XFILLER_77_334 VDD VDD VSS VSS gf180mcu_fd_sc_mcu7t5v0__fill_2
Xspi_regs_inst__0850_ spi_regs_inst__1589_/Q spi_regs_inst__1444_/I1 spi_regs_inst__0851_/S
+ spi_regs_inst__1589_/D VDD VDD VSS VSS gf180mcu_fd_sc_mcu7t5v0__mux2_2
XFILLER_61_702 VDD VDD VSS VSS gf180mcu_fd_sc_mcu7t5v0__fillcap_4
XPHY_EDGE_ROW_116_Left_283 VDD VSS gf180mcu_fd_sc_mcu7t5v0__endcap
Xspi_regs_inst__0781_ spi_regs_inst__0827_/A1 spi_regs_inst__0827_/A2 spi_regs_inst__0827_/A3
+ spi_regs_inst__0818_/A2 VDD VDD VSS VSS gf180mcu_fd_sc_mcu7t5v0__nor3_1
XFILLER_60_212 VDD VDD VSS VSS gf180mcu_fd_sc_mcu7t5v0__fillcap_32
XTAP_TAPCELL_ROW_56_793 VDD VSS gf180mcu_fd_sc_mcu7t5v0__filltie
XFILLER_159_601 VDD VDD VSS VSS gf180mcu_fd_sc_mcu7t5v0__fill_2
Xspi_regs_inst__1402_ fanout523/Z spi_regs_inst__1444_/I1 spi_regs_inst__1402_/S spi_regs_inst__1476_/D
+ VDD VDD VSS VSS gf180mcu_fd_sc_mcu7t5v0__mux2_2
XFILLER_13_194 VDD VDD VSS VSS gf180mcu_fd_sc_mcu7t5v0__fillcap_4
XFILLER_41_492 VDD VDD VSS VSS gf180mcu_fd_sc_mcu7t5v0__fillcap_8
XTAP_TAPCELL_ROW_99_1515 VDD VSS gf180mcu_fd_sc_mcu7t5v0__filltie
XTAP_TAPCELL_ROW_99_1504 VDD VSS gf180mcu_fd_sc_mcu7t5v0__filltie
XFILLER_146_317 VDD VDD VSS VSS gf180mcu_fd_sc_mcu7t5v0__fillcap_16
XFILLER_158_177 VDD VDD VSS VSS gf180mcu_fd_sc_mcu7t5v0__fillcap_32
Xspi_regs_inst__1333_ spi_regs_inst__1333_/A1 spi_regs_inst__1333_/A2 spi_regs_inst__1333_/B1
+ spi_regs_inst__1333_/B2 spi_regs_inst__1360_/A1 VDD VDD VSS VSS gf180mcu_fd_sc_mcu7t5v0__aoi22_1
Xspi_regs_inst__1264_ spi_regs_inst__1264_/A1 spi_regs_inst__1264_/A2 spi_regs_inst__1264_/A3
+ spi_regs_inst__1264_/A4 spi_regs_inst__1265_/B2 VDD VDD VSS VSS gf180mcu_fd_sc_mcu7t5v0__nor4_1
XPHY_EDGE_ROW_125_Left_292 VDD VSS gf180mcu_fd_sc_mcu7t5v0__endcap
Xspi_regs_inst__1195_ spi_regs_inst__1497_/Q spi_regs_inst__1195_/A2 spi_regs_inst__1195_/B1
+ spi_regs_inst__1502_/Q spi_regs_inst__1196_/A3 VDD VDD VSS VSS gf180mcu_fd_sc_mcu7t5v0__aoi22_1
XFILLER_114_247 VDD VDD VSS VSS gf180mcu_fd_sc_mcu7t5v0__fillcap_4
XFILLER_68_312 VDD VDD VSS VSS gf180mcu_fd_sc_mcu7t5v0__fill_2
Xsignal_processor_y_inst__214_ spi_regs_inst__1093_/B2 signal_processor_y_inst__214_/A2
+ signal_processor_y_inst__215_/B VDD VDD VSS VSS gf180mcu_fd_sc_mcu7t5v0__nand2_1
Xsignal_processor_y_inst__145_ signal_processor_y_inst__215_/A1 signal_processor_y_inst__177_/A1
+ signal_processor_y_inst__145_/B signal_processor_y_inst__227_/D VDD VDD VSS VSS
+ gf180mcu_fd_sc_mcu7t5v0__oai21_1
XFILLER_110_453 VDD VDD VSS VSS gf180mcu_fd_sc_mcu7t5v0__fill_2
XFILLER_110_475 VDD VDD VSS VSS gf180mcu_fd_sc_mcu7t5v0__fill_2
XFILLER_95_142 VDD VDD VSS VSS gf180mcu_fd_sc_mcu7t5v0__fillcap_16
XTAP_TAPCELL_ROW_143_2236 VDD VSS gf180mcu_fd_sc_mcu7t5v0__filltie
XTAP_TAPCELL_ROW_51_1_717 VDD VSS gf180mcu_fd_sc_mcu7t5v0__filltie
XFILLER_64_540 VDD VDD VSS VSS gf180mcu_fd_sc_mcu7t5v0__fill_2
XFILLER_64_562 VDD VDD VSS VSS gf180mcu_fd_sc_mcu7t5v0__fillcap_16
XTAP_TAPCELL_ROW_108_1655 VDD VSS gf180mcu_fd_sc_mcu7t5v0__filltie
XTAP_TAPCELL_ROW_108_1666 VDD VSS gf180mcu_fd_sc_mcu7t5v0__filltie
Xwave_controller_x_inst__3430_ wave_controller_x_inst__3430_/A1 wave_controller_x_inst_wire84/I
+ wave_controller_x_inst__3494_/A2 wave_controller_x_inst__3430_/B2 wave_controller_x_inst__3489_/C
+ wave_controller_x_inst__3431_/B VDD VDD VSS VSS gf180mcu_fd_sc_mcu7t5v0__aoi221_1
Xspi_regs_inst__0979_ spi_regs_inst__1032_/A1 spi_regs_inst__1028_/A2 spi_regs_inst__1251_/A2
+ VDD VDD VSS VSS gf180mcu_fd_sc_mcu7t5v0__nor2_1
X_88_ _88_/I _88_/Z VDD VDD VSS VSS gf180mcu_fd_sc_mcu7t5v0__buf_1
XFILLER_149_1154 VDD VDD VSS VSS gf180mcu_fd_sc_mcu7t5v0__fillcap_16
XFILLER_51_212 VDD VDD VSS VSS gf180mcu_fd_sc_mcu7t5v0__fillcap_16
XFILLER_64_584 VDD VDD VSS VSS gf180mcu_fd_sc_mcu7t5v0__fillcap_4
XFILLER_51_245 VDD VDD VSS VSS gf180mcu_fd_sc_mcu7t5v0__fillcap_32
Xwave_controller_x_inst__3361_ wave_controller_x_inst__3306_/Z wave_controller_x_inst__3310_/B
+ wave_controller_x_inst__3361_/Z VDD VDD VSS VSS gf180mcu_fd_sc_mcu7t5v0__xor2_1
XTAP_TAPCELL_ROW_121_1866 VDD VSS gf180mcu_fd_sc_mcu7t5v0__filltie
XTAP_TAPCELL_ROW_121_1877 VDD VSS gf180mcu_fd_sc_mcu7t5v0__filltie
Xwave_controller_x_inst__3292_ wave_controller_x_inst__3371_/A1 wave_controller_x_inst__3375_/A2
+ wave_controller_x_inst__3292_/B wave_controller_x_inst__3384_/A2 VDD VDD VSS VSS
+ gf180mcu_fd_sc_mcu7t5v0__aoi21_1
Xwave_controller_x_inst__2312_ wave_controller_x_inst__2313_/C wave_controller_x_inst__2313_/B
+ wave_controller_x_inst__2345_/A1 VDD VDD VSS VSS gf180mcu_fd_sc_mcu7t5v0__nor2_1
XFILLER_138_807 VDD VDD VSS VSS gf180mcu_fd_sc_mcu7t5v0__fill_1
XFILLER_149_133 VDD VDD VSS VSS gf180mcu_fd_sc_mcu7t5v0__fillcap_4
Xwave_controller_x_inst__2243_ wave_controller_x_inst__2521_/A1 wave_controller_x_inst__2242_/Z
+ wave_controller_x_inst__2265_/A2 VDD VDD VSS VSS gf180mcu_fd_sc_mcu7t5v0__nor2_1
XFILLER_137_328 VDD VDD VSS VSS gf180mcu_fd_sc_mcu7t5v0__fill_2
XFILLER_149_166 VDD VDD VSS VSS gf180mcu_fd_sc_mcu7t5v0__fill_1
XTAP_TAPCELL_ROW_158_2490 VDD VSS gf180mcu_fd_sc_mcu7t5v0__filltie
XTAP_TAPCELL_ROW_7_1_386 VDD VSS gf180mcu_fd_sc_mcu7t5v0__filltie
Xwave_controller_y_inst__2190_ wave_controller_y_inst__2201_/A1 wave_controller_y_inst__2201_/A2
+ wave_controller_y_inst__2202_/A2 VDD VDD VSS VSS gf180mcu_fd_sc_mcu7t5v0__nand2_1
Xwave_controller_x_inst__2174_ wave_controller_x_inst__2757_/B wave_controller_x_inst__2173_/Z
+ wave_controller_x_inst__2187_/B VDD VDD VSS VSS gf180mcu_fd_sc_mcu7t5v0__nor2_1
XFILLER_69_1122 VDD VDD VSS VSS gf180mcu_fd_sc_mcu7t5v0__fillcap_32
XFILLER_118_597 VDD VDD VSS VSS gf180mcu_fd_sc_mcu7t5v0__fillcap_4
XFILLER_133_523 VDD VDD VSS VSS gf180mcu_fd_sc_mcu7t5v0__fillcap_16
XFILLER_121_718 VDD VDD VSS VSS gf180mcu_fd_sc_mcu7t5v0__fillcap_8
XFILLER_154_37 VDD VDD VSS VSS gf180mcu_fd_sc_mcu7t5v0__fillcap_8
XFILLER_59_312 VDD VDD VSS VSS gf180mcu_fd_sc_mcu7t5v0__fill_2
XTAP_TAPCELL_ROW_74_1091 VDD VSS gf180mcu_fd_sc_mcu7t5v0__filltie
XFILLER_101_431 VDD VDD VSS VSS gf180mcu_fd_sc_mcu7t5v0__fillcap_4
XFILLER_87_632 VDD VDD VSS VSS gf180mcu_fd_sc_mcu7t5v0__fillcap_16
XFILLER_99_492 VDD VDD VSS VSS gf180mcu_fd_sc_mcu7t5v0__fillcap_8
Xsignal_processor_x_inst_fanout200 signal_processor_x_inst__210_/A2 signal_processor_x_inst__214_/A2
+ VDD VDD VSS VSS gf180mcu_fd_sc_mcu7t5v0__dlyb_1
XFILLER_47_24 VDD VDD VSS VSS gf180mcu_fd_sc_mcu7t5v0__fillcap_8
XFILLER_47_529 VDD VDD VSS VSS gf180mcu_fd_sc_mcu7t5v0__fill_2
XFILLER_59_367 VDD VDD VSS VSS gf180mcu_fd_sc_mcu7t5v0__fillcap_16
XTAP_TAPCELL_ROW_37_1_607 VDD VSS gf180mcu_fd_sc_mcu7t5v0__filltie
Xwave_controller_y_inst__1974_ wave_controller_y_inst__1981_/C wave_controller_y_inst__1973_/Z
+ spi_regs_inst__1306_/B2 VDD VDD VSS VSS gf180mcu_fd_sc_mcu7t5v0__nor2_1
Xwave_controller_x_inst__1958_ fanout528/Z wave_controller_x_inst__2223_/A1 wave_controller_x_inst__1967_/A1
+ VDD VDD VSS VSS gf180mcu_fd_sc_mcu7t5v0__nor2_1
Xwave_controller_y_inst__3713_ wave_controller_y_inst__3713_/D wave_controller_y_inst__3721_/RN
+ clkload14/I wave_controller_y_inst__3713_/Q VDD VDD VSS VSS gf180mcu_fd_sc_mcu7t5v0__dffrnq_1
Xwave_controller_y_inst_max_cap155 wave_controller_y_inst_wire156/Z wave_controller_y_inst__2090_/A1
+ VDD VDD VSS VSS gf180mcu_fd_sc_mcu7t5v0__clkbuf_1
Xwave_controller_y_inst__3644_ wave_controller_y_inst__3644_/D wave_controller_y_inst__3648_/RN
+ clkload15/I max_cap430/I VDD VDD VSS VSS gf180mcu_fd_sc_mcu7t5v0__dffrnq_1
Xwave_controller_x_inst__1889_ spi_regs_inst__1245_/B2 wave_controller_x_inst__3557_/B2
+ VDD VDD VSS VSS gf180mcu_fd_sc_mcu7t5v0__clkinv_1
XFILLER_103_52 VDD VDD VSS VSS gf180mcu_fd_sc_mcu7t5v0__fillcap_4
XFILLER_27_286 VDD VDD VSS VSS gf180mcu_fd_sc_mcu7t5v0__fill_1
Xwave_controller_x_inst__3628_ wave_controller_x_inst__3628_/D wave_controller_x_inst__3701_/RN
+ clkload31/I spi_regs_inst__1064_/B2 VDD VDD VSS VSS gf180mcu_fd_sc_mcu7t5v0__dffrnq_1
XFILLER_63_67 VDD VDD VSS VSS gf180mcu_fd_sc_mcu7t5v0__fill_2
XTAP_TAPCELL_ROW_53_730 VDD VSS gf180mcu_fd_sc_mcu7t5v0__filltie
XTAP_TAPCELL_ROW_53_741 VDD VSS gf180mcu_fd_sc_mcu7t5v0__filltie
Xwave_controller_y_inst__3575_ wave_controller_y_inst_wire48/Z wave_controller_y_inst__3604_/A2
+ wave_controller_y_inst__3575_/B wave_controller_y_inst__3657_/D VDD VDD VSS VSS
+ gf180mcu_fd_sc_mcu7t5v0__oai21_1
Xwave_controller_x_inst__3559_ wave_controller_x_inst__3594_/I0 spi_regs_inst__1064_/A1
+ wave_controller_x_inst__3569_/S wave_controller_x_inst__3649_/D VDD VDD VSS VSS
+ gf180mcu_fd_sc_mcu7t5v0__mux2_2
XFILLER_144_2 VDD VDD VSS VSS gf180mcu_fd_sc_mcu7t5v0__fillcap_4
XTAP_TAPCELL_ROW_53_752 VDD VSS gf180mcu_fd_sc_mcu7t5v0__filltie
Xwave_controller_y_inst__2526_ wave_controller_y_inst__2543_/A1 wave_controller_y_inst__2543_/A2
+ wave_controller_y_inst__2543_/C wave_controller_y_inst__2527_/A3 VDD VDD VSS VSS
+ gf180mcu_fd_sc_mcu7t5v0__oai21_1
Xsignal_processor_x_inst__234_ signal_processor_x_inst__234_/D signal_processor_x_inst__242_/RN
+ clkload23/I signal_processor_x_inst__234_/Q VDD VDD VSS VSS gf180mcu_fd_sc_mcu7t5v0__dffrnq_1
Xwave_controller_y_inst__2457_ spi_regs_inst__1063_/B2 wave_controller_y_inst__2462_/A2
+ wave_controller_y_inst__2458_/B VDD VDD VSS VSS gf180mcu_fd_sc_mcu7t5v0__nand2_1
Xsignal_processor_x_inst__165_ signal_processor_x_inst__233_/Q signal_processor_x_inst__166_/A2
+ signal_processor_x_inst__169_/A2 VDD VDD VSS VSS gf180mcu_fd_sc_mcu7t5v0__nand2_1
XFILLER_156_637 VDD VDD VSS VSS gf180mcu_fd_sc_mcu7t5v0__fillcap_8
Xwave_controller_y_inst__2388_ wave_controller_y_inst__2389_/A1 wave_controller_y_inst__2389_/A2
+ wave_controller_y_inst__2388_/B wave_controller_y_inst__2396_/C VDD VDD VSS VSS
+ gf180mcu_fd_sc_mcu7t5v0__aoi21_1
XFILLER_155_158 VDD VDD VSS VSS gf180mcu_fd_sc_mcu7t5v0__fillcap_4
XTAP_TAPCELL_ROW_94_1423 VDD VSS gf180mcu_fd_sc_mcu7t5v0__filltie
XFILLER_100_1157 VDD VDD VSS VSS gf180mcu_fd_sc_mcu7t5v0__fillcap_8
XTAP_TAPCELL_ROW_94_1434 VDD VSS gf180mcu_fd_sc_mcu7t5v0__filltie
XFILLER_88_53 VDD VDD VSS VSS gf180mcu_fd_sc_mcu7t5v0__fill_2
Xwave_controller_y_inst__3009_ wave_controller_y_inst__3420_/A1 wave_controller_y_inst_wire25/Z
+ wave_controller_y_inst__3012_/A1 VDD VDD VSS VSS gf180mcu_fd_sc_mcu7t5v0__nand2_1
XFILLER_151_397 VDD VDD VSS VSS gf180mcu_fd_sc_mcu7t5v0__fillcap_16
Xspi_regs_inst__0902_ spi_regs_inst__1641_/Q spi_regs_inst__1627_/Q spi_regs_inst__0928_/B
+ spi_regs_inst__1627_/D VDD VDD VSS VSS gf180mcu_fd_sc_mcu7t5v0__mux2_2
X_11_ _19_/Q _18_/A2 _20_/Q _14_/A1 VDD VDD VSS VSS gf180mcu_fd_sc_mcu7t5v0__aoi21_1
XFILLER_65_348 VDD VDD VSS VSS gf180mcu_fd_sc_mcu7t5v0__fill_2
XFILLER_92_123 VDD VDD VSS VSS gf180mcu_fd_sc_mcu7t5v0__fillcap_4
XFILLER_93_646 VDD VDD VSS VSS gf180mcu_fd_sc_mcu7t5v0__fill_1
XFILLER_81_808 VDD VDD VSS VSS gf180mcu_fd_sc_mcu7t5v0__fillcap_16
Xspi_regs_inst__0833_ spi_regs_inst__1575_/Q spi_regs_inst__1410_/I1 spi_regs_inst__0835_/S
+ spi_regs_inst__1575_/D VDD VDD VSS VSS gf180mcu_fd_sc_mcu7t5v0__mux2_2
XFILLER_33_212 VDD VDD VSS VSS gf180mcu_fd_sc_mcu7t5v0__fill_1
XFILLER_74_893 VDD VDD VSS VSS gf180mcu_fd_sc_mcu7t5v0__fillcap_8
Xspi_regs_inst__0764_ spi_regs_inst__1524_/Q spi_regs_inst__1391_/I1 spi_regs_inst__0766_/S
+ spi_regs_inst__1524_/D VDD VDD VSS VSS gf180mcu_fd_sc_mcu7t5v0__mux2_2
XFILLER_21_418 VDD VDD VSS VSS gf180mcu_fd_sc_mcu7t5v0__fill_2
XPHY_EDGE_ROW_56_Right_56 VDD VSS gf180mcu_fd_sc_mcu7t5v0__endcap
XTAP_TAPCELL_ROW_103_1574 VDD VSS gf180mcu_fd_sc_mcu7t5v0__filltie
XFILLER_105_1046 VDD VDD VSS VSS gf180mcu_fd_sc_mcu7t5v0__fillcap_4
XPHY_EDGE_ROW_133_Left_300 VDD VSS gf180mcu_fd_sc_mcu7t5v0__endcap
Xspi_regs_inst__1316_ spi_regs_inst__1316_/A1 spi_regs_inst__1316_/A2 spi_regs_inst__1316_/B1
+ spi_regs_inst__1547_/Q spi_regs_inst__1319_/A2 VDD VDD VSS VSS gf180mcu_fd_sc_mcu7t5v0__aoi22_1
XFILLER_128_862 VDD VDD VSS VSS gf180mcu_fd_sc_mcu7t5v0__fill_1
XFILLER_143_810 VDD VDD VSS VSS gf180mcu_fd_sc_mcu7t5v0__fillcap_8
XFILLER_143_832 VDD VDD VSS VSS gf180mcu_fd_sc_mcu7t5v0__fill_2
Xspi_regs_inst_wire104 spi_regs_inst_wire105/Z spi_regs_inst_wire104/Z VDD VDD VSS
+ VSS gf180mcu_fd_sc_mcu7t5v0__buf_2
Xspi_regs_inst__1247_ spi_regs_inst__1247_/A1 spi_regs_inst__1316_/A2 spi_regs_inst__1247_/B1
+ spi_regs_inst__1247_/B2 spi_regs_inst__1248_/A4 VDD VDD VSS VSS gf180mcu_fd_sc_mcu7t5v0__aoi22_1
Xspi_regs_inst_wire148 spi_regs_inst_wire148/I spi_regs_inst_wire148/Z VDD VDD VSS
+ VSS gf180mcu_fd_sc_mcu7t5v0__buf_2
Xspi_regs_inst__1178_ spi_regs_inst__1178_/A1 spi_regs_inst__1178_/A2 spi_regs_inst__1345_/B1
+ spi_regs_inst__1178_/B2 spi_regs_inst__1209_/A1 VDD VDD VSS VSS gf180mcu_fd_sc_mcu7t5v0__aoi22_1
XFILLER_69_621 VDD VDD VSS VSS gf180mcu_fd_sc_mcu7t5v0__fill_1
XPHY_EDGE_ROW_65_Right_65 VDD VSS gf180mcu_fd_sc_mcu7t5v0__endcap
Xwave_controller_x_inst__2930_ wave_controller_x_inst__2124_/B fanout399/Z wave_controller_x_inst__3593_/A1
+ VDD VDD VSS VSS gf180mcu_fd_sc_mcu7t5v0__nand2_1
XFILLER_142_397 VDD VDD VSS VSS gf180mcu_fd_sc_mcu7t5v0__fillcap_16
XFILLER_69_632 VDD VDD VSS VSS gf180mcu_fd_sc_mcu7t5v0__fillcap_16
Xwave_controller_x_inst__2861_ wave_controller_x_inst__3430_/A1 spi_regs_inst__1094_/A1
+ wave_controller_x_inst__2861_/Z VDD VDD VSS VSS gf180mcu_fd_sc_mcu7t5v0__xor2_1
XFILLER_84_613 VDD VDD VSS VSS gf180mcu_fd_sc_mcu7t5v0__fill_1
XFILLER_97_974 VDD VDD VSS VSS gf180mcu_fd_sc_mcu7t5v0__fillcap_4
Xwave_controller_x_inst__2792_ wave_controller_x_inst__3568_/A1 wave_controller_x_inst__2791_/Z
+ wave_controller_x_inst__2809_/A1 VDD VDD VSS VSS gf180mcu_fd_sc_mcu7t5v0__nand2_1
Xwave_controller_x_inst__1812_ spi_regs_inst__1549_/Q wave_controller_x_inst__3304_/B
+ VDD VDD VSS VSS gf180mcu_fd_sc_mcu7t5v0__clkinv_1
XFILLER_111_784 VDD VDD VSS VSS gf180mcu_fd_sc_mcu7t5v0__fill_2
XFILLER_112_1017 VDD VDD VSS VSS gf180mcu_fd_sc_mcu7t5v0__fillcap_64
XFILLER_56_337 VDD VDD VSS VSS gf180mcu_fd_sc_mcu7t5v0__fill_1
XFILLER_57_838 VDD VDD VSS VSS gf180mcu_fd_sc_mcu7t5v0__fill_2
Xsignal_processor_y_inst__128_ fanout389/Z signal_processor_y_inst__256_/Q signal_processor_y_inst__244_/D
+ VDD VDD VSS VSS gf180mcu_fd_sc_mcu7t5v0__and2_1
XFILLER_83_156 VDD VDD VSS VSS gf180mcu_fd_sc_mcu7t5v0__fillcap_4
XFILLER_140_39 VDD VDD VSS VSS gf180mcu_fd_sc_mcu7t5v0__fill_1
XFILLER_65_882 VDD VDD VSS VSS gf180mcu_fd_sc_mcu7t5v0__fillcap_16
XFILLER_83_189 VDD VDD VSS VSS gf180mcu_fd_sc_mcu7t5v0__fill_1
XTAP_TAPCELL_ROW_123_1906 VDD VSS gf180mcu_fd_sc_mcu7t5v0__filltie
XFILLER_52_554 VDD VDD VSS VSS gf180mcu_fd_sc_mcu7t5v0__fill_1
XFILLER_64_381 VDD VDD VSS VSS gf180mcu_fd_sc_mcu7t5v0__fillcap_4
XFILLER_92_690 VDD VDD VSS VSS gf180mcu_fd_sc_mcu7t5v0__fill_1
Xwave_controller_x_inst_max_cap129 wave_controller_x_inst__3367_/A2 wave_controller_x_inst__3296_/B2
+ VDD VDD VSS VSS gf180mcu_fd_sc_mcu7t5v0__clkbuf_1
Xwave_controller_x_inst__3413_ spi_regs_inst__1050_/B2 wave_controller_x_inst__3454_/A2
+ wave_controller_x_inst__3414_/A3 VDD VDD VSS VSS gf180mcu_fd_sc_mcu7t5v0__nor2_1
XFILLER_75_1170 VDD VDD VSS VSS gf180mcu_fd_sc_mcu7t5v0__fillcap_4
XFILLER_80_874 VDD VDD VSS VSS gf180mcu_fd_sc_mcu7t5v0__fill_1
XPHY_EDGE_ROW_166_Right_166 VDD VSS gf180mcu_fd_sc_mcu7t5v0__endcap
XPHY_EDGE_ROW_74_Right_74 VDD VSS gf180mcu_fd_sc_mcu7t5v0__endcap
Xwave_controller_y_inst__3360_ wave_controller_y_inst__3360_/A1 wave_controller_y_inst__3310_/C
+ wave_controller_y_inst__3360_/Z VDD VDD VSS VSS gf180mcu_fd_sc_mcu7t5v0__xor2_1
Xwave_controller_x_inst__3344_ wave_controller_x_inst__3344_/A1 wave_controller_x_inst__3344_/A2
+ wave_controller_x_inst__3343_/Z wave_controller_x_inst__3403_/A1 VDD VDD VSS VSS
+ gf180mcu_fd_sc_mcu7t5v0__nand3_1
XFILLER_162_1151 VDD VDD VSS VSS gf180mcu_fd_sc_mcu7t5v0__fillcap_4
XFILLER_33_26 VDD VDD VSS VSS gf180mcu_fd_sc_mcu7t5v0__fillcap_4
Xwave_controller_y_inst__3291_ wave_controller_y_inst__3291_/I wave_controller_y_inst__3292_/B
+ VDD VDD VSS VSS gf180mcu_fd_sc_mcu7t5v0__clkinv_1
Xwave_controller_y_inst__2311_ wave_controller_y_inst__2311_/A1 wave_controller_y_inst__2294_/Z
+ wave_controller_y_inst__2313_/B VDD VDD VSS VSS gf180mcu_fd_sc_mcu7t5v0__nor2_1
XFILLER_130_8 VDD VDD VSS VSS gf180mcu_fd_sc_mcu7t5v0__fill_1
XFILLER_162_1173 VDD VDD VSS VSS gf180mcu_fd_sc_mcu7t5v0__fill_1
XFILLER_20_451 VDD VDD VSS VSS gf180mcu_fd_sc_mcu7t5v0__fillcap_4
XTAP_TAPCELL_ROW_156_2449 VDD VSS gf180mcu_fd_sc_mcu7t5v0__filltie
Xwave_controller_y_inst__2242_ fanout505/Z wave_controller_y_inst__2242_/A2 wave_controller_y_inst__2242_/A3
+ wave_controller_y_inst__2242_/Z VDD VDD VSS VSS gf180mcu_fd_sc_mcu7t5v0__xor3_1
Xwave_controller_x_inst__3275_ wave_controller_x_inst__3564_/A1 spi_regs_inst__1544_/Q
+ wave_controller_x_inst__3371_/A1 VDD VDD VSS VSS gf180mcu_fd_sc_mcu7t5v0__nand2_1
Xwave_controller_x_inst__2226_ wave_controller_x_inst__2226_/A1 wave_controller_x_inst__2521_/A1
+ wave_controller_x_inst__2239_/A2 wave_controller_x_inst__2226_/Z VDD VDD VSS VSS
+ gf180mcu_fd_sc_mcu7t5v0__xor3_1
XFILLER_119_873 VDD VDD VSS VSS gf180mcu_fd_sc_mcu7t5v0__fill_2
Xwave_controller_y_inst__2173_ wave_controller_y_inst__2451_/A1 wave_controller_y_inst__2173_/A2
+ wave_controller_y_inst__2173_/Z VDD VDD VSS VSS gf180mcu_fd_sc_mcu7t5v0__xor2_1
Xwave_controller_x_inst__2157_ wave_controller_x_inst__2451_/A1 spi_regs_inst__1112_/A1
+ wave_controller_x_inst__2157_/Z VDD VDD VSS VSS gf180mcu_fd_sc_mcu7t5v0__and2_1
XFILLER_106_523 VDD VDD VSS VSS gf180mcu_fd_sc_mcu7t5v0__fill_2
XFILLER_118_383 VDD VDD VSS VSS gf180mcu_fd_sc_mcu7t5v0__fill_2
XTAP_TAPCELL_ROW_76_1131 VDD VSS gf180mcu_fd_sc_mcu7t5v0__filltie
XFILLER_134_854 VDD VDD VSS VSS gf180mcu_fd_sc_mcu7t5v0__fillcap_8
XPHY_EDGE_ROW_83_Right_83 VDD VSS gf180mcu_fd_sc_mcu7t5v0__endcap
Xwave_controller_x_inst__2088_ wave_controller_x_inst__2755_/A1 wave_controller_x_inst__2086_/Z
+ wave_controller_x_inst__3727_/D VDD VDD VSS VSS gf180mcu_fd_sc_mcu7t5v0__xor2_1
XFILLER_133_364 VDD VDD VSS VSS gf180mcu_fd_sc_mcu7t5v0__fill_1
XFILLER_133_386 VDD VDD VSS VSS gf180mcu_fd_sc_mcu7t5v0__fillcap_8
XFILLER_121_559 VDD VDD VSS VSS gf180mcu_fd_sc_mcu7t5v0__fill_1
XFILLER_59_120 VDD VDD VSS VSS gf180mcu_fd_sc_mcu7t5v0__fillcap_4
Xwave_controller_x_inst_fanout624 wave_controller_x_inst__3704_/RN wave_controller_x_inst__3707_/RN
+ VDD VDD VSS VSS gf180mcu_fd_sc_mcu7t5v0__dlyb_1
Xwave_controller_x_inst_fanout602 wave_controller_x_inst__3716_/RN wave_controller_x_inst__3690_/RN
+ VDD VDD VSS VSS gf180mcu_fd_sc_mcu7t5v0__dlyb_1
XFILLER_58_89 VDD VDD VSS VSS gf180mcu_fd_sc_mcu7t5v0__fillcap_8
XFILLER_59_142 VDD VDD VSS VSS gf180mcu_fd_sc_mcu7t5v0__fillcap_8
XFILLER_87_440 VDD VDD VSS VSS gf180mcu_fd_sc_mcu7t5v0__fillcap_4
XFILLER_74_101 VDD VDD VSS VSS gf180mcu_fd_sc_mcu7t5v0__fillcap_4
XFILLER_75_624 VDD VDD VSS VSS gf180mcu_fd_sc_mcu7t5v0__fill_2
XFILLER_75_646 VDD VDD VSS VSS gf180mcu_fd_sc_mcu7t5v0__fill_1
XTAP_TAPCELL_ROW_58_833 VDD VSS gf180mcu_fd_sc_mcu7t5v0__filltie
Xwave_controller_y_inst__1957_ wave_controller_y_inst__1956_/B wave_controller_y_inst__1957_/A2
+ spi_regs_inst__1178_/B2 VDD VDD VSS VSS gf180mcu_fd_sc_mcu7t5v0__xnor2_1
XFILLER_56_860 VDD VDD VSS VSS gf180mcu_fd_sc_mcu7t5v0__fillcap_8
XFILLER_75_679 VDD VDD VSS VSS gf180mcu_fd_sc_mcu7t5v0__fill_1
Xwave_controller_y_inst__1888_ spi_regs_inst__1194_/B2 wave_controller_y_inst__3554_/B2
+ VDD VDD VSS VSS gf180mcu_fd_sc_mcu7t5v0__clkinv_1
XFILLER_15_223 VDD VDD VSS VSS gf180mcu_fd_sc_mcu7t5v0__fillcap_32
XPHY_EDGE_ROW_92_Right_92 VDD VSS gf180mcu_fd_sc_mcu7t5v0__endcap
Xwave_controller_y_inst__3627_ wave_controller_y_inst__3627_/D wave_controller_y_inst__3699_/RN
+ clkbuf_leaf_46_clk/Z spi_regs_inst__1334_/A1 VDD VDD VSS VSS gf180mcu_fd_sc_mcu7t5v0__dffrnq_1
XFILLER_167_1073 VDD VDD VSS VSS gf180mcu_fd_sc_mcu7t5v0__fillcap_8
XFILLER_30_204 VDD VDD VSS VSS gf180mcu_fd_sc_mcu7t5v0__fillcap_4
XFILLER_71_863 VDD VDD VSS VSS gf180mcu_fd_sc_mcu7t5v0__fill_1
XFILLER_71_896 VDD VDD VSS VSS gf180mcu_fd_sc_mcu7t5v0__fillcap_4
XFILLER_90_10 VDD VDD VSS VSS gf180mcu_fd_sc_mcu7t5v0__fill_2
XPHY_EDGE_ROW_133_Right_133 VDD VSS gf180mcu_fd_sc_mcu7t5v0__endcap
Xwave_controller_y_inst__3558_ wave_controller_y_inst__2797_/C wave_controller_y_inst_wire323/I
+ wave_controller_y_inst__3594_/I0 VDD VDD VSS VSS gf180mcu_fd_sc_mcu7t5v0__nor2_1
Xwave_controller_y_inst__2509_ wave_controller_y_inst__2481_/I wave_controller_y_inst__2509_/A2
+ wave_controller_y_inst__2509_/A3 wave_controller_y_inst__2509_/B wave_controller_y_inst__2510_/A3
+ VDD VDD VSS VSS gf180mcu_fd_sc_mcu7t5v0__oai31_1
XFILLER_129_626 VDD VDD VSS VSS gf180mcu_fd_sc_mcu7t5v0__fillcap_4
Xwave_controller_y_inst__3489_ wave_controller_y_inst__3489_/A1 wave_controller_y_inst__3489_/A2
+ wave_controller_y_inst__3493_/A2 wave_controller_y_inst__3489_/B2 wave_controller_y_inst__3489_/C
+ wave_controller_y_inst__3490_/B VDD VDD VSS VSS gf180mcu_fd_sc_mcu7t5v0__aoi221_1
Xsignal_processor_x_inst__217_ signal_processor_x_inst__217_/D fanout583/Z clkload10/I
+ _89_/I VDD VDD VSS VSS gf180mcu_fd_sc_mcu7t5v0__dffrnq_1
XFILLER_129_648 VDD VDD VSS VSS gf180mcu_fd_sc_mcu7t5v0__fillcap_8
XFILLER_7_422 VDD VDD VSS VSS gf180mcu_fd_sc_mcu7t5v0__fillcap_16
Xsignal_processor_x_inst__148_ signal_processor_x_inst__215_/A1 signal_processor_x_inst__146_/Z
+ signal_processor_x_inst__148_/B signal_processor_x_inst__228_/D VDD VDD VSS VSS
+ gf180mcu_fd_sc_mcu7t5v0__oai21_1
XFILLER_116_309 VDD VDD VSS VSS gf180mcu_fd_sc_mcu7t5v0__fillcap_4
XTAP_TAPCELL_ROW_50_1_705 VDD VSS gf180mcu_fd_sc_mcu7t5v0__filltie
Xspi_regs_inst__1101_ spi_regs_inst__1101_/A1 spi_regs_inst__1316_/A2 spi_regs_inst__1325_/A2
+ spi_regs_inst__1101_/B2 spi_regs_inst__1104_/A2 VDD VDD VSS VSS gf180mcu_fd_sc_mcu7t5v0__aoi22_1
XFILLER_156_489 VDD VDD VSS VSS gf180mcu_fd_sc_mcu7t5v0__fill_2
XFILLER_87_1052 VDD VDD VSS VSS gf180mcu_fd_sc_mcu7t5v0__fillcap_64
Xspi_regs_inst__1032_ spi_regs_inst__1032_/A1 spi_regs_inst__1032_/A2 spi_regs_inst_wire207/I
+ VDD VDD VSS VSS gf180mcu_fd_sc_mcu7t5v0__nor2_1
XFILLER_112_559 VDD VDD VSS VSS gf180mcu_fd_sc_mcu7t5v0__fill_1
XFILLER_2_171 VDD VDD VSS VSS gf180mcu_fd_sc_mcu7t5v0__fillcap_4
XFILLER_97_248 VDD VDD VSS VSS gf180mcu_fd_sc_mcu7t5v0__fill_1
XFILLER_97_259 VDD VDD VSS VSS gf180mcu_fd_sc_mcu7t5v0__fill_2
XFILLER_94_911 VDD VDD VSS VSS gf180mcu_fd_sc_mcu7t5v0__fill_1
XFILLER_120_581 VDD VDD VSS VSS gf180mcu_fd_sc_mcu7t5v0__fillcap_8
XFILLER_93_410 VDD VDD VSS VSS gf180mcu_fd_sc_mcu7t5v0__fillcap_4
XFILLER_94_944 VDD VDD VSS VSS gf180mcu_fd_sc_mcu7t5v0__fill_1
XTAP_TAPCELL_ROW_6_1_374 VDD VSS gf180mcu_fd_sc_mcu7t5v0__filltie
XFILLER_93_454 VDD VDD VSS VSS gf180mcu_fd_sc_mcu7t5v0__fillcap_4
XFILLER_53_329 VDD VDD VSS VSS gf180mcu_fd_sc_mcu7t5v0__fill_2
XTAP_TAPCELL_ROW_105_1603 VDD VSS gf180mcu_fd_sc_mcu7t5v0__filltie
XTAP_TAPCELL_ROW_105_1614 VDD VSS gf180mcu_fd_sc_mcu7t5v0__filltie
Xspi_regs_inst__0816_ spi_regs_inst__0816_/A1 spi_regs_inst__1651_/Q spi_regs_inst__1437_/A2
+ VDD VDD VSS VSS gf180mcu_fd_sc_mcu7t5v0__nand2_1
XFILLER_34_521 VDD VDD VSS VSS gf180mcu_fd_sc_mcu7t5v0__fillcap_4
XFILLER_34_532 VDD VDD VSS VSS gf180mcu_fd_sc_mcu7t5v0__fillcap_4
XFILLER_59_1154 VDD VDD VSS VSS gf180mcu_fd_sc_mcu7t5v0__fillcap_16
XFILLER_34_554 VDD VDD VSS VSS gf180mcu_fd_sc_mcu7t5v0__fill_1
XFILLER_62_885 VDD VDD VSS VSS gf180mcu_fd_sc_mcu7t5v0__fillcap_4
XFILLER_80_159 VDD VDD VSS VSS gf180mcu_fd_sc_mcu7t5v0__fill_1
Xspi_regs_inst__0747_ spi_regs_inst__1408_/I1 spi_regs_inst__0887_/S spi_regs_inst__1452_/D
+ VDD VDD VSS VSS gf180mcu_fd_sc_mcu7t5v0__and2_1
XFILLER_146_1157 VDD VDD VSS VSS gf180mcu_fd_sc_mcu7t5v0__fillcap_16
XFILLER_62_896 VDD VDD VSS VSS gf180mcu_fd_sc_mcu7t5v0__fillcap_32
XPHY_EDGE_ROW_100_Right_100 VDD VSS gf180mcu_fd_sc_mcu7t5v0__endcap
XFILLER_159_250 VDD VDD VSS VSS gf180mcu_fd_sc_mcu7t5v0__fillcap_4
XFILLER_166_209 VDD VDD VSS VSS gf180mcu_fd_sc_mcu7t5v0__fillcap_4
XFILLER_9_72 VDD VDD VSS VSS gf180mcu_fd_sc_mcu7t5v0__fillcap_16
XTAP_TAPCELL_ROW_138_2146 VDD VSS gf180mcu_fd_sc_mcu7t5v0__filltie
XTAP_TAPCELL_ROW_138_2157 VDD VSS gf180mcu_fd_sc_mcu7t5v0__filltie
XFILLER_159_294 VDD VDD VSS VSS gf180mcu_fd_sc_mcu7t5v0__fillcap_4
Xwave_controller_x_inst__3060_ wave_controller_x_inst__3709_/Q fanout402/Z wave_controller_x_inst__3604_/A2
+ VDD VDD VSS VSS gf180mcu_fd_sc_mcu7t5v0__nand2_1
Xwave_controller_x_inst__2011_ wave_controller_x_inst__2008_/Z wave_controller_x_inst_wire87/Z
+ wave_controller_x_inst__2016_/C wave_controller_x_inst__2013_/A3 VDD VDD VSS VSS
+ gf180mcu_fd_sc_mcu7t5v0__oai21_1
XFILLER_147_489 VDD VDD VSS VSS gf180mcu_fd_sc_mcu7t5v0__fill_1
XPHY_EDGE_ROW_51_1_Left_218 VDD VSS gf180mcu_fd_sc_mcu7t5v0__endcap
XTAP_TAPCELL_ROW_151_2368 VDD VSS gf180mcu_fd_sc_mcu7t5v0__filltie
XTAP_TAPCELL_ROW_44_1_663 VDD VSS gf180mcu_fd_sc_mcu7t5v0__filltie
XFILLER_134_139 VDD VDD VSS VSS gf180mcu_fd_sc_mcu7t5v0__fill_2
XFILLER_89_738 VDD VDD VSS VSS gf180mcu_fd_sc_mcu7t5v0__fill_1
XTAP_TAPCELL_ROW_116_1787 VDD VSS gf180mcu_fd_sc_mcu7t5v0__filltie
XTAP_TAPCELL_ROW_116_1798 VDD VSS gf180mcu_fd_sc_mcu7t5v0__filltie
XFILLER_131_846 VDD VDD VSS VSS gf180mcu_fd_sc_mcu7t5v0__fill_1
XFILLER_142_194 VDD VDD VSS VSS gf180mcu_fd_sc_mcu7t5v0__fill_2
XTAP_TAPCELL_ROW_10_1_408 VDD VSS gf180mcu_fd_sc_mcu7t5v0__filltie
Xwave_controller_x_inst__2913_ spi_regs_inst__1250_/B2 wave_controller_x_inst__2918_/S
+ wave_controller_x_inst__2914_/B VDD VDD VSS VSS gf180mcu_fd_sc_mcu7t5v0__nand2_1
XFILLER_97_760 VDD VDD VSS VSS gf180mcu_fd_sc_mcu7t5v0__fill_1
XTAP_TAPCELL_ROW_71_1050 VDD VSS gf180mcu_fd_sc_mcu7t5v0__filltie
Xwave_controller_y_inst__2860_ wave_controller_y_inst__3693_/Q wave_controller_y_inst__3433_/A1
+ wave_controller_y_inst__2885_/A1 VDD VDD VSS VSS gf180mcu_fd_sc_mcu7t5v0__nand2_1
XFILLER_28_37 VDD VDD VSS VSS gf180mcu_fd_sc_mcu7t5v0__fill_2
Xwave_controller_y_inst__1811_ spi_regs_inst__1608_/Q wave_controller_y_inst__3304_/A2
+ VDD VDD VSS VSS gf180mcu_fd_sc_mcu7t5v0__clkinv_1
Xwave_controller_x_inst__2844_ max_cap451/I wave_controller_x_inst__1902_/I wave_controller_x_inst__2844_/B
+ wave_controller_x_inst__2846_/A2 VDD VDD VSS VSS gf180mcu_fd_sc_mcu7t5v0__oai21_1
XFILLER_29_348 VDD VDD VSS VSS gf180mcu_fd_sc_mcu7t5v0__fill_2
XFILLER_56_134 VDD VDD VSS VSS gf180mcu_fd_sc_mcu7t5v0__fillcap_16
XFILLER_84_454 VDD VDD VSS VSS gf180mcu_fd_sc_mcu7t5v0__fill_1
XFILLER_84_465 VDD VDD VSS VSS gf180mcu_fd_sc_mcu7t5v0__fillcap_4
XFILLER_85_977 VDD VDD VSS VSS gf180mcu_fd_sc_mcu7t5v0__fill_2
Xwave_controller_y_inst__2791_ max_cap427/Z spi_regs_inst__1275_/A1 wave_controller_y_inst__2805_/S
+ wave_controller_y_inst__2791_/Z VDD VDD VSS VSS gf180mcu_fd_sc_mcu7t5v0__mux2_2
Xwave_controller_x_inst__2775_ wave_controller_x_inst__3340_/A1 wave_controller_x_inst__2898_/A2
+ wave_controller_x_inst__2775_/Z VDD VDD VSS VSS gf180mcu_fd_sc_mcu7t5v0__and2_1
XFILLER_71_104 VDD VDD VSS VSS gf180mcu_fd_sc_mcu7t5v0__fill_2
XFILLER_53_852 VDD VDD VSS VSS gf180mcu_fd_sc_mcu7t5v0__fillcap_32
XFILLER_25_554 VDD VDD VSS VSS gf180mcu_fd_sc_mcu7t5v0__fill_1
XFILLER_44_47 VDD VDD VSS VSS gf180mcu_fd_sc_mcu7t5v0__fillcap_8
XFILLER_80_671 VDD VDD VSS VSS gf180mcu_fd_sc_mcu7t5v0__fill_2
Xwave_controller_y_inst__3412_ wave_controller_y_inst__3692_/Q wave_controller_y_inst__3424_/A2
+ wave_controller_y_inst__3414_/A2 VDD VDD VSS VSS gf180mcu_fd_sc_mcu7t5v0__nor2_1
XFILLER_40_524 VDD VDD VSS VSS gf180mcu_fd_sc_mcu7t5v0__fill_1
Xwave_controller_y_inst__3343_ spi_regs_inst__1619_/Q wave_controller_y_inst__2117_/B
+ wave_controller_y_inst__3343_/Z VDD VDD VSS VSS gf180mcu_fd_sc_mcu7t5v0__xor2_1
Xwave_controller_x_inst__3327_ wave_controller_x_inst__3004_/B spi_regs_inst__1537_/Q
+ wave_controller_x_inst__3336_/A1 VDD VDD VSS VSS gf180mcu_fd_sc_mcu7t5v0__nand2_1
Xwave_controller_y_inst__3274_ wave_controller_y_inst__3290_/A1 spi_regs_inst__1603_/Q
+ wave_controller_y_inst__3274_/Z VDD VDD VSS VSS gf180mcu_fd_sc_mcu7t5v0__and2_1
Xwave_controller_x_inst__3258_ wave_controller_x_inst__3616_/Q wave_controller_x_inst__3258_/A2
+ wave_controller_x_inst__3404_/A1 VDD VDD VSS VSS gf180mcu_fd_sc_mcu7t5v0__nand2_1
XFILLER_138_478 VDD VDD VSS VSS gf180mcu_fd_sc_mcu7t5v0__fill_1
XFILLER_20_292 VDD VDD VSS VSS gf180mcu_fd_sc_mcu7t5v0__fill_2
Xwave_controller_y_inst__2225_ wave_controller_y_inst__2260_/A1 wave_controller_y_inst__2257_/A1
+ wave_controller_y_inst__2239_/A2 VDD VDD VSS VSS gf180mcu_fd_sc_mcu7t5v0__nand2_1
Xwave_controller_x_inst__2209_ wave_controller_x_inst__2209_/I wave_controller_x_inst__2248_/A1
+ VDD VDD VSS VSS gf180mcu_fd_sc_mcu7t5v0__clkinv_1
XFILLER_119_670 VDD VDD VSS VSS gf180mcu_fd_sc_mcu7t5v0__fillcap_4
XFILLER_158_1017 VDD VDD VSS VSS gf180mcu_fd_sc_mcu7t5v0__fillcap_64
XFILLER_4_403 VDD VDD VSS VSS gf180mcu_fd_sc_mcu7t5v0__fill_1
Xwave_controller_y_inst__2156_ wave_controller_y_inst__2756_/A1 wave_controller_y_inst__2756_/A2
+ wave_controller_y_inst__3733_/D VDD VDD VSS VSS gf180mcu_fd_sc_mcu7t5v0__xor2_1
Xwave_controller_x_inst__3189_ wave_controller_x_inst__3340_/A1 spi_regs_inst__1518_/Q
+ spi_regs_inst__1517_/Q wave_controller_x_inst__3189_/C wave_controller_x_inst__3190_/A2
+ VDD VDD VSS VSS gf180mcu_fd_sc_mcu7t5v0__oai211_1
Xwave_controller_y_inst__2087_ wave_controller_y_inst__2755_/A1 wave_controller_y_inst__2086_/Z
+ wave_controller_y_inst__2104_/A2 VDD VDD VSS VSS gf180mcu_fd_sc_mcu7t5v0__nand2_1
XFILLER_134_695 VDD VDD VSS VSS gf180mcu_fd_sc_mcu7t5v0__fill_2
XFILLER_161_492 VDD VDD VSS VSS gf180mcu_fd_sc_mcu7t5v0__fillcap_4
XFILLER_69_88 VDD VDD VSS VSS gf180mcu_fd_sc_mcu7t5v0__fillcap_8
Xwave_controller_x_inst_fanout443 wave_controller_x_inst__3720_/Q wave_controller_x_inst__1806_/I
+ VDD VDD VSS VSS gf180mcu_fd_sc_mcu7t5v0__dlyb_1
XFILLER_125_72 VDD VDD VSS VSS gf180mcu_fd_sc_mcu7t5v0__fillcap_8
XFILLER_63_605 VDD VDD VSS VSS gf180mcu_fd_sc_mcu7t5v0__fill_2
XFILLER_91_903 VDD VDD VSS VSS gf180mcu_fd_sc_mcu7t5v0__fillcap_4
XTAP_TAPCELL_ROW_89_1344 VDD VSS gf180mcu_fd_sc_mcu7t5v0__filltie
Xwave_controller_y_inst__2989_ wave_controller_y_inst__3713_/Q wave_controller_y_inst__1818_/I
+ wave_controller_y_inst__2989_/B wave_controller_y_inst__3075_/A1 VDD VDD VSS VSS
+ gf180mcu_fd_sc_mcu7t5v0__aoi21_1
XFILLER_63_616 VDD VDD VSS VSS gf180mcu_fd_sc_mcu7t5v0__fillcap_8
XFILLER_85_87 VDD VDD VSS VSS gf180mcu_fd_sc_mcu7t5v0__fill_2
XFILLER_90_413 VDD VDD VSS VSS gf180mcu_fd_sc_mcu7t5v0__fill_2
XFILLER_62_148 VDD VDD VSS VSS gf180mcu_fd_sc_mcu7t5v0__fillcap_16
XFILLER_90_457 VDD VDD VSS VSS gf180mcu_fd_sc_mcu7t5v0__fillcap_16
Xspi_regs_inst__1650_ spi_regs_inst__1650_/D fanout584/Z clkbuf_leaf_13_clk/Z spi_regs_inst__1650_/Q
+ VDD VDD VSS VSS gf180mcu_fd_sc_mcu7t5v0__dffrnq_1
XFILLER_16_554 VDD VDD VSS VSS gf180mcu_fd_sc_mcu7t5v0__fill_1
XFILLER_71_671 VDD VDD VSS VSS gf180mcu_fd_sc_mcu7t5v0__fillcap_8
Xspi_regs_inst__1581_ spi_regs_inst__1581_/D fanout561/Z clkbuf_leaf_6_clk/Z spi_regs_inst__1581_/Q
+ VDD VDD VSS VSS gf180mcu_fd_sc_mcu7t5v0__dffrnq_1
XFILLER_70_192 VDD VDD VSS VSS gf180mcu_fd_sc_mcu7t5v0__fillcap_32
XTAP_TAPCELL_ROW_100_1522 VDD VSS gf180mcu_fd_sc_mcu7t5v0__filltie
XTAP_TAPCELL_ROW_100_1533 VDD VSS gf180mcu_fd_sc_mcu7t5v0__filltie
XFILLER_129_456 VDD VDD VSS VSS gf180mcu_fd_sc_mcu7t5v0__fill_2
XFILLER_156_242 VDD VDD VSS VSS gf180mcu_fd_sc_mcu7t5v0__fill_2
XTAP_TAPCELL_ROW_133_2065 VDD VSS gf180mcu_fd_sc_mcu7t5v0__filltie
XTAP_TAPCELL_ROW_133_2076 VDD VSS gf180mcu_fd_sc_mcu7t5v0__filltie
XFILLER_153_982 VDD VDD VSS VSS gf180mcu_fd_sc_mcu7t5v0__fillcap_64
XFILLER_98_524 VDD VDD VSS VSS gf180mcu_fd_sc_mcu7t5v0__fill_1
Xspi_regs_inst__1015_ spi_regs_inst__1027_/A1 spi_regs_inst__1025_/A2 spi_regs_inst_wire227/I
+ VDD VDD VSS VSS gf180mcu_fd_sc_mcu7t5v0__nor2_1
XFILLER_113_846 VDD VDD VSS VSS gf180mcu_fd_sc_mcu7t5v0__fill_2
XFILLER_22_2 VDD VDD VSS VSS gf180mcu_fd_sc_mcu7t5v0__fillcap_32
Xwave_controller_y_inst_fanout46 wave_controller_y_inst__2934_/ZN wave_controller_y_inst__3591_/S
+ VDD VDD VSS VSS gf180mcu_fd_sc_mcu7t5v0__dlyb_1
Xwave_controller_y_inst_fanout24 wave_controller_y_inst__3493_/Z wave_controller_y_inst__3528_/A2
+ VDD VDD VSS VSS gf180mcu_fd_sc_mcu7t5v0__dlyb_1
XFILLER_38_123 VDD VDD VSS VSS gf180mcu_fd_sc_mcu7t5v0__fill_1
XFILLER_53_104 VDD VDD VSS VSS gf180mcu_fd_sc_mcu7t5v0__fill_1
XFILLER_81_402 VDD VDD VSS VSS gf180mcu_fd_sc_mcu7t5v0__fill_1
XFILLER_82_925 VDD VDD VSS VSS gf180mcu_fd_sc_mcu7t5v0__fillcap_8
XFILLER_82_947 VDD VDD VSS VSS gf180mcu_fd_sc_mcu7t5v0__fillcap_64
Xwave_controller_x_inst__2560_ spi_regs_inst__1332_/A1 wave_controller_x_inst__2558_/Z
+ wave_controller_x_inst__2561_/B VDD VDD VSS VSS gf180mcu_fd_sc_mcu7t5v0__xor2_1
XFILLER_53_115 VDD VDD VSS VSS gf180mcu_fd_sc_mcu7t5v0__fillcap_16
XFILLER_93_284 VDD VDD VSS VSS gf180mcu_fd_sc_mcu7t5v0__fill_1
Xwave_controller_x_inst__2491_ wave_controller_x_inst__2517_/A1 wave_controller_x_inst__2517_/A2
+ wave_controller_x_inst__2517_/C wave_controller_x_inst__2501_/A2 VDD VDD VSS VSS
+ gf180mcu_fd_sc_mcu7t5v0__oai21_1
XFILLER_34_384 VDD VDD VSS VSS gf180mcu_fd_sc_mcu7t5v0__fill_1
XFILLER_34_395 VDD VDD VSS VSS gf180mcu_fd_sc_mcu7t5v0__fill_2
Xspi_regs_inst_load_slew491 spi_regs_inst__1378_/I1 spi_regs_inst__1448_/I1 VDD VDD
+ VSS VSS gf180mcu_fd_sc_mcu7t5v0__buf_4
XFILLER_72_1151 VDD VDD VSS VSS gf180mcu_fd_sc_mcu7t5v0__fillcap_4
XFILLER_72_1173 VDD VDD VSS VSS gf180mcu_fd_sc_mcu7t5v0__fill_1
XTAP_TAPCELL_ROW_153_2408 VDD VSS gf180mcu_fd_sc_mcu7t5v0__filltie
XTAP_TAPCELL_ROW_60_861 VDD VSS gf180mcu_fd_sc_mcu7t5v0__filltie
XTAP_TAPCELL_ROW_60_872 VDD VSS gf180mcu_fd_sc_mcu7t5v0__filltie
Xwave_controller_x_inst__3112_ wave_controller_x_inst__3312_/A1 spi_regs_inst__1531_/Q
+ wave_controller_x_inst__3164_/A1 VDD VDD VSS VSS gf180mcu_fd_sc_mcu7t5v0__nand2_1
XFILLER_148_754 VDD VDD VSS VSS gf180mcu_fd_sc_mcu7t5v0__fill_1
XFILLER_163_702 VDD VDD VSS VSS gf180mcu_fd_sc_mcu7t5v0__fillcap_64
XTAP_TAPCELL_ROW_118_1816 VDD VSS gf180mcu_fd_sc_mcu7t5v0__filltie
XTAP_TAPCELL_ROW_118_1827 VDD VSS gf180mcu_fd_sc_mcu7t5v0__filltie
Xwave_controller_x_inst__3043_ wave_controller_x_inst__3279_/A1 wave_controller_x_inst__3043_/A2
+ wave_controller_x_inst__3043_/A3 wave_controller_x_inst__3043_/Z VDD VDD VSS VSS
+ gf180mcu_fd_sc_mcu7t5v0__xor3_1
Xwave_controller_y_inst__2010_ wave_controller_y_inst__2008_/Z wave_controller_y_inst_wire82/Z
+ spi_regs_inst__1308_/B2 VDD VDD VSS VSS gf180mcu_fd_sc_mcu7t5v0__xor2_1
XFILLER_104_802 VDD VDD VSS VSS gf180mcu_fd_sc_mcu7t5v0__fill_2
XFILLER_116_673 VDD VDD VSS VSS gf180mcu_fd_sc_mcu7t5v0__fillcap_32
XFILLER_162_278 VDD VDD VSS VSS gf180mcu_fd_sc_mcu7t5v0__fill_1
XFILLER_1_417 VDD VDD VSS VSS gf180mcu_fd_sc_mcu7t5v0__fill_2
Xmax_cap461 max_cap461/I max_cap461/Z VDD VDD VSS VSS gf180mcu_fd_sc_mcu7t5v0__buf_4
XFILLER_131_632 VDD VDD VSS VSS gf180mcu_fd_sc_mcu7t5v0__fillcap_8
XFILLER_143_492 VDD VDD VSS VSS gf180mcu_fd_sc_mcu7t5v0__fill_2
XFILLER_103_356 VDD VDD VSS VSS gf180mcu_fd_sc_mcu7t5v0__fill_2
XFILLER_103_367 VDD VDD VSS VSS gf180mcu_fd_sc_mcu7t5v0__fillcap_4
XFILLER_130_153 VDD VDD VSS VSS gf180mcu_fd_sc_mcu7t5v0__fillcap_4
XFILLER_89_579 VDD VDD VSS VSS gf180mcu_fd_sc_mcu7t5v0__fillcap_8
Xwave_controller_y_inst__2912_ wave_controller_y_inst__3713_/Q wave_controller_y_inst__3408_/A1
+ wave_controller_y_inst__3583_/A1 VDD VDD VSS VSS gf180mcu_fd_sc_mcu7t5v0__nand2_1
XFILLER_162_37 VDD VDD VSS VSS gf180mcu_fd_sc_mcu7t5v0__fillcap_64
XFILLER_39_58 VDD VDD VSS VSS gf180mcu_fd_sc_mcu7t5v0__fillcap_8
Xwave_controller_y_inst__2843_ wave_controller_y_inst__3548_/B2 wave_controller_y_inst__2844_/A2
+ wave_controller_y_inst__2844_/B VDD VDD VSS VSS gf180mcu_fd_sc_mcu7t5v0__nand2_1
Xwave_controller_x_inst__2827_ wave_controller_x_inst__2838_/A1 wave_controller_x_inst__2826_/Z
+ wave_controller_x_inst__2834_/C VDD VDD VSS VSS gf180mcu_fd_sc_mcu7t5v0__nand2_1
XFILLER_57_487 VDD VDD VSS VSS gf180mcu_fd_sc_mcu7t5v0__fill_2
Xwave_controller_y_inst__2774_ wave_controller_y_inst__2774_/A1 wave_controller_y_inst__2844_/A2
+ wave_controller_y_inst__2774_/B wave_controller_y_inst__2898_/A2 VDD VDD VSS VSS
+ gf180mcu_fd_sc_mcu7t5v0__oai21_1
XFILLER_73_969 VDD VDD VSS VSS gf180mcu_fd_sc_mcu7t5v0__fillcap_8
XTAP_TAPCELL_ROW_68_994 VDD VSS gf180mcu_fd_sc_mcu7t5v0__filltie
Xwave_controller_x_inst__2758_ wave_controller_x_inst__3497_/A1 wave_controller_x_inst__2456_/B
+ wave_controller_x_inst__2758_/B spi_regs_inst_wire167/I VDD VDD VSS VSS gf180mcu_fd_sc_mcu7t5v0__aoi21_1
XFILLER_72_457 VDD VDD VSS VSS gf180mcu_fd_sc_mcu7t5v0__fillcap_4
Xwave_controller_x_inst__2689_ spi_regs_inst__1060_/A1 wave_controller_x_inst__3545_/B2
+ wave_controller_x_inst_wire113/Z wave_controller_x_inst__2689_/Z VDD VDD VSS VSS
+ gf180mcu_fd_sc_mcu7t5v0__xor3_1
XFILLER_13_502 VDD VDD VSS VSS gf180mcu_fd_sc_mcu7t5v0__fill_1
XFILLER_52_170 VDD VDD VSS VSS gf180mcu_fd_sc_mcu7t5v0__fillcap_4
XFILLER_53_682 VDD VDD VSS VSS gf180mcu_fd_sc_mcu7t5v0__fillcap_8
XTAP_TAPCELL_ROW_84_1263 VDD VSS gf180mcu_fd_sc_mcu7t5v0__filltie
XFILLER_164_1087 VDD VDD VSS VSS gf180mcu_fd_sc_mcu7t5v0__fillcap_64
XFILLER_40_321 VDD VDD VSS VSS gf180mcu_fd_sc_mcu7t5v0__fillcap_16
XFILLER_40_376 VDD VDD VSS VSS gf180mcu_fd_sc_mcu7t5v0__fill_1
XFILLER_9_528 VDD VDD VSS VSS gf180mcu_fd_sc_mcu7t5v0__fill_1
Xwave_controller_y_inst__3326_ wave_controller_y_inst__1778_/I spi_regs_inst__1615_/Q
+ wave_controller_y_inst__3326_/Z VDD VDD VSS VSS gf180mcu_fd_sc_mcu7t5v0__xor2_1
XFILLER_127_916 VDD VDD VSS VSS gf180mcu_fd_sc_mcu7t5v0__fillcap_64
XFILLER_166_551 VDD VDD VSS VSS gf180mcu_fd_sc_mcu7t5v0__fill_2
Xwave_controller_y_inst__3257_ wave_controller_y_inst__3257_/A1 wave_controller_y_inst__3257_/A2
+ wave_controller_y_inst__3404_/B wave_controller_y_inst__3615_/D VDD VDD VSS VSS
+ gf180mcu_fd_sc_mcu7t5v0__aoi21_1
XFILLER_126_426 VDD VDD VSS VSS gf180mcu_fd_sc_mcu7t5v0__fillcap_16
Xwave_controller_y_inst__2208_ wave_controller_y_inst__3566_/A1 wave_controller_y_inst__2207_/Z
+ wave_controller_y_inst__2209_/I VDD VDD VSS VSS gf180mcu_fd_sc_mcu7t5v0__xor2_1
Xwave_controller_y_inst__3188_ wave_controller_y_inst__3194_/A1 wave_controller_y_inst__3194_/A2
+ wave_controller_y_inst__3188_/B wave_controller_y_inst__3255_/A1 VDD VDD VSS VSS
+ gf180mcu_fd_sc_mcu7t5v0__aoi21_1
XFILLER_135_982 VDD VDD VSS VSS gf180mcu_fd_sc_mcu7t5v0__fillcap_64
XFILLER_84_1011 VDD VDD VSS VSS gf180mcu_fd_sc_mcu7t5v0__fillcap_4
Xwave_controller_y_inst__2139_ wave_controller_y_inst__2145_/I1 wave_controller_y_inst__2139_/A2
+ wave_controller_y_inst__2139_/Z VDD VDD VSS VSS gf180mcu_fd_sc_mcu7t5v0__xor2_1
XFILLER_150_941 VDD VDD VSS VSS gf180mcu_fd_sc_mcu7t5v0__fillcap_4
Xwave_controller_x_inst_load_slew606 wave_controller_x_inst__3692_/RN wave_controller_x_inst__3723_/RN
+ VDD VDD VSS VSS gf180mcu_fd_sc_mcu7t5v0__buf_4
XFILLER_136_93 VDD VDD VSS VSS gf180mcu_fd_sc_mcu7t5v0__fill_1
XFILLER_110_827 VDD VDD VSS VSS gf180mcu_fd_sc_mcu7t5v0__fill_1
XFILLER_121_186 VDD VDD VSS VSS gf180mcu_fd_sc_mcu7t5v0__fill_1
XFILLER_0_494 VDD VDD VSS VSS gf180mcu_fd_sc_mcu7t5v0__fillcap_8
XFILLER_48_421 VDD VDD VSS VSS gf180mcu_fd_sc_mcu7t5v0__fill_1
XFILLER_48_432 VDD VDD VSS VSS gf180mcu_fd_sc_mcu7t5v0__fillcap_16
XFILLER_48_454 VDD VDD VSS VSS gf180mcu_fd_sc_mcu7t5v0__fill_1
XFILLER_75_273 VDD VDD VSS VSS gf180mcu_fd_sc_mcu7t5v0__fillcap_4
XFILLER_63_435 VDD VDD VSS VSS gf180mcu_fd_sc_mcu7t5v0__fillcap_16
XFILLER_64_947 VDD VDD VSS VSS gf180mcu_fd_sc_mcu7t5v0__fillcap_64
XFILLER_91_733 VDD VDD VSS VSS gf180mcu_fd_sc_mcu7t5v0__fill_2
XTAP_TAPCELL_ROW_43_1_651 VDD VSS gf180mcu_fd_sc_mcu7t5v0__filltie
XFILLER_63_457 VDD VDD VSS VSS gf180mcu_fd_sc_mcu7t5v0__fill_1
Xspi_regs_inst__1633_ spi_regs_inst__1633_/D spi_regs_inst__1662_/RN clkbuf_leaf_7_clk/Z
+ spi_regs_inst__1633_/Q VDD VDD VSS VSS gf180mcu_fd_sc_mcu7t5v0__dffrnq_1
XFILLER_50_107 VDD VDD VSS VSS gf180mcu_fd_sc_mcu7t5v0__fill_2
XFILLER_91_799 VDD VDD VSS VSS gf180mcu_fd_sc_mcu7t5v0__fill_1
XFILLER_143_1116 VDD VDD VSS VSS gf180mcu_fd_sc_mcu7t5v0__fillcap_4
XFILLER_56_1157 VDD VDD VSS VSS gf180mcu_fd_sc_mcu7t5v0__fillcap_8
Xspi_regs_inst__1564_ spi_regs_inst__1564_/D spi_regs_inst__1647_/RN clkbuf_leaf_39_clk/Z
+ spi_regs_inst__1564_/Q VDD VDD VSS VSS gf180mcu_fd_sc_mcu7t5v0__dffrnq_1
XFILLER_31_387 VDD VDD VSS VSS gf180mcu_fd_sc_mcu7t5v0__fill_2
Xspi_regs_inst__1495_ spi_regs_inst__1495_/D fanout589/Z clkload25/I spi_regs_inst__1495_/Q
+ VDD VDD VSS VSS gf180mcu_fd_sc_mcu7t5v0__dffrnq_1
XFILLER_145_702 VDD VDD VSS VSS gf180mcu_fd_sc_mcu7t5v0__fill_1
XFILLER_157_562 VDD VDD VSS VSS gf180mcu_fd_sc_mcu7t5v0__fillcap_4
XTAP_TAPCELL_ROW_135_2105 VDD VSS gf180mcu_fd_sc_mcu7t5v0__filltie
XFILLER_133_908 VDD VDD VSS VSS gf180mcu_fd_sc_mcu7t5v0__fill_2
XFILLER_144_267 VDD VDD VSS VSS gf180mcu_fd_sc_mcu7t5v0__fill_1
XFILLER_113_610 VDD VDD VSS VSS gf180mcu_fd_sc_mcu7t5v0__fillcap_4
XTAP_TAPCELL_ROW_113_1735 VDD VSS gf180mcu_fd_sc_mcu7t5v0__filltie
XTAP_TAPCELL_ROW_113_1746 VDD VSS gf180mcu_fd_sc_mcu7t5v0__filltie
Xwave_controller_x_inst__1991_ wave_controller_x_inst__1991_/A1 wave_controller_x_inst__1999_/C
+ wave_controller_x_inst__1999_/B1 VDD VDD VSS VSS gf180mcu_fd_sc_mcu7t5v0__nand2_1
Xstate_machine_inst__28_ spi_regs_inst__1058_/B2 state_machine_inst__27_/B state_machine_inst__28_/Z
+ VDD VDD VSS VSS gf180mcu_fd_sc_mcu7t5v0__and2_1
Xfanout529 fanout529/I fanout529/Z VDD VDD VSS VSS gf180mcu_fd_sc_mcu7t5v0__dlyb_1
Xfanout507 fanout508/Z fanout507/Z VDD VDD VSS VSS gf180mcu_fd_sc_mcu7t5v0__dlyb_1
XFILLER_140_473 VDD VDD VSS VSS gf180mcu_fd_sc_mcu7t5v0__fill_2
XFILLER_58_229 VDD VDD VSS VSS gf180mcu_fd_sc_mcu7t5v0__fill_1
XFILLER_86_527 VDD VDD VSS VSS gf180mcu_fd_sc_mcu7t5v0__fill_1
XFILLER_98_387 VDD VDD VSS VSS gf180mcu_fd_sc_mcu7t5v0__fillcap_16
Xwave_controller_x_inst__3730_ wave_controller_x_inst__3730_/D fanout597/Z clkbuf_leaf_20_clk/Z
+ wave_controller_x_inst__3730_/Q VDD VDD VSS VSS gf180mcu_fd_sc_mcu7t5v0__dffrnq_1
XFILLER_39_443 VDD VDD VSS VSS gf180mcu_fd_sc_mcu7t5v0__fillcap_16
Xwave_controller_x_inst__3661_ wave_controller_x_inst__3661_/D wave_controller_x_inst__3682_/RN
+ clkload34/I max_cap453/I VDD VDD VSS VSS gf180mcu_fd_sc_mcu7t5v0__dffrnq_1
XFILLER_39_487 VDD VDD VSS VSS gf180mcu_fd_sc_mcu7t5v0__fill_2
XTAP_TAPCELL_ROW_146_2278 VDD VSS gf180mcu_fd_sc_mcu7t5v0__filltie
XTAP_TAPCELL_ROW_146_2289 VDD VSS gf180mcu_fd_sc_mcu7t5v0__filltie
XTAP_TAPCELL_ROW_163_2570 VDD VSS gf180mcu_fd_sc_mcu7t5v0__filltie
XTAP_TAPCELL_ROW_29_1_552 VDD VSS gf180mcu_fd_sc_mcu7t5v0__filltie
Xwave_controller_x_inst__2612_ wave_controller_x_inst__2612_/A1 wave_controller_x_inst__2610_/Z
+ spi_regs_inst_wire38/I VDD VDD VSS VSS gf180mcu_fd_sc_mcu7t5v0__xor2_1
XFILLER_26_104 VDD VDD VSS VSS gf180mcu_fd_sc_mcu7t5v0__fill_1
XFILLER_26_126 VDD VDD VSS VSS gf180mcu_fd_sc_mcu7t5v0__fill_2
XFILLER_94_593 VDD VDD VSS VSS gf180mcu_fd_sc_mcu7t5v0__fill_2
XTAP_TAPCELL_ROW_65_942 VDD VSS gf180mcu_fd_sc_mcu7t5v0__filltie
Xwave_controller_x_inst__3592_ spi_regs_inst__1225_/A1 wave_controller_x_inst__3591_/S
+ wave_controller_x_inst__3593_/B VDD VDD VSS VSS gf180mcu_fd_sc_mcu7t5v0__nand2_1
XFILLER_54_468 VDD VDD VSS VSS gf180mcu_fd_sc_mcu7t5v0__fillcap_8
XFILLER_81_243 VDD VDD VSS VSS gf180mcu_fd_sc_mcu7t5v0__fill_1
XTAP_TAPCELL_ROW_65_953 VDD VSS gf180mcu_fd_sc_mcu7t5v0__filltie
Xwave_controller_x_inst__2543_ wave_controller_x_inst__2543_/A1 wave_controller_x_inst__2543_/A2
+ wave_controller_x_inst__2543_/B1 wave_controller_x_inst__2524_/Z wave_controller_x_inst__2543_/C
+ wave_controller_x_inst__2545_/A2 VDD VDD VSS VSS gf180mcu_fd_sc_mcu7t5v0__oai221_1
Xwave_controller_y_inst__2490_ wave_controller_y_inst__2490_/A1 wave_controller_y_inst__2490_/A2
+ wave_controller_y_inst__2517_/A2 VDD VDD VSS VSS gf180mcu_fd_sc_mcu7t5v0__nand2_1
Xwave_controller_x_inst__2474_ wave_controller_x_inst__2470_/Z wave_controller_x_inst__2476_/A3
+ wave_controller_x_inst__2474_/Z VDD VDD VSS VSS gf180mcu_fd_sc_mcu7t5v0__xor2_1
XFILLER_109_905 VDD VDD VSS VSS gf180mcu_fd_sc_mcu7t5v0__fill_1
XFILLER_10_527 VDD VDD VSS VSS gf180mcu_fd_sc_mcu7t5v0__fillcap_4
XFILLER_10_549 VDD VDD VSS VSS gf180mcu_fd_sc_mcu7t5v0__fillcap_4
XFILLER_22_387 VDD VDD VSS VSS gf180mcu_fd_sc_mcu7t5v0__fillcap_16
Xwave_controller_y_inst__3111_ wave_controller_y_inst__3713_/Q spi_regs_inst__1595_/Q
+ wave_controller_y_inst__3166_/B VDD VDD VSS VSS gf180mcu_fd_sc_mcu7t5v0__xor2_1
XTAP_TAPCELL_ROW_52_1_719 VDD VSS gf180mcu_fd_sc_mcu7t5v0__filltie
XFILLER_135_212 VDD VDD VSS VSS gf180mcu_fd_sc_mcu7t5v0__fillcap_8
XFILLER_136_757 VDD VDD VSS VSS gf180mcu_fd_sc_mcu7t5v0__fill_2
XFILLER_68_1017 VDD VDD VSS VSS gf180mcu_fd_sc_mcu7t5v0__fillcap_64
Xwave_controller_y_inst__3042_ wave_controller_y_inst__2797_/C wave_controller_y_inst__3042_/A2
+ wave_controller_y_inst__3042_/B1 wave_controller_y_inst__3059_/A2 wave_controller_y_inst__3701_/D
+ VDD VDD VSS VSS gf180mcu_fd_sc_mcu7t5v0__aoi22_1
Xwave_controller_x_inst__3026_ wave_controller_x_inst__3695_/Q wave_controller_x_inst__3696_/Q
+ wave_controller_x_inst__3026_/A3 wave_controller_x_inst__3032_/A3 VDD VDD VSS VSS
+ gf180mcu_fd_sc_mcu7t5v0__nand3_1
XFILLER_117_982 VDD VDD VSS VSS gf180mcu_fd_sc_mcu7t5v0__fillcap_64
XFILLER_104_632 VDD VDD VSS VSS gf180mcu_fd_sc_mcu7t5v0__fill_1
XFILLER_151_749 VDD VDD VSS VSS gf180mcu_fd_sc_mcu7t5v0__fill_2
XFILLER_103_142 VDD VDD VSS VSS gf180mcu_fd_sc_mcu7t5v0__fill_2
XFILLER_106_41 VDD VDD VSS VSS gf180mcu_fd_sc_mcu7t5v0__fillcap_4
XFILLER_131_484 VDD VDD VSS VSS gf180mcu_fd_sc_mcu7t5v0__fillcap_4
XFILLER_89_387 VDD VDD VSS VSS gf180mcu_fd_sc_mcu7t5v0__fill_1
XFILLER_66_34 VDD VDD VSS VSS gf180mcu_fd_sc_mcu7t5v0__fill_1
XFILLER_66_45 VDD VDD VSS VSS gf180mcu_fd_sc_mcu7t5v0__fill_1
XTAP_TAPCELL_ROW_8_1_388 VDD VSS gf180mcu_fd_sc_mcu7t5v0__filltie
XFILLER_100_871 VDD VDD VSS VSS gf180mcu_fd_sc_mcu7t5v0__fillcap_4
XTAP_TAPCELL_ROW_86_1303 VDD VSS gf180mcu_fd_sc_mcu7t5v0__filltie
Xwave_controller_y_inst__2826_ wave_controller_y_inst__3320_/A1 wave_controller_y_inst__2837_/A2
+ wave_controller_y_inst__2826_/Z VDD VDD VSS VSS gf180mcu_fd_sc_mcu7t5v0__xor2_1
XFILLER_73_722 VDD VDD VSS VSS gf180mcu_fd_sc_mcu7t5v0__fill_1
Xwave_controller_y_inst__2757_ wave_controller_y_inst__2757_/A1 wave_controller_y_inst__2163_/B
+ wave_controller_y_inst__2757_/B spi_regs_inst__1069_/B2 VDD VDD VSS VSS gf180mcu_fd_sc_mcu7t5v0__aoi21_1
Xwave_controller_y_inst__2688_ wave_controller_y_inst__2824_/A1 max_cap431/Z wave_controller_y_inst__2688_/B1
+ wave_controller_y_inst__2686_/Z wave_controller_y_inst__2688_/C wave_controller_y_inst__2717_/B2
+ VDD VDD VSS VSS gf180mcu_fd_sc_mcu7t5v0__oai221_1
XFILLER_60_449 VDD VDD VSS VSS gf180mcu_fd_sc_mcu7t5v0__fillcap_4
Xclkbuf_leaf_52_clk clkbuf_leaf_3_clk/I clkload4/I VDD VDD VSS VSS gf180mcu_fd_sc_mcu7t5v0__clkbuf_8
XFILLER_40_162 VDD VDD VSS VSS gf180mcu_fd_sc_mcu7t5v0__fill_2
XFILLER_9_314 VDD VDD VSS VSS gf180mcu_fd_sc_mcu7t5v0__fillcap_16
XFILLER_90_1081 VDD VDD VSS VSS gf180mcu_fd_sc_mcu7t5v0__fillcap_4
Xspi_regs_inst__1280_ spi_regs_inst__1280_/A1 spi_regs_inst__1280_/A2 spi_regs_inst__1280_/A3
+ spi_regs_inst__1281_/C VDD VDD VSS VSS gf180mcu_fd_sc_mcu7t5v0__nand3_1
XFILLER_103_1122 VDD VDD VSS VSS gf180mcu_fd_sc_mcu7t5v0__fillcap_32
XFILLER_127_702 VDD VDD VSS VSS gf180mcu_fd_sc_mcu7t5v0__fillcap_8
XFILLER_139_562 VDD VDD VSS VSS gf180mcu_fd_sc_mcu7t5v0__fillcap_4
Xwave_controller_y_inst__3309_ wave_controller_y_inst__3712_/Q spi_regs_inst__1610_/Q
+ wave_controller_y_inst__3310_/C VDD VDD VSS VSS gf180mcu_fd_sc_mcu7t5v0__xor2_1
XFILLER_154_543 VDD VDD VSS VSS gf180mcu_fd_sc_mcu7t5v0__fill_1
XTAP_TAPCELL_ROW_46_1_677 VDD VSS gf180mcu_fd_sc_mcu7t5v0__filltie
XTAP_TAPCELL_ROW_97_1476 VDD VSS gf180mcu_fd_sc_mcu7t5v0__filltie
XTAP_TAPCELL_ROW_130_2024 VDD VSS gf180mcu_fd_sc_mcu7t5v0__filltie
XFILLER_107_492 VDD VDD VSS VSS gf180mcu_fd_sc_mcu7t5v0__fill_2
XFILLER_142_749 VDD VDD VSS VSS gf180mcu_fd_sc_mcu7t5v0__fill_1
Xsignal_processor_y_inst__230_ signal_processor_y_inst__230_/D signal_processor_y_inst__253_/RN
+ clkload1/I signal_processor_y_inst__230_/Q VDD VDD VSS VSS gf180mcu_fd_sc_mcu7t5v0__dffrnq_1
XFILLER_122_440 VDD VDD VSS VSS gf180mcu_fd_sc_mcu7t5v0__fill_1
XFILLER_123_974 VDD VDD VSS VSS gf180mcu_fd_sc_mcu7t5v0__fillcap_4
XFILLER_96_803 VDD VDD VSS VSS gf180mcu_fd_sc_mcu7t5v0__fill_2
Xwave_controller_x_inst_load_slew403 fanout402/Z wave_controller_x_inst__3049_/A2
+ VDD VDD VSS VSS gf180mcu_fd_sc_mcu7t5v0__buf_4
Xsignal_processor_y_inst__161_ signal_processor_y_inst__248_/Q signal_processor_y_inst__161_/A2
+ signal_processor_y_inst__203_/A1 signal_processor_y_inst__161_/A4 signal_processor_y_inst__166_/A2
+ VDD VDD VSS VSS gf180mcu_fd_sc_mcu7t5v0__nor4_1
XFILLER_96_869 VDD VDD VSS VSS gf180mcu_fd_sc_mcu7t5v0__fill_2
XTAP_TAPCELL_ROW_20_1_479 VDD VSS gf180mcu_fd_sc_mcu7t5v0__filltie
XFILLER_64_700 VDD VDD VSS VSS gf180mcu_fd_sc_mcu7t5v0__fillcap_8
XFILLER_83_508 VDD VDD VSS VSS gf180mcu_fd_sc_mcu7t5v0__fillcap_4
XFILLER_95_368 VDD VDD VSS VSS gf180mcu_fd_sc_mcu7t5v0__fill_2
Xspi_regs_inst__0995_ spi_regs_inst__1629_/Q spi_regs_inst__1364_/A1 spi_regs_inst__0995_/A3
+ spi_regs_inst__1027_/A2 VDD VDD VSS VSS gf180mcu_fd_sc_mcu7t5v0__nand3_1
XFILLER_64_733 VDD VDD VSS VSS gf180mcu_fd_sc_mcu7t5v0__fill_2
XFILLER_76_582 VDD VDD VSS VSS gf180mcu_fd_sc_mcu7t5v0__fill_2
XFILLER_76_593 VDD VDD VSS VSS gf180mcu_fd_sc_mcu7t5v0__fill_2
XFILLER_36_479 VDD VDD VSS VSS gf180mcu_fd_sc_mcu7t5v0__fillcap_8
XTAP_TAPCELL_ROW_62_901 VDD VSS gf180mcu_fd_sc_mcu7t5v0__filltie
XTAP_TAPCELL_ROW_141_2197 VDD VSS gf180mcu_fd_sc_mcu7t5v0__filltie
XFILLER_108_1011 VDD VDD VSS VSS gf180mcu_fd_sc_mcu7t5v0__fillcap_4
Xspi_regs_inst__1616_ spi_regs_inst__1616_/D fanout563/Z clkbuf_leaf_7_clk/Z spi_regs_inst__1616_/Q
+ VDD VDD VSS VSS gf180mcu_fd_sc_mcu7t5v0__dffrnq_1
Xclkbuf_leaf_43_clk clkbuf_leaf_9_clk/I clkload20/I VDD VDD VSS VSS gf180mcu_fd_sc_mcu7t5v0__clkbuf_8
Xspi_regs_inst__1547_ spi_regs_inst__1547_/D spi_regs_inst__1605_/RN clkbuf_leaf_38_clk/Z
+ spi_regs_inst__1547_/Q VDD VDD VSS VSS gf180mcu_fd_sc_mcu7t5v0__dffrnq_1
XFILLER_149_348 VDD VDD VSS VSS gf180mcu_fd_sc_mcu7t5v0__fill_2
Xwave_controller_x_inst__2190_ wave_controller_x_inst__2201_/A1 wave_controller_x_inst__2201_/A2
+ wave_controller_x_inst__2202_/A2 VDD VDD VSS VSS gf180mcu_fd_sc_mcu7t5v0__nand2_1
XFILLER_158_871 VDD VDD VSS VSS gf180mcu_fd_sc_mcu7t5v0__fillcap_4
Xspi_regs_inst__1478_ spi_regs_inst__1478_/D spi_regs_inst__1649_/RN clkload13/I spi_regs_inst__1478_/Q
+ VDD VDD VSS VSS gf180mcu_fd_sc_mcu7t5v0__dffrnq_1
XFILLER_117_212 VDD VDD VSS VSS gf180mcu_fd_sc_mcu7t5v0__fillcap_8
XFILLER_145_532 VDD VDD VSS VSS gf180mcu_fd_sc_mcu7t5v0__fillcap_4
XFILLER_127_18 VDD VDD VSS VSS gf180mcu_fd_sc_mcu7t5v0__fillcap_4
XFILLER_145_554 VDD VDD VSS VSS gf180mcu_fd_sc_mcu7t5v0__fillcap_4
XFILLER_145_576 VDD VDD VSS VSS gf180mcu_fd_sc_mcu7t5v0__fill_1
Xwave_controller_y_inst_fanout409 wave_controller_y_inst__2800_/S wave_controller_y_inst__2815_/A2
+ VDD VDD VSS VSS gf180mcu_fd_sc_mcu7t5v0__dlyb_1
XFILLER_160_524 VDD VDD VSS VSS gf180mcu_fd_sc_mcu7t5v0__fill_1
XTAP_TAPCELL_ROW_148_2318 VDD VSS gf180mcu_fd_sc_mcu7t5v0__filltie
XFILLER_86_313 VDD VDD VSS VSS gf180mcu_fd_sc_mcu7t5v0__fill_2
XFILLER_98_151 VDD VDD VSS VSS gf180mcu_fd_sc_mcu7t5v0__fill_1
XFILLER_98_173 VDD VDD VSS VSS gf180mcu_fd_sc_mcu7t5v0__fill_2
Xwave_controller_y_inst__1990_ wave_controller_y_inst__2979_/A2 spi_regs_inst__1159_/C2
+ wave_controller_y_inst__1999_/C VDD VDD VSS VSS gf180mcu_fd_sc_mcu7t5v0__nand2_1
Xwave_controller_x_inst__3713_ wave_controller_x_inst__3713_/D wave_controller_x_inst__3715_/RN
+ clkbuf_leaf_25_clk/Z wave_controller_x_inst__3713_/Q VDD VDD VSS VSS gf180mcu_fd_sc_mcu7t5v0__dffrnq_1
Xwave_controller_x_inst__1974_ wave_controller_x_inst__1981_/C wave_controller_x_inst__1973_/Z
+ spi_regs_inst__1324_/B2 VDD VDD VSS VSS gf180mcu_fd_sc_mcu7t5v0__nor2_1
XFILLER_101_668 VDD VDD VSS VSS gf180mcu_fd_sc_mcu7t5v0__fillcap_32
XFILLER_86_368 VDD VDD VSS VSS gf180mcu_fd_sc_mcu7t5v0__fillcap_4
XTAP_TAPCELL_ROW_161_2529 VDD VSS gf180mcu_fd_sc_mcu7t5v0__filltie
XTAP_TAPCELL_ROW_4_1_361 VDD VSS gf180mcu_fd_sc_mcu7t5v0__filltie
XTAP_TAPCELL_ROW_68_1000 VDD VSS gf180mcu_fd_sc_mcu7t5v0__filltie
Xwave_controller_y_inst_max_cap359 wave_controller_y_inst__2125_/A1 wave_controller_y_inst__2092_/A1
+ VDD VDD VSS VSS gf180mcu_fd_sc_mcu7t5v0__buf_2
Xwave_controller_y_inst__3660_ wave_controller_y_inst__3660_/D wave_controller_y_inst__3683_/RN
+ clkbuf_leaf_46_clk/Z spi_regs_inst__1199_/A1 VDD VDD VSS VSS gf180mcu_fd_sc_mcu7t5v0__dffrnq_1
Xwave_controller_x_inst__3644_ wave_controller_x_inst__3644_/D wave_controller_x_inst__3686_/RN
+ clkload27/I spi_regs_inst__1038_/A1 VDD VDD VSS VSS gf180mcu_fd_sc_mcu7t5v0__dffrnq_1
XTAP_TAPCELL_ROW_126_1948 VDD VSS gf180mcu_fd_sc_mcu7t5v0__filltie
XTAP_TAPCELL_ROW_126_1959 VDD VSS gf180mcu_fd_sc_mcu7t5v0__filltie
Xwave_controller_y_inst__2611_ wave_controller_y_inst__2612_/A1 wave_controller_y_inst__2610_/Z
+ wave_controller_y_inst__2629_/B VDD VDD VSS VSS gf180mcu_fd_sc_mcu7t5v0__nor2_1
Xwave_controller_y_inst__3591_ wave_controller_y_inst__3591_/I0 spi_regs_inst__1204_/B2
+ wave_controller_y_inst__3591_/S wave_controller_y_inst__3668_/D VDD VDD VSS VSS
+ gf180mcu_fd_sc_mcu7t5v0__mux2_2
Xwave_controller_x_inst__3575_ wave_controller_x_inst__3581_/A1 wave_controller_x_inst__3604_/A2
+ wave_controller_x_inst__3575_/B wave_controller_x_inst__3657_/D VDD VDD VSS VSS
+ gf180mcu_fd_sc_mcu7t5v0__oai21_1
Xspi_regs_inst_max_cap219 spi_regs_inst__1050_/C1 spi_regs_inst__1176_/B1 VDD VDD
+ VSS VSS gf180mcu_fd_sc_mcu7t5v0__buf_2
Xspi_regs_inst_max_cap208 spi_regs_inst__1106_/B1 spi_regs_inst__1227_/B1 VDD VDD
+ VSS VSS gf180mcu_fd_sc_mcu7t5v0__buf_2
XFILLER_42_405 VDD VDD VSS VSS gf180mcu_fd_sc_mcu7t5v0__fill_2
Xwave_controller_y_inst__2542_ wave_controller_y_inst__2542_/A1 wave_controller_y_inst__2540_/I
+ wave_controller_y_inst__2545_/B VDD VDD VSS VSS gf180mcu_fd_sc_mcu7t5v0__xnor2_1
Xwave_controller_x_inst__2526_ wave_controller_x_inst__2543_/A1 wave_controller_x_inst__2543_/A2
+ wave_controller_x_inst__2543_/C wave_controller_x_inst__2527_/A3 VDD VDD VSS VSS
+ gf180mcu_fd_sc_mcu7t5v0__oai21_1
Xsignal_processor_x_inst__250_ signal_processor_x_inst__250_/D fanout595/Z clkbuf_leaf_19_clk/Z
+ signal_processor_x_inst__250_/Q VDD VDD VSS VSS gf180mcu_fd_sc_mcu7t5v0__dffrnq_1
XFILLER_70_758 VDD VDD VSS VSS gf180mcu_fd_sc_mcu7t5v0__fill_2
XTAP_TAPCELL_ROW_81_1211 VDD VSS gf180mcu_fd_sc_mcu7t5v0__filltie
Xwave_controller_y_inst__2473_ wave_controller_y_inst__2490_/A2 wave_controller_y_inst__2517_/C
+ wave_controller_y_inst__2476_/A3 VDD VDD VSS VSS gf180mcu_fd_sc_mcu7t5v0__nand2_1
Xclkbuf_leaf_34_clk clkbuf_3_6__f_clk/Z clkload31/I VDD VDD VSS VSS gf180mcu_fd_sc_mcu7t5v0__clkbuf_8
XFILLER_74_1087 VDD VDD VSS VSS gf180mcu_fd_sc_mcu7t5v0__fillcap_64
Xwave_controller_x_inst__2457_ spi_regs_inst__1064_/B2 wave_controller_x_inst__2462_/A2
+ wave_controller_x_inst__2458_/B VDD VDD VSS VSS gf180mcu_fd_sc_mcu7t5v0__nand2_1
Xsignal_processor_x_inst__181_ signal_processor_x_inst__239_/Q signal_processor_x_inst__191_/A2
+ signal_processor_x_inst__181_/B signal_processor_x_inst__239_/D VDD VDD VSS VSS
+ gf180mcu_fd_sc_mcu7t5v0__oai21_1
XFILLER_161_1046 VDD VDD VSS VSS gf180mcu_fd_sc_mcu7t5v0__fillcap_4
Xwave_controller_x_inst__2388_ wave_controller_x_inst__2389_/A1 wave_controller_x_inst__2389_/A2
+ wave_controller_x_inst__2388_/B wave_controller_x_inst__2396_/C VDD VDD VSS VSS
+ gf180mcu_fd_sc_mcu7t5v0__aoi21_1
XFILLER_6_317 VDD VDD VSS VSS gf180mcu_fd_sc_mcu7t5v0__fillcap_4
XFILLER_148_381 VDD VDD VSS VSS gf180mcu_fd_sc_mcu7t5v0__fillcap_4
XFILLER_124_705 VDD VDD VSS VSS gf180mcu_fd_sc_mcu7t5v0__fillcap_4
XTAP_TAPCELL_ROW_79_1173 VDD VSS gf180mcu_fd_sc_mcu7t5v0__filltie
XTAP_TAPCELL_ROW_79_1184 VDD VSS gf180mcu_fd_sc_mcu7t5v0__filltie
Xwave_controller_y_inst__3025_ wave_controller_y_inst__3449_/A1 wave_controller_y_inst__3458_/A1
+ wave_controller_y_inst__3025_/A3 wave_controller_y_inst__3033_/A2 VDD VDD VSS VSS
+ gf180mcu_fd_sc_mcu7t5v0__nor3_1
XFILLER_163_395 VDD VDD VSS VSS gf180mcu_fd_sc_mcu7t5v0__fillcap_8
XTAP_TAPCELL_ROW_42_1_650 VDD VSS gf180mcu_fd_sc_mcu7t5v0__filltie
Xwave_controller_x_inst__3009_ wave_controller_x_inst__3420_/A1 wave_controller_x_inst__3036_/B2
+ wave_controller_x_inst__3012_/A1 VDD VDD VSS VSS gf180mcu_fd_sc_mcu7t5v0__nand2_1
XFILLER_123_259 VDD VDD VSS VSS gf180mcu_fd_sc_mcu7t5v0__fill_2
XFILLER_151_546 VDD VDD VSS VSS gf180mcu_fd_sc_mcu7t5v0__fillcap_8
XFILLER_104_451 VDD VDD VSS VSS gf180mcu_fd_sc_mcu7t5v0__fillcap_4
XFILLER_77_313 VDD VDD VSS VSS gf180mcu_fd_sc_mcu7t5v0__fillcap_8
XTAP_TAPCELL_ROW_92_1395 VDD VSS gf180mcu_fd_sc_mcu7t5v0__filltie
XFILLER_92_305 VDD VDD VSS VSS gf180mcu_fd_sc_mcu7t5v0__fillcap_4
XFILLER_58_571 VDD VDD VSS VSS gf180mcu_fd_sc_mcu7t5v0__fill_1
XFILLER_58_582 VDD VDD VSS VSS gf180mcu_fd_sc_mcu7t5v0__fillcap_8
XFILLER_86_891 VDD VDD VSS VSS gf180mcu_fd_sc_mcu7t5v0__fill_1
XFILLER_18_446 VDD VDD VSS VSS gf180mcu_fd_sc_mcu7t5v0__fillcap_8
XFILLER_18_457 VDD VDD VSS VSS gf180mcu_fd_sc_mcu7t5v0__fillcap_16
Xwave_controller_y_inst__2809_ wave_controller_y_inst__2809_/A1 wave_controller_y_inst__2809_/A2
+ wave_controller_y_inst__2809_/B1 wave_controller_y_inst__3707_/Q wave_controller_y_inst__2810_/B
+ VDD VDD VSS VSS gf180mcu_fd_sc_mcu7t5v0__aoi22_1
Xspi_regs_inst__0780_ spi_regs_inst__1535_/Q spi_regs_inst__1412_/I1 spi_regs_inst__0780_/S
+ spi_regs_inst__1535_/D VDD VDD VSS VSS gf180mcu_fd_sc_mcu7t5v0__mux2_2
XFILLER_45_276 VDD VDD VSS VSS gf180mcu_fd_sc_mcu7t5v0__fillcap_4
XFILLER_93_98 VDD VDD VSS VSS gf180mcu_fd_sc_mcu7t5v0__fill_1
XFILLER_33_438 VDD VDD VSS VSS gf180mcu_fd_sc_mcu7t5v0__fillcap_16
XFILLER_61_769 VDD VDD VSS VSS gf180mcu_fd_sc_mcu7t5v0__fill_1
XTAP_TAPCELL_ROW_56_794 VDD VSS gf180mcu_fd_sc_mcu7t5v0__filltie
Xclkbuf_leaf_25_clk clkbuf_3_5__f_clk/Z clkbuf_leaf_25_clk/Z VDD VDD VSS VSS gf180mcu_fd_sc_mcu7t5v0__clkbuf_8
XFILLER_158_101 VDD VDD VSS VSS gf180mcu_fd_sc_mcu7t5v0__fillcap_4
XFILLER_92_1165 VDD VDD VSS VSS gf180mcu_fd_sc_mcu7t5v0__fillcap_4
XFILLER_9_100 VDD VDD VSS VSS gf180mcu_fd_sc_mcu7t5v0__fill_2
Xspi_regs_inst__1401_ fanout524/Z spi_regs_inst__1443_/I1 spi_regs_inst__1403_/S spi_regs_inst__1475_/D
+ VDD VDD VSS VSS gf180mcu_fd_sc_mcu7t5v0__mux2_2
Xspi_regs_inst__1332_ spi_regs_inst__1332_/A1 spi_regs_inst_wire214/Z spi_regs_inst__1332_/B1
+ fanout521/Z spi_regs_inst__1338_/A1 VDD VDD VSS VSS gf180mcu_fd_sc_mcu7t5v0__aoi22_1
XTAP_TAPCELL_ROW_99_1516 VDD VSS gf180mcu_fd_sc_mcu7t5v0__filltie
XTAP_TAPCELL_ROW_99_1505 VDD VSS gf180mcu_fd_sc_mcu7t5v0__filltie
XFILLER_146_307 VDD VDD VSS VSS gf180mcu_fd_sc_mcu7t5v0__fillcap_8
XFILLER_127_532 VDD VDD VSS VSS gf180mcu_fd_sc_mcu7t5v0__fillcap_4
XTAP_TAPCELL_ROW_28_1_540 VDD VSS gf180mcu_fd_sc_mcu7t5v0__filltie
Xspi_regs_inst__1263_ spi_regs_inst__1263_/A1 spi_regs_inst__1263_/A2 spi_regs_inst__1263_/A3
+ spi_regs_inst__1263_/A4 spi_regs_inst__1264_/A4 VDD VDD VSS VSS gf180mcu_fd_sc_mcu7t5v0__nand4_1
XFILLER_154_362 VDD VDD VSS VSS gf180mcu_fd_sc_mcu7t5v0__fillcap_16
Xspi_regs_inst__1194_ wire454/Z spi_regs_inst__1194_/A2 spi_regs_inst__1261_/B1 spi_regs_inst__1194_/B2
+ spi_regs_inst__1196_/A2 VDD VDD VSS VSS gf180mcu_fd_sc_mcu7t5v0__aoi22_1
XFILLER_115_749 VDD VDD VSS VSS gf180mcu_fd_sc_mcu7t5v0__fillcap_16
Xspi_regs_inst_wire308 spi_regs_inst_wire308/I spi_regs_inst__0824_/S VDD VDD VSS
+ VSS gf180mcu_fd_sc_mcu7t5v0__buf_2
XFILLER_114_237 VDD VDD VSS VSS gf180mcu_fd_sc_mcu7t5v0__fillcap_8
Xsignal_processor_y_inst__213_ signal_processor_y_inst__215_/A1 signal_processor_y_inst__213_/A2
+ signal_processor_y_inst__213_/B signal_processor_y_inst__225_/D VDD VDD VSS VSS
+ gf180mcu_fd_sc_mcu7t5v0__oai21_1
XFILLER_110_421 VDD VDD VSS VSS gf180mcu_fd_sc_mcu7t5v0__fillcap_32
XFILLER_123_793 VDD VDD VSS VSS gf180mcu_fd_sc_mcu7t5v0__fill_1
XFILLER_96_633 VDD VDD VSS VSS gf180mcu_fd_sc_mcu7t5v0__fillcap_32
Xsignal_processor_y_inst__144_ spi_regs_inst__1144_/B2 signal_processor_y_inst__212_/A2
+ signal_processor_y_inst__145_/B VDD VDD VSS VSS gf180mcu_fd_sc_mcu7t5v0__nand2_1
XFILLER_68_368 VDD VDD VSS VSS gf180mcu_fd_sc_mcu7t5v0__fill_1
XFILLER_84_828 VDD VDD VSS VSS gf180mcu_fd_sc_mcu7t5v0__fill_1
XFILLER_110_487 VDD VDD VSS VSS gf180mcu_fd_sc_mcu7t5v0__fillcap_16
XFILLER_114_1081 VDD VDD VSS VSS gf180mcu_fd_sc_mcu7t5v0__fillcap_4
XPHY_EDGE_ROW_147_Right_147 VDD VSS gf180mcu_fd_sc_mcu7t5v0__endcap
XTAP_TAPCELL_ROW_143_2237 VDD VSS gf180mcu_fd_sc_mcu7t5v0__filltie
XFILLER_149_1122 VDD VDD VSS VSS gf180mcu_fd_sc_mcu7t5v0__fillcap_32
XFILLER_36_221 VDD VDD VSS VSS gf180mcu_fd_sc_mcu7t5v0__fill_2
XTAP_TAPCELL_ROW_108_1656 VDD VSS gf180mcu_fd_sc_mcu7t5v0__filltie
Xspi_regs_inst__0978_ spi_regs_inst__1366_/A1 spi_regs_inst__1628_/Q spi_regs_inst__0918_/Z
+ spi_regs_inst__1028_/A2 VDD VDD VSS VSS gf180mcu_fd_sc_mcu7t5v0__nand3_1
X_87_ _87_/I _87_/Z VDD VDD VSS VSS gf180mcu_fd_sc_mcu7t5v0__buf_1
XFILLER_92_883 VDD VDD VSS VSS gf180mcu_fd_sc_mcu7t5v0__fill_2
XTAP_TAPCELL_ROW_108_1667 VDD VSS gf180mcu_fd_sc_mcu7t5v0__filltie
Xwave_controller_x_inst__3360_ wave_controller_x_inst__3360_/A1 wave_controller_x_inst__3310_/C
+ wave_controller_x_inst__3360_/Z VDD VDD VSS VSS gf180mcu_fd_sc_mcu7t5v0__xor2_1
Xclkbuf_leaf_16_clk clkbuf_3_4__f_clk/Z clkload23/I VDD VDD VSS VSS gf180mcu_fd_sc_mcu7t5v0__clkbuf_8
XFILLER_51_279 VDD VDD VSS VSS gf180mcu_fd_sc_mcu7t5v0__fill_1
XTAP_TAPCELL_ROW_121_1867 VDD VSS gf180mcu_fd_sc_mcu7t5v0__filltie
Xwave_controller_x_inst__3291_ wave_controller_x_inst__3291_/I wave_controller_x_inst__3292_/B
+ VDD VDD VSS VSS gf180mcu_fd_sc_mcu7t5v0__clkinv_1
Xwave_controller_x_inst__2311_ wave_controller_x_inst__2311_/A1 wave_controller_x_inst__2294_/Z
+ wave_controller_x_inst__2313_/B VDD VDD VSS VSS gf180mcu_fd_sc_mcu7t5v0__nor2_1
XFILLER_32_471 VDD VDD VSS VSS gf180mcu_fd_sc_mcu7t5v0__fill_1
XFILLER_60_780 VDD VDD VSS VSS gf180mcu_fd_sc_mcu7t5v0__fillcap_16
XTAP_TAPCELL_ROW_121_1878 VDD VSS gf180mcu_fd_sc_mcu7t5v0__filltie
Xwave_controller_x_inst__2242_ fanout526/Z wave_controller_x_inst__2242_/A2 wave_controller_x_inst__2242_/A3
+ wave_controller_x_inst__2242_/Z VDD VDD VSS VSS gf180mcu_fd_sc_mcu7t5v0__xor3_1
XFILLER_149_189 VDD VDD VSS VSS gf180mcu_fd_sc_mcu7t5v0__fillcap_8
XTAP_TAPCELL_ROW_158_2480 VDD VSS gf180mcu_fd_sc_mcu7t5v0__filltie
XTAP_TAPCELL_ROW_158_2491 VDD VSS gf180mcu_fd_sc_mcu7t5v0__filltie
XTAP_TAPCELL_ROW_7_1_387 VDD VSS gf180mcu_fd_sc_mcu7t5v0__filltie
Xwave_controller_x_inst__2173_ wave_controller_x_inst__2451_/A1 wave_controller_x_inst__2173_/A2
+ wave_controller_x_inst__2173_/Z VDD VDD VSS VSS gf180mcu_fd_sc_mcu7t5v0__xor2_1
XFILLER_121_1052 VDD VDD VSS VSS gf180mcu_fd_sc_mcu7t5v0__fillcap_64
XFILLER_133_502 VDD VDD VSS VSS gf180mcu_fd_sc_mcu7t5v0__fill_1
XFILLER_133_579 VDD VDD VSS VSS gf180mcu_fd_sc_mcu7t5v0__fill_2
XFILLER_160_387 VDD VDD VSS VSS gf180mcu_fd_sc_mcu7t5v0__fillcap_4
XFILLER_102_944 VDD VDD VSS VSS gf180mcu_fd_sc_mcu7t5v0__fill_1
XFILLER_120_229 VDD VDD VSS VSS gf180mcu_fd_sc_mcu7t5v0__fillcap_16
XTAP_TAPCELL_ROW_74_1092 VDD VSS gf180mcu_fd_sc_mcu7t5v0__filltie
XFILLER_47_36 VDD VDD VSS VSS gf180mcu_fd_sc_mcu7t5v0__fill_1
XTAP_TAPCELL_ROW_37_1_608 VDD VSS gf180mcu_fd_sc_mcu7t5v0__filltie
Xwave_controller_y_inst__1973_ wave_controller_y_inst__1973_/A1 wave_controller_y_inst__1973_/A2
+ wave_controller_y_inst__1972_/B wave_controller_y_inst__1973_/Z VDD VDD VSS VSS
+ gf180mcu_fd_sc_mcu7t5v0__and3_1
Xwave_controller_x_inst__1957_ wave_controller_x_inst__1956_/B wave_controller_x_inst__1957_/A2
+ spi_regs_inst__1208_/B2 VDD VDD VSS VSS gf180mcu_fd_sc_mcu7t5v0__xnor2_1
XFILLER_101_487 VDD VDD VSS VSS gf180mcu_fd_sc_mcu7t5v0__fill_2
XFILLER_75_839 VDD VDD VSS VSS gf180mcu_fd_sc_mcu7t5v0__fill_1
XPHY_EDGE_ROW_114_Right_114 VDD VSS gf180mcu_fd_sc_mcu7t5v0__endcap
Xwave_controller_y_inst_max_cap123 wave_controller_y_inst_wire124/Z wave_controller_y_inst__3149_/B2
+ VDD VDD VSS VSS gf180mcu_fd_sc_mcu7t5v0__clkbuf_1
Xwave_controller_y_inst__3712_ wave_controller_y_inst__3712_/D wave_controller_y_inst__3716_/RN
+ clkload14/I wave_controller_y_inst__3712_/Q VDD VDD VSS VSS gf180mcu_fd_sc_mcu7t5v0__dffrnq_1
XFILLER_74_349 VDD VDD VSS VSS gf180mcu_fd_sc_mcu7t5v0__fill_1
Xwave_controller_y_inst_max_cap145 wave_controller_y_inst__3491_/B wave_controller_y_inst__3496_/B
+ VDD VDD VSS VSS gf180mcu_fd_sc_mcu7t5v0__buf_2
Xwave_controller_y_inst_max_cap178 wave_controller_y_inst__3034_/A2 wave_controller_y_inst__3409_/A3
+ VDD VDD VSS VSS gf180mcu_fd_sc_mcu7t5v0__clkbuf_1
Xwave_controller_y_inst__3643_ wave_controller_y_inst__3643_/D wave_controller_y_inst__3711_/RN
+ clkload15/I max_cap431/I VDD VDD VSS VSS gf180mcu_fd_sc_mcu7t5v0__dffrnq_1
Xwave_controller_x_inst__3627_ wave_controller_x_inst__3627_/D wave_controller_x_inst__3715_/RN
+ clkload28/I spi_regs_inst__1333_/A1 VDD VDD VSS VSS gf180mcu_fd_sc_mcu7t5v0__dffrnq_1
Xwave_controller_x_inst__1888_ spi_regs_inst__1188_/C1 wave_controller_x_inst__3554_/B2
+ VDD VDD VSS VSS gf180mcu_fd_sc_mcu7t5v0__clkinv_1
XFILLER_15_438 VDD VDD VSS VSS gf180mcu_fd_sc_mcu7t5v0__fill_1
XTAP_TAPCELL_ROW_53_731 VDD VSS gf180mcu_fd_sc_mcu7t5v0__filltie
XTAP_TAPCELL_ROW_53_742 VDD VSS gf180mcu_fd_sc_mcu7t5v0__filltie
Xwave_controller_y_inst__3574_ spi_regs_inst__1034_/A1 wave_controller_y_inst_wire48/Z
+ wave_controller_y_inst__3575_/B VDD VDD VSS VSS gf180mcu_fd_sc_mcu7t5v0__nand2_1
Xwave_controller_x_inst__3558_ wave_controller_x_inst__2797_/C wave_controller_x_inst_wire333/Z
+ wave_controller_x_inst__3594_/I0 VDD VDD VSS VSS gf180mcu_fd_sc_mcu7t5v0__nor2_1
XFILLER_30_419 VDD VDD VSS VSS gf180mcu_fd_sc_mcu7t5v0__fill_2
XFILLER_70_577 VDD VDD VSS VSS gf180mcu_fd_sc_mcu7t5v0__fill_1
XTAP_TAPCELL_ROW_53_753 VDD VSS gf180mcu_fd_sc_mcu7t5v0__filltie
Xwave_controller_y_inst__2525_ wave_controller_y_inst__2543_/B1 wave_controller_y_inst__2524_/Z
+ wave_controller_y_inst__2545_/A1 VDD VDD VSS VSS gf180mcu_fd_sc_mcu7t5v0__nand2_1
Xwave_controller_x_inst__3489_ wave_controller_x_inst__3489_/A1 wave_controller_x_inst_wire84/Z
+ wave_controller_x_inst__3489_/B1 wave_controller_x_inst__3489_/B2 wave_controller_x_inst__3489_/C
+ wave_controller_x_inst__3490_/B VDD VDD VSS VSS gf180mcu_fd_sc_mcu7t5v0__aoi221_1
Xwave_controller_x_inst__2509_ wave_controller_x_inst__2481_/I wave_controller_x_inst__2509_/A2
+ wave_controller_x_inst__2509_/A3 wave_controller_x_inst__2509_/B wave_controller_x_inst_wire115/I
+ VDD VDD VSS VSS gf180mcu_fd_sc_mcu7t5v0__oai31_1
Xsignal_processor_x_inst__233_ signal_processor_x_inst__233_/D fanout583/Z clkload23/I
+ signal_processor_x_inst__233_/Q VDD VDD VSS VSS gf180mcu_fd_sc_mcu7t5v0__dffrnq_1
Xwave_controller_y_inst__2456_ spi_regs_inst__0967_/A1 wave_controller_y_inst__3497_/A1
+ wave_controller_y_inst__2456_/B wave_controller_y_inst__2462_/A2 VDD VDD VSS VSS
+ gf180mcu_fd_sc_mcu7t5v0__oai21_1
Xsignal_processor_x_inst__164_ signal_processor_x_inst__187_/A1 signal_processor_x_inst__163_/Z
+ signal_processor_x_inst__232_/D VDD VDD VSS VSS gf180mcu_fd_sc_mcu7t5v0__nor2_1
Xwave_controller_y_inst__2387_ fanout513/Z max_cap425/Z wave_controller_y_inst__2383_/Z
+ wave_controller_y_inst__2388_/B VDD VDD VSS VSS gf180mcu_fd_sc_mcu7t5v0__xor3_1
XFILLER_128_329 VDD VDD VSS VSS gf180mcu_fd_sc_mcu7t5v0__fill_2
XFILLER_149_690 VDD VDD VSS VSS gf180mcu_fd_sc_mcu7t5v0__fillcap_8
XFILLER_124_524 VDD VDD VSS VSS gf180mcu_fd_sc_mcu7t5v0__fill_1
XFILLER_136_384 VDD VDD VSS VSS gf180mcu_fd_sc_mcu7t5v0__fill_1
XTAP_TAPCELL_ROW_94_1435 VDD VSS gf180mcu_fd_sc_mcu7t5v0__filltie
XTAP_TAPCELL_ROW_94_1424 VDD VSS gf180mcu_fd_sc_mcu7t5v0__filltie
XFILLER_152_877 VDD VDD VSS VSS gf180mcu_fd_sc_mcu7t5v0__fillcap_64
Xwave_controller_y_inst__3008_ wave_controller_y_inst__3010_/B wave_controller_y_inst__3008_/A2
+ wave_controller_y_inst__3097_/A1 wave_controller_y_inst_wire25/I VDD VDD VSS VSS
+ gf180mcu_fd_sc_mcu7t5v0__nand3_1
XFILLER_105_793 VDD VDD VSS VSS gf180mcu_fd_sc_mcu7t5v0__fillcap_16
XFILLER_120_741 VDD VDD VSS VSS gf180mcu_fd_sc_mcu7t5v0__fillcap_64
XFILLER_78_655 VDD VDD VSS VSS gf180mcu_fd_sc_mcu7t5v0__fill_1
XFILLER_77_165 VDD VDD VSS VSS gf180mcu_fd_sc_mcu7t5v0__fill_1
Xspi_regs_inst__0901_ spi_regs_inst__0901_/A1 spi_regs_inst__0749_/Z spi_regs_inst__0939_/S
+ spi_regs_inst__0928_/B VDD VDD VSS VSS gf180mcu_fd_sc_mcu7t5v0__nand3_1
X_10_ _10_/A1 _10_/A2 _10_/Z VDD VDD VSS VSS gf180mcu_fd_sc_mcu7t5v0__or2_1
XFILLER_78_699 VDD VDD VSS VSS gf180mcu_fd_sc_mcu7t5v0__fillcap_4
Xspi_regs_inst__0832_ spi_regs_inst__1574_/Q spi_regs_inst__1451_/I1 spi_regs_inst__0835_/S
+ spi_regs_inst__1574_/D VDD VDD VSS VSS gf180mcu_fd_sc_mcu7t5v0__mux2_2
XFILLER_37_80 VDD VDD VSS VSS gf180mcu_fd_sc_mcu7t5v0__fillcap_8
Xspi_regs_inst__0763_ spi_regs_inst__1523_/Q spi_regs_inst_wire480/Z spi_regs_inst__0766_/S
+ spi_regs_inst__1523_/D VDD VDD VSS VSS gf180mcu_fd_sc_mcu7t5v0__mux2_2
XFILLER_33_279 VDD VDD VSS VSS gf180mcu_fd_sc_mcu7t5v0__fill_1
XTAP_TAPCELL_ROW_103_1575 VDD VSS gf180mcu_fd_sc_mcu7t5v0__filltie
XFILLER_146_104 VDD VDD VSS VSS gf180mcu_fd_sc_mcu7t5v0__fill_1
Xspi_regs_inst__1315_ spi_regs_inst__1315_/A1 spi_regs_inst_wire290/Z spi_regs_inst__1315_/B1
+ spi_regs_inst__1526_/Q spi_regs_inst__1326_/A2 VDD VDD VSS VSS gf180mcu_fd_sc_mcu7t5v0__aoi22_1
XFILLER_128_874 VDD VDD VSS VSS gf180mcu_fd_sc_mcu7t5v0__fill_1
XFILLER_146_159 VDD VDD VSS VSS gf180mcu_fd_sc_mcu7t5v0__fillcap_8
Xspi_regs_inst__1246_ spi_regs_inst__1519_/Q spi_regs_inst__1246_/A2 spi_regs_inst__1246_/B1
+ max_cap433/Z spi_regs_inst__1248_/A3 VDD VDD VSS VSS gf180mcu_fd_sc_mcu7t5v0__aoi22_1
XFILLER_127_384 VDD VDD VSS VSS gf180mcu_fd_sc_mcu7t5v0__fillcap_16
XFILLER_143_822 VDD VDD VSS VSS gf180mcu_fd_sc_mcu7t5v0__fill_1
Xspi_regs_inst_wire105 spi_regs_inst_wire105/I spi_regs_inst_wire105/Z VDD VDD VSS
+ VSS gf180mcu_fd_sc_mcu7t5v0__clkbuf_2
XFILLER_115_546 VDD VDD VSS VSS gf180mcu_fd_sc_mcu7t5v0__fillcap_8
XFILLER_89_909 VDD VDD VSS VSS gf180mcu_fd_sc_mcu7t5v0__fill_1
Xspi_regs_inst__1177_ spi_regs_inst__1544_/Q spi_regs_inst_wire252/Z spi_regs_inst__1241_/B1
+ spi_regs_inst__1177_/B2 spi_regs_inst__1214_/A1 VDD VDD VSS VSS gf180mcu_fd_sc_mcu7t5v0__aoi22_1
XFILLER_142_387 VDD VDD VSS VSS gf180mcu_fd_sc_mcu7t5v0__fillcap_4
XFILLER_69_611 VDD VDD VSS VSS gf180mcu_fd_sc_mcu7t5v0__fill_2
Xclkbuf_leaf_5_clk clkbuf_leaf_8_clk/I clkload8/I VDD VDD VSS VSS gf180mcu_fd_sc_mcu7t5v0__clkbuf_8
XFILLER_102_229 VDD VDD VSS VSS gf180mcu_fd_sc_mcu7t5v0__fillcap_16
XFILLER_130_549 VDD VDD VSS VSS gf180mcu_fd_sc_mcu7t5v0__fillcap_4
XFILLER_155_1170 VDD VDD VSS VSS gf180mcu_fd_sc_mcu7t5v0__fillcap_4
Xwave_controller_x_inst__2860_ wave_controller_x_inst__3693_/Q wave_controller_x_inst__3433_/A1
+ wave_controller_x_inst__2885_/A1 VDD VDD VSS VSS gf180mcu_fd_sc_mcu7t5v0__nand2_1
XFILLER_110_240 VDD VDD VSS VSS gf180mcu_fd_sc_mcu7t5v0__fillcap_4
XFILLER_116_1165 VDD VDD VSS VSS gf180mcu_fd_sc_mcu7t5v0__fillcap_4
Xwave_controller_x_inst__2791_ max_cap458/I spi_regs_inst__1286_/B2 wave_controller_x_inst__2805_/S
+ wave_controller_x_inst__2791_/Z VDD VDD VSS VSS gf180mcu_fd_sc_mcu7t5v0__mux2_2
Xwave_controller_x_inst__1811_ spi_regs_inst__1550_/Q wave_controller_x_inst__3304_/A2
+ VDD VDD VSS VSS gf180mcu_fd_sc_mcu7t5v0__clkinv_1
XFILLER_110_284 VDD VDD VSS VSS gf180mcu_fd_sc_mcu7t5v0__fill_2
XFILLER_68_187 VDD VDD VSS VSS gf180mcu_fd_sc_mcu7t5v0__fill_1
XFILLER_99_1116 VDD VDD VSS VSS gf180mcu_fd_sc_mcu7t5v0__fillcap_4
Xsignal_processor_y_inst__127_ fanout389/Z signal_processor_y_inst__247_/Q signal_processor_y_inst__248_/D
+ VDD VDD VSS VSS gf180mcu_fd_sc_mcu7t5v0__and2_1
XFILLER_80_820 VDD VDD VSS VSS gf180mcu_fd_sc_mcu7t5v0__fillcap_4
XTAP_TAPCELL_ROW_123_1907 VDD VSS gf180mcu_fd_sc_mcu7t5v0__filltie
XFILLER_52_533 VDD VDD VSS VSS gf180mcu_fd_sc_mcu7t5v0__fill_2
XFILLER_80_853 VDD VDD VSS VSS gf180mcu_fd_sc_mcu7t5v0__fill_1
Xwave_controller_x_inst__3412_ wave_controller_x_inst__3692_/Q wave_controller_x_inst__2892_/Z
+ wave_controller_x_inst__3414_/A2 VDD VDD VSS VSS gf180mcu_fd_sc_mcu7t5v0__nor2_1
Xwave_controller_x_inst__3343_ spi_regs_inst__1540_/Q wave_controller_x_inst__2117_/B
+ wave_controller_x_inst__3343_/Z VDD VDD VSS VSS gf180mcu_fd_sc_mcu7t5v0__xor2_1
Xwave_controller_y_inst__3290_ wave_controller_y_inst__3290_/A1 spi_regs_inst__1603_/Q
+ wave_controller_y_inst__3291_/I VDD VDD VSS VSS gf180mcu_fd_sc_mcu7t5v0__xor2_1
Xwave_controller_y_inst__2310_ wave_controller_y_inst__2310_/I wave_controller_y_inst__2313_/A2
+ VDD VDD VSS VSS gf180mcu_fd_sc_mcu7t5v0__clkinv_1
XFILLER_71_1046 VDD VDD VSS VSS gf180mcu_fd_sc_mcu7t5v0__fillcap_4
Xwave_controller_y_inst__2241_ fanout505/Z wave_controller_y_inst__2241_/A2 wave_controller_y_inst__2265_/A1
+ VDD VDD VSS VSS gf180mcu_fd_sc_mcu7t5v0__nor2_1
Xwave_controller_x_inst__3274_ wave_controller_x_inst__3290_/A1 spi_regs_inst__1545_/Q
+ wave_controller_x_inst__3274_/Z VDD VDD VSS VSS gf180mcu_fd_sc_mcu7t5v0__and2_1
XFILLER_166_947 VDD VDD VSS VSS gf180mcu_fd_sc_mcu7t5v0__fillcap_64
Xwave_controller_x_inst__2225_ wave_controller_x_inst_wire183/Z wave_controller_x_inst__2257_/A1
+ wave_controller_x_inst__2239_/A2 VDD VDD VSS VSS gf180mcu_fd_sc_mcu7t5v0__nand2_1
XFILLER_146_660 VDD VDD VSS VSS gf180mcu_fd_sc_mcu7t5v0__fillcap_4
Xwave_controller_y_inst__2172_ spi_regs_inst__1101_/A1 wave_controller_y_inst__2173_/A2
+ wave_controller_y_inst__2187_/A1 VDD VDD VSS VSS gf180mcu_fd_sc_mcu7t5v0__nor2_1
Xwave_controller_x_inst__2156_ wave_controller_x_inst__2756_/A1 wave_controller_x_inst__2756_/A2
+ wave_controller_x_inst__3733_/D VDD VDD VSS VSS gf180mcu_fd_sc_mcu7t5v0__xor2_1
XFILLER_146_671 VDD VDD VSS VSS gf180mcu_fd_sc_mcu7t5v0__fill_2
XFILLER_146_693 VDD VDD VSS VSS gf180mcu_fd_sc_mcu7t5v0__fillcap_8
XFILLER_152_129 VDD VDD VSS VSS gf180mcu_fd_sc_mcu7t5v0__fillcap_32
XTAP_TAPCELL_ROW_76_1132 VDD VSS gf180mcu_fd_sc_mcu7t5v0__filltie
XFILLER_145_192 VDD VDD VSS VSS gf180mcu_fd_sc_mcu7t5v0__fill_2
Xwave_controller_x_inst__2087_ wave_controller_x_inst__2755_/A1 wave_controller_x_inst__2086_/Z
+ wave_controller_x_inst__2104_/A2 VDD VDD VSS VSS gf180mcu_fd_sc_mcu7t5v0__nand2_1
XFILLER_134_877 VDD VDD VSS VSS gf180mcu_fd_sc_mcu7t5v0__fillcap_64
XFILLER_99_290 VDD VDD VSS VSS gf180mcu_fd_sc_mcu7t5v0__fillcap_4
XFILLER_101_240 VDD VDD VSS VSS gf180mcu_fd_sc_mcu7t5v0__fill_2
XFILLER_102_752 VDD VDD VSS VSS gf180mcu_fd_sc_mcu7t5v0__fillcap_8
XFILLER_59_154 VDD VDD VSS VSS gf180mcu_fd_sc_mcu7t5v0__fill_2
XFILLER_101_284 VDD VDD VSS VSS gf180mcu_fd_sc_mcu7t5v0__fill_1
XTAP_TAPCELL_ROW_58_834 VDD VSS gf180mcu_fd_sc_mcu7t5v0__filltie
Xwave_controller_y_inst__1956_ wave_controller_y_inst__3376_/B spi_regs_inst__1159_/A1
+ wave_controller_y_inst__1956_/B wave_controller_y_inst__1962_/A2 VDD VDD VSS VSS
+ gf180mcu_fd_sc_mcu7t5v0__oai21_1
Xwave_controller_x_inst__2989_ wave_controller_x_inst__3713_/Q fanout536/Z wave_controller_x_inst__2989_/B
+ wave_controller_x_inst__3075_/A1 VDD VDD VSS VSS gf180mcu_fd_sc_mcu7t5v0__aoi21_1
XFILLER_47_349 VDD VDD VSS VSS gf180mcu_fd_sc_mcu7t5v0__fill_1
XFILLER_74_45 VDD VDD VSS VSS gf180mcu_fd_sc_mcu7t5v0__fillcap_8
Xwave_controller_y_inst__1887_ spi_regs_inst__1138_/B2 wave_controller_y_inst__3551_/B2
+ VDD VDD VSS VSS gf180mcu_fd_sc_mcu7t5v0__clkinv_1
XFILLER_55_382 VDD VDD VSS VSS gf180mcu_fd_sc_mcu7t5v0__fill_2
XFILLER_71_842 VDD VDD VSS VSS gf180mcu_fd_sc_mcu7t5v0__fill_1
Xwave_controller_y_inst__3626_ wave_controller_y_inst__3626_/D wave_controller_y_inst__3699_/RN
+ clkload11/I spi_regs_inst__1310_/A1 VDD VDD VSS VSS gf180mcu_fd_sc_mcu7t5v0__dffrnq_1
XFILLER_130_51 VDD VDD VSS VSS gf180mcu_fd_sc_mcu7t5v0__fill_2
XFILLER_167_1085 VDD VDD VSS VSS gf180mcu_fd_sc_mcu7t5v0__fill_2
XFILLER_82_190 VDD VDD VSS VSS gf180mcu_fd_sc_mcu7t5v0__fillcap_8
Xwave_controller_y_inst__3557_ wave_controller_y_inst__3557_/A1 wave_controller_y_inst__3557_/A2
+ wave_controller_y_inst__3557_/A3 wave_controller_y_inst__3557_/B1 wave_controller_y_inst__3557_/B2
+ wave_controller_y_inst__3648_/D VDD VDD VSS VSS gf180mcu_fd_sc_mcu7t5v0__oai32_1
XFILLER_90_22 VDD VDD VSS VSS gf180mcu_fd_sc_mcu7t5v0__fill_1
Xwave_controller_y_inst__2508_ wave_controller_y_inst__2505_/Z wave_controller_y_inst__2510_/A2
+ wave_controller_y_inst__2543_/A1 VDD VDD VSS VSS gf180mcu_fd_sc_mcu7t5v0__nor2_1
Xsignal_processor_x_inst__216_ signal_processor_x_inst__216_/D signal_processor_x_inst__242_/RN
+ clkload10/I _90_/I VDD VDD VSS VSS gf180mcu_fd_sc_mcu7t5v0__dffrnq_1
XFILLER_129_616 VDD VDD VSS VSS gf180mcu_fd_sc_mcu7t5v0__fill_2
XFILLER_23_290 VDD VDD VSS VSS gf180mcu_fd_sc_mcu7t5v0__fill_1
XFILLER_90_66 VDD VDD VSS VSS gf180mcu_fd_sc_mcu7t5v0__fill_2
Xwave_controller_y_inst__3488_ wave_controller_y_inst__3488_/I wave_controller_y_inst__3489_/B2
+ VDD VDD VSS VSS gf180mcu_fd_sc_mcu7t5v0__clkinv_1
XFILLER_128_104 VDD VDD VSS VSS gf180mcu_fd_sc_mcu7t5v0__fill_1
XFILLER_128_115 VDD VDD VSS VSS gf180mcu_fd_sc_mcu7t5v0__fillcap_4
Xwave_controller_y_inst__2439_ wave_controller_y_inst__2027_/B spi_regs_inst__1204_/B2
+ wave_controller_y_inst__2439_/B wave_controller_y_inst__2440_/A3 VDD VDD VSS VSS
+ gf180mcu_fd_sc_mcu7t5v0__aoi21_1
Xsignal_processor_x_inst__147_ spi_regs_inst__1200_/B2 signal_processor_x_inst__214_/A2
+ signal_processor_x_inst__148_/B VDD VDD VSS VSS gf180mcu_fd_sc_mcu7t5v0__nand2_1
XFILLER_139_60 VDD VDD VSS VSS gf180mcu_fd_sc_mcu7t5v0__fill_2
XFILLER_156_457 VDD VDD VSS VSS gf180mcu_fd_sc_mcu7t5v0__fillcap_32
XTAP_TAPCELL_ROW_50_1_706 VDD VSS gf180mcu_fd_sc_mcu7t5v0__filltie
Xspi_regs_inst__1100_ spi_regs_inst__1100_/A1 spi_regs_inst__1100_/A2 spi_regs_inst__1250_/B1
+ spi_regs_inst__1100_/B2 spi_regs_inst__1115_/A2 VDD VDD VSS VSS gf180mcu_fd_sc_mcu7t5v0__aoi22_1
XFILLER_125_833 VDD VDD VSS VSS gf180mcu_fd_sc_mcu7t5v0__fill_1
XFILLER_137_682 VDD VDD VSS VSS gf180mcu_fd_sc_mcu7t5v0__fillcap_16
XFILLER_7_489 VDD VDD VSS VSS gf180mcu_fd_sc_mcu7t5v0__fill_1
Xspi_regs_inst__1031_ spi_regs_inst__1031_/A1 spi_regs_inst__1031_/A2 spi_regs_inst__1106_/B1
+ VDD VDD VSS VSS gf180mcu_fd_sc_mcu7t5v0__nor2_1
XFILLER_139_1154 VDD VDD VSS VSS gf180mcu_fd_sc_mcu7t5v0__fillcap_16
XFILLER_152_663 VDD VDD VSS VSS gf180mcu_fd_sc_mcu7t5v0__fill_2
XFILLER_112_527 VDD VDD VSS VSS gf180mcu_fd_sc_mcu7t5v0__fillcap_4
XFILLER_140_847 VDD VDD VSS VSS gf180mcu_fd_sc_mcu7t5v0__fill_2
XFILLER_140_869 VDD VDD VSS VSS gf180mcu_fd_sc_mcu7t5v0__fillcap_4
XFILLER_93_422 VDD VDD VSS VSS gf180mcu_fd_sc_mcu7t5v0__fill_1
XFILLER_94_934 VDD VDD VSS VSS gf180mcu_fd_sc_mcu7t5v0__fillcap_8
XTAP_TAPCELL_ROW_6_1_375 VDD VSS gf180mcu_fd_sc_mcu7t5v0__filltie
XFILLER_59_1122 VDD VDD VSS VSS gf180mcu_fd_sc_mcu7t5v0__fillcap_32
XTAP_TAPCELL_ROW_105_1604 VDD VSS gf180mcu_fd_sc_mcu7t5v0__filltie
Xspi_regs_inst__0815_ spi_regs_inst__1650_/Q spi_regs_inst__0815_/A2 spi_regs_inst__0852_/A2
+ VDD VDD VSS VSS gf180mcu_fd_sc_mcu7t5v0__nor2_1
XFILLER_46_382 VDD VDD VSS VSS gf180mcu_fd_sc_mcu7t5v0__fill_2
XFILLER_74_691 VDD VDD VSS VSS gf180mcu_fd_sc_mcu7t5v0__fill_1
XTAP_TAPCELL_ROW_105_1615 VDD VSS gf180mcu_fd_sc_mcu7t5v0__filltie
XFILLER_61_352 VDD VDD VSS VSS gf180mcu_fd_sc_mcu7t5v0__fillcap_16
Xspi_regs_inst__0746_ spi_regs_inst__1437_/A1 spi_regs_inst__1422_/A2 spi_regs_inst__0880_/A2
+ spi_regs_inst__0886_/S VDD VDD VSS VSS gf180mcu_fd_sc_mcu7t5v0__nor3_1
XTAP_TAPCELL_ROW_138_2147 VDD VSS gf180mcu_fd_sc_mcu7t5v0__filltie
XFILLER_148_947 VDD VDD VSS VSS gf180mcu_fd_sc_mcu7t5v0__fillcap_64
XTAP_TAPCELL_ROW_138_2158 VDD VSS gf180mcu_fd_sc_mcu7t5v0__filltie
XFILLER_135_608 VDD VDD VSS VSS gf180mcu_fd_sc_mcu7t5v0__fillcap_8
XFILLER_163_906 VDD VDD VSS VSS gf180mcu_fd_sc_mcu7t5v0__fillcap_4
Xwave_controller_x_inst__2010_ wave_controller_x_inst__2008_/Z wave_controller_x_inst_wire87/Z
+ spi_regs_inst__1321_/B2 VDD VDD VSS VSS gf180mcu_fd_sc_mcu7t5v0__xor2_1
XFILLER_128_660 VDD VDD VSS VSS gf180mcu_fd_sc_mcu7t5v0__fillcap_4
XFILLER_134_107 VDD VDD VSS VSS gf180mcu_fd_sc_mcu7t5v0__fillcap_32
XTAP_TAPCELL_ROW_44_1_664 VDD VSS gf180mcu_fd_sc_mcu7t5v0__filltie
XTAP_TAPCELL_ROW_151_2369 VDD VSS gf180mcu_fd_sc_mcu7t5v0__filltie
Xspi_regs_inst__1229_ spi_regs_inst__1229_/A1 spi_regs_inst_wire297/Z spi_regs_inst__1281_/B1
+ spi_regs_inst__1574_/Q spi_regs_inst__1233_/A1 VDD VDD VSS VSS gf180mcu_fd_sc_mcu7t5v0__aoi22_1
XFILLER_116_877 VDD VDD VSS VSS gf180mcu_fd_sc_mcu7t5v0__fill_2
XFILLER_130_302 VDD VDD VSS VSS gf180mcu_fd_sc_mcu7t5v0__fill_1
XTAP_TAPCELL_ROW_116_1788 VDD VSS gf180mcu_fd_sc_mcu7t5v0__filltie
XTAP_TAPCELL_ROW_116_1799 VDD VSS gf180mcu_fd_sc_mcu7t5v0__filltie
XFILLER_88_227 VDD VDD VSS VSS gf180mcu_fd_sc_mcu7t5v0__fillcap_8
XTAP_TAPCELL_ROW_10_1_409 VDD VSS gf180mcu_fd_sc_mcu7t5v0__filltie
Xwave_controller_x_inst__2912_ wave_controller_x_inst__3713_/Q fanout402/Z wave_controller_x_inst__3583_/A1
+ VDD VDD VSS VSS gf180mcu_fd_sc_mcu7t5v0__nand2_1
XFILLER_130_346 VDD VDD VSS VSS gf180mcu_fd_sc_mcu7t5v0__fill_2
XFILLER_85_912 VDD VDD VSS VSS gf180mcu_fd_sc_mcu7t5v0__fillcap_4
XFILLER_97_772 VDD VDD VSS VSS gf180mcu_fd_sc_mcu7t5v0__fillcap_8
XTAP_TAPCELL_ROW_71_1051 VDD VSS gf180mcu_fd_sc_mcu7t5v0__filltie
Xwave_controller_x_inst__2843_ wave_controller_x_inst__3548_/B2 wave_controller_x_inst__1902_/I
+ wave_controller_x_inst__2844_/B VDD VDD VSS VSS gf180mcu_fd_sc_mcu7t5v0__nand2_1
XFILLER_29_327 VDD VDD VSS VSS gf180mcu_fd_sc_mcu7t5v0__fillcap_4
XFILLER_84_411 VDD VDD VSS VSS gf180mcu_fd_sc_mcu7t5v0__fillcap_4
Xwave_controller_y_inst__1810_ spi_regs_inst__1609_/Q wave_controller_y_inst__3311_/B
+ VDD VDD VSS VSS gf180mcu_fd_sc_mcu7t5v0__clkinv_1
Xwave_controller_y_inst__2790_ wave_controller_y_inst__2790_/I wave_controller_y_inst__2813_/B1
+ VDD VDD VSS VSS gf180mcu_fd_sc_mcu7t5v0__clkinv_1
Xwave_controller_x_inst__2774_ wave_controller_x_inst__2774_/A1 wave_controller_x_inst__1902_/I
+ wave_controller_x_inst__2774_/B wave_controller_x_inst__2898_/A2 VDD VDD VSS VSS
+ gf180mcu_fd_sc_mcu7t5v0__oai21_1
XFILLER_37_360 VDD VDD VSS VSS gf180mcu_fd_sc_mcu7t5v0__fillcap_4
XFILLER_25_511 VDD VDD VSS VSS gf180mcu_fd_sc_mcu7t5v0__fill_2
XFILLER_53_886 VDD VDD VSS VSS gf180mcu_fd_sc_mcu7t5v0__fillcap_32
Xwave_controller_y_inst__3411_ wave_controller_y_inst__1902_/I wave_controller_y_inst__3419_/B
+ wave_controller_y_inst__3454_/B VDD VDD VSS VSS gf180mcu_fd_sc_mcu7t5v0__nand2_1
XFILLER_100_21 VDD VDD VSS VSS gf180mcu_fd_sc_mcu7t5v0__fill_2
XFILLER_40_536 VDD VDD VSS VSS gf180mcu_fd_sc_mcu7t5v0__fillcap_8
XPHY_EDGE_ROW_40_1_Right_39 VDD VSS gf180mcu_fd_sc_mcu7t5v0__endcap
Xwave_controller_y_inst__3342_ spi_regs_inst__1619_/Q wave_controller_y_inst__3721_/Q
+ wave_controller_y_inst__3402_/B VDD VDD VSS VSS gf180mcu_fd_sc_mcu7t5v0__xor2_1
Xwave_controller_x_inst__3326_ wave_controller_x_inst__1778_/I spi_regs_inst__1536_/Q
+ wave_controller_x_inst__3326_/Z VDD VDD VSS VSS gf180mcu_fd_sc_mcu7t5v0__xor2_1
Xwave_controller_y_inst__3273_ wave_controller_y_inst__3706_/Q wave_controller_y_inst__3273_/A2
+ wave_controller_y_inst__3294_/B VDD VDD VSS VSS gf180mcu_fd_sc_mcu7t5v0__nand2_1
Xwave_controller_x_inst__3257_ wave_controller_x_inst__3257_/A1 wave_controller_x_inst__3257_/A2
+ wave_controller_x_inst__3404_/B wave_controller_x_inst__3615_/D VDD VDD VSS VSS
+ gf180mcu_fd_sc_mcu7t5v0__aoi21_1
XFILLER_138_457 VDD VDD VSS VSS gf180mcu_fd_sc_mcu7t5v0__fill_2
Xwave_controller_y_inst__2224_ spi_regs_inst__1281_/A1 wave_controller_y_inst__2229_/A1
+ wave_controller_y_inst__2224_/B wave_controller_y_inst__2257_/A1 VDD VDD VSS VSS
+ gf180mcu_fd_sc_mcu7t5v0__oai21_1
Xwave_controller_x_inst__2208_ wave_controller_x_inst__2793_/I0 wave_controller_x_inst__2207_/Z
+ wave_controller_x_inst__2209_/I VDD VDD VSS VSS gf180mcu_fd_sc_mcu7t5v0__xor2_1
XFILLER_125_129 VDD VDD VSS VSS gf180mcu_fd_sc_mcu7t5v0__fill_2
XFILLER_153_405 VDD VDD VSS VSS gf180mcu_fd_sc_mcu7t5v0__fillcap_8
XFILLER_153_438 VDD VDD VSS VSS gf180mcu_fd_sc_mcu7t5v0__fill_1
XFILLER_165_276 VDD VDD VSS VSS gf180mcu_fd_sc_mcu7t5v0__fillcap_4
Xwave_controller_y_inst__2155_ wave_controller_y_inst__3733_/Q wave_controller_y_inst__2155_/A2
+ wave_controller_y_inst__2756_/A2 VDD VDD VSS VSS gf180mcu_fd_sc_mcu7t5v0__xnor2_1
Xwave_controller_x_inst__3188_ wave_controller_x_inst__3194_/A1 wave_controller_x_inst__3194_/A2
+ wave_controller_x_inst__3188_/B wave_controller_x_inst__3255_/A1 VDD VDD VSS VSS
+ gf180mcu_fd_sc_mcu7t5v0__aoi21_1
XFILLER_106_332 VDD VDD VSS VSS gf180mcu_fd_sc_mcu7t5v0__fill_1
XFILLER_107_833 VDD VDD VSS VSS gf180mcu_fd_sc_mcu7t5v0__fillcap_4
XFILLER_109_63 VDD VDD VSS VSS gf180mcu_fd_sc_mcu7t5v0__fillcap_4
Xwave_controller_x_inst__2139_ wave_controller_x_inst__2145_/I1 wave_controller_x_inst__2139_/A2
+ wave_controller_x_inst__2139_/Z VDD VDD VSS VSS gf180mcu_fd_sc_mcu7t5v0__xor2_1
XFILLER_4_459 VDD VDD VSS VSS gf180mcu_fd_sc_mcu7t5v0__fill_1
XPHY_EDGE_ROW_152_Left_319 VDD VSS gf180mcu_fd_sc_mcu7t5v0__endcap
Xwave_controller_y_inst__2086_ wave_controller_y_inst__3727_/Q wave_controller_y_inst__2086_/A2
+ wave_controller_y_inst__2086_/Z VDD VDD VSS VSS gf180mcu_fd_sc_mcu7t5v0__xor2_1
XFILLER_121_324 VDD VDD VSS VSS gf180mcu_fd_sc_mcu7t5v0__fillcap_8
XFILLER_122_858 VDD VDD VSS VSS gf180mcu_fd_sc_mcu7t5v0__fillcap_16
XFILLER_88_761 VDD VDD VSS VSS gf180mcu_fd_sc_mcu7t5v0__fillcap_4
Xspi_regs_inst_wire480 spi_regs_inst_wire480/I spi_regs_inst_wire480/Z VDD VDD VSS
+ VSS gf180mcu_fd_sc_mcu7t5v0__buf_4
XFILLER_102_571 VDD VDD VSS VSS gf180mcu_fd_sc_mcu7t5v0__fillcap_4
XFILLER_75_422 VDD VDD VSS VSS gf180mcu_fd_sc_mcu7t5v0__fill_2
XFILLER_88_794 VDD VDD VSS VSS gf180mcu_fd_sc_mcu7t5v0__fill_2
XFILLER_75_444 VDD VDD VSS VSS gf180mcu_fd_sc_mcu7t5v0__fill_2
XTAP_TAPCELL_ROW_89_1345 VDD VSS gf180mcu_fd_sc_mcu7t5v0__filltie
Xwave_controller_y_inst__2988_ wave_controller_y_inst__3073_/A1 wave_controller_y_inst__2987_/Z
+ wave_controller_y_inst__2989_/B VDD VDD VSS VSS gf180mcu_fd_sc_mcu7t5v0__nor2_1
XFILLER_35_308 VDD VDD VSS VSS gf180mcu_fd_sc_mcu7t5v0__fillcap_8
XFILLER_63_628 VDD VDD VSS VSS gf180mcu_fd_sc_mcu7t5v0__fill_2
Xwave_controller_y_inst_max_cap79 wave_controller_y_inst__3252_/A2 wave_controller_y_inst__3248_/A2
+ VDD VDD VSS VSS gf180mcu_fd_sc_mcu7t5v0__dlyb_1
Xwave_controller_y_inst__1939_ wave_controller_y_inst__1939_/A1 wave_controller_y_inst__1939_/A2
+ wave_controller_y_inst__1939_/B wave_controller_y_inst__1940_/B VDD VDD VSS VSS
+ gf180mcu_fd_sc_mcu7t5v0__oai21_1
XFILLER_62_116 VDD VDD VSS VSS gf180mcu_fd_sc_mcu7t5v0__fillcap_32
XFILLER_43_330 VDD VDD VSS VSS gf180mcu_fd_sc_mcu7t5v0__fill_2
XPHY_EDGE_ROW_161_Left_328 VDD VSS gf180mcu_fd_sc_mcu7t5v0__endcap
Xwave_controller_y_inst__3609_ spi_regs_inst__1179_/A1 wave_controller_y_inst__2929_/S
+ wave_controller_y_inst__3610_/B VDD VDD VSS VSS gf180mcu_fd_sc_mcu7t5v0__nand2_1
Xspi_regs_inst__1580_ spi_regs_inst__1580_/D fanout561/Z clkbuf_leaf_6_clk/Z spi_regs_inst__1580_/Q
+ VDD VDD VSS VSS gf180mcu_fd_sc_mcu7t5v0__dffrnq_1
XTAP_TAPCELL_ROW_100_1523 VDD VSS gf180mcu_fd_sc_mcu7t5v0__filltie
XTAP_TAPCELL_ROW_100_1534 VDD VSS gf180mcu_fd_sc_mcu7t5v0__filltie
XFILLER_102_1017 VDD VDD VSS VSS gf180mcu_fd_sc_mcu7t5v0__fillcap_64
XFILLER_11_282 VDD VDD VSS VSS gf180mcu_fd_sc_mcu7t5v0__fillcap_16
XFILLER_145_906 VDD VDD VSS VSS gf180mcu_fd_sc_mcu7t5v0__fillcap_4
XFILLER_157_766 VDD VDD VSS VSS gf180mcu_fd_sc_mcu7t5v0__fillcap_4
XFILLER_117_619 VDD VDD VSS VSS gf180mcu_fd_sc_mcu7t5v0__fill_1
XFILLER_144_449 VDD VDD VSS VSS gf180mcu_fd_sc_mcu7t5v0__fillcap_4
XTAP_TAPCELL_ROW_133_2066 VDD VSS gf180mcu_fd_sc_mcu7t5v0__filltie
XTAP_TAPCELL_ROW_133_2077 VDD VSS gf180mcu_fd_sc_mcu7t5v0__filltie
XFILLER_125_674 VDD VDD VSS VSS gf180mcu_fd_sc_mcu7t5v0__fillcap_4
Xspi_regs_inst__1014_ spi_regs_inst__1027_/A1 spi_regs_inst__1016_/A2 spi_regs_inst_wire228/I
+ VDD VDD VSS VSS gf180mcu_fd_sc_mcu7t5v0__nor2_1
XFILLER_112_313 VDD VDD VSS VSS gf180mcu_fd_sc_mcu7t5v0__fill_2
XFILLER_3_470 VDD VDD VSS VSS gf180mcu_fd_sc_mcu7t5v0__fillcap_4
XFILLER_98_547 VDD VDD VSS VSS gf180mcu_fd_sc_mcu7t5v0__fillcap_4
XFILLER_65_1170 VDD VDD VSS VSS gf180mcu_fd_sc_mcu7t5v0__fillcap_4
XFILLER_140_699 VDD VDD VSS VSS gf180mcu_fd_sc_mcu7t5v0__fillcap_16
XFILLER_152_1151 VDD VDD VSS VSS gf180mcu_fd_sc_mcu7t5v0__fillcap_4
XFILLER_66_411 VDD VDD VSS VSS gf180mcu_fd_sc_mcu7t5v0__fill_2
XFILLER_79_772 VDD VDD VSS VSS gf180mcu_fd_sc_mcu7t5v0__fillcap_8
Xwave_controller_y_inst_fanout47 wave_controller_y_inst__3584_/S wave_controller_y_inst_wire48/I
+ VDD VDD VSS VSS gf180mcu_fd_sc_mcu7t5v0__dlyb_1
XFILLER_15_2 VDD VDD VSS VSS gf180mcu_fd_sc_mcu7t5v0__fillcap_64
XFILLER_67_956 VDD VDD VSS VSS gf180mcu_fd_sc_mcu7t5v0__fillcap_16
XFILLER_66_477 VDD VDD VSS VSS gf180mcu_fd_sc_mcu7t5v0__fill_2
XFILLER_82_937 VDD VDD VSS VSS gf180mcu_fd_sc_mcu7t5v0__fill_1
XFILLER_53_138 VDD VDD VSS VSS gf180mcu_fd_sc_mcu7t5v0__fillcap_4
XFILLER_34_352 VDD VDD VSS VSS gf180mcu_fd_sc_mcu7t5v0__fillcap_4
XFILLER_62_650 VDD VDD VSS VSS gf180mcu_fd_sc_mcu7t5v0__fillcap_8
Xwave_controller_x_inst__2490_ wave_controller_x_inst__2490_/A1 wave_controller_x_inst__2490_/A2
+ wave_controller_x_inst__2517_/A2 VDD VDD VSS VSS gf180mcu_fd_sc_mcu7t5v0__nand2_1
XFILLER_14_18 VDD VDD VSS VSS gf180mcu_fd_sc_mcu7t5v0__fillcap_8
XFILLER_22_514 VDD VDD VSS VSS gf180mcu_fd_sc_mcu7t5v0__fillcap_4
XFILLER_34_363 VDD VDD VSS VSS gf180mcu_fd_sc_mcu7t5v0__fillcap_8
Xspi_regs_inst__0729_ spi_regs_inst__1652_/Q spi_regs_inst__0827_/A2 VDD VDD VSS VSS
+ gf180mcu_fd_sc_mcu7t5v0__clkinv_1
XFILLER_148_733 VDD VDD VSS VSS gf180mcu_fd_sc_mcu7t5v0__fill_2
XTAP_TAPCELL_ROW_153_2409 VDD VSS gf180mcu_fd_sc_mcu7t5v0__filltie
XTAP_TAPCELL_ROW_60_862 VDD VSS gf180mcu_fd_sc_mcu7t5v0__filltie
XTAP_TAPCELL_ROW_60_873 VDD VSS gf180mcu_fd_sc_mcu7t5v0__filltie
Xwave_controller_x_inst__3111_ wave_controller_x_inst__3713_/Q spi_regs_inst__1532_/Q
+ wave_controller_x_inst__3166_/B VDD VDD VSS VSS gf180mcu_fd_sc_mcu7t5v0__xor2_1
XFILLER_148_766 VDD VDD VSS VSS gf180mcu_fd_sc_mcu7t5v0__fill_2
XTAP_TAPCELL_ROW_118_1817 VDD VSS gf180mcu_fd_sc_mcu7t5v0__filltie
XTAP_TAPCELL_ROW_118_1828 VDD VSS gf180mcu_fd_sc_mcu7t5v0__filltie
Xwave_controller_x_inst__3042_ wave_controller_x_inst__2797_/C wave_controller_x_inst__3042_/A2
+ wave_controller_x_inst__3042_/B1 wave_controller_x_inst__3069_/B1 wave_controller_x_inst__3701_/D
+ VDD VDD VSS VSS gf180mcu_fd_sc_mcu7t5v0__aoi22_1
XFILLER_148_799 VDD VDD VSS VSS gf180mcu_fd_sc_mcu7t5v0__fillcap_4
XFILLER_135_438 VDD VDD VSS VSS gf180mcu_fd_sc_mcu7t5v0__fillcap_8
XPHY_EDGE_ROW_3_1_Right_2 VDD VSS gf180mcu_fd_sc_mcu7t5v0__endcap
Xmax_cap451 max_cap451/I max_cap451/Z VDD VDD VSS VSS gf180mcu_fd_sc_mcu7t5v0__buf_4
XFILLER_131_611 VDD VDD VSS VSS gf180mcu_fd_sc_mcu7t5v0__fillcap_4
XFILLER_89_547 VDD VDD VSS VSS gf180mcu_fd_sc_mcu7t5v0__fillcap_8
XFILLER_131_644 VDD VDD VSS VSS gf180mcu_fd_sc_mcu7t5v0__fill_2
XFILLER_131_666 VDD VDD VSS VSS gf180mcu_fd_sc_mcu7t5v0__fillcap_8
Xwave_controller_y_inst__2911_ wave_controller_y_inst__3407_/B wave_controller_y_inst__2934_/A2
+ wave_controller_y_inst__2911_/B wave_controller_y_inst__2911_/ZN VDD VDD VSS VSS
+ gf180mcu_fd_sc_mcu7t5v0__oai21_1
XFILLER_130_187 VDD VDD VSS VSS gf180mcu_fd_sc_mcu7t5v0__fill_1
XFILLER_57_422 VDD VDD VSS VSS gf180mcu_fd_sc_mcu7t5v0__fillcap_16
XFILLER_69_282 VDD VDD VSS VSS gf180mcu_fd_sc_mcu7t5v0__fillcap_8
Xwave_controller_y_inst__2842_ wave_controller_y_inst__3081_/B wave_controller_y_inst__2847_/A2
+ wave_controller_y_inst__2850_/B1 VDD VDD VSS VSS gf180mcu_fd_sc_mcu7t5v0__nor2_1
Xwave_controller_x_inst__2826_ wave_controller_x_inst__3078_/A1 wave_controller_x_inst__2837_/A2
+ wave_controller_x_inst__2826_/Z VDD VDD VSS VSS gf180mcu_fd_sc_mcu7t5v0__xor2_1
XFILLER_29_146 VDD VDD VSS VSS gf180mcu_fd_sc_mcu7t5v0__fill_2
XFILLER_29_157 VDD VDD VSS VSS gf180mcu_fd_sc_mcu7t5v0__fill_1
XFILLER_73_937 VDD VDD VSS VSS gf180mcu_fd_sc_mcu7t5v0__fillcap_32
XFILLER_84_241 VDD VDD VSS VSS gf180mcu_fd_sc_mcu7t5v0__fillcap_4
Xwave_controller_y_inst__2773_ spi_regs_inst__1194_/B2 wave_controller_y_inst__2844_/A2
+ wave_controller_y_inst__2774_/B VDD VDD VSS VSS gf180mcu_fd_sc_mcu7t5v0__nand2_1
Xwave_controller_x_inst__2757_ wave_controller_x_inst__2757_/A1 wave_controller_x_inst__2163_/B
+ wave_controller_x_inst__2757_/B spi_regs_inst__1051_/A1 VDD VDD VSS VSS gf180mcu_fd_sc_mcu7t5v0__aoi21_1
XFILLER_55_69 VDD VDD VSS VSS gf180mcu_fd_sc_mcu7t5v0__fill_1
XTAP_TAPCELL_ROW_68_995 VDD VSS gf180mcu_fd_sc_mcu7t5v0__filltie
XFILLER_164_1011 VDD VDD VSS VSS gf180mcu_fd_sc_mcu7t5v0__fillcap_4
XFILLER_25_352 VDD VDD VSS VSS gf180mcu_fd_sc_mcu7t5v0__fill_1
XFILLER_77_1052 VDD VDD VSS VSS gf180mcu_fd_sc_mcu7t5v0__fillcap_64
Xwave_controller_x_inst__2688_ wave_controller_x_inst__2824_/A1 spi_regs_inst__1337_/A1
+ wave_controller_x_inst__2688_/B1 wave_controller_x_inst__2686_/Z wave_controller_x_inst__2688_/C
+ wave_controller_x_inst_wire113/I VDD VDD VSS VSS gf180mcu_fd_sc_mcu7t5v0__oai221_1
XFILLER_111_64 VDD VDD VSS VSS gf180mcu_fd_sc_mcu7t5v0__fillcap_4
XFILLER_53_694 VDD VDD VSS VSS gf180mcu_fd_sc_mcu7t5v0__fill_1
XTAP_TAPCELL_ROW_84_1264 VDD VSS gf180mcu_fd_sc_mcu7t5v0__filltie
XFILLER_139_722 VDD VDD VSS VSS gf180mcu_fd_sc_mcu7t5v0__fillcap_16
Xwave_controller_y_inst__3325_ wave_controller_y_inst__3081_/B spi_regs_inst__1615_/Q
+ wave_controller_y_inst__3398_/A1 VDD VDD VSS VSS gf180mcu_fd_sc_mcu7t5v0__nor2_1
Xwave_controller_x_inst__3309_ wave_controller_x_inst__3712_/Q spi_regs_inst__1552_/Q
+ wave_controller_x_inst__3310_/C VDD VDD VSS VSS gf180mcu_fd_sc_mcu7t5v0__xor2_1
Xwave_controller_y_inst__3256_ wave_controller_y_inst__3256_/A1 wave_controller_y_inst__3256_/A2
+ wave_controller_y_inst__3256_/A3 wave_controller_y_inst__3255_/Z wave_controller_y_inst__3257_/A2
+ VDD VDD VSS VSS gf180mcu_fd_sc_mcu7t5v0__nand4_1
XFILLER_138_287 VDD VDD VSS VSS gf180mcu_fd_sc_mcu7t5v0__fill_2
Xwave_controller_y_inst__2207_ fanout507/Z wave_controller_y_inst__2203_/Z wave_controller_y_inst__2207_/A3
+ wave_controller_y_inst__2207_/Z VDD VDD VSS VSS gf180mcu_fd_sc_mcu7t5v0__xor3_1
Xwave_controller_y_inst__3187_ wave_controller_y_inst__3184_/Z wave_controller_y_inst__3194_/B
+ wave_controller_y_inst__3188_/B VDD VDD VSS VSS gf180mcu_fd_sc_mcu7t5v0__nand2_1
XFILLER_141_419 VDD VDD VSS VSS gf180mcu_fd_sc_mcu7t5v0__fill_1
XFILLER_153_279 VDD VDD VSS VSS gf180mcu_fd_sc_mcu7t5v0__fill_1
Xwave_controller_y_inst__2138_ wave_controller_y_inst__2138_/A1 wave_controller_y_inst__2138_/A2
+ wave_controller_y_inst__2138_/B1 wave_controller_y_inst__2051_/Z wave_controller_y_inst__2138_/C
+ wave_controller_y_inst__2139_/A2 VDD VDD VSS VSS gf180mcu_fd_sc_mcu7t5v0__aoi221_1
XFILLER_96_10 VDD VDD VSS VSS gf180mcu_fd_sc_mcu7t5v0__fillcap_4
Xwave_controller_y_inst__2069_ wave_controller_y_inst__1783_/I wave_controller_y_inst__1785_/I
+ wave_controller_y_inst__2069_/Z VDD VDD VSS VSS gf180mcu_fd_sc_mcu7t5v0__xor2_1
XFILLER_136_1157 VDD VDD VSS VSS gf180mcu_fd_sc_mcu7t5v0__fillcap_16
XFILLER_121_154 VDD VDD VSS VSS gf180mcu_fd_sc_mcu7t5v0__fillcap_4
XFILLER_121_176 VDD VDD VSS VSS gf180mcu_fd_sc_mcu7t5v0__fillcap_8
XFILLER_96_87 VDD VDD VSS VSS gf180mcu_fd_sc_mcu7t5v0__fill_1
XFILLER_152_82 VDD VDD VSS VSS gf180mcu_fd_sc_mcu7t5v0__fillcap_8
XFILLER_48_477 VDD VDD VSS VSS gf180mcu_fd_sc_mcu7t5v0__fill_1
XFILLER_35_116 VDD VDD VSS VSS gf180mcu_fd_sc_mcu7t5v0__fillcap_16
XFILLER_75_296 VDD VDD VSS VSS gf180mcu_fd_sc_mcu7t5v0__fill_2
XFILLER_76_797 VDD VDD VSS VSS gf180mcu_fd_sc_mcu7t5v0__fillcap_8
XTAP_TAPCELL_ROW_43_1_652 VDD VSS gf180mcu_fd_sc_mcu7t5v0__filltie
XFILLER_90_244 VDD VDD VSS VSS gf180mcu_fd_sc_mcu7t5v0__fill_1
Xspi_regs_inst__1632_ spi_regs_inst__1632_/D spi_regs_inst__1662_/RN clkbuf_leaf_6_clk/Z
+ spi_regs_inst__1632_/Q VDD VDD VSS VSS gf180mcu_fd_sc_mcu7t5v0__dffrnq_1
XFILLER_45_91 VDD VDD VSS VSS gf180mcu_fd_sc_mcu7t5v0__fill_2
XFILLER_50_119 VDD VDD VSS VSS gf180mcu_fd_sc_mcu7t5v0__fill_1
XFILLER_43_171 VDD VDD VSS VSS gf180mcu_fd_sc_mcu7t5v0__fillcap_4
XFILLER_43_193 VDD VDD VSS VSS gf180mcu_fd_sc_mcu7t5v0__fillcap_16
Xspi_regs_inst__1563_ spi_regs_inst__1563_/D spi_regs_inst__1649_/RN clkbuf_leaf_41_clk/Z
+ spi_regs_inst__1563_/Q VDD VDD VSS VSS gf180mcu_fd_sc_mcu7t5v0__dffrnq_1
Xspi_regs_inst__1494_ spi_regs_inst__1494_/D fanout588/Z clkbuf_leaf_13_clk/Z spi_regs_inst__1494_/Q
+ VDD VDD VSS VSS gf180mcu_fd_sc_mcu7t5v0__dffrnq_1
XTAP_TAPCELL_ROW_135_2106 VDD VSS gf180mcu_fd_sc_mcu7t5v0__filltie
XFILLER_117_438 VDD VDD VSS VSS gf180mcu_fd_sc_mcu7t5v0__fillcap_8
XFILLER_129_298 VDD VDD VSS VSS gf180mcu_fd_sc_mcu7t5v0__fillcap_8
XFILLER_144_224 VDD VDD VSS VSS gf180mcu_fd_sc_mcu7t5v0__fillcap_8
XPHY_EDGE_ROW_13_1_Left_180 VDD VSS gf180mcu_fd_sc_mcu7t5v0__endcap
XFILLER_99_834 VDD VDD VSS VSS gf180mcu_fd_sc_mcu7t5v0__fill_2
XTAP_TAPCELL_ROW_113_1736 VDD VSS gf180mcu_fd_sc_mcu7t5v0__filltie
XTAP_TAPCELL_ROW_113_1747 VDD VSS gf180mcu_fd_sc_mcu7t5v0__filltie
XFILLER_140_441 VDD VDD VSS VSS gf180mcu_fd_sc_mcu7t5v0__fill_2
Xwave_controller_x_inst__1990_ wave_controller_x_inst__2979_/A2 spi_regs_inst__1140_/B2
+ wave_controller_x_inst__1999_/C VDD VDD VSS VSS gf180mcu_fd_sc_mcu7t5v0__nand2_1
Xstate_machine_inst__27_ spi_regs_inst__1058_/B2 spi_regs_inst__1620_/Q state_machine_inst__27_/B
+ state_machine_inst__29_/A2 VDD VDD VSS VSS gf180mcu_fd_sc_mcu7t5v0__oai21_1
Xfanout519 fanout519/I fanout519/Z VDD VDD VSS VSS gf180mcu_fd_sc_mcu7t5v0__dlyb_1
Xfanout508 fanout508/I fanout508/Z VDD VDD VSS VSS gf180mcu_fd_sc_mcu7t5v0__dlyb_1
XFILLER_101_839 VDD VDD VSS VSS gf180mcu_fd_sc_mcu7t5v0__fill_1
XFILLER_112_154 VDD VDD VSS VSS gf180mcu_fd_sc_mcu7t5v0__fillcap_16
XFILLER_113_677 VDD VDD VSS VSS gf180mcu_fd_sc_mcu7t5v0__fill_1
XFILLER_39_400 VDD VDD VSS VSS gf180mcu_fd_sc_mcu7t5v0__fillcap_4
XFILLER_39_422 VDD VDD VSS VSS gf180mcu_fd_sc_mcu7t5v0__fillcap_8
Xwave_controller_x_inst__3660_ wave_controller_x_inst__3660_/D wave_controller_x_inst__3682_/RN
+ clkload34/I wire454/I VDD VDD VSS VSS gf180mcu_fd_sc_mcu7t5v0__dffrnq_1
XFILLER_94_561 VDD VDD VSS VSS gf180mcu_fd_sc_mcu7t5v0__fill_2
XTAP_TAPCELL_ROW_146_2279 VDD VSS gf180mcu_fd_sc_mcu7t5v0__filltie
XTAP_TAPCELL_ROW_163_2560 VDD VSS gf180mcu_fd_sc_mcu7t5v0__filltie
XTAP_TAPCELL_ROW_163_2571 VDD VSS gf180mcu_fd_sc_mcu7t5v0__filltie
Xwave_controller_x_inst__2611_ wave_controller_x_inst__2612_/A1 wave_controller_x_inst__2610_/Z
+ wave_controller_x_inst__2629_/B VDD VDD VSS VSS gf180mcu_fd_sc_mcu7t5v0__nor2_1
XFILLER_54_436 VDD VDD VSS VSS gf180mcu_fd_sc_mcu7t5v0__fill_1
XFILLER_82_745 VDD VDD VSS VSS gf180mcu_fd_sc_mcu7t5v0__fillcap_4
Xwave_controller_x_inst__3591_ wave_controller_x_inst__3591_/I0 spi_regs_inst__1185_/B2
+ wave_controller_x_inst__3591_/S wave_controller_x_inst__3668_/D VDD VDD VSS VSS
+ gf180mcu_fd_sc_mcu7t5v0__mux2_2
XFILLER_148_1017 VDD VDD VSS VSS gf180mcu_fd_sc_mcu7t5v0__fillcap_64
XFILLER_70_929 VDD VDD VSS VSS gf180mcu_fd_sc_mcu7t5v0__fillcap_16
XTAP_TAPCELL_ROW_128_1990 VDD VSS gf180mcu_fd_sc_mcu7t5v0__filltie
XTAP_TAPCELL_ROW_65_943 VDD VSS gf180mcu_fd_sc_mcu7t5v0__filltie
XTAP_TAPCELL_ROW_65_954 VDD VSS gf180mcu_fd_sc_mcu7t5v0__filltie
Xwave_controller_x_inst__2542_ wave_controller_x_inst__2542_/A1 wave_controller_x_inst__2540_/I
+ wave_controller_x_inst__2545_/B VDD VDD VSS VSS gf180mcu_fd_sc_mcu7t5v0__xnor2_1
XFILLER_81_288 VDD VDD VSS VSS gf180mcu_fd_sc_mcu7t5v0__fill_1
Xwave_controller_x_inst__2473_ wave_controller_x_inst__2490_/A2 wave_controller_x_inst__2517_/C
+ wave_controller_x_inst__2476_/A3 VDD VDD VSS VSS gf180mcu_fd_sc_mcu7t5v0__nand2_1
XFILLER_10_506 VDD VDD VSS VSS gf180mcu_fd_sc_mcu7t5v0__fillcap_8
XFILLER_41_16 VDD VDD VSS VSS gf180mcu_fd_sc_mcu7t5v0__fillcap_16
XFILLER_41_38 VDD VDD VSS VSS gf180mcu_fd_sc_mcu7t5v0__fill_1
Xwave_controller_y_inst__3110_ wave_controller_y_inst__3266_/A1 spi_regs_inst__1595_/Q
+ wave_controller_y_inst__3110_/Z VDD VDD VSS VSS gf180mcu_fd_sc_mcu7t5v0__and2_1
XFILLER_163_500 VDD VDD VSS VSS gf180mcu_fd_sc_mcu7t5v0__fill_2
Xwave_controller_y_inst__3041_ wave_controller_y_inst__1829_/I wave_controller_y_inst__3043_/A3
+ wave_controller_y_inst__3042_/B1 VDD VDD VSS VSS gf180mcu_fd_sc_mcu7t5v0__nand2_1
Xwave_controller_x_inst__3025_ wave_controller_x_inst__3449_/A1 wave_controller_x_inst__3458_/A1
+ wave_controller_x_inst__3025_/A3 wave_controller_x_inst__3033_/A2 VDD VDD VSS VSS
+ gf180mcu_fd_sc_mcu7t5v0__nor3_1
XFILLER_135_279 VDD VDD VSS VSS gf180mcu_fd_sc_mcu7t5v0__fill_1
XFILLER_103_198 VDD VDD VSS VSS gf180mcu_fd_sc_mcu7t5v0__fillcap_8
XTAP_TAPCELL_ROW_8_1_389 VDD VSS gf180mcu_fd_sc_mcu7t5v0__filltie
Xwave_controller_x_inst_load_slew70 wave_controller_x_inst__2929_/S wave_controller_x_inst__2918_/S
+ VDD VDD VSS VSS gf180mcu_fd_sc_mcu7t5v0__buf_4
XFILLER_66_68 VDD VDD VSS VSS gf180mcu_fd_sc_mcu7t5v0__fill_2
XTAP_TAPCELL_ROW_86_1304 VDD VSS gf180mcu_fd_sc_mcu7t5v0__filltie
Xwave_controller_y_inst__2825_ wave_controller_y_inst__3080_/A1 wave_controller_y_inst__2837_/B1
+ wave_controller_y_inst__2838_/A1 VDD VDD VSS VSS gf180mcu_fd_sc_mcu7t5v0__nand2_1
XFILLER_57_274 VDD VDD VSS VSS gf180mcu_fd_sc_mcu7t5v0__fillcap_4
XFILLER_85_583 VDD VDD VSS VSS gf180mcu_fd_sc_mcu7t5v0__fill_2
Xwave_controller_x_inst__2809_ wave_controller_x_inst__2809_/A1 wave_controller_x_inst__2809_/A2
+ wave_controller_x_inst__2809_/B1 wave_controller_x_inst__3707_/Q wave_controller_x_inst__2810_/B
+ VDD VDD VSS VSS gf180mcu_fd_sc_mcu7t5v0__aoi22_1
Xwave_controller_y_inst__2756_ wave_controller_y_inst__2756_/A1 wave_controller_y_inst__2756_/A2
+ wave_controller_y_inst__2756_/B wave_controller_y_inst__3734_/D VDD VDD VSS VSS
+ gf180mcu_fd_sc_mcu7t5v0__oai21_1
XFILLER_13_300 VDD VDD VSS VSS gf180mcu_fd_sc_mcu7t5v0__fillcap_8
XFILLER_60_417 VDD VDD VSS VSS gf180mcu_fd_sc_mcu7t5v0__fill_1
Xwave_controller_y_inst__2687_ max_cap425/I wave_controller_y_inst__3542_/B2 wave_controller_y_inst__2687_/B
+ wave_controller_y_inst__2688_/C VDD VDD VSS VSS gf180mcu_fd_sc_mcu7t5v0__oai21_1
XFILLER_15_72 VDD VDD VSS VSS gf180mcu_fd_sc_mcu7t5v0__fillcap_32
XFILLER_40_174 VDD VDD VSS VSS gf180mcu_fd_sc_mcu7t5v0__fill_1
Xwave_controller_y_inst__3308_ wave_controller_y_inst__3711_/Q wave_controller_y_inst__3311_/B
+ wave_controller_y_inst__3306_/Z wave_controller_y_inst__3310_/B wave_controller_y_inst__3360_/A1
+ VDD VDD VSS VSS gf180mcu_fd_sc_mcu7t5v0__oai22_1
XFILLER_127_714 VDD VDD VSS VSS gf180mcu_fd_sc_mcu7t5v0__fill_1
XFILLER_127_736 VDD VDD VSS VSS gf180mcu_fd_sc_mcu7t5v0__fillcap_8
XTAP_TAPCELL_ROW_46_1_678 VDD VSS gf180mcu_fd_sc_mcu7t5v0__filltie
Xwave_controller_y_inst__3239_ wave_controller_y_inst__3212_/B wave_controller_y_inst__3151_/Z
+ wave_controller_y_inst__3239_/A3 wave_controller_y_inst__3240_/A3 VDD VDD VSS VSS
+ gf180mcu_fd_sc_mcu7t5v0__nor3_1
XFILLER_115_909 VDD VDD VSS VSS gf180mcu_fd_sc_mcu7t5v0__fill_1
XFILLER_154_566 VDD VDD VSS VSS gf180mcu_fd_sc_mcu7t5v0__fillcap_8
XTAP_TAPCELL_ROW_130_2014 VDD VSS gf180mcu_fd_sc_mcu7t5v0__filltie
XTAP_TAPCELL_ROW_130_2025 VDD VSS gf180mcu_fd_sc_mcu7t5v0__filltie
XTAP_TAPCELL_ROW_97_1477 VDD VSS gf180mcu_fd_sc_mcu7t5v0__filltie
XFILLER_154_588 VDD VDD VSS VSS gf180mcu_fd_sc_mcu7t5v0__fillcap_4
XPHY_EDGE_ROW_128_Right_128 VDD VSS gf180mcu_fd_sc_mcu7t5v0__endcap
Xsignal_processor_y_inst__160_ signal_processor_y_inst__231_/Q signal_processor_y_inst__232_/Q
+ signal_processor_y_inst__161_/A4 VDD VDD VSS VSS gf180mcu_fd_sc_mcu7t5v0__nand2_1
XFILLER_110_658 VDD VDD VSS VSS gf180mcu_fd_sc_mcu7t5v0__fillcap_4
XFILLER_62_1151 VDD VDD VSS VSS gf180mcu_fd_sc_mcu7t5v0__fillcap_4
XFILLER_95_347 VDD VDD VSS VSS gf180mcu_fd_sc_mcu7t5v0__fill_2
XFILLER_62_1173 VDD VDD VSS VSS gf180mcu_fd_sc_mcu7t5v0__fill_1
Xspi_regs_inst__0994_ spi_regs_inst__1031_/A1 spi_regs_inst__1022_/A2 spi_regs_inst_wire251/I
+ VDD VDD VSS VSS gf180mcu_fd_sc_mcu7t5v0__nor2_1
XFILLER_63_222 VDD VDD VSS VSS gf180mcu_fd_sc_mcu7t5v0__fill_1
XFILLER_91_564 VDD VDD VSS VSS gf180mcu_fd_sc_mcu7t5v0__fill_1
XTAP_TAPCELL_ROW_62_902 VDD VSS gf180mcu_fd_sc_mcu7t5v0__filltie
XFILLER_16_182 VDD VDD VSS VSS gf180mcu_fd_sc_mcu7t5v0__fillcap_16
XTAP_TAPCELL_ROW_141_2198 VDD VSS gf180mcu_fd_sc_mcu7t5v0__filltie
Xspi_regs_inst__1615_ spi_regs_inst__1615_/D fanout563/Z clkload9/I spi_regs_inst__1615_/Q
+ VDD VDD VSS VSS gf180mcu_fd_sc_mcu7t5v0__dffrnq_1
XFILLER_149_316 VDD VDD VSS VSS gf180mcu_fd_sc_mcu7t5v0__fill_2
Xspi_regs_inst__1546_ spi_regs_inst__1546_/D fanout620/Z clkbuf_leaf_38_clk/Z spi_regs_inst__1546_/Q
+ VDD VDD VSS VSS gf180mcu_fd_sc_mcu7t5v0__dffrnq_1
XFILLER_82_2 VDD VDD VSS VSS gf180mcu_fd_sc_mcu7t5v0__fillcap_8
Xspi_regs_inst__1477_ spi_regs_inst__1477_/D spi_regs_inst__1527_/RN clkload33/I fanout521/I
+ VDD VDD VSS VSS gf180mcu_fd_sc_mcu7t5v0__dffrnq_1
XFILLER_105_408 VDD VDD VSS VSS gf180mcu_fd_sc_mcu7t5v0__fill_2
XFILLER_117_279 VDD VDD VSS VSS gf180mcu_fd_sc_mcu7t5v0__fill_1
XFILLER_125_290 VDD VDD VSS VSS gf180mcu_fd_sc_mcu7t5v0__fillcap_4
XFILLER_99_664 VDD VDD VSS VSS gf180mcu_fd_sc_mcu7t5v0__fillcap_8
XFILLER_141_772 VDD VDD VSS VSS gf180mcu_fd_sc_mcu7t5v0__fillcap_8
XFILLER_59_528 VDD VDD VSS VSS gf180mcu_fd_sc_mcu7t5v0__fill_1
XFILLER_99_697 VDD VDD VSS VSS gf180mcu_fd_sc_mcu7t5v0__fill_2
XTAP_TAPCELL_ROW_148_2319 VDD VSS gf180mcu_fd_sc_mcu7t5v0__filltie
XTAP_TAPCELL_ROW_165_2600 VDD VSS gf180mcu_fd_sc_mcu7t5v0__filltie
Xwave_controller_x_inst__1973_ wave_controller_x_inst__1973_/A1 wave_controller_x_inst__1973_/A2
+ wave_controller_x_inst__1972_/B wave_controller_x_inst__1973_/Z VDD VDD VSS VSS
+ gf180mcu_fd_sc_mcu7t5v0__and3_1
XFILLER_140_282 VDD VDD VSS VSS gf180mcu_fd_sc_mcu7t5v0__fill_1
XFILLER_154_1087 VDD VDD VSS VSS gf180mcu_fd_sc_mcu7t5v0__fillcap_64
XFILLER_86_347 VDD VDD VSS VSS gf180mcu_fd_sc_mcu7t5v0__fill_1
Xwave_controller_x_inst__3712_ wave_controller_x_inst__3712_/D wave_controller_x_inst__3712_/RN
+ clkload33/I wave_controller_x_inst__3712_/Q VDD VDD VSS VSS gf180mcu_fd_sc_mcu7t5v0__dffrnq_1
XFILLER_100_146 VDD VDD VSS VSS gf180mcu_fd_sc_mcu7t5v0__fillcap_8
Xwave_controller_y_inst_max_cap316 wave_controller_y_inst__3424_/A2 wave_controller_y_inst__3483_/A2
+ VDD VDD VSS VSS gf180mcu_fd_sc_mcu7t5v0__clkbuf_2
XFILLER_55_723 VDD VDD VSS VSS gf180mcu_fd_sc_mcu7t5v0__fill_2
XTAP_TAPCELL_ROW_4_1_362 VDD VSS gf180mcu_fd_sc_mcu7t5v0__filltie
XTAP_TAPCELL_ROW_68_1001 VDD VSS gf180mcu_fd_sc_mcu7t5v0__filltie
Xwave_controller_y_inst__2610_ wave_controller_y_inst__2610_/A1 wave_controller_y_inst__2634_/A1
+ wave_controller_y_inst__2610_/Z VDD VDD VSS VSS gf180mcu_fd_sc_mcu7t5v0__and2_1
Xwave_controller_x_inst__3643_ wave_controller_x_inst__3643_/D wave_controller_x_inst__3686_/RN
+ clkbuf_leaf_25_clk/Z spi_regs_inst__1337_/A1 VDD VDD VSS VSS gf180mcu_fd_sc_mcu7t5v0__dffrnq_1
XFILLER_27_458 VDD VDD VSS VSS gf180mcu_fd_sc_mcu7t5v0__fill_1
XFILLER_54_244 VDD VDD VSS VSS gf180mcu_fd_sc_mcu7t5v0__fill_1
XTAP_TAPCELL_ROW_126_1949 VDD VSS gf180mcu_fd_sc_mcu7t5v0__filltie
Xwave_controller_y_inst__3590_ wave_controller_y_inst__3590_/I0 spi_regs_inst__1150_/A1
+ wave_controller_y_inst__3591_/S wave_controller_y_inst__3667_/D VDD VDD VSS VSS
+ gf180mcu_fd_sc_mcu7t5v0__mux2_2
Xwave_controller_x_inst__3574_ wire456/I wave_controller_x_inst__3573_/S wave_controller_x_inst__3575_/B
+ VDD VDD VSS VSS gf180mcu_fd_sc_mcu7t5v0__nand2_1
Xspi_regs_inst_max_cap209 spi_regs_inst__1339_/B1 spi_regs_inst__1325_/A2 VDD VDD
+ VSS VSS gf180mcu_fd_sc_mcu7t5v0__buf_4
XFILLER_74_1011 VDD VDD VSS VSS gf180mcu_fd_sc_mcu7t5v0__fillcap_4
XFILLER_82_586 VDD VDD VSS VSS gf180mcu_fd_sc_mcu7t5v0__fillcap_8
XFILLER_82_597 VDD VDD VSS VSS gf180mcu_fd_sc_mcu7t5v0__fillcap_8
Xwave_controller_y_inst__2541_ wave_controller_y_inst__2542_/A1 wave_controller_y_inst__2541_/A2
+ wave_controller_y_inst__2563_/A1 VDD VDD VSS VSS gf180mcu_fd_sc_mcu7t5v0__nor2_1
Xwave_controller_x_inst__2525_ wave_controller_x_inst__2543_/B1 wave_controller_x_inst__2524_/Z
+ wave_controller_x_inst__2545_/A1 VDD VDD VSS VSS gf180mcu_fd_sc_mcu7t5v0__nand2_1
XTAP_TAPCELL_ROW_81_1212 VDD VSS gf180mcu_fd_sc_mcu7t5v0__filltie
Xwave_controller_y_inst__2472_ wave_controller_y_inst__2516_/A1 spi_regs_inst__1183_/A1
+ wave_controller_y_inst__2517_/C VDD VDD VSS VSS gf180mcu_fd_sc_mcu7t5v0__nand2_1
XFILLER_52_48 VDD VDD VSS VSS gf180mcu_fd_sc_mcu7t5v0__fillcap_16
Xwave_controller_x_inst__2456_ spi_regs_inst__1064_/A1 wave_controller_x_inst__3497_/A1
+ wave_controller_x_inst__2456_/B wave_controller_x_inst__2462_/A2 VDD VDD VSS VSS
+ gf180mcu_fd_sc_mcu7t5v0__oai21_1
Xsignal_processor_x_inst__180_ signal_processor_x_inst__129_/Z signal_processor_x_inst__214_/A2
+ signal_processor_x_inst__191_/A2 VDD VDD VSS VSS gf180mcu_fd_sc_mcu7t5v0__nand2_1
XFILLER_167_135 VDD VDD VSS VSS gf180mcu_fd_sc_mcu7t5v0__fill_1
XFILLER_22_174 VDD VDD VSS VSS gf180mcu_fd_sc_mcu7t5v0__fill_1
Xwave_controller_x_inst__2387_ fanout535/Z spi_regs_inst__1336_/A1 wave_controller_x_inst__2383_/Z
+ wave_controller_x_inst__2388_/B VDD VDD VSS VSS gf180mcu_fd_sc_mcu7t5v0__xor3_1
XFILLER_109_736 VDD VDD VSS VSS gf180mcu_fd_sc_mcu7t5v0__fill_2
XFILLER_136_522 VDD VDD VSS VSS gf180mcu_fd_sc_mcu7t5v0__fill_2
XFILLER_108_257 VDD VDD VSS VSS gf180mcu_fd_sc_mcu7t5v0__fill_1
XFILLER_163_352 VDD VDD VSS VSS gf180mcu_fd_sc_mcu7t5v0__fillcap_8
XTAP_TAPCELL_ROW_79_1174 VDD VSS gf180mcu_fd_sc_mcu7t5v0__filltie
XTAP_TAPCELL_ROW_79_1185 VDD VSS gf180mcu_fd_sc_mcu7t5v0__filltie
Xwave_controller_y_inst__3024_ wave_controller_y_inst__3695_/Q wave_controller_y_inst__3034_/B1
+ wave_controller_y_inst__3026_/A3 wave_controller_y_inst__3029_/A2 VDD VDD VSS VSS
+ gf180mcu_fd_sc_mcu7t5v0__nand3_1
Xwave_controller_x_inst__3008_ wave_controller_x_inst__2910_/B wave_controller_x_inst__3008_/A2
+ wave_controller_x_inst__3097_/A1 wave_controller_x_inst__3036_/B2 VDD VDD VSS VSS
+ gf180mcu_fd_sc_mcu7t5v0__nand3_1
XFILLER_2_524 VDD VDD VSS VSS gf180mcu_fd_sc_mcu7t5v0__fill_1
XFILLER_151_558 VDD VDD VSS VSS gf180mcu_fd_sc_mcu7t5v0__fill_2
XFILLER_78_804 VDD VDD VSS VSS gf180mcu_fd_sc_mcu7t5v0__fill_1
XTAP_TAPCELL_ROW_92_1396 VDD VSS gf180mcu_fd_sc_mcu7t5v0__filltie
XFILLER_133_1116 VDD VDD VSS VSS gf180mcu_fd_sc_mcu7t5v0__fillcap_4
XFILLER_77_336 VDD VDD VSS VSS gf180mcu_fd_sc_mcu7t5v0__fill_1
XFILLER_58_594 VDD VDD VSS VSS gf180mcu_fd_sc_mcu7t5v0__fill_1
XFILLER_85_380 VDD VDD VSS VSS gf180mcu_fd_sc_mcu7t5v0__fill_1
XFILLER_92_317 VDD VDD VSS VSS gf180mcu_fd_sc_mcu7t5v0__fillcap_4
XFILLER_73_553 VDD VDD VSS VSS gf180mcu_fd_sc_mcu7t5v0__fillcap_4
Xwave_controller_y_inst__2808_ wave_controller_y_inst__2809_/A1 wave_controller_y_inst__2808_/A2
+ wave_controller_y_inst__2810_/C wave_controller_y_inst__2807_/Z wave_controller_y_inst__2810_/A2
+ VDD VDD VSS VSS gf180mcu_fd_sc_mcu7t5v0__nand4_1
XFILLER_93_88 VDD VDD VSS VSS gf180mcu_fd_sc_mcu7t5v0__fillcap_8
Xwave_controller_y_inst__2739_ wave_controller_y_inst__2722_/Z wave_controller_y_inst__2739_/A2
+ wave_controller_y_inst__2739_/B1 wave_controller_y_inst__2739_/B2 wave_controller_y_inst__2739_/C
+ wave_controller_y_inst__2740_/A2 VDD VDD VSS VSS gf180mcu_fd_sc_mcu7t5v0__aoi221_1
XFILLER_26_71 VDD VDD VSS VSS gf180mcu_fd_sc_mcu7t5v0__fill_1
XFILLER_60_247 VDD VDD VSS VSS gf180mcu_fd_sc_mcu7t5v0__fillcap_16
XTAP_TAPCELL_ROW_56_795 VDD VSS gf180mcu_fd_sc_mcu7t5v0__filltie
XFILLER_159_625 VDD VDD VSS VSS gf180mcu_fd_sc_mcu7t5v0__fillcap_4
Xspi_regs_inst__1400_ fanout526/Z spi_regs_inst_wire476/Z spi_regs_inst__1402_/S spi_regs_inst__1474_/D
+ VDD VDD VSS VSS gf180mcu_fd_sc_mcu7t5v0__mux2_2
Xspi_regs_inst__1331_ _88_/I spi_regs_inst__1362_/A1 spi_regs_inst__1362_/B VDD VDD
+ VSS VSS gf180mcu_fd_sc_mcu7t5v0__nand2_1
XTAP_TAPCELL_ROW_99_1517 VDD VSS gf180mcu_fd_sc_mcu7t5v0__filltie
XTAP_TAPCELL_ROW_99_1506 VDD VSS gf180mcu_fd_sc_mcu7t5v0__filltie
XFILLER_139_360 VDD VDD VSS VSS gf180mcu_fd_sc_mcu7t5v0__fillcap_4
XFILLER_155_842 VDD VDD VSS VSS gf180mcu_fd_sc_mcu7t5v0__fillcap_64
XTAP_TAPCELL_ROW_28_1_541 VDD VSS gf180mcu_fd_sc_mcu7t5v0__filltie
Xspi_regs_inst__1262_ spi_regs_inst__1262_/A1 spi_regs_inst_wire284/Z spi_regs_inst_wire242/I
+ spi_regs_inst__1511_/Q spi_regs_inst__1263_/A4 VDD VDD VSS VSS gf180mcu_fd_sc_mcu7t5v0__aoi22_1
Xspi_regs_inst__1193_ spi_regs_inst__1193_/A1 spi_regs_inst__1342_/B1 spi_regs_inst_wire226/Z
+ spi_regs_inst__1193_/B2 spi_regs_inst__1196_/A1 VDD VDD VSS VSS gf180mcu_fd_sc_mcu7t5v0__aoi22_1
XFILLER_127_599 VDD VDD VSS VSS gf180mcu_fd_sc_mcu7t5v0__fillcap_4
XFILLER_54_6 VDD VDD VSS VSS gf180mcu_fd_sc_mcu7t5v0__fill_1
XFILLER_5_373 VDD VDD VSS VSS gf180mcu_fd_sc_mcu7t5v0__fill_2
XFILLER_123_772 VDD VDD VSS VSS gf180mcu_fd_sc_mcu7t5v0__fill_2
XPHY_EDGE_ROW_1_1_Left_168 VDD VSS gf180mcu_fd_sc_mcu7t5v0__endcap
Xsignal_processor_y_inst__212_ spi_regs_inst__1050_/C2 signal_processor_y_inst__212_/A2
+ signal_processor_y_inst__213_/B VDD VDD VSS VSS gf180mcu_fd_sc_mcu7t5v0__nand2_1
XFILLER_68_314 VDD VDD VSS VSS gf180mcu_fd_sc_mcu7t5v0__fill_1
XFILLER_68_325 VDD VDD VSS VSS gf180mcu_fd_sc_mcu7t5v0__fill_2
XFILLER_69_859 VDD VDD VSS VSS gf180mcu_fd_sc_mcu7t5v0__fillcap_8
Xsignal_processor_y_inst__143_ fanout393/Z signal_processor_y_inst__195_/B signal_processor_y_inst__187_/A1
+ VDD VDD VSS VSS gf180mcu_fd_sc_mcu7t5v0__nand2_1
XFILLER_96_667 VDD VDD VSS VSS gf180mcu_fd_sc_mcu7t5v0__fillcap_8
XFILLER_110_477 VDD VDD VSS VSS gf180mcu_fd_sc_mcu7t5v0__fill_1
XTAP_TAPCELL_ROW_143_2238 VDD VSS gf180mcu_fd_sc_mcu7t5v0__filltie
XFILLER_36_244 VDD VDD VSS VSS gf180mcu_fd_sc_mcu7t5v0__fill_1
XFILLER_64_542 VDD VDD VSS VSS gf180mcu_fd_sc_mcu7t5v0__fill_1
XTAP_TAPCELL_ROW_108_1657 VDD VSS gf180mcu_fd_sc_mcu7t5v0__filltie
Xspi_regs_inst__0977_ spi_regs_inst__1021_/A1 spi_regs_inst__1022_/A2 spi_regs_inst__1249_/A2
+ VDD VDD VSS VSS gf180mcu_fd_sc_mcu7t5v0__nor2_1
X_86_ analog[1] _86_/Z VDD VDD VSS VSS gf180mcu_fd_sc_mcu7t5v0__buf_1
XFILLER_58_1017 VDD VDD VSS VSS gf180mcu_fd_sc_mcu7t5v0__fillcap_64
XFILLER_91_361 VDD VDD VSS VSS gf180mcu_fd_sc_mcu7t5v0__fill_2
Xwave_controller_x_inst__2310_ wave_controller_x_inst__2310_/I wave_controller_x_inst__2313_/A2
+ VDD VDD VSS VSS gf180mcu_fd_sc_mcu7t5v0__clkinv_1
XTAP_TAPCELL_ROW_121_1868 VDD VSS gf180mcu_fd_sc_mcu7t5v0__filltie
Xwave_controller_x_inst__3290_ wave_controller_x_inst__3290_/A1 spi_regs_inst__1545_/Q
+ wave_controller_x_inst__3291_/I VDD VDD VSS VSS gf180mcu_fd_sc_mcu7t5v0__xor2_1
XTAP_TAPCELL_ROW_121_1879 VDD VSS gf180mcu_fd_sc_mcu7t5v0__filltie
Xwave_controller_x_inst__2241_ fanout526/Z wave_controller_x_inst__2241_/A2 wave_controller_x_inst__2265_/A1
+ VDD VDD VSS VSS gf180mcu_fd_sc_mcu7t5v0__nor2_1
XTAP_TAPCELL_ROW_158_2481 VDD VSS gf180mcu_fd_sc_mcu7t5v0__filltie
XTAP_TAPCELL_ROW_158_2492 VDD VSS gf180mcu_fd_sc_mcu7t5v0__filltie
Xwave_controller_x_inst__2172_ wire462/I wave_controller_x_inst__2173_/A2 wave_controller_x_inst__2187_/A1
+ VDD VDD VSS VSS gf180mcu_fd_sc_mcu7t5v0__nor2_1
Xspi_regs_inst__1529_ spi_regs_inst__1529_/D wire594/Z clkbuf_leaf_11_clk/Z spi_regs_inst__1529_/Q
+ VDD VDD VSS VSS gf180mcu_fd_sc_mcu7t5v0__dffrnq_1
XFILLER_118_511 VDD VDD VSS VSS gf180mcu_fd_sc_mcu7t5v0__fillcap_8
XFILLER_118_544 VDD VDD VSS VSS gf180mcu_fd_sc_mcu7t5v0__fillcap_16
XFILLER_145_330 VDD VDD VSS VSS gf180mcu_fd_sc_mcu7t5v0__fillcap_4
XFILLER_106_717 VDD VDD VSS VSS gf180mcu_fd_sc_mcu7t5v0__fillcap_16
XFILLER_145_374 VDD VDD VSS VSS gf180mcu_fd_sc_mcu7t5v0__fillcap_4
XFILLER_154_28 VDD VDD VSS VSS gf180mcu_fd_sc_mcu7t5v0__fillcap_4
XFILLER_160_355 VDD VDD VSS VSS gf180mcu_fd_sc_mcu7t5v0__fill_2
XFILLER_99_461 VDD VDD VSS VSS gf180mcu_fd_sc_mcu7t5v0__fillcap_16
XFILLER_113_282 VDD VDD VSS VSS gf180mcu_fd_sc_mcu7t5v0__fill_2
XFILLER_141_591 VDD VDD VSS VSS gf180mcu_fd_sc_mcu7t5v0__fillcap_4
XFILLER_160_399 VDD VDD VSS VSS gf180mcu_fd_sc_mcu7t5v0__fill_2
XFILLER_59_314 VDD VDD VSS VSS gf180mcu_fd_sc_mcu7t5v0__fill_1
XTAP_TAPCELL_ROW_74_1093 VDD VSS gf180mcu_fd_sc_mcu7t5v0__filltie
XFILLER_101_444 VDD VDD VSS VSS gf180mcu_fd_sc_mcu7t5v0__fillcap_4
XFILLER_101_455 VDD VDD VSS VSS gf180mcu_fd_sc_mcu7t5v0__fill_2
XTAP_TAPCELL_ROW_37_1_609 VDD VSS gf180mcu_fd_sc_mcu7t5v0__filltie
Xwave_controller_y_inst__3711_ wave_controller_y_inst__3711_/D wave_controller_y_inst__3711_/RN
+ clkload15/I wave_controller_y_inst__3711_/Q VDD VDD VSS VSS gf180mcu_fd_sc_mcu7t5v0__dffrnq_1
Xwave_controller_y_inst__1972_ wave_controller_y_inst__1973_/A1 wave_controller_y_inst__1973_/A2
+ wave_controller_y_inst__1972_/B wave_controller_y_inst__1981_/C VDD VDD VSS VSS
+ gf180mcu_fd_sc_mcu7t5v0__aoi21_1
Xwave_controller_x_inst__1956_ wave_controller_x_inst__3376_/B spi_regs_inst__1128_/B2
+ wave_controller_x_inst__1956_/B wave_controller_x_inst__1962_/A2 VDD VDD VSS VSS
+ gf180mcu_fd_sc_mcu7t5v0__oai21_1
XFILLER_74_317 VDD VDD VSS VSS gf180mcu_fd_sc_mcu7t5v0__fill_2
XFILLER_80_1081 VDD VDD VSS VSS gf180mcu_fd_sc_mcu7t5v0__fillcap_4
Xwave_controller_x_inst__1887_ spi_regs_inst__1169_/B2 wave_controller_x_inst__3551_/B2
+ VDD VDD VSS VSS gf180mcu_fd_sc_mcu7t5v0__clkinv_1
XFILLER_83_862 VDD VDD VSS VSS gf180mcu_fd_sc_mcu7t5v0__fill_2
XTAP_TAPCELL_ROW_45_1_666 VDD VSS gf180mcu_fd_sc_mcu7t5v0__filltie
Xwave_controller_y_inst__3642_ wave_controller_y_inst__3642_/D wave_controller_y_inst__3711_/RN
+ clkload15/I spi_regs_inst__1303_/A1 VDD VDD VSS VSS gf180mcu_fd_sc_mcu7t5v0__dffrnq_1
Xwave_controller_x_inst__3626_ wave_controller_x_inst__3626_/D wave_controller_x_inst__3715_/RN
+ clkbuf_leaf_25_clk/Z spi_regs_inst__1305_/B2 VDD VDD VSS VSS gf180mcu_fd_sc_mcu7t5v0__dffrnq_1
XFILLER_15_417 VDD VDD VSS VSS gf180mcu_fd_sc_mcu7t5v0__fill_2
XFILLER_27_277 VDD VDD VSS VSS gf180mcu_fd_sc_mcu7t5v0__fill_2
XFILLER_70_501 VDD VDD VSS VSS gf180mcu_fd_sc_mcu7t5v0__fill_2
Xwave_controller_y_inst__3573_ wave_controller_y_inst__3602_/I0 spi_regs_inst__1353_/A1
+ wave_controller_y_inst__3584_/S wave_controller_y_inst__3656_/D VDD VDD VSS VSS
+ gf180mcu_fd_sc_mcu7t5v0__mux2_2
XFILLER_82_383 VDD VDD VSS VSS gf180mcu_fd_sc_mcu7t5v0__fill_2
XPHY_EDGE_ROW_0_1_Left_335 VDD VSS gf180mcu_fd_sc_mcu7t5v0__endcap
XTAP_TAPCELL_ROW_53_732 VDD VSS gf180mcu_fd_sc_mcu7t5v0__filltie
Xwave_controller_y_inst__2524_ wave_controller_y_inst__3512_/B2 wave_controller_y_inst__2523_/Z
+ wave_controller_y_inst__2524_/Z VDD VDD VSS VSS gf180mcu_fd_sc_mcu7t5v0__xor2_1
Xwave_controller_x_inst__3557_ wave_controller_x_inst__3557_/A1 wave_controller_x_inst__3557_/A2
+ wave_controller_x_inst__3557_/A3 wave_controller_x_inst__3557_/B1 wave_controller_x_inst__3557_/B2
+ wave_controller_x_inst__3648_/D VDD VDD VSS VSS gf180mcu_fd_sc_mcu7t5v0__oai32_1
XFILLER_42_247 VDD VDD VSS VSS gf180mcu_fd_sc_mcu7t5v0__fillcap_4
XFILLER_63_69 VDD VDD VSS VSS gf180mcu_fd_sc_mcu7t5v0__fill_1
XTAP_TAPCELL_ROW_53_743 VDD VSS gf180mcu_fd_sc_mcu7t5v0__filltie
XTAP_TAPCELL_ROW_53_754 VDD VSS gf180mcu_fd_sc_mcu7t5v0__filltie
Xwave_controller_x_inst__3488_ wave_controller_x_inst__3488_/I wave_controller_x_inst__3489_/B2
+ VDD VDD VSS VSS gf180mcu_fd_sc_mcu7t5v0__clkinv_1
Xwave_controller_x_inst__2508_ wave_controller_x_inst__2505_/Z wave_controller_x_inst__2510_/A2
+ wave_controller_x_inst__2543_/A1 VDD VDD VSS VSS gf180mcu_fd_sc_mcu7t5v0__nor2_1
Xsignal_processor_x_inst__232_ signal_processor_x_inst__232_/D fanout583/Z clkbuf_leaf_14_clk/Z
+ signal_processor_x_inst__232_/Q VDD VDD VSS VSS gf180mcu_fd_sc_mcu7t5v0__dffrnq_1
XFILLER_23_483 VDD VDD VSS VSS gf180mcu_fd_sc_mcu7t5v0__fill_1
Xwave_controller_y_inst__2455_ wave_controller_y_inst__2757_/A1 spi_regs_inst__1063_/B2
+ wave_controller_y_inst__2455_/B wave_controller_y_inst__2464_/A2 VDD VDD VSS VSS
+ gf180mcu_fd_sc_mcu7t5v0__aoi21_1
Xwave_controller_x_inst__2439_ wave_controller_x_inst__2027_/B spi_regs_inst__1185_/B2
+ wave_controller_x_inst__2439_/B wave_controller_x_inst__2440_/A3 VDD VDD VSS VSS
+ gf180mcu_fd_sc_mcu7t5v0__aoi21_1
Xsignal_processor_x_inst__163_ signal_processor_x_inst__232_/Q signal_processor_x_inst__163_/A2
+ signal_processor_x_inst__163_/Z VDD VDD VSS VSS gf180mcu_fd_sc_mcu7t5v0__xor2_1
XFILLER_10_111 VDD VDD VSS VSS gf180mcu_fd_sc_mcu7t5v0__fill_1
Xwave_controller_y_inst__2386_ max_cap425/Z wave_controller_y_inst__2384_/Z wave_controller_y_inst__2407_/A1
+ wave_controller_y_inst__2407_/A2 VDD VDD VSS VSS gf180mcu_fd_sc_mcu7t5v0__nand3_1
XFILLER_10_177 VDD VDD VSS VSS gf180mcu_fd_sc_mcu7t5v0__fillcap_64
XFILLER_137_842 VDD VDD VSS VSS gf180mcu_fd_sc_mcu7t5v0__fill_2
XFILLER_155_138 VDD VDD VSS VSS gf180mcu_fd_sc_mcu7t5v0__fill_2
XFILLER_109_555 VDD VDD VSS VSS gf180mcu_fd_sc_mcu7t5v0__fillcap_4
XFILLER_136_341 VDD VDD VSS VSS gf180mcu_fd_sc_mcu7t5v0__fillcap_8
XTAP_TAPCELL_ROW_94_1436 VDD VSS gf180mcu_fd_sc_mcu7t5v0__filltie
XTAP_TAPCELL_ROW_94_1425 VDD VSS gf180mcu_fd_sc_mcu7t5v0__filltie
XFILLER_88_55 VDD VDD VSS VSS gf180mcu_fd_sc_mcu7t5v0__fill_1
Xwave_controller_y_inst__3007_ wave_controller_y_inst__2117_/B wave_controller_y_inst__3094_/A2
+ wave_controller_y_inst__3097_/A1 VDD VDD VSS VSS gf180mcu_fd_sc_mcu7t5v0__nor2_1
XFILLER_111_208 VDD VDD VSS VSS gf180mcu_fd_sc_mcu7t5v0__fill_2
XFILLER_2_365 VDD VDD VSS VSS gf180mcu_fd_sc_mcu7t5v0__fillcap_8
XFILLER_132_591 VDD VDD VSS VSS gf180mcu_fd_sc_mcu7t5v0__fillcap_4
XFILLER_66_807 VDD VDD VSS VSS gf180mcu_fd_sc_mcu7t5v0__fillcap_8
XFILLER_78_667 VDD VDD VSS VSS gf180mcu_fd_sc_mcu7t5v0__fillcap_32
Xspi_regs_inst__0900_ spi_regs_inst__1623_/Q spi_regs_inst__0889_/B spi_regs_inst__0931_/A2
+ VDD VDD VSS VSS gf180mcu_fd_sc_mcu7t5v0__nor2_1
XFILLER_59_892 VDD VDD VSS VSS gf180mcu_fd_sc_mcu7t5v0__fillcap_4
XFILLER_58_380 VDD VDD VSS VSS gf180mcu_fd_sc_mcu7t5v0__fillcap_4
Xspi_regs_inst__0831_ spi_regs_inst__1573_/Q spi_regs_inst__1408_/I1 spi_regs_inst__0834_/S
+ spi_regs_inst__1573_/D VDD VDD VSS VSS gf180mcu_fd_sc_mcu7t5v0__mux2_2
XFILLER_18_244 VDD VDD VSS VSS gf180mcu_fd_sc_mcu7t5v0__fill_1
XFILLER_37_92 VDD VDD VSS VSS gf180mcu_fd_sc_mcu7t5v0__fill_2
XFILLER_46_553 VDD VDD VSS VSS gf180mcu_fd_sc_mcu7t5v0__fill_2
XFILLER_73_361 VDD VDD VSS VSS gf180mcu_fd_sc_mcu7t5v0__fillcap_4
XFILLER_92_169 VDD VDD VSS VSS gf180mcu_fd_sc_mcu7t5v0__fillcap_4
Xspi_regs_inst__0762_ spi_regs_inst__1522_/Q spi_regs_inst__1416_/I0 spi_regs_inst__0766_/S
+ spi_regs_inst__1522_/D VDD VDD VSS VSS gf180mcu_fd_sc_mcu7t5v0__mux2_2
XFILLER_159_422 VDD VDD VSS VSS gf180mcu_fd_sc_mcu7t5v0__fillcap_32
XTAP_TAPCELL_ROW_103_1576 VDD VSS gf180mcu_fd_sc_mcu7t5v0__filltie
XFILLER_159_488 VDD VDD VSS VSS gf180mcu_fd_sc_mcu7t5v0__fill_2
Xspi_regs_inst__1314_ spi_regs_inst__1484_/Q spi_regs_inst__1314_/A2 spi_regs_inst_wire277/Z
+ spi_regs_inst__1505_/Q spi_regs_inst__1314_/C spi_regs_inst__1328_/A3 VDD VDD VSS
+ VSS gf180mcu_fd_sc_mcu7t5v0__aoi221_1
XFILLER_127_330 VDD VDD VSS VSS gf180mcu_fd_sc_mcu7t5v0__fillcap_8
XFILLER_143_801 VDD VDD VSS VSS gf180mcu_fd_sc_mcu7t5v0__fillcap_4
XPHY_EDGE_ROW_41_1_Left_208 VDD VSS gf180mcu_fd_sc_mcu7t5v0__endcap
Xspi_regs_inst__1245_ spi_regs_inst__1482_/Q spi_regs_inst__1341_/A2 spi_regs_inst__1245_/B1
+ spi_regs_inst__1245_/B2 spi_regs_inst__1248_/A2 VDD VDD VSS VSS gf180mcu_fd_sc_mcu7t5v0__aoi22_1
XFILLER_115_514 VDD VDD VSS VSS gf180mcu_fd_sc_mcu7t5v0__fill_1
XFILLER_127_352 VDD VDD VSS VSS gf180mcu_fd_sc_mcu7t5v0__fillcap_32
XFILLER_128_897 VDD VDD VSS VSS gf180mcu_fd_sc_mcu7t5v0__fill_2
XFILLER_142_311 VDD VDD VSS VSS gf180mcu_fd_sc_mcu7t5v0__fillcap_4
Xspi_regs_inst_wire106 spi_regs_inst_wire106/I spi_regs_inst_wire106/Z VDD VDD VSS
+ VSS gf180mcu_fd_sc_mcu7t5v0__buf_2
XFILLER_115_558 VDD VDD VSS VSS gf180mcu_fd_sc_mcu7t5v0__fill_2
XFILLER_154_171 VDD VDD VSS VSS gf180mcu_fd_sc_mcu7t5v0__fillcap_4
XFILLER_154_193 VDD VDD VSS VSS gf180mcu_fd_sc_mcu7t5v0__fill_1
Xspi_regs_inst__1176_ spi_regs_inst_wire103/Z spi_regs_inst__1176_/A2 spi_regs_inst__1176_/B1
+ spi_regs_inst__1176_/B2 spi_regs_inst__1187_/A1 VDD VDD VSS VSS gf180mcu_fd_sc_mcu7t5v0__aoi22_1
XFILLER_88_409 VDD VDD VSS VSS gf180mcu_fd_sc_mcu7t5v0__fillcap_8
XFILLER_151_1046 VDD VDD VSS VSS gf180mcu_fd_sc_mcu7t5v0__fillcap_4
XFILLER_64_1087 VDD VDD VSS VSS gf180mcu_fd_sc_mcu7t5v0__fillcap_64
XFILLER_69_656 VDD VDD VSS VSS gf180mcu_fd_sc_mcu7t5v0__fillcap_8
Xwave_controller_x_inst__2790_ wave_controller_x_inst__2790_/I wave_controller_x_inst__2813_/B1
+ VDD VDD VSS VSS gf180mcu_fd_sc_mcu7t5v0__clkinv_1
Xwave_controller_x_inst__1810_ spi_regs_inst__1551_/Q wave_controller_x_inst__3311_/B
+ VDD VDD VSS VSS gf180mcu_fd_sc_mcu7t5v0__clkinv_1
XFILLER_56_317 VDD VDD VSS VSS gf180mcu_fd_sc_mcu7t5v0__fillcap_16
XFILLER_57_829 VDD VDD VSS VSS gf180mcu_fd_sc_mcu7t5v0__fill_1
Xsignal_processor_y_inst__126_ signal_processor_y_inst__179_/A1 signal_processor_y_inst__246_/Q
+ signal_processor_y_inst__247_/D VDD VDD VSS VSS gf180mcu_fd_sc_mcu7t5v0__and2_1
XFILLER_83_136 VDD VDD VSS VSS gf180mcu_fd_sc_mcu7t5v0__fillcap_4
XPHY_EDGE_ROW_56_Left_223 VDD VSS gf180mcu_fd_sc_mcu7t5v0__endcap
XTAP_TAPCELL_ROW_123_1908 VDD VSS gf180mcu_fd_sc_mcu7t5v0__filltie
Xwave_controller_x_inst__3411_ wave_controller_x_inst__3446_/A2 wave_controller_x_inst__3419_/B
+ wave_controller_x_inst__3454_/B VDD VDD VSS VSS gf180mcu_fd_sc_mcu7t5v0__nand2_1
XFILLER_24_247 VDD VDD VSS VSS gf180mcu_fd_sc_mcu7t5v0__fillcap_4
Xwave_controller_x_inst__3342_ spi_regs_inst__1540_/Q wave_controller_x_inst__2124_/B
+ wave_controller_x_inst__3402_/B VDD VDD VSS VSS gf180mcu_fd_sc_mcu7t5v0__xor2_1
Xwave_controller_x_inst__3273_ wave_controller_x_inst__3706_/Q wave_controller_x_inst__3273_/A2
+ wave_controller_x_inst__3294_/B VDD VDD VSS VSS gf180mcu_fd_sc_mcu7t5v0__nand2_1
Xwave_controller_y_inst__2240_ wave_controller_y_inst__2242_/A2 wave_controller_y_inst__2242_/A3
+ wave_controller_y_inst__2241_/A2 VDD VDD VSS VSS gf180mcu_fd_sc_mcu7t5v0__xnor2_1
Xwave_controller_x_inst__2224_ spi_regs_inst__1284_/B2 wave_controller_x_inst__2229_/A1
+ wave_controller_x_inst__2224_/B wave_controller_x_inst__2257_/A1 VDD VDD VSS VSS
+ gf180mcu_fd_sc_mcu7t5v0__oai21_1
XFILLER_119_842 VDD VDD VSS VSS gf180mcu_fd_sc_mcu7t5v0__fillcap_8
XPHY_EDGE_ROW_65_Left_232 VDD VSS gf180mcu_fd_sc_mcu7t5v0__endcap
Xwave_controller_y_inst__2171_ wave_controller_y_inst__2222_/B1 wave_controller_y_inst__2171_/A2
+ wave_controller_y_inst__2173_/A2 VDD VDD VSS VSS gf180mcu_fd_sc_mcu7t5v0__nor2_1
Xwave_controller_x_inst__2155_ wave_controller_x_inst__3733_/Q wave_controller_x_inst__2155_/A2
+ wave_controller_x_inst__2756_/A2 VDD VDD VSS VSS gf180mcu_fd_sc_mcu7t5v0__xnor2_1
XFILLER_134_823 VDD VDD VSS VSS gf180mcu_fd_sc_mcu7t5v0__fill_2
XTAP_TAPCELL_ROW_76_1133 VDD VSS gf180mcu_fd_sc_mcu7t5v0__filltie
Xwave_controller_x_inst__2086_ wave_controller_x_inst__3727_/Q wave_controller_x_inst__2086_/A2
+ wave_controller_x_inst__2086_/Z VDD VDD VSS VSS gf180mcu_fd_sc_mcu7t5v0__xor2_1
XFILLER_121_506 VDD VDD VSS VSS gf180mcu_fd_sc_mcu7t5v0__fillcap_16
XFILLER_161_686 VDD VDD VSS VSS gf180mcu_fd_sc_mcu7t5v0__fillcap_8
Xwave_controller_x_inst_fanout626 wire628/Z wave_controller_x_inst__3704_/RN VDD VDD
+ VSS VSS gf180mcu_fd_sc_mcu7t5v0__dlyb_1
Xwave_controller_x_inst_fanout604 wave_controller_x_inst__3716_/RN wave_controller_x_inst__3715_/RN
+ VDD VDD VSS VSS gf180mcu_fd_sc_mcu7t5v0__dlyb_1
XFILLER_59_133 VDD VDD VSS VSS gf180mcu_fd_sc_mcu7t5v0__fill_1
XFILLER_82_1165 VDD VDD VSS VSS gf180mcu_fd_sc_mcu7t5v0__fillcap_4
XFILLER_47_306 VDD VDD VSS VSS gf180mcu_fd_sc_mcu7t5v0__fill_2
XFILLER_47_317 VDD VDD VSS VSS gf180mcu_fd_sc_mcu7t5v0__fillcap_32
XFILLER_59_188 VDD VDD VSS VSS gf180mcu_fd_sc_mcu7t5v0__fillcap_8
Xwave_controller_y_inst__1955_ wave_controller_y_inst__3376_/B spi_regs_inst__1159_/A1
+ wave_controller_y_inst__1957_/A2 VDD VDD VSS VSS gf180mcu_fd_sc_mcu7t5v0__nor2_1
Xwave_controller_x_inst__2988_ wave_controller_x_inst__3073_/A1 wave_controller_x_inst__2987_/Z
+ wave_controller_x_inst__2989_/B VDD VDD VSS VSS gf180mcu_fd_sc_mcu7t5v0__nor2_1
XFILLER_74_147 VDD VDD VSS VSS gf180mcu_fd_sc_mcu7t5v0__fillcap_4
XPHY_EDGE_ROW_74_Left_241 VDD VSS gf180mcu_fd_sc_mcu7t5v0__endcap
XTAP_TAPCELL_ROW_58_835 VDD VSS gf180mcu_fd_sc_mcu7t5v0__filltie
Xwave_controller_x_inst__1939_ wave_controller_x_inst__1939_/A1 wave_controller_x_inst__1939_/A2
+ wave_controller_x_inst__1939_/B wave_controller_x_inst__1940_/B VDD VDD VSS VSS
+ gf180mcu_fd_sc_mcu7t5v0__oai21_1
XFILLER_74_57 VDD VDD VSS VSS gf180mcu_fd_sc_mcu7t5v0__fill_2
Xwave_controller_y_inst__3625_ wave_controller_y_inst__3625_/D wave_controller_y_inst__3699_/RN
+ clkload11/I spi_regs_inst__1270_/A1 VDD VDD VSS VSS gf180mcu_fd_sc_mcu7t5v0__dffrnq_1
Xwave_controller_y_inst__1886_ spi_regs_inst__1121_/A1 wave_controller_y_inst__3548_/B2
+ VDD VDD VSS VSS gf180mcu_fd_sc_mcu7t5v0__clkinv_1
XFILLER_56_895 VDD VDD VSS VSS gf180mcu_fd_sc_mcu7t5v0__fillcap_32
Xwave_controller_x_inst__3609_ spi_regs_inst__1211_/B2 wave_controller_x_inst__3610_/A1
+ wave_controller_x_inst__3610_/B VDD VDD VSS VSS gf180mcu_fd_sc_mcu7t5v0__nand2_1
XFILLER_130_41 VDD VDD VSS VSS gf180mcu_fd_sc_mcu7t5v0__fill_2
XFILLER_167_1064 VDD VDD VSS VSS gf180mcu_fd_sc_mcu7t5v0__fillcap_4
XFILLER_71_876 VDD VDD VSS VSS gf180mcu_fd_sc_mcu7t5v0__fillcap_8
Xwave_controller_y_inst__3556_ spi_regs_inst__1261_/B2 wave_controller_y_inst__3556_/A2
+ wave_controller_y_inst__3557_/A3 VDD VDD VSS VSS gf180mcu_fd_sc_mcu7t5v0__nor2_1
XFILLER_70_364 VDD VDD VSS VSS gf180mcu_fd_sc_mcu7t5v0__fillcap_8
Xwave_controller_y_inst__2507_ wave_controller_y_inst__2505_/Z wave_controller_y_inst__2510_/A2
+ wave_controller_y_inst__2543_/C VDD VDD VSS VSS gf180mcu_fd_sc_mcu7t5v0__nand2_1
Xwave_controller_y_inst__3487_ wave_controller_y_inst__3489_/A1 wave_controller_y_inst__3493_/A1
+ wave_controller_y_inst__3487_/B wave_controller_y_inst__3488_/I VDD VDD VSS VSS
+ gf180mcu_fd_sc_mcu7t5v0__oai21_1
Xsignal_processor_x_inst__215_ signal_processor_x_inst__215_/A1 signal_processor_x_inst__175_/Z
+ signal_processor_x_inst__215_/B signal_processor_x_inst__226_/D VDD VDD VSS VSS
+ gf180mcu_fd_sc_mcu7t5v0__oai21_1
Xwave_controller_y_inst__2438_ spi_regs_inst__1202_/A1 wave_controller_y_inst__2774_/A1
+ wave_controller_y_inst__2438_/B wave_controller_y_inst__2439_/B VDD VDD VSS VSS
+ gf180mcu_fd_sc_mcu7t5v0__aoi21_1
XFILLER_23_72 VDD VDD VSS VSS gf180mcu_fd_sc_mcu7t5v0__fillcap_4
XPHY_EDGE_ROW_83_Left_250 VDD VSS gf180mcu_fd_sc_mcu7t5v0__endcap
Xsignal_processor_x_inst__146_ signal_processor_x_inst__238_/Q signal_processor_x_inst__146_/A2
+ signal_processor_x_inst__146_/Z VDD VDD VSS VSS gf180mcu_fd_sc_mcu7t5v0__xor2_1
XFILLER_109_330 VDD VDD VSS VSS gf180mcu_fd_sc_mcu7t5v0__fillcap_8
XFILLER_11_486 VDD VDD VSS VSS gf180mcu_fd_sc_mcu7t5v0__fillcap_4
XFILLER_139_72 VDD VDD VSS VSS gf180mcu_fd_sc_mcu7t5v0__fillcap_32
XFILLER_7_446 VDD VDD VSS VSS gf180mcu_fd_sc_mcu7t5v0__fillcap_4
XTAP_TAPCELL_ROW_50_1_707 VDD VSS gf180mcu_fd_sc_mcu7t5v0__filltie
Xwave_controller_y_inst__2369_ spi_regs_inst__1321_/A1 wave_controller_y_inst__2367_/Z
+ wave_controller_y_inst__2369_/Z VDD VDD VSS VSS gf180mcu_fd_sc_mcu7t5v0__xor2_1
XFILLER_104_1081 VDD VDD VSS VSS gf180mcu_fd_sc_mcu7t5v0__fillcap_4
XFILLER_99_65 VDD VDD VSS VSS gf180mcu_fd_sc_mcu7t5v0__fillcap_4
XFILLER_139_1122 VDD VDD VSS VSS gf180mcu_fd_sc_mcu7t5v0__fillcap_32
Xspi_regs_inst__1030_ spi_regs_inst__1030_/A1 spi_regs_inst__1030_/A2 spi_regs_inst__1339_/B1
+ VDD VDD VSS VSS gf180mcu_fd_sc_mcu7t5v0__nor2_2
XFILLER_124_366 VDD VDD VSS VSS gf180mcu_fd_sc_mcu7t5v0__fillcap_4
XFILLER_79_932 VDD VDD VSS VSS gf180mcu_fd_sc_mcu7t5v0__fill_1
Xwave_controller_y_inst_fanout571 fanout581/Z wave_controller_y_inst__3696_/RN VDD
+ VDD VSS VSS gf180mcu_fd_sc_mcu7t5v0__dlyb_1
XFILLER_0_10 VDD VDD VSS VSS gf180mcu_fd_sc_mcu7t5v0__fillcap_16
XTAP_TAPCELL_ROW_6_1_376 VDD VSS gf180mcu_fd_sc_mcu7t5v0__filltie
XFILLER_111_1052 VDD VDD VSS VSS gf180mcu_fd_sc_mcu7t5v0__fillcap_64
XFILLER_93_467 VDD VDD VSS VSS gf180mcu_fd_sc_mcu7t5v0__fillcap_8
XTAP_TAPCELL_ROW_105_1605 VDD VSS gf180mcu_fd_sc_mcu7t5v0__filltie
Xwave_controller_y_inst_load_slew137 wave_controller_y_inst__3554_/B1 wave_controller_y_inst__3524_/B1
+ VDD VDD VSS VSS gf180mcu_fd_sc_mcu7t5v0__buf_4
Xspi_regs_inst__0814_ spi_regs_inst__1561_/Q spi_regs_inst__1451_/I1 spi_regs_inst__0814_/S
+ spi_regs_inst__1561_/D VDD VDD VSS VSS gf180mcu_fd_sc_mcu7t5v0__mux2_2
XFILLER_62_843 VDD VDD VSS VSS gf180mcu_fd_sc_mcu7t5v0__fill_2
XTAP_TAPCELL_ROW_105_1616 VDD VSS gf180mcu_fd_sc_mcu7t5v0__filltie
XFILLER_62_865 VDD VDD VSS VSS gf180mcu_fd_sc_mcu7t5v0__fillcap_8
Xspi_regs_inst__0745_ spi_regs_inst__1654_/Q spi_regs_inst__1454_/Q spi_regs_inst__0808_/A2
+ spi_regs_inst__0880_/A2 VDD VDD VSS VSS gf180mcu_fd_sc_mcu7t5v0__nand3_1
XTAP_TAPCELL_ROW_138_2148 VDD VSS gf180mcu_fd_sc_mcu7t5v0__filltie
XFILLER_9_96 VDD VDD VSS VSS gf180mcu_fd_sc_mcu7t5v0__fillcap_4
XTAP_TAPCELL_ROW_138_2159 VDD VSS gf180mcu_fd_sc_mcu7t5v0__filltie
XTAP_TAPCELL_ROW_155_2440 VDD VSS gf180mcu_fd_sc_mcu7t5v0__filltie
XFILLER_116_801 VDD VDD VSS VSS gf180mcu_fd_sc_mcu7t5v0__fillcap_4
XTAP_TAPCELL_ROW_44_1_665 VDD VSS gf180mcu_fd_sc_mcu7t5v0__filltie
XFILLER_115_333 VDD VDD VSS VSS gf180mcu_fd_sc_mcu7t5v0__fill_2
Xspi_regs_inst__1228_ spi_regs_inst__1228_/A1 spi_regs_inst__1228_/A2 spi_regs_inst__1228_/A3
+ spi_regs_inst__1228_/A4 spi_regs_inst__1243_/A1 VDD VDD VSS VSS gf180mcu_fd_sc_mcu7t5v0__nand4_1
XFILLER_88_206 VDD VDD VSS VSS gf180mcu_fd_sc_mcu7t5v0__fillcap_16
XTAP_TAPCELL_ROW_116_1789 VDD VSS gf180mcu_fd_sc_mcu7t5v0__filltie
Xspi_regs_inst__1159_ spi_regs_inst__1159_/A1 spi_regs_inst_wire290/I spi_regs_inst_wire254/Z
+ spi_regs_inst__1580_/Q spi_regs_inst__1278_/A2 spi_regs_inst__1159_/C2 spi_regs_inst__1161_/A2
+ VDD VDD VSS VSS gf180mcu_fd_sc_mcu7t5v0__aoi222_1
XFILLER_103_539 VDD VDD VSS VSS gf180mcu_fd_sc_mcu7t5v0__fill_2
XFILLER_88_239 VDD VDD VSS VSS gf180mcu_fd_sc_mcu7t5v0__fill_2
Xwave_controller_x_inst__2911_ wave_controller_x_inst__3406_/A1 wave_controller_x_inst__2934_/A2
+ wave_controller_x_inst__2911_/B wave_controller_x_inst_wire75/I VDD VDD VSS VSS
+ gf180mcu_fd_sc_mcu7t5v0__oai21_1
XTAP_TAPCELL_ROW_71_1041 VDD VSS gf180mcu_fd_sc_mcu7t5v0__filltie
XTAP_TAPCELL_ROW_71_1052 VDD VSS gf180mcu_fd_sc_mcu7t5v0__filltie
Xwave_controller_x_inst__2842_ wave_controller_x_inst__3081_/B wave_controller_x_inst__2847_/A2
+ wave_controller_x_inst__2850_/B1 VDD VDD VSS VSS gf180mcu_fd_sc_mcu7t5v0__nor2_1
XFILLER_29_306 VDD VDD VSS VSS gf180mcu_fd_sc_mcu7t5v0__fillcap_8
XFILLER_85_979 VDD VDD VSS VSS gf180mcu_fd_sc_mcu7t5v0__fill_1
Xwave_controller_x_inst__2773_ spi_regs_inst__1188_/C1 wave_controller_x_inst__1902_/I
+ wave_controller_x_inst__2774_/B VDD VDD VSS VSS gf180mcu_fd_sc_mcu7t5v0__nand2_1
Xsignal_processor_y_inst__109_ signal_processor_y_inst__248_/Q signal_processor_y_inst__202_/A2
+ VDD VDD VSS VSS gf180mcu_fd_sc_mcu7t5v0__clkinv_1
XFILLER_56_158 VDD VDD VSS VSS gf180mcu_fd_sc_mcu7t5v0__fill_1
XFILLER_80_640 VDD VDD VSS VSS gf180mcu_fd_sc_mcu7t5v0__fillcap_8
Xwave_controller_y_inst__3410_ wave_controller_y_inst__3410_/A1 wave_controller_y_inst__3410_/A2
+ wave_controller_y_inst__3619_/D VDD VDD VSS VSS gf180mcu_fd_sc_mcu7t5v0__nand2_1
XFILLER_52_364 VDD VDD VSS VSS gf180mcu_fd_sc_mcu7t5v0__fillcap_8
XFILLER_80_673 VDD VDD VSS VSS gf180mcu_fd_sc_mcu7t5v0__fill_1
Xwave_controller_y_inst__3341_ wave_controller_y_inst__3345_/A2 wave_controller_y_inst__3345_/A3
+ wave_controller_y_inst__3341_/B wave_controller_y_inst__3341_/C wave_controller_y_inst__3344_/A2
+ VDD VDD VSS VSS gf180mcu_fd_sc_mcu7t5v0__oai211_1
XFILLER_100_55 VDD VDD VSS VSS gf180mcu_fd_sc_mcu7t5v0__fillcap_16
Xwave_controller_x_inst__3325_ wave_controller_x_inst__3081_/B spi_regs_inst__1536_/Q
+ wave_controller_x_inst__3398_/A1 VDD VDD VSS VSS gf180mcu_fd_sc_mcu7t5v0__nor2_1
Xwave_controller_y_inst__3272_ wave_controller_y_inst__3706_/Q wave_controller_y_inst__3273_/A2
+ wave_controller_y_inst__3294_/A1 VDD VDD VSS VSS gf180mcu_fd_sc_mcu7t5v0__nor2_1
Xwave_controller_x_inst__3256_ wave_controller_x_inst__3256_/A1 wave_controller_x_inst__3256_/A2
+ wave_controller_x_inst__3256_/A3 wave_controller_x_inst__3255_/Z wave_controller_x_inst__3257_/A2
+ VDD VDD VSS VSS gf180mcu_fd_sc_mcu7t5v0__nand4_1
Xwave_controller_y_inst__2223_ wave_controller_y_inst__2223_/A1 wave_controller_y_inst__3566_/A1
+ max_cap427/Z wave_controller_y_inst__2223_/B2 wave_controller_y_inst__2224_/B VDD
+ VDD VSS VSS gf180mcu_fd_sc_mcu7t5v0__oai22_1
Xwave_controller_x_inst__3187_ wave_controller_x_inst__3184_/Z wave_controller_x_inst__3194_/B
+ wave_controller_x_inst__3188_/B VDD VDD VSS VSS gf180mcu_fd_sc_mcu7t5v0__nand2_1
Xwave_controller_x_inst__2207_ fanout528/Z wave_controller_x_inst__2203_/Z wave_controller_x_inst__2207_/A3
+ wave_controller_x_inst__2207_/Z VDD VDD VSS VSS gf180mcu_fd_sc_mcu7t5v0__xor3_1
XFILLER_153_417 VDD VDD VSS VSS gf180mcu_fd_sc_mcu7t5v0__fill_2
XFILLER_165_288 VDD VDD VSS VSS gf180mcu_fd_sc_mcu7t5v0__fillcap_8
Xwave_controller_y_inst__2154_ wave_controller_y_inst__3733_/Q wave_controller_y_inst__2155_/A2
+ wave_controller_y_inst__2756_/B VDD VDD VSS VSS gf180mcu_fd_sc_mcu7t5v0__nand2_1
Xwave_controller_x_inst__2138_ wave_controller_x_inst__2138_/A1 wave_controller_x_inst__2138_/A2
+ wave_controller_x_inst__2138_/B1 wave_controller_x_inst__2051_/Z wave_controller_x_inst__2138_/C
+ wave_controller_x_inst__2139_/A2 VDD VDD VSS VSS gf180mcu_fd_sc_mcu7t5v0__aoi221_1
XFILLER_106_311 VDD VDD VSS VSS gf180mcu_fd_sc_mcu7t5v0__fillcap_4
XFILLER_106_322 VDD VDD VSS VSS gf180mcu_fd_sc_mcu7t5v0__fillcap_8
XFILLER_118_193 VDD VDD VSS VSS gf180mcu_fd_sc_mcu7t5v0__fill_2
XFILLER_107_878 VDD VDD VSS VSS gf180mcu_fd_sc_mcu7t5v0__fillcap_16
Xwave_controller_y_inst__2085_ wave_controller_y_inst__3727_/Q wave_controller_y_inst__2086_/A2
+ wave_controller_y_inst__2104_/A1 VDD VDD VSS VSS gf180mcu_fd_sc_mcu7t5v0__nand2_1
Xwave_controller_x_inst__2069_ wave_controller_x_inst__1783_/I wave_controller_x_inst__1785_/I
+ wave_controller_x_inst__2069_/Z VDD VDD VSS VSS gf180mcu_fd_sc_mcu7t5v0__xor2_1
XFILLER_133_174 VDD VDD VSS VSS gf180mcu_fd_sc_mcu7t5v0__fillcap_8
Xwave_controller_x_inst_fanout401 fanout402/Z wave_controller_x_inst__2910_/B VDD
+ VDD VSS VSS gf180mcu_fd_sc_mcu7t5v0__dlyb_1
XFILLER_87_272 VDD VDD VSS VSS gf180mcu_fd_sc_mcu7t5v0__fill_2
XFILLER_94_209 VDD VDD VSS VSS gf180mcu_fd_sc_mcu7t5v0__fill_1
Xwave_controller_x_inst_fanout445 wave_controller_x_inst__3716_/Q wave_controller_x_inst__1781_/I
+ VDD VDD VSS VSS gf180mcu_fd_sc_mcu7t5v0__dlyb_1
XFILLER_102_594 VDD VDD VSS VSS gf180mcu_fd_sc_mcu7t5v0__fill_1
XTAP_TAPCELL_ROW_89_1346 VDD VSS gf180mcu_fd_sc_mcu7t5v0__filltie
Xwave_controller_y_inst__2987_ wave_controller_y_inst__3266_/A1 wave_controller_y_inst__1818_/I
+ wave_controller_y_inst__2987_/Z VDD VDD VSS VSS gf180mcu_fd_sc_mcu7t5v0__xor2_1
XFILLER_47_158 VDD VDD VSS VSS gf180mcu_fd_sc_mcu7t5v0__fill_1
XFILLER_47_169 VDD VDD VSS VSS gf180mcu_fd_sc_mcu7t5v0__fillcap_32
XFILLER_63_607 VDD VDD VSS VSS gf180mcu_fd_sc_mcu7t5v0__fill_1
XFILLER_85_89 VDD VDD VSS VSS gf180mcu_fd_sc_mcu7t5v0__fill_1
Xwave_controller_y_inst__1938_ wave_controller_y_inst__1938_/A1 wave_controller_y_inst__1939_/A1
+ wave_controller_y_inst__1939_/B wave_controller_y_inst__1938_/A4 wave_controller_y_inst__1941_/A2
+ VDD VDD VSS VSS gf180mcu_fd_sc_mcu7t5v0__nand4_1
Xwave_controller_y_inst__1869_ spi_regs_inst__1097_/A1 wave_controller_y_inst__3500_/B2
+ VDD VDD VSS VSS gf180mcu_fd_sc_mcu7t5v0__clkinv_1
XFILLER_55_180 VDD VDD VSS VSS gf180mcu_fd_sc_mcu7t5v0__fill_2
XFILLER_71_640 VDD VDD VSS VSS gf180mcu_fd_sc_mcu7t5v0__fillcap_4
Xwave_controller_y_inst__3608_ wave_controller_y_inst__2923_/S wave_controller_y_inst__3608_/A2
+ wave_controller_y_inst__3608_/B wave_controller_y_inst__3680_/D VDD VDD VSS VSS
+ gf180mcu_fd_sc_mcu7t5v0__oai21_1
XFILLER_70_172 VDD VDD VSS VSS gf180mcu_fd_sc_mcu7t5v0__fill_2
XFILLER_71_684 VDD VDD VSS VSS gf180mcu_fd_sc_mcu7t5v0__fillcap_4
Xwave_controller_y_inst__3539_ wave_controller_y_inst__3557_/A1 wave_controller_y_inst__3539_/A2
+ wave_controller_y_inst__3539_/A3 wave_controller_y_inst__3557_/B1 wave_controller_y_inst__3539_/B2
+ wave_controller_y_inst__3642_/D VDD VDD VSS VSS gf180mcu_fd_sc_mcu7t5v0__oai32_1
XTAP_TAPCELL_ROW_100_1524 VDD VSS gf180mcu_fd_sc_mcu7t5v0__filltie
XTAP_TAPCELL_ROW_100_1535 VDD VSS gf180mcu_fd_sc_mcu7t5v0__filltie
XFILLER_145_1170 VDD VDD VSS VSS gf180mcu_fd_sc_mcu7t5v0__fillcap_4
XFILLER_156_244 VDD VDD VSS VSS gf180mcu_fd_sc_mcu7t5v0__fill_1
XFILLER_89_1116 VDD VDD VSS VSS gf180mcu_fd_sc_mcu7t5v0__fillcap_4
Xsignal_processor_x_inst__129_ signal_processor_x_inst__230_/Q signal_processor_x_inst__256_/Q
+ signal_processor_x_inst__129_/Z VDD VDD VSS VSS gf180mcu_fd_sc_mcu7t5v0__and2_1
XFILLER_7_276 VDD VDD VSS VSS gf180mcu_fd_sc_mcu7t5v0__fillcap_4
XTAP_TAPCELL_ROW_133_2067 VDD VSS gf180mcu_fd_sc_mcu7t5v0__filltie
XTAP_TAPCELL_ROW_133_2078 VDD VSS gf180mcu_fd_sc_mcu7t5v0__filltie
XFILLER_140_601 VDD VDD VSS VSS gf180mcu_fd_sc_mcu7t5v0__fill_2
XFILLER_152_450 VDD VDD VSS VSS gf180mcu_fd_sc_mcu7t5v0__fillcap_4
Xspi_regs_inst__1013_ spi_regs_inst__1013_/A1 spi_regs_inst__1019_/A2 spi_regs_inst_wire231/I
+ VDD VDD VSS VSS gf180mcu_fd_sc_mcu7t5v0__nor2_1
XFILLER_113_837 VDD VDD VSS VSS gf180mcu_fd_sc_mcu7t5v0__fill_2
XFILLER_124_163 VDD VDD VSS VSS gf180mcu_fd_sc_mcu7t5v0__fillcap_4
XFILLER_125_697 VDD VDD VSS VSS gf180mcu_fd_sc_mcu7t5v0__fill_2
XFILLER_140_656 VDD VDD VSS VSS gf180mcu_fd_sc_mcu7t5v0__fillcap_4
Xwave_controller_y_inst_fanout390 wave_controller_y_inst__3039_/A1 wave_controller_y_inst__3010_/B
+ VDD VDD VSS VSS gf180mcu_fd_sc_mcu7t5v0__dlyb_1
XFILLER_61_1046 VDD VDD VSS VSS gf180mcu_fd_sc_mcu7t5v0__fillcap_4
XFILLER_67_924 VDD VDD VSS VSS gf180mcu_fd_sc_mcu7t5v0__fillcap_32
XFILLER_79_784 VDD VDD VSS VSS gf180mcu_fd_sc_mcu7t5v0__fill_1
XFILLER_85_209 VDD VDD VSS VSS gf180mcu_fd_sc_mcu7t5v0__fill_1
XFILLER_66_445 VDD VDD VSS VSS gf180mcu_fd_sc_mcu7t5v0__fill_2
XFILLER_93_275 VDD VDD VSS VSS gf180mcu_fd_sc_mcu7t5v0__fillcap_4
XFILLER_62_662 VDD VDD VSS VSS gf180mcu_fd_sc_mcu7t5v0__fill_2
Xspi_regs_inst__0728_ spi_regs_inst__1653_/Q spi_regs_inst__0827_/A1 VDD VDD VSS VSS
+ gf180mcu_fd_sc_mcu7t5v0__clkinv_1
XFILLER_61_183 VDD VDD VSS VSS gf180mcu_fd_sc_mcu7t5v0__fillcap_8
XTAP_TAPCELL_ROW_60_863 VDD VSS gf180mcu_fd_sc_mcu7t5v0__filltie
XTAP_TAPCELL_ROW_60_874 VDD VSS gf180mcu_fd_sc_mcu7t5v0__filltie
Xwave_controller_x_inst__3110_ wave_controller_x_inst__3266_/A1 spi_regs_inst__1532_/Q
+ wave_controller_x_inst__3110_/Z VDD VDD VSS VSS gf180mcu_fd_sc_mcu7t5v0__and2_1
XFILLER_147_222 VDD VDD VSS VSS gf180mcu_fd_sc_mcu7t5v0__fill_2
XTAP_TAPCELL_ROW_118_1818 VDD VSS gf180mcu_fd_sc_mcu7t5v0__filltie
Xwave_controller_x_inst__3041_ wave_controller_x_inst__3049_/A2 wave_controller_x_inst__3043_/A3
+ wave_controller_x_inst__3042_/B1 VDD VDD VSS VSS gf180mcu_fd_sc_mcu7t5v0__nand2_1
XTAP_TAPCELL_ROW_118_1829 VDD VSS gf180mcu_fd_sc_mcu7t5v0__filltie
XFILLER_162_225 VDD VDD VSS VSS gf180mcu_fd_sc_mcu7t5v0__fillcap_4
XFILLER_162_247 VDD VDD VSS VSS gf180mcu_fd_sc_mcu7t5v0__fill_1
XFILLER_104_804 VDD VDD VSS VSS gf180mcu_fd_sc_mcu7t5v0__fill_1
XFILLER_116_653 VDD VDD VSS VSS gf180mcu_fd_sc_mcu7t5v0__fill_1
Xmax_cap463 max_cap463/I max_cap463/Z VDD VDD VSS VSS gf180mcu_fd_sc_mcu7t5v0__buf_3
Xmax_cap452 max_cap452/I max_cap452/Z VDD VDD VSS VSS gf180mcu_fd_sc_mcu7t5v0__buf_3
Xmax_cap430 max_cap430/I max_cap430/Z VDD VDD VSS VSS gf180mcu_fd_sc_mcu7t5v0__buf_2
XFILLER_157_1052 VDD VDD VSS VSS gf180mcu_fd_sc_mcu7t5v0__fillcap_64
XFILLER_1_419 VDD VDD VSS VSS gf180mcu_fd_sc_mcu7t5v0__fill_1
XFILLER_103_347 VDD VDD VSS VSS gf180mcu_fd_sc_mcu7t5v0__fill_2
XFILLER_104_859 VDD VDD VSS VSS gf180mcu_fd_sc_mcu7t5v0__fillcap_16
XFILLER_89_559 VDD VDD VSS VSS gf180mcu_fd_sc_mcu7t5v0__fill_1
Xwave_controller_y_inst__2910_ wave_controller_y_inst__3489_/C wave_controller_y_inst__2896_/B
+ wave_controller_y_inst__3010_/B wave_controller_y_inst__2911_/B VDD VDD VSS VSS
+ gf180mcu_fd_sc_mcu7t5v0__oai21_1
XFILLER_85_710 VDD VDD VSS VSS gf180mcu_fd_sc_mcu7t5v0__fillcap_16
Xwave_controller_y_inst__2841_ wave_controller_y_inst__2841_/A1 wave_controller_y_inst__1902_/I
+ wave_controller_y_inst__2841_/B wave_controller_y_inst__2847_/A2 VDD VDD VSS VSS
+ gf180mcu_fd_sc_mcu7t5v0__oai21_1
Xwave_controller_x_inst__2825_ wave_controller_x_inst__3080_/A1 wave_controller_x_inst__2837_/B1
+ wave_controller_x_inst__2838_/A1 VDD VDD VSS VSS gf180mcu_fd_sc_mcu7t5v0__nand2_1
XFILLER_57_467 VDD VDD VSS VSS gf180mcu_fd_sc_mcu7t5v0__fillcap_4
Xwave_controller_y_inst__2772_ wave_controller_y_inst__2117_/B wave_controller_y_inst__2897_/A2
+ wave_controller_y_inst__2855_/A1 VDD VDD VSS VSS gf180mcu_fd_sc_mcu7t5v0__nand2_1
Xwave_controller_x_inst__2756_ wave_controller_x_inst__2756_/A1 wave_controller_x_inst__2756_/A2
+ wave_controller_x_inst__2756_/B wave_controller_x_inst__3734_/D VDD VDD VSS VSS
+ gf180mcu_fd_sc_mcu7t5v0__oai21_1
XFILLER_57_489 VDD VDD VSS VSS gf180mcu_fd_sc_mcu7t5v0__fill_1
XTAP_TAPCELL_ROW_68_996 VDD VSS gf180mcu_fd_sc_mcu7t5v0__filltie
XFILLER_37_191 VDD VDD VSS VSS gf180mcu_fd_sc_mcu7t5v0__fillcap_8
XFILLER_44_139 VDD VDD VSS VSS gf180mcu_fd_sc_mcu7t5v0__fill_1
Xwave_controller_x_inst__2687_ spi_regs_inst__1336_/A1 wave_controller_x_inst__3542_/B2
+ wave_controller_x_inst__2687_/B wave_controller_x_inst__2688_/C VDD VDD VSS VSS
+ gf180mcu_fd_sc_mcu7t5v0__oai21_1
XFILLER_129_1154 VDD VDD VSS VSS gf180mcu_fd_sc_mcu7t5v0__fillcap_16
XFILLER_52_150 VDD VDD VSS VSS gf180mcu_fd_sc_mcu7t5v0__fill_2
XFILLER_81_982 VDD VDD VSS VSS gf180mcu_fd_sc_mcu7t5v0__fillcap_64
XTAP_TAPCELL_ROW_84_1265 VDD VSS gf180mcu_fd_sc_mcu7t5v0__filltie
XFILLER_111_76 VDD VDD VSS VSS gf180mcu_fd_sc_mcu7t5v0__fill_2
Xwave_controller_y_inst__3324_ wave_controller_y_inst__3320_/B wave_controller_y_inst__3333_/A2
+ wave_controller_y_inst__3333_/A3 wave_controller_y_inst__3397_/A1 VDD VDD VSS VSS
+ gf180mcu_fd_sc_mcu7t5v0__nor3_1
Xwave_controller_x_inst__3308_ wave_controller_x_inst__3711_/Q wave_controller_x_inst__3311_/B
+ wave_controller_x_inst__3306_/Z wave_controller_x_inst__3310_/B wave_controller_x_inst__3360_/A1
+ VDD VDD VSS VSS gf180mcu_fd_sc_mcu7t5v0__oai22_1
XFILLER_127_907 VDD VDD VSS VSS gf180mcu_fd_sc_mcu7t5v0__fill_2
XFILLER_138_244 VDD VDD VSS VSS gf180mcu_fd_sc_mcu7t5v0__fill_1
XPHY_EDGE_ROW_109_Right_109 VDD VSS gf180mcu_fd_sc_mcu7t5v0__endcap
Xwave_controller_y_inst__3255_ wave_controller_y_inst__3255_/A1 wave_controller_y_inst__3255_/A2
+ wave_controller_y_inst__3192_/B wave_controller_y_inst__3255_/Z VDD VDD VSS VSS
+ gf180mcu_fd_sc_mcu7t5v0__or3_1
XFILLER_154_726 VDD VDD VSS VSS gf180mcu_fd_sc_mcu7t5v0__fillcap_8
Xwave_controller_y_inst__2206_ fanout507/Z wave_controller_y_inst__2205_/Z wave_controller_y_inst__2216_/B
+ VDD VDD VSS VSS gf180mcu_fd_sc_mcu7t5v0__nor2_1
Xwave_controller_x_inst__3239_ fanout542/I wave_controller_x_inst__3151_/Z wave_controller_x_inst__3239_/A3
+ wave_controller_x_inst__3240_/A3 VDD VDD VSS VSS gf180mcu_fd_sc_mcu7t5v0__nor3_1
XFILLER_112_2 VDD VDD VSS VSS gf180mcu_fd_sc_mcu7t5v0__fillcap_16
XFILLER_153_236 VDD VDD VSS VSS gf180mcu_fd_sc_mcu7t5v0__fillcap_4
XFILLER_154_737 VDD VDD VSS VSS gf180mcu_fd_sc_mcu7t5v0__fillcap_8
XFILLER_166_597 VDD VDD VSS VSS gf180mcu_fd_sc_mcu7t5v0__fillcap_64
Xwave_controller_y_inst__3186_ wave_controller_y_inst__3189_/C spi_regs_inst__1580_/Q
+ wave_controller_y_inst__3194_/B VDD VDD VSS VSS gf180mcu_fd_sc_mcu7t5v0__xor2_1
XFILLER_141_409 VDD VDD VSS VSS gf180mcu_fd_sc_mcu7t5v0__fillcap_8
Xwave_controller_y_inst__2137_ wave_controller_y_inst__2080_/B wave_controller_y_inst__2137_/A2
+ wave_controller_y_inst__2138_/C VDD VDD VSS VSS gf180mcu_fd_sc_mcu7t5v0__nor2_1
Xwave_controller_y_inst__2068_ wave_controller_y_inst__2092_/A1 wave_controller_y_inst__2092_/A2
+ wave_controller_y_inst__2109_/A2 VDD VDD VSS VSS gf180mcu_fd_sc_mcu7t5v0__nand2_1
XFILLER_110_807 VDD VDD VSS VSS gf180mcu_fd_sc_mcu7t5v0__fillcap_4
XFILLER_122_667 VDD VDD VSS VSS gf180mcu_fd_sc_mcu7t5v0__fillcap_8
XFILLER_96_22 VDD VDD VSS VSS gf180mcu_fd_sc_mcu7t5v0__fillcap_8
XFILLER_102_391 VDD VDD VSS VSS gf180mcu_fd_sc_mcu7t5v0__fill_2
XFILLER_76_743 VDD VDD VSS VSS gf180mcu_fd_sc_mcu7t5v0__fillcap_8
XFILLER_91_702 VDD VDD VSS VSS gf180mcu_fd_sc_mcu7t5v0__fillcap_8
XFILLER_152_94 VDD VDD VSS VSS gf180mcu_fd_sc_mcu7t5v0__fill_1
XFILLER_90_212 VDD VDD VSS VSS gf180mcu_fd_sc_mcu7t5v0__fill_1
XFILLER_91_735 VDD VDD VSS VSS gf180mcu_fd_sc_mcu7t5v0__fill_1
XPHY_EDGE_ROW_50_1_Left_217 VDD VSS gf180mcu_fd_sc_mcu7t5v0__endcap
XTAP_TAPCELL_ROW_43_1_653 VDD VSS gf180mcu_fd_sc_mcu7t5v0__filltie
XFILLER_16_331 VDD VDD VSS VSS gf180mcu_fd_sc_mcu7t5v0__fill_2
Xspi_regs_inst__1631_ spi_regs_inst__1631_/D fanout584/Z clkbuf_leaf_14_clk/Z spi_regs_inst__1631_/Q
+ VDD VDD VSS VSS gf180mcu_fd_sc_mcu7t5v0__dffrnq_1
XFILLER_90_267 VDD VDD VSS VSS gf180mcu_fd_sc_mcu7t5v0__fillcap_16
Xspi_regs_inst__1562_ spi_regs_inst__1562_/D spi_regs_inst__1649_/RN clkbuf_leaf_41_clk/Z
+ spi_regs_inst__1562_/Q VDD VDD VSS VSS gf180mcu_fd_sc_mcu7t5v0__dffrnq_1
XFILLER_71_492 VDD VDD VSS VSS gf180mcu_fd_sc_mcu7t5v0__fillcap_16
XFILLER_31_367 VDD VDD VSS VSS gf180mcu_fd_sc_mcu7t5v0__fillcap_8
Xspi_regs_inst__1493_ spi_regs_inst__1493_/D spi_regs_inst__1647_/RN clkbuf_leaf_39_clk/Z
+ fanout501/I VDD VDD VSS VSS gf180mcu_fd_sc_mcu7t5v0__dffrnq_1
XFILLER_129_222 VDD VDD VSS VSS gf180mcu_fd_sc_mcu7t5v0__fillcap_8
XFILLER_31_389 VDD VDD VSS VSS gf180mcu_fd_sc_mcu7t5v0__fill_1
XTAP_TAPCELL_ROW_135_2107 VDD VSS gf180mcu_fd_sc_mcu7t5v0__filltie
XFILLER_144_236 VDD VDD VSS VSS gf180mcu_fd_sc_mcu7t5v0__fill_1
XFILLER_157_597 VDD VDD VSS VSS gf180mcu_fd_sc_mcu7t5v0__fillcap_4
XFILLER_112_100 VDD VDD VSS VSS gf180mcu_fd_sc_mcu7t5v0__fillcap_4
XFILLER_125_483 VDD VDD VSS VSS gf180mcu_fd_sc_mcu7t5v0__fillcap_4
XTAP_TAPCELL_ROW_113_1737 VDD VSS gf180mcu_fd_sc_mcu7t5v0__filltie
XTAP_TAPCELL_ROW_113_1748 VDD VSS gf180mcu_fd_sc_mcu7t5v0__filltie
Xstate_machine_inst__26_ spi_regs_inst__1058_/B2 state_machine_inst__26_/A2 spi_regs_inst__1146_/A1
+ state_machine_inst__26_/A4 state_machine_inst__26_/Z VDD VDD VSS VSS gf180mcu_fd_sc_mcu7t5v0__or4_1
XFILLER_112_111 VDD VDD VSS VSS gf180mcu_fd_sc_mcu7t5v0__fill_2
XFILLER_141_976 VDD VDD VSS VSS gf180mcu_fd_sc_mcu7t5v0__fillcap_4
Xfanout509 fanout509/I fanout509/Z VDD VDD VSS VSS gf180mcu_fd_sc_mcu7t5v0__dlyb_1
XFILLER_100_317 VDD VDD VSS VSS gf180mcu_fd_sc_mcu7t5v0__fill_2
XFILLER_112_177 VDD VDD VSS VSS gf180mcu_fd_sc_mcu7t5v0__fill_2
XFILLER_140_453 VDD VDD VSS VSS gf180mcu_fd_sc_mcu7t5v0__fill_2
XFILLER_140_475 VDD VDD VSS VSS gf180mcu_fd_sc_mcu7t5v0__fill_1
XFILLER_79_570 VDD VDD VSS VSS gf180mcu_fd_sc_mcu7t5v0__fill_1
XFILLER_100_339 VDD VDD VSS VSS gf180mcu_fd_sc_mcu7t5v0__fillcap_32
XFILLER_39_467 VDD VDD VSS VSS gf180mcu_fd_sc_mcu7t5v0__fillcap_4
XTAP_TAPCELL_ROW_163_2561 VDD VSS gf180mcu_fd_sc_mcu7t5v0__filltie
Xwave_controller_x_inst__3590_ wave_controller_x_inst__3590_/I0 wire450/I wave_controller_x_inst__3591_/S
+ wave_controller_x_inst__3667_/D VDD VDD VSS VSS gf180mcu_fd_sc_mcu7t5v0__mux2_2
Xwave_controller_x_inst__2610_ wave_controller_x_inst__2610_/A1 wave_controller_x_inst__2634_/A1
+ wave_controller_x_inst__2610_/Z VDD VDD VSS VSS gf180mcu_fd_sc_mcu7t5v0__and2_1
XFILLER_26_128 VDD VDD VSS VSS gf180mcu_fd_sc_mcu7t5v0__fill_1
XFILLER_39_489 VDD VDD VSS VSS gf180mcu_fd_sc_mcu7t5v0__fill_1
XFILLER_94_573 VDD VDD VSS VSS gf180mcu_fd_sc_mcu7t5v0__fillcap_16
XTAP_TAPCELL_ROW_163_2572 VDD VSS gf180mcu_fd_sc_mcu7t5v0__filltie
XTAP_TAPCELL_ROW_128_1991 VDD VSS gf180mcu_fd_sc_mcu7t5v0__filltie
XTAP_TAPCELL_ROW_65_944 VDD VSS gf180mcu_fd_sc_mcu7t5v0__filltie
XTAP_TAPCELL_ROW_65_955 VDD VSS gf180mcu_fd_sc_mcu7t5v0__filltie
Xwave_controller_x_inst__2541_ wave_controller_x_inst__2542_/A1 wave_controller_x_inst__2541_/A2
+ wave_controller_x_inst__2563_/A1 VDD VDD VSS VSS gf180mcu_fd_sc_mcu7t5v0__nor2_1
XFILLER_34_161 VDD VDD VSS VSS gf180mcu_fd_sc_mcu7t5v0__fill_2
XFILLER_63_982 VDD VDD VSS VSS gf180mcu_fd_sc_mcu7t5v0__fillcap_64
XFILLER_81_278 VDD VDD VSS VSS gf180mcu_fd_sc_mcu7t5v0__fill_2
Xwave_controller_x_inst__2472_ wave_controller_x_inst__2516_/A1 spi_regs_inst__1212_/B2
+ wave_controller_x_inst__2517_/C VDD VDD VSS VSS gf180mcu_fd_sc_mcu7t5v0__nand2_1
Xwave_controller_y_inst__3040_ spi_regs_inst__1486_/Q wave_controller_y_inst__3090_/B1
+ wave_controller_y_inst__3042_/A2 VDD VDD VSS VSS gf180mcu_fd_sc_mcu7t5v0__nand2_1
XFILLER_108_439 VDD VDD VSS VSS gf180mcu_fd_sc_mcu7t5v0__fill_2
XFILLER_136_737 VDD VDD VSS VSS gf180mcu_fd_sc_mcu7t5v0__fillcap_16
XFILLER_136_759 VDD VDD VSS VSS gf180mcu_fd_sc_mcu7t5v0__fill_1
Xwave_controller_x_inst__3024_ wave_controller_x_inst__3695_/Q wave_controller_x_inst_wire60/Z
+ wave_controller_x_inst__3026_/A3 wave_controller_x_inst__3029_/A2 VDD VDD VSS VSS
+ gf180mcu_fd_sc_mcu7t5v0__nand3_1
XFILLER_123_409 VDD VDD VSS VSS gf180mcu_fd_sc_mcu7t5v0__fill_2
XFILLER_151_718 VDD VDD VSS VSS gf180mcu_fd_sc_mcu7t5v0__fillcap_8
XFILLER_104_601 VDD VDD VSS VSS gf180mcu_fd_sc_mcu7t5v0__fill_1
XFILLER_150_228 VDD VDD VSS VSS gf180mcu_fd_sc_mcu7t5v0__fill_2
XFILLER_106_10 VDD VDD VSS VSS gf180mcu_fd_sc_mcu7t5v0__fillcap_4
XFILLER_132_943 VDD VDD VSS VSS gf180mcu_fd_sc_mcu7t5v0__fill_2
Xsignal_processor_y_inst_max_cap347 signal_processor_y_inst__166_/A2 signal_processor_y_inst__167_/A2
+ VDD VDD VSS VSS gf180mcu_fd_sc_mcu7t5v0__clkbuf_1
XFILLER_104_667 VDD VDD VSS VSS gf180mcu_fd_sc_mcu7t5v0__fillcap_4
XFILLER_131_453 VDD VDD VSS VSS gf180mcu_fd_sc_mcu7t5v0__fillcap_16
XFILLER_49_209 VDD VDD VSS VSS gf180mcu_fd_sc_mcu7t5v0__fill_1
Xsignal_processor_y_inst_fanout543 fanout544/Z signal_processor_y_inst__253_/RN VDD
+ VDD VSS VSS gf180mcu_fd_sc_mcu7t5v0__dlyb_1
XFILLER_73_702 VDD VDD VSS VSS gf180mcu_fd_sc_mcu7t5v0__fillcap_16
Xwave_controller_y_inst__2824_ wave_controller_y_inst__2824_/A1 wave_controller_y_inst__2844_/A2
+ wave_controller_y_inst__2824_/B wave_controller_y_inst__2837_/B1 VDD VDD VSS VSS
+ gf180mcu_fd_sc_mcu7t5v0__oai21_1
Xwave_controller_x_inst__2808_ wave_controller_x_inst__2809_/A1 wave_controller_x_inst__2808_/A2
+ wave_controller_x_inst__2810_/C wave_controller_x_inst__2807_/Z wave_controller_x_inst__2810_/A2
+ VDD VDD VSS VSS gf180mcu_fd_sc_mcu7t5v0__nand4_1
XFILLER_58_787 VDD VDD VSS VSS gf180mcu_fd_sc_mcu7t5v0__fillcap_4
Xwave_controller_y_inst__2755_ wave_controller_y_inst__2755_/A1 wave_controller_y_inst__2755_/A2
+ wave_controller_y_inst__3726_/D VDD VDD VSS VSS gf180mcu_fd_sc_mcu7t5v0__nor2_1
XFILLER_122_53 VDD VDD VSS VSS gf180mcu_fd_sc_mcu7t5v0__fillcap_16
XFILLER_61_908 VDD VDD VSS VSS gf180mcu_fd_sc_mcu7t5v0__fill_2
Xwave_controller_x_inst__2739_ wave_controller_x_inst__2722_/Z wave_controller_x_inst__2739_/A2
+ wave_controller_x_inst__2739_/B1 wave_controller_x_inst__2739_/B2 wave_controller_x_inst__2739_/C
+ wave_controller_x_inst_wire36/I VDD VDD VSS VSS gf180mcu_fd_sc_mcu7t5v0__aoi221_1
XFILLER_82_57 VDD VDD VSS VSS gf180mcu_fd_sc_mcu7t5v0__fill_2
Xwave_controller_y_inst__2686_ wave_controller_y_inst__2686_/A1 wave_controller_y_inst__2668_/Z
+ wave_controller_y_inst__2686_/Z VDD VDD VSS VSS gf180mcu_fd_sc_mcu7t5v0__or2_1
XFILLER_25_183 VDD VDD VSS VSS gf180mcu_fd_sc_mcu7t5v0__fill_1
XFILLER_13_356 VDD VDD VSS VSS gf180mcu_fd_sc_mcu7t5v0__fill_2
XFILLER_158_317 VDD VDD VSS VSS gf180mcu_fd_sc_mcu7t5v0__fillcap_4
XFILLER_55_1170 VDD VDD VSS VSS gf180mcu_fd_sc_mcu7t5v0__fillcap_4
Xwave_controller_y_inst__3307_ wave_controller_y_inst__3711_/Q spi_regs_inst__1609_/Q
+ wave_controller_y_inst__3310_/B VDD VDD VSS VSS gf180mcu_fd_sc_mcu7t5v0__xor2_1
XFILLER_142_1151 VDD VDD VSS VSS gf180mcu_fd_sc_mcu7t5v0__fillcap_4
XFILLER_126_225 VDD VDD VSS VSS gf180mcu_fd_sc_mcu7t5v0__fill_2
XFILLER_127_748 VDD VDD VSS VSS gf180mcu_fd_sc_mcu7t5v0__fill_2
XFILLER_154_512 VDD VDD VSS VSS gf180mcu_fd_sc_mcu7t5v0__fill_2
XTAP_TAPCELL_ROW_46_1_679 VDD VSS gf180mcu_fd_sc_mcu7t5v0__filltie
Xwave_controller_y_inst__3238_ wave_controller_y_inst__1823_/I wave_controller_y_inst__3213_/Z
+ wave_controller_y_inst__3217_/Z wave_controller_y_inst_wire108/Z wave_controller_y_inst__3238_/C
+ wave_controller_y_inst__3240_/A2 VDD VDD VSS VSS gf180mcu_fd_sc_mcu7t5v0__aoi221_1
XFILLER_126_247 VDD VDD VSS VSS gf180mcu_fd_sc_mcu7t5v0__fillcap_16
XTAP_TAPCELL_ROW_130_2015 VDD VSS gf180mcu_fd_sc_mcu7t5v0__filltie
Xwave_controller_y_inst__3169_ wave_controller_y_inst__3197_/A1 wave_controller_y_inst__3174_/A2
+ wave_controller_y_inst__3196_/A2 VDD VDD VSS VSS gf180mcu_fd_sc_mcu7t5v0__nor2_1
XTAP_TAPCELL_ROW_97_1478 VDD VSS gf180mcu_fd_sc_mcu7t5v0__filltie
XTAP_TAPCELL_ROW_130_2026 VDD VSS gf180mcu_fd_sc_mcu7t5v0__filltie
XFILLER_122_453 VDD VDD VSS VSS gf180mcu_fd_sc_mcu7t5v0__fill_2
XFILLER_0_271 VDD VDD VSS VSS gf180mcu_fd_sc_mcu7t5v0__fill_1
Xspi_regs_inst_fanout562 fanout563/Z spi_regs_inst__1662_/RN VDD VDD VSS VSS gf180mcu_fd_sc_mcu7t5v0__dlyb_1
Xspi_regs_inst__0993_ spi_regs_inst__1032_/A1 spi_regs_inst__1021_/A2 spi_regs_inst_wire252/I
+ VDD VDD VSS VSS gf180mcu_fd_sc_mcu7t5v0__nor2_1
XFILLER_63_212 VDD VDD VSS VSS gf180mcu_fd_sc_mcu7t5v0__fillcap_8
XFILLER_91_521 VDD VDD VSS VSS gf180mcu_fd_sc_mcu7t5v0__fillcap_4
XFILLER_48_297 VDD VDD VSS VSS gf180mcu_fd_sc_mcu7t5v0__fillcap_8
XFILLER_56_80 VDD VDD VSS VSS gf180mcu_fd_sc_mcu7t5v0__fillcap_16
XFILLER_91_554 VDD VDD VSS VSS gf180mcu_fd_sc_mcu7t5v0__fillcap_4
XTAP_TAPCELL_ROW_62_903 VDD VSS gf180mcu_fd_sc_mcu7t5v0__filltie
Xspi_regs_inst__1614_ spi_regs_inst__1614_/D fanout563/Z clkload9/I spi_regs_inst__1614_/Q
+ VDD VDD VSS VSS gf180mcu_fd_sc_mcu7t5v0__dffrnq_1
XTAP_TAPCELL_ROW_141_2199 VDD VSS gf180mcu_fd_sc_mcu7t5v0__filltie
XFILLER_31_131 VDD VDD VSS VSS gf180mcu_fd_sc_mcu7t5v0__fillcap_8
Xspi_regs_inst__1545_ spi_regs_inst__1545_/D spi_regs_inst__1601_/RN clkbuf_leaf_38_clk/Z
+ spi_regs_inst__1545_/Q VDD VDD VSS VSS gf180mcu_fd_sc_mcu7t5v0__dffrnq_1
XFILLER_31_175 VDD VDD VSS VSS gf180mcu_fd_sc_mcu7t5v0__fill_2
XFILLER_31_186 VDD VDD VSS VSS gf180mcu_fd_sc_mcu7t5v0__fillcap_16
Xspi_regs_inst__1476_ spi_regs_inst__1476_/D spi_regs_inst__1605_/RN clkbuf_leaf_38_clk/Z
+ fanout523/I VDD VDD VSS VSS gf180mcu_fd_sc_mcu7t5v0__dffrnq_1
XFILLER_164_309 VDD VDD VSS VSS gf180mcu_fd_sc_mcu7t5v0__fillcap_4
XFILLER_118_748 VDD VDD VSS VSS gf180mcu_fd_sc_mcu7t5v0__fill_2
XFILLER_157_372 VDD VDD VSS VSS gf180mcu_fd_sc_mcu7t5v0__fillcap_8
XFILLER_126_781 VDD VDD VSS VSS gf180mcu_fd_sc_mcu7t5v0__fillcap_16
XFILLER_154_1011 VDD VDD VSS VSS gf180mcu_fd_sc_mcu7t5v0__fillcap_4
XFILLER_67_1052 VDD VDD VSS VSS gf180mcu_fd_sc_mcu7t5v0__fillcap_64
XFILLER_99_632 VDD VDD VSS VSS gf180mcu_fd_sc_mcu7t5v0__fillcap_32
XFILLER_141_784 VDD VDD VSS VSS gf180mcu_fd_sc_mcu7t5v0__fill_1
XFILLER_87_805 VDD VDD VSS VSS gf180mcu_fd_sc_mcu7t5v0__fillcap_16
XTAP_TAPCELL_ROW_165_2601 VDD VSS gf180mcu_fd_sc_mcu7t5v0__filltie
Xwave_controller_x_inst__1972_ wave_controller_x_inst__1973_/A1 wave_controller_x_inst__1973_/A2
+ wave_controller_x_inst__1972_/B wave_controller_x_inst__1981_/C VDD VDD VSS VSS
+ gf180mcu_fd_sc_mcu7t5v0__aoi21_1
XFILLER_100_125 VDD VDD VSS VSS gf180mcu_fd_sc_mcu7t5v0__fillcap_4
Xwave_controller_x_inst__3711_ wave_controller_x_inst__3711_/D wave_controller_x_inst__3712_/RN
+ clkload33/I wave_controller_x_inst__3711_/Q VDD VDD VSS VSS gf180mcu_fd_sc_mcu7t5v0__dffrnq_1
XFILLER_100_158 VDD VDD VSS VSS gf180mcu_fd_sc_mcu7t5v0__fill_1
XFILLER_55_702 VDD VDD VSS VSS gf180mcu_fd_sc_mcu7t5v0__fillcap_8
Xwave_controller_y_inst_max_cap317 wave_controller_y_inst__2896_/B wave_controller_y_inst__3424_/A2
+ VDD VDD VSS VSS gf180mcu_fd_sc_mcu7t5v0__buf_2
XFILLER_100_169 VDD VDD VSS VSS gf180mcu_fd_sc_mcu7t5v0__fillcap_4
XFILLER_95_893 VDD VDD VSS VSS gf180mcu_fd_sc_mcu7t5v0__fillcap_4
XTAP_TAPCELL_ROW_4_1_363 VDD VSS gf180mcu_fd_sc_mcu7t5v0__filltie
XTAP_TAPCELL_ROW_68_1002 VDD VSS gf180mcu_fd_sc_mcu7t5v0__filltie
Xwave_controller_x_inst__3642_ wave_controller_x_inst__3642_/D wave_controller_x_inst__3715_/RN
+ clkbuf_leaf_25_clk/Z spi_regs_inst__1301_/A1 VDD VDD VSS VSS gf180mcu_fd_sc_mcu7t5v0__dffrnq_1
Xwave_controller_x_inst__3573_ wave_controller_x_inst__3602_/I0 max_cap457/I wave_controller_x_inst__3573_/S
+ wave_controller_x_inst__3656_/D VDD VDD VSS VSS gf180mcu_fd_sc_mcu7t5v0__mux2_2
XFILLER_70_716 VDD VDD VSS VSS gf180mcu_fd_sc_mcu7t5v0__fill_2
Xwave_controller_y_inst__2540_ wave_controller_y_inst__2540_/I wave_controller_y_inst__2541_/A2
+ VDD VDD VSS VSS gf180mcu_fd_sc_mcu7t5v0__clkinv_1
Xwave_controller_x_inst__2524_ wave_controller_x_inst__3512_/B2 wave_controller_x_inst__2523_/Z
+ wave_controller_x_inst__2524_/Z VDD VDD VSS VSS gf180mcu_fd_sc_mcu7t5v0__xor2_1
XFILLER_35_470 VDD VDD VSS VSS gf180mcu_fd_sc_mcu7t5v0__fill_2
XFILLER_54_289 VDD VDD VSS VSS gf180mcu_fd_sc_mcu7t5v0__fillcap_4
XTAP_TAPCELL_ROW_81_1213 VDD VSS gf180mcu_fd_sc_mcu7t5v0__filltie
Xwave_controller_y_inst__2471_ spi_regs_inst__1218_/A1 wave_controller_y_inst__3506_/B2
+ wave_controller_y_inst__2490_/A2 VDD VDD VSS VSS gf180mcu_fd_sc_mcu7t5v0__nand2_1
XFILLER_165_1162 VDD VDD VSS VSS gf180mcu_fd_sc_mcu7t5v0__fillcap_4
XFILLER_22_131 VDD VDD VSS VSS gf180mcu_fd_sc_mcu7t5v0__fill_1
Xwave_controller_x_inst__2455_ wave_controller_x_inst__2757_/A1 spi_regs_inst__1064_/B2
+ wave_controller_x_inst__2455_/B wave_controller_x_inst__2464_/A2 VDD VDD VSS VSS
+ gf180mcu_fd_sc_mcu7t5v0__aoi21_1
XFILLER_126_1157 VDD VDD VSS VSS gf180mcu_fd_sc_mcu7t5v0__fillcap_8
XFILLER_22_164 VDD VDD VSS VSS gf180mcu_fd_sc_mcu7t5v0__fillcap_8
Xwave_controller_x_inst__2386_ spi_regs_inst__1336_/A1 wave_controller_x_inst__2384_/Z
+ wave_controller_x_inst__2407_/A1 wave_controller_x_inst__2407_/A2 VDD VDD VSS VSS
+ gf180mcu_fd_sc_mcu7t5v0__nand3_1
XFILLER_136_501 VDD VDD VSS VSS gf180mcu_fd_sc_mcu7t5v0__fill_1
XFILLER_108_247 VDD VDD VSS VSS gf180mcu_fd_sc_mcu7t5v0__fillcap_8
XFILLER_109_759 VDD VDD VSS VSS gf180mcu_fd_sc_mcu7t5v0__fill_2
XTAP_TAPCELL_ROW_79_1175 VDD VSS gf180mcu_fd_sc_mcu7t5v0__filltie
Xwave_controller_y_inst__3023_ wave_controller_y_inst__3695_/Q wave_controller_y_inst_wire25/Z
+ wave_controller_y_inst__3025_/A3 wave_controller_y_inst__3023_/B wave_controller_y_inst__3695_/D
+ VDD VDD VSS VSS gf180mcu_fd_sc_mcu7t5v0__oai31_1
Xwave_controller_x_inst__3007_ wave_controller_x_inst__2117_/B wave_controller_x_inst__3094_/A2
+ wave_controller_x_inst__3097_/A1 VDD VDD VSS VSS gf180mcu_fd_sc_mcu7t5v0__nor2_1
XFILLER_163_364 VDD VDD VSS VSS gf180mcu_fd_sc_mcu7t5v0__fill_1
XTAP_TAPCELL_ROW_79_1186 VDD VSS gf180mcu_fd_sc_mcu7t5v0__filltie
XFILLER_89_120 VDD VDD VSS VSS gf180mcu_fd_sc_mcu7t5v0__fillcap_16
XFILLER_105_976 VDD VDD VSS VSS gf180mcu_fd_sc_mcu7t5v0__fillcap_4
XFILLER_117_86 VDD VDD VSS VSS gf180mcu_fd_sc_mcu7t5v0__fillcap_4
XFILLER_120_913 VDD VDD VSS VSS gf180mcu_fd_sc_mcu7t5v0__fillcap_32
XTAP_TAPCELL_ROW_92_1397 VDD VSS gf180mcu_fd_sc_mcu7t5v0__filltie
XFILLER_77_79 VDD VDD VSS VSS gf180mcu_fd_sc_mcu7t5v0__fillcap_4
XFILLER_45_212 VDD VDD VSS VSS gf180mcu_fd_sc_mcu7t5v0__fillcap_64
Xwave_controller_y_inst__2807_ wave_controller_y_inst__3290_/A1 wave_controller_y_inst__2793_/Z
+ wave_controller_y_inst__2807_/Z VDD VDD VSS VSS gf180mcu_fd_sc_mcu7t5v0__xor2_1
Xwave_controller_y_inst__2738_ wave_controller_y_inst__2726_/B wave_controller_y_inst__2738_/A2
+ wave_controller_y_inst__2739_/C VDD VDD VSS VSS gf180mcu_fd_sc_mcu7t5v0__nor2_1
XTAP_TAPCELL_ROW_56_796 VDD VSS gf180mcu_fd_sc_mcu7t5v0__filltie
Xwave_controller_y_inst__2669_ wave_controller_y_inst__2688_/B1 wave_controller_y_inst__2686_/A1
+ wave_controller_y_inst__2669_/B wave_controller_y_inst__2672_/A3 VDD VDD VSS VSS
+ gf180mcu_fd_sc_mcu7t5v0__oai21_1
XFILLER_13_142 VDD VDD VSS VSS gf180mcu_fd_sc_mcu7t5v0__fillcap_16
XPHY_EDGE_ROW_161_Right_161 VDD VSS gf180mcu_fd_sc_mcu7t5v0__endcap
Xspi_regs_inst__1330_ spi_regs_inst__1362_/A1 spi_regs_inst__1328_/Z spi_regs_inst__1330_/A3
+ spi_regs_inst__1330_/B spi_regs_inst__1648_/D VDD VDD VSS VSS gf180mcu_fd_sc_mcu7t5v0__oai31_1
XTAP_TAPCELL_ROW_99_1518 VDD VSS gf180mcu_fd_sc_mcu7t5v0__filltie
XTAP_TAPCELL_ROW_99_1507 VDD VSS gf180mcu_fd_sc_mcu7t5v0__filltie
XFILLER_13_186 VDD VDD VSS VSS gf180mcu_fd_sc_mcu7t5v0__fillcap_8
XFILLER_139_372 VDD VDD VSS VSS gf180mcu_fd_sc_mcu7t5v0__fillcap_8
XTAP_TAPCELL_ROW_28_1_542 VDD VSS gf180mcu_fd_sc_mcu7t5v0__filltie
Xspi_regs_inst__1261_ spi_regs_inst__1261_/A1 spi_regs_inst__1290_/A2 spi_regs_inst__1261_/B1
+ spi_regs_inst__1261_/B2 spi_regs_inst__1263_/A3 VDD VDD VSS VSS gf180mcu_fd_sc_mcu7t5v0__aoi22_1
XFILLER_154_353 VDD VDD VSS VSS gf180mcu_fd_sc_mcu7t5v0__fill_2
Xspi_regs_inst__1192_ spi_regs_inst__1192_/A1 spi_regs_inst__1192_/A2 spi_regs_inst__1221_/A1
+ VDD VDD VSS VSS gf180mcu_fd_sc_mcu7t5v0__nor2_1
XFILLER_127_578 VDD VDD VSS VSS gf180mcu_fd_sc_mcu7t5v0__fillcap_4
XFILLER_138_1017 VDD VDD VSS VSS gf180mcu_fd_sc_mcu7t5v0__fillcap_64
XFILLER_5_352 VDD VDD VSS VSS gf180mcu_fd_sc_mcu7t5v0__fillcap_16
Xsignal_processor_y_inst__211_ signal_processor_y_inst__215_/A1 signal_processor_y_inst__169_/Z
+ signal_processor_y_inst__211_/B signal_processor_y_inst__224_/D VDD VDD VSS VSS
+ gf180mcu_fd_sc_mcu7t5v0__oai21_1
XFILLER_150_592 VDD VDD VSS VSS gf180mcu_fd_sc_mcu7t5v0__fill_2
Xwave_controller_x_inst_wire370 wave_controller_x_inst__2893_/Z wave_controller_x_inst_wire370/Z
+ VDD VDD VSS VSS gf180mcu_fd_sc_mcu7t5v0__clkbuf_2
Xsignal_processor_y_inst__142_ signal_processor_y_inst__202_/A1 signal_processor_y_inst__199_/A2
+ signal_processor_y_inst__214_/A2 VDD VDD VSS VSS gf180mcu_fd_sc_mcu7t5v0__nor2_1
XFILLER_95_134 VDD VDD VSS VSS gf180mcu_fd_sc_mcu7t5v0__fillcap_4
XFILLER_36_201 VDD VDD VSS VSS gf180mcu_fd_sc_mcu7t5v0__fillcap_4
XFILLER_83_329 VDD VDD VSS VSS gf180mcu_fd_sc_mcu7t5v0__fill_2
XTAP_TAPCELL_ROW_143_2239 VDD VSS gf180mcu_fd_sc_mcu7t5v0__filltie
XFILLER_92_852 VDD VDD VSS VSS gf180mcu_fd_sc_mcu7t5v0__fill_1
XTAP_TAPCELL_ROW_160_2520 VDD VSS gf180mcu_fd_sc_mcu7t5v0__filltie
Xspi_regs_inst__0976_ spi_regs_inst__1013_/A1 spi_regs_inst__1032_/A1 spi_regs_inst__1317_/A2
+ VDD VDD VSS VSS gf180mcu_fd_sc_mcu7t5v0__nor2_1
X_85_ analog[0] _85_/Z VDD VDD VSS VSS gf180mcu_fd_sc_mcu7t5v0__buf_1
XFILLER_92_863 VDD VDD VSS VSS gf180mcu_fd_sc_mcu7t5v0__fill_2
XFILLER_92_885 VDD VDD VSS VSS gf180mcu_fd_sc_mcu7t5v0__fill_1
XTAP_TAPCELL_ROW_108_1658 VDD VSS gf180mcu_fd_sc_mcu7t5v0__filltie
XPHY_EDGE_ROW_103_Left_270 VDD VSS gf180mcu_fd_sc_mcu7t5v0__endcap
XFILLER_149_114 VDD VDD VSS VSS gf180mcu_fd_sc_mcu7t5v0__fillcap_4
XFILLER_149_125 VDD VDD VSS VSS gf180mcu_fd_sc_mcu7t5v0__fillcap_8
XTAP_TAPCELL_ROW_121_1869 VDD VSS gf180mcu_fd_sc_mcu7t5v0__filltie
Xwave_controller_x_inst__2240_ wave_controller_x_inst__2242_/A2 wave_controller_x_inst__2242_/A3
+ wave_controller_x_inst__2241_/A2 VDD VDD VSS VSS gf180mcu_fd_sc_mcu7t5v0__xnor2_1
Xspi_regs_inst__1528_ spi_regs_inst__1528_/D fanout591/Z clkbuf_leaf_11_clk/Z spi_regs_inst__1528_/Q
+ VDD VDD VSS VSS gf180mcu_fd_sc_mcu7t5v0__dffrnq_1
XFILLER_165_629 VDD VDD VSS VSS gf180mcu_fd_sc_mcu7t5v0__fill_1
XTAP_TAPCELL_ROW_158_2482 VDD VSS gf180mcu_fd_sc_mcu7t5v0__filltie
Xwave_controller_x_inst__2171_ wave_controller_x_inst__2222_/B1 wave_controller_x_inst__2171_/A2
+ wave_controller_x_inst__2173_/A2 VDD VDD VSS VSS gf180mcu_fd_sc_mcu7t5v0__nor2_1
XFILLER_118_523 VDD VDD VSS VSS gf180mcu_fd_sc_mcu7t5v0__fill_2
XFILLER_160_1081 VDD VDD VSS VSS gf180mcu_fd_sc_mcu7t5v0__fillcap_4
Xspi_regs_inst__1459_ spi_regs_inst__1459_/D fanout558/Z _21_/CLK spi_regs_inst__1459_/Q
+ VDD VDD VSS VSS gf180mcu_fd_sc_mcu7t5v0__dffrnq_1
XFILLER_105_228 VDD VDD VSS VSS gf180mcu_fd_sc_mcu7t5v0__fill_2
XFILLER_154_18 VDD VDD VSS VSS gf180mcu_fd_sc_mcu7t5v0__fill_2
XFILLER_59_304 VDD VDD VSS VSS gf180mcu_fd_sc_mcu7t5v0__fillcap_8
XTAP_TAPCELL_ROW_74_1094 VDD VSS gf180mcu_fd_sc_mcu7t5v0__filltie
Xwave_controller_y_inst__1971_ wave_controller_y_inst__1971_/I wave_controller_y_inst__1972_/B
+ VDD VDD VSS VSS gf180mcu_fd_sc_mcu7t5v0__clkinv_1
Xwave_controller_y_inst__3710_ wave_controller_y_inst__3710_/D fanout575/Z clkload12/I
+ wave_controller_y_inst__3710_/Q VDD VDD VSS VSS gf180mcu_fd_sc_mcu7t5v0__dffrnq_1
Xwave_controller_x_inst__1955_ wave_controller_x_inst__3376_/B spi_regs_inst__1128_/B2
+ wave_controller_x_inst__1957_/A2 VDD VDD VSS VSS gf180mcu_fd_sc_mcu7t5v0__nor2_1
XFILLER_101_467 VDD VDD VSS VSS gf180mcu_fd_sc_mcu7t5v0__fillcap_16
XFILLER_101_489 VDD VDD VSS VSS gf180mcu_fd_sc_mcu7t5v0__fill_1
XFILLER_68_893 VDD VDD VSS VSS gf180mcu_fd_sc_mcu7t5v0__fillcap_4
Xwave_controller_y_inst_max_cap125 wave_controller_y_inst__3091_/A1 wave_controller_y_inst__3062_/A1
+ VDD VDD VSS VSS gf180mcu_fd_sc_mcu7t5v0__clkbuf_3
Xwave_controller_x_inst__1886_ spi_regs_inst__1119_/A1 wave_controller_x_inst__3548_/B2
+ VDD VDD VSS VSS gf180mcu_fd_sc_mcu7t5v0__clkinv_1
XFILLER_27_212 VDD VDD VSS VSS gf180mcu_fd_sc_mcu7t5v0__fill_2
XFILLER_83_830 VDD VDD VSS VSS gf180mcu_fd_sc_mcu7t5v0__fillcap_8
XTAP_TAPCELL_ROW_45_1_667 VDD VSS gf180mcu_fd_sc_mcu7t5v0__filltie
Xwave_controller_y_inst__3641_ wave_controller_y_inst__3641_/D wave_controller_y_inst__3711_/RN
+ clkload15/I spi_regs_inst__1285_/B2 VDD VDD VSS VSS gf180mcu_fd_sc_mcu7t5v0__dffrnq_1
Xwave_controller_x_inst__3625_ wave_controller_x_inst__3625_/D wave_controller_x_inst__3715_/RN
+ clkbuf_leaf_25_clk/Z spi_regs_inst__1274_/A1 VDD VDD VSS VSS gf180mcu_fd_sc_mcu7t5v0__dffrnq_1
XFILLER_103_44 VDD VDD VSS VSS gf180mcu_fd_sc_mcu7t5v0__fill_1
XFILLER_55_554 VDD VDD VSS VSS gf180mcu_fd_sc_mcu7t5v0__fill_1
Xwave_controller_y_inst__3572_ wave_controller_y_inst__3572_/A1 wave_controller_y_inst__3572_/A2
+ wave_controller_y_inst__3602_/I0 VDD VDD VSS VSS gf180mcu_fd_sc_mcu7t5v0__nor2_1
XFILLER_70_524 VDD VDD VSS VSS gf180mcu_fd_sc_mcu7t5v0__fill_1
XFILLER_70_535 VDD VDD VSS VSS gf180mcu_fd_sc_mcu7t5v0__fill_2
XTAP_TAPCELL_ROW_53_733 VDD VSS gf180mcu_fd_sc_mcu7t5v0__filltie
Xwave_controller_y_inst__2523_ wave_controller_y_inst__1826_/I wave_controller_y_inst__2521_/Z
+ wave_controller_y_inst__2523_/Z VDD VDD VSS VSS gf180mcu_fd_sc_mcu7t5v0__xor2_1
Xwave_controller_x_inst__3556_ spi_regs_inst__1245_/B2 wave_controller_x_inst__3556_/A2
+ wave_controller_x_inst__3557_/A3 VDD VDD VSS VSS gf180mcu_fd_sc_mcu7t5v0__nor2_1
XTAP_TAPCELL_ROW_53_744 VDD VSS gf180mcu_fd_sc_mcu7t5v0__filltie
XTAP_TAPCELL_ROW_53_755 VDD VSS gf180mcu_fd_sc_mcu7t5v0__filltie
Xwave_controller_x_inst__3487_ wave_controller_x_inst__3489_/A1 wave_controller_x_inst__3487_/A2
+ wave_controller_x_inst__3487_/B wave_controller_x_inst__3488_/I VDD VDD VSS VSS
+ gf180mcu_fd_sc_mcu7t5v0__oai21_1
Xwave_controller_x_inst__2507_ wave_controller_x_inst__2505_/Z wave_controller_x_inst__2510_/A2
+ wave_controller_x_inst__2543_/C VDD VDD VSS VSS gf180mcu_fd_sc_mcu7t5v0__nand2_1
Xsignal_processor_x_inst__231_ signal_processor_x_inst__231_/D signal_processor_x_inst__242_/RN
+ clkload23/I signal_processor_x_inst__231_/Q VDD VDD VSS VSS gf180mcu_fd_sc_mcu7t5v0__dffrnq_1
XFILLER_10_101 VDD VDD VSS VSS gf180mcu_fd_sc_mcu7t5v0__fillcap_4
Xwave_controller_y_inst__2454_ spi_regs_inst__1101_/A1 spi_regs_inst__1097_/A1 wave_controller_y_inst__2455_/B
+ VDD VDD VSS VSS gf180mcu_fd_sc_mcu7t5v0__xor2_1
Xwave_controller_x_inst__2438_ spi_regs_inst__1198_/B2 wave_controller_x_inst__2774_/A1
+ wave_controller_x_inst__2438_/B wave_controller_x_inst__2439_/B VDD VDD VSS VSS
+ gf180mcu_fd_sc_mcu7t5v0__aoi21_1
Xsignal_processor_x_inst__162_ signal_processor_x_inst__232_/Q signal_processor_x_inst__163_/A2
+ signal_processor_x_inst__192_/A2 VDD VDD VSS VSS gf180mcu_fd_sc_mcu7t5v0__xnor2_1
Xwave_controller_y_inst__2385_ wave_controller_y_inst__3245_/A1 wave_controller_y_inst__2383_/Z
+ wave_controller_y_inst__2407_/A1 VDD VDD VSS VSS gf180mcu_fd_sc_mcu7t5v0__nand2_1
XFILLER_109_512 VDD VDD VSS VSS gf180mcu_fd_sc_mcu7t5v0__fill_2
Xwave_controller_x_inst__2369_ spi_regs_inst__1306_/A1 wave_controller_x_inst__2367_/Z
+ wave_controller_x_inst__2369_/Z VDD VDD VSS VSS gf180mcu_fd_sc_mcu7t5v0__xor2_1
XFILLER_12_96 VDD VDD VSS VSS gf180mcu_fd_sc_mcu7t5v0__fillcap_8
XFILLER_137_898 VDD VDD VSS VSS gf180mcu_fd_sc_mcu7t5v0__fillcap_8
Xwave_controller_y_inst__3006_ wave_controller_y_inst__3719_/Q wave_controller_y_inst__3089_/B
+ wave_controller_y_inst__3089_/A2 wave_controller_y_inst__3094_/A2 VDD VDD VSS VSS
+ gf180mcu_fd_sc_mcu7t5v0__nand3_1
XTAP_TAPCELL_ROW_94_1426 VDD VSS gf180mcu_fd_sc_mcu7t5v0__filltie
XFILLER_124_559 VDD VDD VSS VSS gf180mcu_fd_sc_mcu7t5v0__fillcap_4
XFILLER_128_85 VDD VDD VSS VSS gf180mcu_fd_sc_mcu7t5v0__fill_2
XFILLER_2_311 VDD VDD VSS VSS gf180mcu_fd_sc_mcu7t5v0__fillcap_4
XFILLER_88_34 VDD VDD VSS VSS gf180mcu_fd_sc_mcu7t5v0__fill_1
XFILLER_5_2 VDD VDD VSS VSS gf180mcu_fd_sc_mcu7t5v0__fillcap_64
XFILLER_120_710 VDD VDD VSS VSS gf180mcu_fd_sc_mcu7t5v0__fillcap_16
XFILLER_78_613 VDD VDD VSS VSS gf180mcu_fd_sc_mcu7t5v0__fillcap_4
XFILLER_65_329 VDD VDD VSS VSS gf180mcu_fd_sc_mcu7t5v0__fill_2
XFILLER_92_104 VDD VDD VSS VSS gf180mcu_fd_sc_mcu7t5v0__fill_1
XFILLER_93_627 VDD VDD VSS VSS gf180mcu_fd_sc_mcu7t5v0__fill_2
Xspi_regs_inst__0830_ spi_regs_inst__1572_/Q spi_regs_inst__0883_/I1 spi_regs_inst__0834_/S
+ spi_regs_inst__1572_/D VDD VDD VSS VSS gf180mcu_fd_sc_mcu7t5v0__mux2_2
XFILLER_46_521 VDD VDD VSS VSS gf180mcu_fd_sc_mcu7t5v0__fillcap_4
XFILLER_74_874 VDD VDD VSS VSS gf180mcu_fd_sc_mcu7t5v0__fill_1
Xspi_regs_inst__0761_ spi_regs_inst__1521_/Q spi_regs_inst__1439_/I1 spi_regs_inst__0766_/S
+ spi_regs_inst__1521_/D VDD VDD VSS VSS gf180mcu_fd_sc_mcu7t5v0__mux2_2
XFILLER_73_384 VDD VDD VSS VSS gf180mcu_fd_sc_mcu7t5v0__fillcap_4
XTAP_TAPCELL_ROW_103_1577 VDD VSS gf180mcu_fd_sc_mcu7t5v0__filltie
XFILLER_14_484 VDD VDD VSS VSS gf180mcu_fd_sc_mcu7t5v0__fill_1
XFILLER_144_1087 VDD VDD VSS VSS gf180mcu_fd_sc_mcu7t5v0__fillcap_64
XFILLER_147_629 VDD VDD VSS VSS gf180mcu_fd_sc_mcu7t5v0__fill_1
Xspi_regs_inst__1313_ spi_regs_inst__1313_/A1 spi_regs_inst__1313_/A2 spi_regs_inst__1313_/A3
+ spi_regs_inst__1314_/C VDD VDD VSS VSS gf180mcu_fd_sc_mcu7t5v0__nand3_1
XFILLER_127_342 VDD VDD VSS VSS gf180mcu_fd_sc_mcu7t5v0__fill_1
XFILLER_139_191 VDD VDD VSS VSS gf180mcu_fd_sc_mcu7t5v0__fill_2
XTAP_TAPCELL_ROW_3_1_351 VDD VSS gf180mcu_fd_sc_mcu7t5v0__filltie
Xspi_regs_inst__1244_ spi_regs_inst__1498_/Q spi_regs_inst__1244_/A2 spi_regs_inst_wire251/Z
+ spi_regs_inst__1611_/Q spi_regs_inst__1248_/A1 VDD VDD VSS VSS gf180mcu_fd_sc_mcu7t5v0__aoi22_1
Xspi_regs_inst_wire107 spi_regs_inst_wire107/I spi_regs_inst_wire107/Z VDD VDD VSS
+ VSS gf180mcu_fd_sc_mcu7t5v0__buf_2
Xspi_regs_inst__1175_ spi_regs_inst__1645_/Q spi_regs_inst__1266_/S spi_regs_inst__1223_/B
+ VDD VDD VSS VSS gf180mcu_fd_sc_mcu7t5v0__nand2_1
XFILLER_64_1011 VDD VDD VSS VSS gf180mcu_fd_sc_mcu7t5v0__fillcap_4
XFILLER_38_2 VDD VDD VSS VSS gf180mcu_fd_sc_mcu7t5v0__fillcap_16
XFILLER_68_101 VDD VDD VSS VSS gf180mcu_fd_sc_mcu7t5v0__fillcap_4
XFILLER_69_613 VDD VDD VSS VSS gf180mcu_fd_sc_mcu7t5v0__fill_1
XFILLER_96_421 VDD VDD VSS VSS gf180mcu_fd_sc_mcu7t5v0__fillcap_16
XFILLER_111_798 VDD VDD VSS VSS gf180mcu_fd_sc_mcu7t5v0__fill_1
Xsignal_processor_y_inst__125_ signal_processor_y_inst__179_/A1 signal_processor_y_inst__245_/Q
+ signal_processor_y_inst__246_/D VDD VDD VSS VSS gf180mcu_fd_sc_mcu7t5v0__and2_1
XFILLER_37_554 VDD VDD VSS VSS gf180mcu_fd_sc_mcu7t5v0__fill_1
XTAP_TAPCELL_ROW_123_1909 VDD VSS gf180mcu_fd_sc_mcu7t5v0__filltie
Xwave_controller_x_inst__3410_ wave_controller_x_inst__3410_/A1 wave_controller_x_inst__3410_/A2
+ wave_controller_x_inst__3619_/D VDD VDD VSS VSS gf180mcu_fd_sc_mcu7t5v0__nand2_1
Xspi_regs_inst__0959_ spi_regs_inst__1024_/A1 spi_regs_inst__1021_/A1 spi_regs_inst__1184_/A2
+ VDD VDD VSS VSS gf180mcu_fd_sc_mcu7t5v0__nor2_1
XFILLER_52_513 VDD VDD VSS VSS gf180mcu_fd_sc_mcu7t5v0__fillcap_4
XFILLER_52_535 VDD VDD VSS VSS gf180mcu_fd_sc_mcu7t5v0__fill_1
XFILLER_64_373 VDD VDD VSS VSS gf180mcu_fd_sc_mcu7t5v0__fillcap_8
XTAP_TAPCELL_ROW_41_1_640 VDD VSS gf180mcu_fd_sc_mcu7t5v0__filltie
XFILLER_80_877 VDD VDD VSS VSS gf180mcu_fd_sc_mcu7t5v0__fillcap_16
XPHY_EDGE_ROW_30_1_Right_29 VDD VSS gf180mcu_fd_sc_mcu7t5v0__endcap
Xwave_controller_x_inst__3341_ wave_controller_x_inst__3345_/A2 wave_controller_x_inst__3345_/A3
+ wave_controller_x_inst__3341_/B wave_controller_x_inst__3341_/C wave_controller_x_inst__3344_/A2
+ VDD VDD VSS VSS gf180mcu_fd_sc_mcu7t5v0__oai211_1
XFILLER_33_18 VDD VDD VSS VSS gf180mcu_fd_sc_mcu7t5v0__fillcap_8
Xwave_controller_x_inst__3272_ wave_controller_x_inst__3706_/Q wave_controller_x_inst__3273_/A2
+ wave_controller_x_inst__3294_/A1 VDD VDD VSS VSS gf180mcu_fd_sc_mcu7t5v0__nor2_1
XFILLER_123_1116 VDD VDD VSS VSS gf180mcu_fd_sc_mcu7t5v0__fillcap_4
Xwave_controller_x_inst__2223_ wave_controller_x_inst__2223_/A1 wave_controller_x_inst__2793_/I0
+ max_cap458/Z wave_controller_x_inst__2223_/B2 wave_controller_x_inst__2224_/B VDD
+ VDD VSS VSS gf180mcu_fd_sc_mcu7t5v0__oai22_1
XFILLER_138_629 VDD VDD VSS VSS gf180mcu_fd_sc_mcu7t5v0__fill_2
Xwave_controller_y_inst__2170_ wave_controller_y_inst__2157_/Z wave_controller_y_inst__2170_/A2
+ wave_controller_y_inst__2169_/B wave_controller_y_inst__2171_/A2 VDD VDD VSS VSS
+ gf180mcu_fd_sc_mcu7t5v0__nor3_1
Xwave_controller_x_inst__2154_ wave_controller_x_inst__3733_/Q wave_controller_x_inst__2155_/A2
+ wave_controller_x_inst__2756_/B VDD VDD VSS VSS gf180mcu_fd_sc_mcu7t5v0__nand2_1
XFILLER_118_364 VDD VDD VSS VSS gf180mcu_fd_sc_mcu7t5v0__fill_2
XFILLER_119_898 VDD VDD VSS VSS gf180mcu_fd_sc_mcu7t5v0__fillcap_4
XTAP_TAPCELL_ROW_76_1123 VDD VSS gf180mcu_fd_sc_mcu7t5v0__filltie
Xwave_controller_x_inst__2085_ wave_controller_x_inst__3727_/Q wave_controller_x_inst__2086_/A2
+ wave_controller_x_inst__2104_/A1 VDD VDD VSS VSS gf180mcu_fd_sc_mcu7t5v0__nand2_1
XFILLER_145_194 VDD VDD VSS VSS gf180mcu_fd_sc_mcu7t5v0__fill_1
XFILLER_161_621 VDD VDD VSS VSS gf180mcu_fd_sc_mcu7t5v0__fillcap_8
XFILLER_161_632 VDD VDD VSS VSS gf180mcu_fd_sc_mcu7t5v0__fillcap_4
XTAP_TAPCELL_ROW_76_1134 VDD VSS gf180mcu_fd_sc_mcu7t5v0__filltie
XFILLER_88_911 VDD VDD VSS VSS gf180mcu_fd_sc_mcu7t5v0__fillcap_8
XFILLER_121_529 VDD VDD VSS VSS gf180mcu_fd_sc_mcu7t5v0__fillcap_16
XFILLER_161_698 VDD VDD VSS VSS gf180mcu_fd_sc_mcu7t5v0__fill_2
XFILLER_59_112 VDD VDD VSS VSS gf180mcu_fd_sc_mcu7t5v0__fillcap_8
Xwave_controller_x_inst_fanout605 wave_controller_x_inst__3716_/RN wave_controller_x_inst__3692_/RN
+ VDD VDD VSS VSS gf180mcu_fd_sc_mcu7t5v0__dlyb_1
XFILLER_87_432 VDD VDD VSS VSS gf180mcu_fd_sc_mcu7t5v0__fillcap_8
Xwave_controller_x_inst__2987_ wave_controller_x_inst__3266_/A1 fanout536/Z wave_controller_x_inst__2987_/Z
+ VDD VDD VSS VSS gf180mcu_fd_sc_mcu7t5v0__xor2_1
XFILLER_101_242 VDD VDD VSS VSS gf180mcu_fd_sc_mcu7t5v0__fill_1
XFILLER_59_156 VDD VDD VSS VSS gf180mcu_fd_sc_mcu7t5v0__fill_1
XFILLER_59_178 VDD VDD VSS VSS gf180mcu_fd_sc_mcu7t5v0__fill_2
Xwave_controller_y_inst__1954_ fanout509/Z max_cap423/Z wave_controller_y_inst__1956_/B
+ VDD VDD VSS VSS gf180mcu_fd_sc_mcu7t5v0__xnor2_1
Xwave_controller_x_inst__1938_ wave_controller_x_inst__1938_/A1 wave_controller_x_inst__1939_/A1
+ wave_controller_x_inst__1939_/B wave_controller_x_inst__1938_/A4 wave_controller_x_inst__1941_/A2
+ VDD VDD VSS VSS gf180mcu_fd_sc_mcu7t5v0__nand4_1
XFILLER_114_54 VDD VDD VSS VSS gf180mcu_fd_sc_mcu7t5v0__fill_2
XTAP_TAPCELL_ROW_58_836 VDD VSS gf180mcu_fd_sc_mcu7t5v0__filltie
Xwave_controller_y_inst__1885_ max_cap430/I wave_controller_y_inst__3545_/B2 VDD VDD
+ VSS VSS gf180mcu_fd_sc_mcu7t5v0__clkinv_1
XFILLER_114_98 VDD VDD VSS VSS gf180mcu_fd_sc_mcu7t5v0__fillcap_4
XFILLER_28_554 VDD VDD VSS VSS gf180mcu_fd_sc_mcu7t5v0__fill_1
Xwave_controller_y_inst__3624_ wave_controller_y_inst__3624_/D wave_controller_y_inst__3696_/RN
+ clkload11/I spi_regs_inst__1262_/A1 VDD VDD VSS VSS gf180mcu_fd_sc_mcu7t5v0__dffrnq_1
Xwave_controller_x_inst__1869_ max_cap467/Z wave_controller_x_inst__3500_/B2 VDD VDD
+ VSS VSS gf180mcu_fd_sc_mcu7t5v0__clkinv_1
XFILLER_71_822 VDD VDD VSS VSS gf180mcu_fd_sc_mcu7t5v0__fillcap_16
XFILLER_83_693 VDD VDD VSS VSS gf180mcu_fd_sc_mcu7t5v0__fillcap_4
Xwave_controller_x_inst__3608_ wave_controller_x_inst__2923_/S wave_controller_x_inst__3608_/A2
+ wave_controller_x_inst__3608_/B wave_controller_x_inst__3680_/D VDD VDD VSS VSS
+ gf180mcu_fd_sc_mcu7t5v0__oai21_1
XFILLER_167_1087 VDD VDD VSS VSS gf180mcu_fd_sc_mcu7t5v0__fill_1
Xwave_controller_y_inst__3555_ wave_controller_y_inst__2124_/B wave_controller_y_inst__3555_/A2
+ wave_controller_y_inst__3557_/A2 VDD VDD VSS VSS gf180mcu_fd_sc_mcu7t5v0__nor2_1
Xwave_controller_x_inst__3539_ wave_controller_x_inst__3539_/A1 wave_controller_x_inst__3539_/A2
+ wave_controller_x_inst__3539_/A3 wave_controller_x_inst__3545_/B1 wave_controller_x_inst__3539_/B2
+ wave_controller_x_inst__3642_/D VDD VDD VSS VSS gf180mcu_fd_sc_mcu7t5v0__oai32_1
XFILLER_70_376 VDD VDD VSS VSS gf180mcu_fd_sc_mcu7t5v0__fill_1
XFILLER_71_888 VDD VDD VSS VSS gf180mcu_fd_sc_mcu7t5v0__fill_2
Xwave_controller_y_inst__2506_ fanout509/I wave_controller_y_inst__2492_/Z wave_controller_y_inst__2506_/B
+ wave_controller_y_inst__2510_/A2 VDD VDD VSS VSS gf180mcu_fd_sc_mcu7t5v0__oai21_1
Xwave_controller_y_inst__3486_ spi_regs_inst__1334_/A1 wave_controller_y_inst__3493_/A1
+ wave_controller_y_inst__3487_/B VDD VDD VSS VSS gf180mcu_fd_sc_mcu7t5v0__nand2_1
Xsignal_processor_x_inst__214_ spi_regs_inst__1119_/B2 signal_processor_x_inst__214_/A2
+ signal_processor_x_inst__215_/B VDD VDD VSS VSS gf180mcu_fd_sc_mcu7t5v0__nand2_1
XFILLER_129_618 VDD VDD VSS VSS gf180mcu_fd_sc_mcu7t5v0__fill_1
XFILLER_142_2 VDD VDD VSS VSS gf180mcu_fd_sc_mcu7t5v0__fillcap_16
XPHY_EDGE_ROW_61_Right_61 VDD VSS gf180mcu_fd_sc_mcu7t5v0__endcap
Xwave_controller_y_inst__2437_ wave_controller_y_inst__2446_/A1 wave_controller_y_inst__2449_/B2
+ spi_regs_inst__1168_/A1 VDD VDD VSS VSS gf180mcu_fd_sc_mcu7t5v0__xor2_1
XFILLER_156_437 VDD VDD VSS VSS gf180mcu_fd_sc_mcu7t5v0__fillcap_16
Xsignal_processor_x_inst__145_ signal_processor_x_inst__215_/A1 signal_processor_x_inst__177_/A1
+ signal_processor_x_inst__145_/B signal_processor_x_inst__227_/D VDD VDD VSS VSS
+ gf180mcu_fd_sc_mcu7t5v0__oai21_1
Xwave_controller_y_inst__2368_ spi_regs_inst__1321_/A1 wave_controller_y_inst__2367_/Z
+ wave_controller_y_inst__2389_/A2 VDD VDD VSS VSS gf180mcu_fd_sc_mcu7t5v0__nand2_1
XFILLER_165_982 VDD VDD VSS VSS gf180mcu_fd_sc_mcu7t5v0__fillcap_64
XTAP_TAPCELL_ROW_50_1_708 VDD VSS gf180mcu_fd_sc_mcu7t5v0__filltie
Xwave_controller_y_inst__2299_ wave_controller_y_inst__2284_/Z wave_controller_y_inst__2299_/A2
+ wave_controller_y_inst__2299_/B wave_controller_y_inst__2302_/A3 VDD VDD VSS VSS
+ gf180mcu_fd_sc_mcu7t5v0__aoi21_1
XFILLER_112_507 VDD VDD VSS VSS gf180mcu_fd_sc_mcu7t5v0__fill_2
XFILLER_98_708 VDD VDD VSS VSS gf180mcu_fd_sc_mcu7t5v0__fill_2
XFILLER_105_570 VDD VDD VSS VSS gf180mcu_fd_sc_mcu7t5v0__fillcap_16
XFILLER_140_849 VDD VDD VSS VSS gf180mcu_fd_sc_mcu7t5v0__fill_1
XFILLER_151_175 VDD VDD VSS VSS gf180mcu_fd_sc_mcu7t5v0__fillcap_16
XFILLER_155_94 VDD VDD VSS VSS gf180mcu_fd_sc_mcu7t5v0__fillcap_4
XPHY_EDGE_ROW_70_Right_70 VDD VSS gf180mcu_fd_sc_mcu7t5v0__endcap
Xwave_controller_y_inst_fanout550 fanout570/Z wave_controller_y_inst__3695_/RN VDD
+ VDD VSS VSS gf180mcu_fd_sc_mcu7t5v0__dlyb_1
XFILLER_79_977 VDD VDD VSS VSS gf180mcu_fd_sc_mcu7t5v0__fill_2
XFILLER_94_903 VDD VDD VSS VSS gf180mcu_fd_sc_mcu7t5v0__fillcap_4
XFILLER_93_402 VDD VDD VSS VSS gf180mcu_fd_sc_mcu7t5v0__fillcap_8
XFILLER_19_510 VDD VDD VSS VSS gf180mcu_fd_sc_mcu7t5v0__fill_2
XFILLER_78_498 VDD VDD VSS VSS gf180mcu_fd_sc_mcu7t5v0__fillcap_8
XFILLER_94_947 VDD VDD VSS VSS gf180mcu_fd_sc_mcu7t5v0__fillcap_64
XTAP_TAPCELL_ROW_6_1_377 VDD VSS gf180mcu_fd_sc_mcu7t5v0__filltie
XFILLER_93_479 VDD VDD VSS VSS gf180mcu_fd_sc_mcu7t5v0__fill_2
XFILLER_98_1151 VDD VDD VSS VSS gf180mcu_fd_sc_mcu7t5v0__fillcap_4
Xspi_regs_inst__0813_ spi_regs_inst__1560_/Q spi_regs_inst__1380_/I1 spi_regs_inst__0813_/S
+ spi_regs_inst__1560_/D VDD VDD VSS VSS gf180mcu_fd_sc_mcu7t5v0__mux2_2
XFILLER_46_384 VDD VDD VSS VSS gf180mcu_fd_sc_mcu7t5v0__fill_1
XFILLER_98_1173 VDD VDD VSS VSS gf180mcu_fd_sc_mcu7t5v0__fill_1
XTAP_TAPCELL_ROW_105_1606 VDD VSS gf180mcu_fd_sc_mcu7t5v0__filltie
XTAP_TAPCELL_ROW_105_1617 VDD VSS gf180mcu_fd_sc_mcu7t5v0__filltie
Xspi_regs_inst__0744_ spi_regs_inst__1655_/Q spi_regs_inst__1656_/Q spi_regs_inst__0808_/A2
+ VDD VDD VSS VSS gf180mcu_fd_sc_mcu7t5v0__nor2_1
XFILLER_61_343 VDD VDD VSS VSS gf180mcu_fd_sc_mcu7t5v0__fillcap_4
XFILLER_62_877 VDD VDD VSS VSS gf180mcu_fd_sc_mcu7t5v0__fillcap_8
XFILLER_159_242 VDD VDD VSS VSS gf180mcu_fd_sc_mcu7t5v0__fillcap_8
XFILLER_159_286 VDD VDD VSS VSS gf180mcu_fd_sc_mcu7t5v0__fillcap_8
XTAP_TAPCELL_ROW_138_2149 VDD VSS gf180mcu_fd_sc_mcu7t5v0__filltie
XTAP_TAPCELL_ROW_155_2430 VDD VSS gf180mcu_fd_sc_mcu7t5v0__filltie
XTAP_TAPCELL_ROW_155_2441 VDD VSS gf180mcu_fd_sc_mcu7t5v0__filltie
XFILLER_70_1081 VDD VDD VSS VSS gf180mcu_fd_sc_mcu7t5v0__fillcap_4
XFILLER_143_632 VDD VDD VSS VSS gf180mcu_fd_sc_mcu7t5v0__fillcap_16
XFILLER_155_492 VDD VDD VSS VSS gf180mcu_fd_sc_mcu7t5v0__fill_1
Xspi_regs_inst__1227_ spi_regs_inst__1582_/Q spi_regs_inst_wire254/Z spi_regs_inst__1227_/B1
+ spi_regs_inst__1619_/Q spi_regs_inst__1228_/A4 VDD VDD VSS VSS gf180mcu_fd_sc_mcu7t5v0__aoi22_1
Xspi_regs_inst__1158_ spi_regs_inst__1158_/A1 spi_regs_inst__1176_/A2 spi_regs_inst__1316_/B1
+ spi_regs_inst__1543_/Q spi_regs_inst__1308_/B1 spi_regs_inst__1158_/C2 spi_regs_inst__1161_/A1
+ VDD VDD VSS VSS gf180mcu_fd_sc_mcu7t5v0__aoi222_1
Xwave_controller_x_inst__2910_ wave_controller_x_inst__3489_/C wave_controller_x_inst__2896_/B
+ wave_controller_x_inst__2910_/B wave_controller_x_inst__2911_/B VDD VDD VSS VSS
+ gf180mcu_fd_sc_mcu7t5v0__oai21_1
XFILLER_130_348 VDD VDD VSS VSS gf180mcu_fd_sc_mcu7t5v0__fill_1
XFILLER_69_454 VDD VDD VSS VSS gf180mcu_fd_sc_mcu7t5v0__fill_2
XTAP_TAPCELL_ROW_71_1042 VDD VSS gf180mcu_fd_sc_mcu7t5v0__filltie
XTAP_TAPCELL_ROW_71_1053 VDD VSS gf180mcu_fd_sc_mcu7t5v0__filltie
Xwave_controller_x_inst__2841_ wave_controller_x_inst__2841_/A1 wave_controller_x_inst__1902_/I
+ wave_controller_x_inst__2841_/B wave_controller_x_inst__2847_/A2 VDD VDD VSS VSS
+ gf180mcu_fd_sc_mcu7t5v0__oai21_1
Xspi_regs_inst__1089_ fanout540/Z spi_regs_inst__1156_/A2 spi_regs_inst__1322_/A2
+ spi_regs_inst_wire132/Z spi_regs_inst__1120_/A1 VDD VDD VSS VSS gf180mcu_fd_sc_mcu7t5v0__aoi22_1
XFILLER_111_562 VDD VDD VSS VSS gf180mcu_fd_sc_mcu7t5v0__fill_1
XFILLER_57_627 VDD VDD VSS VSS gf180mcu_fd_sc_mcu7t5v0__fill_2
XFILLER_96_251 VDD VDD VSS VSS gf180mcu_fd_sc_mcu7t5v0__fill_2
XFILLER_96_295 VDD VDD VSS VSS gf180mcu_fd_sc_mcu7t5v0__fill_2
Xwave_controller_x_inst__2772_ wave_controller_x_inst__2117_/B wave_controller_x_inst__2897_/A2
+ wave_controller_x_inst__2855_/A1 VDD VDD VSS VSS gf180mcu_fd_sc_mcu7t5v0__nand2_1
Xsignal_processor_y_inst__108_ fanout393/Z signal_processor_y_inst__202_/A1 VDD VDD
+ VSS VSS gf180mcu_fd_sc_mcu7t5v0__clkinv_1
XFILLER_84_457 VDD VDD VSS VSS gf180mcu_fd_sc_mcu7t5v0__fillcap_8
XFILLER_25_513 VDD VDD VSS VSS gf180mcu_fd_sc_mcu7t5v0__fill_1
XFILLER_52_310 VDD VDD VSS VSS gf180mcu_fd_sc_mcu7t5v0__fillcap_4
XFILLER_53_833 VDD VDD VSS VSS gf180mcu_fd_sc_mcu7t5v0__fill_2
XFILLER_40_527 VDD VDD VSS VSS gf180mcu_fd_sc_mcu7t5v0__fill_1
Xwave_controller_y_inst__3340_ wave_controller_y_inst__3340_/A1 spi_regs_inst__1618_/Q
+ wave_controller_y_inst__3341_/B VDD VDD VSS VSS gf180mcu_fd_sc_mcu7t5v0__xor2_1
Xwave_controller_x_inst__3324_ wave_controller_x_inst__3320_/B wave_controller_x_inst__3333_/A2
+ wave_controller_x_inst__3333_/A3 wave_controller_x_inst__3397_/A1 VDD VDD VSS VSS
+ gf180mcu_fd_sc_mcu7t5v0__nor3_1
XFILLER_100_45 VDD VDD VSS VSS gf180mcu_fd_sc_mcu7t5v0__fill_2
Xwave_controller_y_inst__3271_ wave_controller_y_inst__3707_/Q spi_regs_inst__1605_/Q
+ wave_controller_y_inst__3271_/Z VDD VDD VSS VSS gf180mcu_fd_sc_mcu7t5v0__xor2_1
XFILLER_165_212 VDD VDD VSS VSS gf180mcu_fd_sc_mcu7t5v0__fill_1
XFILLER_60_16 VDD VDD VSS VSS gf180mcu_fd_sc_mcu7t5v0__fill_2
Xwave_controller_y_inst__2222_ max_cap423/I wave_controller_y_inst__2516_/A1 wave_controller_y_inst__2222_/B1
+ wave_controller_y_inst__2222_/B2 wave_controller_y_inst__2222_/C wave_controller_y_inst__2260_/A1
+ VDD VDD VSS VSS gf180mcu_fd_sc_mcu7t5v0__oai221_1
Xwave_controller_x_inst__3255_ wave_controller_x_inst__3255_/A1 wave_controller_x_inst__3255_/A2
+ wave_controller_x_inst__3192_/B wave_controller_x_inst__3255_/Z VDD VDD VSS VSS
+ gf180mcu_fd_sc_mcu7t5v0__or3_1
XFILLER_138_459 VDD VDD VSS VSS gf180mcu_fd_sc_mcu7t5v0__fill_1
Xwave_controller_x_inst__3186_ wave_controller_x_inst__3189_/C spi_regs_inst__1517_/Q
+ wave_controller_x_inst__3194_/B VDD VDD VSS VSS gf180mcu_fd_sc_mcu7t5v0__xor2_1
Xwave_controller_x_inst__2206_ fanout528/Z wave_controller_x_inst__2205_/Z wave_controller_x_inst__2216_/B
+ VDD VDD VSS VSS gf180mcu_fd_sc_mcu7t5v0__nor2_1
XFILLER_119_662 VDD VDD VSS VSS gf180mcu_fd_sc_mcu7t5v0__fillcap_8
XFILLER_147_982 VDD VDD VSS VSS gf180mcu_fd_sc_mcu7t5v0__fillcap_64
Xwave_controller_y_inst__2153_ wave_controller_y_inst__2124_/B wave_controller_y_inst__2153_/A2
+ wave_controller_y_inst__2155_/A2 VDD VDD VSS VSS gf180mcu_fd_sc_mcu7t5v0__nand2_1
Xwave_controller_x_inst__2137_ wave_controller_x_inst__2080_/B wave_controller_x_inst__2137_/A2
+ wave_controller_x_inst__2138_/C VDD VDD VSS VSS gf180mcu_fd_sc_mcu7t5v0__nor2_1
Xclkbuf_3_0__f_clk clkbuf_0_clk/Z clkbuf_leaf_3_clk/I VDD VDD VSS VSS gf180mcu_fd_sc_mcu7t5v0__clkbuf_16
XFILLER_162_941 VDD VDD VSS VSS gf180mcu_fd_sc_mcu7t5v0__fillcap_4
Xwave_controller_y_inst__2084_ wave_controller_y_inst__2132_/A1 wave_controller_y_inst__2082_/Z
+ wave_controller_y_inst__2117_/A1 wave_controller_y_inst__2086_/A2 VDD VDD VSS VSS
+ gf180mcu_fd_sc_mcu7t5v0__nor3_1
XFILLER_133_120 VDD VDD VSS VSS gf180mcu_fd_sc_mcu7t5v0__fillcap_16
XFILLER_133_142 VDD VDD VSS VSS gf180mcu_fd_sc_mcu7t5v0__fillcap_32
Xwave_controller_x_inst__2068_ wave_controller_x_inst__2125_/A1 wave_controller_x_inst__2068_/A2
+ wave_controller_x_inst__2109_/A2 VDD VDD VSS VSS gf180mcu_fd_sc_mcu7t5v0__nand2_1
XFILLER_79_207 VDD VDD VSS VSS gf180mcu_fd_sc_mcu7t5v0__fill_2
XFILLER_130_871 VDD VDD VSS VSS gf180mcu_fd_sc_mcu7t5v0__fillcap_4
XFILLER_88_796 VDD VDD VSS VSS gf180mcu_fd_sc_mcu7t5v0__fill_1
Xwave_controller_x_inst_fanout446 wave_controller_x_inst__3715_/Q wave_controller_x_inst__1783_/I
+ VDD VDD VSS VSS gf180mcu_fd_sc_mcu7t5v0__dlyb_1
Xwave_controller_x_inst_fanout435 wave_controller_x_inst__3446_/A2 wave_controller_x_inst__1902_/I
+ VDD VDD VSS VSS gf180mcu_fd_sc_mcu7t5v0__dlyb_1
XFILLER_47_137 VDD VDD VSS VSS gf180mcu_fd_sc_mcu7t5v0__fill_2
XFILLER_75_446 VDD VDD VSS VSS gf180mcu_fd_sc_mcu7t5v0__fill_1
XFILLER_85_68 VDD VDD VSS VSS gf180mcu_fd_sc_mcu7t5v0__fill_2
XTAP_TAPCELL_ROW_89_1347 VDD VSS gf180mcu_fd_sc_mcu7t5v0__filltie
Xwave_controller_y_inst__2986_ wave_controller_y_inst__3000_/A1 wave_controller_y_inst_wire93/Z
+ wave_controller_y_inst__3073_/A1 VDD VDD VSS VSS gf180mcu_fd_sc_mcu7t5v0__nand2_1
Xwave_controller_y_inst_max_cap26 wave_controller_y_inst__2740_/A2 wave_controller_y_inst__2752_/B2
+ VDD VDD VSS VSS gf180mcu_fd_sc_mcu7t5v0__clkbuf_1
XFILLER_90_405 VDD VDD VSS VSS gf180mcu_fd_sc_mcu7t5v0__fillcap_8
XFILLER_91_928 VDD VDD VSS VSS gf180mcu_fd_sc_mcu7t5v0__fill_1
Xwave_controller_y_inst__1937_ wave_controller_y_inst__1937_/A1 wave_controller_y_inst__1783_/I
+ wave_controller_y_inst__1937_/B1 wave_controller_y_inst__1785_/I wave_controller_y_inst__1939_/A2
+ VDD VDD VSS VSS gf180mcu_fd_sc_mcu7t5v0__oai22_1
XFILLER_16_524 VDD VDD VSS VSS gf180mcu_fd_sc_mcu7t5v0__fill_1
XFILLER_28_384 VDD VDD VSS VSS gf180mcu_fd_sc_mcu7t5v0__fill_1
XFILLER_62_107 VDD VDD VSS VSS gf180mcu_fd_sc_mcu7t5v0__fillcap_4
XFILLER_90_427 VDD VDD VSS VSS gf180mcu_fd_sc_mcu7t5v0__fillcap_16
XTAP_TAPCELL_ROW_2_1_350 VDD VSS gf180mcu_fd_sc_mcu7t5v0__filltie
Xwave_controller_y_inst__1868_ spi_regs_inst__1204_/B2 wave_controller_y_inst__2774_/A1
+ VDD VDD VSS VSS gf180mcu_fd_sc_mcu7t5v0__clkinv_1
Xwave_controller_y_inst__3607_ spi_regs_inst__1159_/C2 wave_controller_y_inst__2923_/S
+ wave_controller_y_inst__3608_/B VDD VDD VSS VSS gf180mcu_fd_sc_mcu7t5v0__nand2_1
Xwave_controller_y_inst__1799_ wave_controller_y_inst__3701_/Q wave_controller_y_inst__2797_/C
+ VDD VDD VSS VSS gf180mcu_fd_sc_mcu7t5v0__clkinv_1
Xwave_controller_y_inst__3538_ spi_regs_inst__1303_/A1 wave_controller_y_inst__3556_/A2
+ wave_controller_y_inst__3539_/A3 VDD VDD VSS VSS gf180mcu_fd_sc_mcu7t5v0__nor2_1
XFILLER_157_702 VDD VDD VSS VSS gf180mcu_fd_sc_mcu7t5v0__fillcap_64
XFILLER_34_61 VDD VDD VSS VSS gf180mcu_fd_sc_mcu7t5v0__fill_1
XTAP_TAPCELL_ROW_100_1525 VDD VSS gf180mcu_fd_sc_mcu7t5v0__filltie
XFILLER_129_426 VDD VDD VSS VSS gf180mcu_fd_sc_mcu7t5v0__fill_2
Xwave_controller_y_inst__3469_ wave_controller_y_inst__3469_/A1 wave_controller_y_inst__3489_/A2
+ wave_controller_y_inst__3493_/A2 wave_controller_y_inst__3469_/B2 wave_controller_y_inst__3489_/C
+ wave_controller_y_inst__3470_/B VDD VDD VSS VSS gf180mcu_fd_sc_mcu7t5v0__aoi221_1
XFILLER_141_1046 VDD VDD VSS VSS gf180mcu_fd_sc_mcu7t5v0__fillcap_4
XFILLER_54_1087 VDD VDD VSS VSS gf180mcu_fd_sc_mcu7t5v0__fillcap_64
Xsignal_processor_x_inst__128_ signal_processor_x_inst__128_/A1 signal_processor_x_inst__256_/Q
+ signal_processor_x_inst__244_/D VDD VDD VSS VSS gf180mcu_fd_sc_mcu7t5v0__and2_1
XFILLER_125_632 VDD VDD VSS VSS gf180mcu_fd_sc_mcu7t5v0__fill_1
XFILLER_137_492 VDD VDD VSS VSS gf180mcu_fd_sc_mcu7t5v0__fillcap_16
XTAP_TAPCELL_ROW_133_2068 VDD VSS gf180mcu_fd_sc_mcu7t5v0__filltie
XFILLER_113_805 VDD VDD VSS VSS gf180mcu_fd_sc_mcu7t5v0__fillcap_32
XFILLER_125_643 VDD VDD VSS VSS gf180mcu_fd_sc_mcu7t5v0__fill_2
XTAP_TAPCELL_ROW_133_2079 VDD VSS gf180mcu_fd_sc_mcu7t5v0__filltie
XTAP_TAPCELL_ROW_150_2360 VDD VSS gf180mcu_fd_sc_mcu7t5v0__filltie
Xspi_regs_inst__1012_ spi_regs_inst__1029_/A1 spi_regs_inst__1023_/A2 spi_regs_inst_wire233/I
+ VDD VDD VSS VSS gf180mcu_fd_sc_mcu7t5v0__nor2_1
XFILLER_140_624 VDD VDD VSS VSS gf180mcu_fd_sc_mcu7t5v0__fillcap_16
XFILLER_3_461 VDD VDD VSS VSS gf180mcu_fd_sc_mcu7t5v0__fill_2
XFILLER_112_337 VDD VDD VSS VSS gf180mcu_fd_sc_mcu7t5v0__fill_2
XFILLER_3_483 VDD VDD VSS VSS gf180mcu_fd_sc_mcu7t5v0__fillcap_4
Xwave_controller_y_inst_fanout391 fanout392/Z wave_controller_y_inst__3039_/A1 VDD
+ VDD VSS VSS gf180mcu_fd_sc_mcu7t5v0__dlyb_1
Xwave_controller_y_inst_fanout49 wave_controller_y_inst__2934_/ZN wave_controller_y_inst__3579_/A1
+ VDD VDD VSS VSS gf180mcu_fd_sc_mcu7t5v0__dlyb_1
XFILLER_66_457 VDD VDD VSS VSS gf180mcu_fd_sc_mcu7t5v0__fill_2
XFILLER_66_479 VDD VDD VSS VSS gf180mcu_fd_sc_mcu7t5v0__fill_1
XFILLER_34_321 VDD VDD VSS VSS gf180mcu_fd_sc_mcu7t5v0__fill_1
XFILLER_34_376 VDD VDD VSS VSS gf180mcu_fd_sc_mcu7t5v0__fillcap_8
Xspi_regs_inst_load_slew494 spi_regs_inst__1405_/I1 spi_regs_inst__1438_/I1 VDD VDD
+ VSS VSS gf180mcu_fd_sc_mcu7t5v0__buf_4
Xspi_regs_inst_load_slew483 spi_regs_inst__1379_/I1 spi_regs_inst__0883_/I1 VDD VDD
+ VSS VSS gf180mcu_fd_sc_mcu7t5v0__buf_4
Xspi_regs_inst__0727_ spi_regs_inst__1651_/Q spi_regs_inst__0815_/A2 VDD VDD VSS VSS
+ gf180mcu_fd_sc_mcu7t5v0__clkinv_1
XFILLER_22_527 VDD VDD VSS VSS gf180mcu_fd_sc_mcu7t5v0__fillcap_4
XFILLER_34_387 VDD VDD VSS VSS gf180mcu_fd_sc_mcu7t5v0__fillcap_8
XFILLER_61_195 VDD VDD VSS VSS gf180mcu_fd_sc_mcu7t5v0__fill_2
XPHY_EDGE_ROW_10_1_Right_9 VDD VSS gf180mcu_fd_sc_mcu7t5v0__endcap
XTAP_TAPCELL_ROW_60_864 VDD VSS gf180mcu_fd_sc_mcu7t5v0__filltie
XTAP_TAPCELL_ROW_60_875 VDD VSS gf180mcu_fd_sc_mcu7t5v0__filltie
XTAP_TAPCELL_ROW_118_1819 VDD VSS gf180mcu_fd_sc_mcu7t5v0__filltie
Xwave_controller_x_inst__3040_ wave_controller_x_inst__3231_/B wave_controller_x_inst__3069_/B1
+ wave_controller_x_inst__3042_/A2 VDD VDD VSS VSS gf180mcu_fd_sc_mcu7t5v0__nand2_1
XFILLER_129_982 VDD VDD VSS VSS gf180mcu_fd_sc_mcu7t5v0__fillcap_64
XFILLER_135_418 VDD VDD VSS VSS gf180mcu_fd_sc_mcu7t5v0__fill_2
XFILLER_116_621 VDD VDD VSS VSS gf180mcu_fd_sc_mcu7t5v0__fill_2
XFILLER_116_632 VDD VDD VSS VSS gf180mcu_fd_sc_mcu7t5v0__fillcap_4
XFILLER_144_941 VDD VDD VSS VSS gf180mcu_fd_sc_mcu7t5v0__fillcap_4
Xmax_cap453 max_cap453/I max_cap453/Z VDD VDD VSS VSS gf180mcu_fd_sc_mcu7t5v0__buf_3
Xmax_cap431 max_cap431/I max_cap431/Z VDD VDD VSS VSS gf180mcu_fd_sc_mcu7t5v0__clkbuf_3
XFILLER_104_827 VDD VDD VSS VSS gf180mcu_fd_sc_mcu7t5v0__fillcap_32
Xmax_cap464 max_cap464/I max_cap464/Z VDD VDD VSS VSS gf180mcu_fd_sc_mcu7t5v0__clkbuf_3
XFILLER_58_925 VDD VDD VSS VSS gf180mcu_fd_sc_mcu7t5v0__fillcap_16
XFILLER_97_571 VDD VDD VSS VSS gf180mcu_fd_sc_mcu7t5v0__fillcap_8
Xwave_controller_y_inst__2840_ max_cap430/I wave_controller_y_inst__1902_/I wave_controller_y_inst__2841_/B
+ VDD VDD VSS VSS gf180mcu_fd_sc_mcu7t5v0__nand2_1
XFILLER_29_104 VDD VDD VSS VSS gf180mcu_fd_sc_mcu7t5v0__fill_2
XFILLER_29_115 VDD VDD VSS VSS gf180mcu_fd_sc_mcu7t5v0__fillcap_16
XFILLER_58_947 VDD VDD VSS VSS gf180mcu_fd_sc_mcu7t5v0__fillcap_64
XFILLER_85_744 VDD VDD VSS VSS gf180mcu_fd_sc_mcu7t5v0__fill_1
Xwave_controller_x_inst__2824_ wave_controller_x_inst__2824_/A1 wave_controller_x_inst__3446_/A2
+ wave_controller_x_inst__2824_/B wave_controller_x_inst__2837_/B1 VDD VDD VSS VSS
+ gf180mcu_fd_sc_mcu7t5v0__oai21_1
XFILLER_111_392 VDD VDD VSS VSS gf180mcu_fd_sc_mcu7t5v0__fill_2
XFILLER_29_148 VDD VDD VSS VSS gf180mcu_fd_sc_mcu7t5v0__fill_1
XFILLER_57_457 VDD VDD VSS VSS gf180mcu_fd_sc_mcu7t5v0__fill_2
XFILLER_57_479 VDD VDD VSS VSS gf180mcu_fd_sc_mcu7t5v0__fillcap_8
XFILLER_85_766 VDD VDD VSS VSS gf180mcu_fd_sc_mcu7t5v0__fillcap_4
XFILLER_85_788 VDD VDD VSS VSS gf180mcu_fd_sc_mcu7t5v0__fillcap_8
Xwave_controller_y_inst__2771_ wave_controller_y_inst__2117_/B wave_controller_y_inst__2897_/A2
+ wave_controller_y_inst__2855_/B VDD VDD VSS VSS gf180mcu_fd_sc_mcu7t5v0__nor2_1
Xwave_controller_x_inst__2755_ wave_controller_x_inst__2755_/A1 wave_controller_x_inst__2755_/A2
+ wave_controller_x_inst__3726_/D VDD VDD VSS VSS gf180mcu_fd_sc_mcu7t5v0__nor2_1
XFILLER_44_107 VDD VDD VSS VSS gf180mcu_fd_sc_mcu7t5v0__fillcap_32
XTAP_TAPCELL_ROW_68_997 VDD VSS gf180mcu_fd_sc_mcu7t5v0__filltie
XFILLER_129_1122 VDD VDD VSS VSS gf180mcu_fd_sc_mcu7t5v0__fillcap_32
Xwave_controller_x_inst__2686_ wave_controller_x_inst__2686_/A1 wave_controller_x_inst__2668_/Z
+ wave_controller_x_inst__2686_/Z VDD VDD VSS VSS gf180mcu_fd_sc_mcu7t5v0__or2_1
XFILLER_52_162 VDD VDD VSS VSS gf180mcu_fd_sc_mcu7t5v0__fillcap_8
XFILLER_53_674 VDD VDD VSS VSS gf180mcu_fd_sc_mcu7t5v0__fillcap_4
XTAP_TAPCELL_ROW_84_1255 VDD VSS gf180mcu_fd_sc_mcu7t5v0__filltie
XTAP_TAPCELL_ROW_84_1266 VDD VSS gf180mcu_fd_sc_mcu7t5v0__filltie
XFILLER_139_702 VDD VDD VSS VSS gf180mcu_fd_sc_mcu7t5v0__fillcap_16
XFILLER_166_510 VDD VDD VSS VSS gf180mcu_fd_sc_mcu7t5v0__fillcap_8
XFILLER_40_368 VDD VDD VSS VSS gf180mcu_fd_sc_mcu7t5v0__fillcap_8
Xwave_controller_y_inst__3323_ wave_controller_y_inst__3350_/A1 wave_controller_y_inst__3315_/Z
+ wave_controller_y_inst__3350_/B wave_controller_y_inst__3321_/Z wave_controller_y_inst__3333_/A3
+ VDD VDD VSS VSS gf180mcu_fd_sc_mcu7t5v0__nor4_1
Xwave_controller_x_inst__3307_ wave_controller_x_inst__3711_/Q spi_regs_inst__1551_/Q
+ wave_controller_x_inst__3310_/B VDD VDD VSS VSS gf180mcu_fd_sc_mcu7t5v0__xor2_1
XFILLER_139_746 VDD VDD VSS VSS gf180mcu_fd_sc_mcu7t5v0__fillcap_4
XFILLER_139_768 VDD VDD VSS VSS gf180mcu_fd_sc_mcu7t5v0__fill_2
XFILLER_166_543 VDD VDD VSS VSS gf180mcu_fd_sc_mcu7t5v0__fillcap_8
Xwave_controller_y_inst__3254_ wave_controller_y_inst__3254_/A1 wave_controller_y_inst__3254_/A2
+ wave_controller_y_inst__3254_/B wave_controller_y_inst__3254_/C wave_controller_y_inst__3256_/A3
+ VDD VDD VSS VSS gf180mcu_fd_sc_mcu7t5v0__aoi211_1
Xwave_controller_x_inst__3238_ wave_controller_x_inst__3238_/A1 wave_controller_x_inst__3213_/Z
+ wave_controller_x_inst__3217_/Z wave_controller_x_inst__3238_/B2 wave_controller_x_inst__3238_/C
+ wave_controller_x_inst__3240_/A2 VDD VDD VSS VSS gf180mcu_fd_sc_mcu7t5v0__aoi221_1
XFILLER_138_267 VDD VDD VSS VSS gf180mcu_fd_sc_mcu7t5v0__fillcap_16
XFILLER_166_587 VDD VDD VSS VSS gf180mcu_fd_sc_mcu7t5v0__fillcap_8
Xwave_controller_y_inst__3185_ wave_controller_y_inst__3189_/C spi_regs_inst__1580_/Q
+ wave_controller_y_inst__3250_/A2 VDD VDD VSS VSS gf180mcu_fd_sc_mcu7t5v0__nor2_1
Xwave_controller_y_inst__2205_ wave_controller_y_inst__2203_/Z wave_controller_y_inst__2207_/A3
+ wave_controller_y_inst__2205_/Z VDD VDD VSS VSS gf180mcu_fd_sc_mcu7t5v0__xor2_1
XFILLER_119_481 VDD VDD VSS VSS gf180mcu_fd_sc_mcu7t5v0__fill_1
Xwave_controller_y_inst__2136_ wave_controller_y_inst__2136_/A1 wave_controller_y_inst__2134_/Z
+ wave_controller_y_inst__2136_/B wave_controller_y_inst__2149_/A1 VDD VDD VSS VSS
+ gf180mcu_fd_sc_mcu7t5v0__aoi21_1
Xwave_controller_x_inst__3169_ wave_controller_x_inst__3197_/A1 wave_controller_x_inst__3174_/A2
+ wave_controller_x_inst__3196_/A2 VDD VDD VSS VSS gf180mcu_fd_sc_mcu7t5v0__nor2_1
XFILLER_101_1052 VDD VDD VSS VSS gf180mcu_fd_sc_mcu7t5v0__fillcap_64
XFILLER_105_2 VDD VDD VSS VSS gf180mcu_fd_sc_mcu7t5v0__fillcap_8
XFILLER_4_247 VDD VDD VSS VSS gf180mcu_fd_sc_mcu7t5v0__fillcap_64
Xwave_controller_y_inst__2067_ wave_controller_y_inst__2067_/I wave_controller_y_inst__2755_/A1
+ VDD VDD VSS VSS gf180mcu_fd_sc_mcu7t5v0__clkinv_1
XFILLER_122_646 VDD VDD VSS VSS gf180mcu_fd_sc_mcu7t5v0__fill_2
XFILLER_96_34 VDD VDD VSS VSS gf180mcu_fd_sc_mcu7t5v0__fill_1
XFILLER_122_679 VDD VDD VSS VSS gf180mcu_fd_sc_mcu7t5v0__fill_1
Xspi_regs_inst_wire290 spi_regs_inst_wire290/I spi_regs_inst_wire290/Z VDD VDD VSS
+ VSS gf180mcu_fd_sc_mcu7t5v0__buf_2
XFILLER_102_381 VDD VDD VSS VSS gf180mcu_fd_sc_mcu7t5v0__fillcap_4
XFILLER_29_72 VDD VDD VSS VSS gf180mcu_fd_sc_mcu7t5v0__fillcap_32
Xwave_controller_y_inst__2969_ wave_controller_y_inst__3047_/A3 wave_controller_y_inst__2969_/A2
+ wave_controller_y_inst__2969_/B wave_controller_y_inst__3050_/B VDD VDD VSS VSS
+ gf180mcu_fd_sc_mcu7t5v0__oai21_1
XFILLER_28_181 VDD VDD VSS VSS gf180mcu_fd_sc_mcu7t5v0__fill_2
XTAP_TAPCELL_ROW_43_1_654 VDD VSS gf180mcu_fd_sc_mcu7t5v0__filltie
Xspi_regs_inst__1630_ spi_regs_inst__1630_/D fanout584/Z clkbuf_leaf_14_clk/Z spi_regs_inst__1630_/Q
+ VDD VDD VSS VSS gf180mcu_fd_sc_mcu7t5v0__dffrnq_1
XFILLER_16_365 VDD VDD VSS VSS gf180mcu_fd_sc_mcu7t5v0__fillcap_8
XFILLER_95_1154 VDD VDD VSS VSS gf180mcu_fd_sc_mcu7t5v0__fillcap_16
Xspi_regs_inst__1561_ spi_regs_inst__1561_/D fanout563/Z clkbuf_leaf_7_clk/Z spi_regs_inst__1561_/Q
+ VDD VDD VSS VSS gf180mcu_fd_sc_mcu7t5v0__dffrnq_1
XFILLER_16_398 VDD VDD VSS VSS gf180mcu_fd_sc_mcu7t5v0__fill_1
XFILLER_45_93 VDD VDD VSS VSS gf180mcu_fd_sc_mcu7t5v0__fill_1
Xspi_regs_inst__1492_ spi_regs_inst__1492_/D spi_regs_inst__1647_/RN clkbuf_leaf_38_clk/Z
+ fanout502/I VDD VDD VSS VSS gf180mcu_fd_sc_mcu7t5v0__dffrnq_1
XFILLER_157_532 VDD VDD VSS VSS gf180mcu_fd_sc_mcu7t5v0__fillcap_4
XTAP_TAPCELL_ROW_135_2108 VDD VSS gf180mcu_fd_sc_mcu7t5v0__filltie
XFILLER_8_553 VDD VDD VSS VSS gf180mcu_fd_sc_mcu7t5v0__fill_2
XFILLER_126_941 VDD VDD VSS VSS gf180mcu_fd_sc_mcu7t5v0__fillcap_4
XFILLER_98_313 VDD VDD VSS VSS gf180mcu_fd_sc_mcu7t5v0__fill_2
XTAP_TAPCELL_ROW_113_1738 VDD VSS gf180mcu_fd_sc_mcu7t5v0__filltie
XTAP_TAPCELL_ROW_113_1749 VDD VSS gf180mcu_fd_sc_mcu7t5v0__filltie
Xstate_machine_inst__25_ _09_/Z _10_/Z state_machine_inst__26_/A4 VDD VDD VSS VSS
+ gf180mcu_fd_sc_mcu7t5v0__nor2_1
XFILLER_98_346 VDD VDD VSS VSS gf180mcu_fd_sc_mcu7t5v0__fillcap_4
XFILLER_86_519 VDD VDD VSS VSS gf180mcu_fd_sc_mcu7t5v0__fillcap_4
XFILLER_20_2 VDD VDD VSS VSS gf180mcu_fd_sc_mcu7t5v0__fillcap_32
XFILLER_67_722 VDD VDD VSS VSS gf180mcu_fd_sc_mcu7t5v0__fill_2
XFILLER_94_563 VDD VDD VSS VSS gf180mcu_fd_sc_mcu7t5v0__fill_1
XTAP_TAPCELL_ROW_163_2562 VDD VSS gf180mcu_fd_sc_mcu7t5v0__filltie
XFILLER_26_107 VDD VDD VSS VSS gf180mcu_fd_sc_mcu7t5v0__fill_2
XFILLER_67_799 VDD VDD VSS VSS gf180mcu_fd_sc_mcu7t5v0__fill_1
XTAP_TAPCELL_ROW_163_2573 VDD VSS gf180mcu_fd_sc_mcu7t5v0__filltie
Xwave_controller_x_inst__2540_ wave_controller_x_inst__2540_/I wave_controller_x_inst__2541_/A2
+ VDD VDD VSS VSS gf180mcu_fd_sc_mcu7t5v0__clkinv_1
XTAP_TAPCELL_ROW_128_1981 VDD VSS gf180mcu_fd_sc_mcu7t5v0__filltie
XTAP_TAPCELL_ROW_128_1992 VDD VSS gf180mcu_fd_sc_mcu7t5v0__filltie
XTAP_TAPCELL_ROW_65_945 VDD VSS gf180mcu_fd_sc_mcu7t5v0__filltie
XTAP_TAPCELL_ROW_65_956 VDD VSS gf180mcu_fd_sc_mcu7t5v0__filltie
Xclkbuf_leaf_46_clk clkbuf_3_2__f_clk/Z clkbuf_leaf_46_clk/Z VDD VDD VSS VSS gf180mcu_fd_sc_mcu7t5v0__clkbuf_8
Xwave_controller_x_inst__2471_ max_cap460/I wave_controller_x_inst__3506_/B2 wave_controller_x_inst__2490_/A2
+ VDD VDD VSS VSS gf180mcu_fd_sc_mcu7t5v0__nand2_1
XFILLER_129_790 VDD VDD VSS VSS gf180mcu_fd_sc_mcu7t5v0__fillcap_4
Xwave_controller_x_inst__3023_ wave_controller_x_inst__3695_/Q wave_controller_x_inst__3036_/B2
+ wave_controller_x_inst__3025_/A3 wave_controller_x_inst__3023_/B wave_controller_x_inst__3695_/D
+ VDD VDD VSS VSS gf180mcu_fd_sc_mcu7t5v0__oai31_1
XFILLER_163_546 VDD VDD VSS VSS gf180mcu_fd_sc_mcu7t5v0__fillcap_4
XFILLER_163_557 VDD VDD VSS VSS gf180mcu_fd_sc_mcu7t5v0__fill_2
XFILLER_1_206 VDD VDD VSS VSS gf180mcu_fd_sc_mcu7t5v0__fillcap_4
XFILLER_103_123 VDD VDD VSS VSS gf180mcu_fd_sc_mcu7t5v0__fillcap_16
Xsignal_processor_y_inst_max_cap348 signal_processor_y_inst__140_/A2 signal_processor_y_inst__141_/A2
+ VDD VDD VSS VSS gf180mcu_fd_sc_mcu7t5v0__clkbuf_1
XFILLER_77_508 VDD VDD VSS VSS gf180mcu_fd_sc_mcu7t5v0__fill_2
XFILLER_135_1170 VDD VDD VSS VSS gf180mcu_fd_sc_mcu7t5v0__fillcap_4
XFILLER_58_733 VDD VDD VSS VSS gf180mcu_fd_sc_mcu7t5v0__fill_2
XFILLER_100_863 VDD VDD VSS VSS gf180mcu_fd_sc_mcu7t5v0__fillcap_8
XFILLER_66_37 VDD VDD VSS VSS gf180mcu_fd_sc_mcu7t5v0__fillcap_8
Xwave_controller_y_inst__2823_ max_cap431/Z wave_controller_y_inst__2844_/A2 wave_controller_y_inst__2824_/B
+ VDD VDD VSS VSS gf180mcu_fd_sc_mcu7t5v0__nand2_1
Xwave_controller_x_inst__2807_ wave_controller_x_inst__3290_/A1 wave_controller_x_inst__2793_/Z
+ wave_controller_x_inst__2807_/Z VDD VDD VSS VSS gf180mcu_fd_sc_mcu7t5v0__xor2_1
XFILLER_79_1116 VDD VDD VSS VSS gf180mcu_fd_sc_mcu7t5v0__fillcap_4
XFILLER_85_585 VDD VDD VSS VSS gf180mcu_fd_sc_mcu7t5v0__fill_1
XPHY_EDGE_ROW_142_Right_142 VDD VSS gf180mcu_fd_sc_mcu7t5v0__endcap
Xwave_controller_y_inst__2754_ wave_controller_y_inst_wire156/Z wave_controller_y_inst__2754_/A2
+ wave_controller_y_inst__3726_/Q wave_controller_y_inst__2755_/A2 VDD VDD VSS VSS
+ gf180mcu_fd_sc_mcu7t5v0__aoi21_1
XFILLER_57_298 VDD VDD VSS VSS gf180mcu_fd_sc_mcu7t5v0__fillcap_8
XFILLER_73_769 VDD VDD VSS VSS gf180mcu_fd_sc_mcu7t5v0__fill_1
XFILLER_82_14 VDD VDD VSS VSS gf180mcu_fd_sc_mcu7t5v0__fill_2
Xwave_controller_x_inst__2738_ wave_controller_x_inst__2726_/B wave_controller_x_inst__2738_/A2
+ wave_controller_x_inst__2739_/C VDD VDD VSS VSS gf180mcu_fd_sc_mcu7t5v0__nor2_1
Xclkbuf_leaf_37_clk clkbuf_3_6__f_clk/Z clkload32/I VDD VDD VSS VSS gf180mcu_fd_sc_mcu7t5v0__clkbuf_8
Xwave_controller_y_inst__2685_ wave_controller_y_inst__2841_/A1 max_cap430/I wave_controller_y_inst__2717_/C
+ VDD VDD VSS VSS gf180mcu_fd_sc_mcu7t5v0__nor2_1
Xwave_controller_x_inst__2669_ wave_controller_x_inst__2688_/B1 wave_controller_x_inst__2686_/A1
+ wave_controller_x_inst__2669_/B wave_controller_x_inst__2672_/A3 VDD VDD VSS VSS
+ gf180mcu_fd_sc_mcu7t5v0__oai21_1
XFILLER_13_346 VDD VDD VSS VSS gf180mcu_fd_sc_mcu7t5v0__fillcap_4
XFILLER_167_852 VDD VDD VSS VSS gf180mcu_fd_sc_mcu7t5v0__fillcap_32
Xwave_controller_y_inst__3306_ wave_controller_y_inst__3310_/A1 wave_controller_y_inst__3310_/A2
+ wave_controller_y_inst__3306_/Z VDD VDD VSS VSS gf180mcu_fd_sc_mcu7t5v0__and2_1
XPHY_EDGE_ROW_149_Left_316 VDD VSS gf180mcu_fd_sc_mcu7t5v0__endcap
XFILLER_108_930 VDD VDD VSS VSS gf180mcu_fd_sc_mcu7t5v0__fillcap_8
XFILLER_154_524 VDD VDD VSS VSS gf180mcu_fd_sc_mcu7t5v0__fill_1
XFILLER_154_535 VDD VDD VSS VSS gf180mcu_fd_sc_mcu7t5v0__fill_1
XFILLER_166_384 VDD VDD VSS VSS gf180mcu_fd_sc_mcu7t5v0__fill_1
Xwave_controller_y_inst__3237_ wave_controller_y_inst__3237_/A1 wave_controller_y_inst__3237_/A2
+ wave_controller_y_inst__3237_/A3 wave_controller_y_inst__3237_/B wave_controller_y_inst_wire108/I
+ VDD VDD VSS VSS gf180mcu_fd_sc_mcu7t5v0__oai31_1
XFILLER_142_708 VDD VDD VSS VSS gf180mcu_fd_sc_mcu7t5v0__fillcap_4
XTAP_TAPCELL_ROW_130_2016 VDD VSS gf180mcu_fd_sc_mcu7t5v0__filltie
Xwave_controller_y_inst__3168_ wave_controller_y_inst__3109_/Z wave_controller_y_inst__3110_/Z
+ wave_controller_y_inst__3168_/A3 wave_controller_y_inst__3174_/A2 VDD VDD VSS VSS
+ gf180mcu_fd_sc_mcu7t5v0__nor3_1
XTAP_TAPCELL_ROW_97_1479 VDD VSS gf180mcu_fd_sc_mcu7t5v0__filltie
XFILLER_123_900 VDD VDD VSS VSS gf180mcu_fd_sc_mcu7t5v0__fill_1
XTAP_TAPCELL_ROW_130_2027 VDD VSS gf180mcu_fd_sc_mcu7t5v0__filltie
Xwave_controller_y_inst__3099_ wave_controller_y_inst__3613_/Q wave_controller_y_inst__3611_/Q
+ wave_controller_y_inst__3100_/A2 VDD VDD VSS VSS gf180mcu_fd_sc_mcu7t5v0__nor2_1
Xwave_controller_y_inst__2119_ wave_controller_y_inst__2754_/A2 wave_controller_y_inst__2118_/Z
+ wave_controller_y_inst__2122_/A3 VDD VDD VSS VSS gf180mcu_fd_sc_mcu7t5v0__nand2_1
XFILLER_123_966 VDD VDD VSS VSS gf180mcu_fd_sc_mcu7t5v0__fillcap_8
XFILLER_150_741 VDD VDD VSS VSS gf180mcu_fd_sc_mcu7t5v0__fill_2
XFILLER_110_605 VDD VDD VSS VSS gf180mcu_fd_sc_mcu7t5v0__fillcap_4
XFILLER_163_72 VDD VDD VSS VSS gf180mcu_fd_sc_mcu7t5v0__fillcap_64
XPHY_EDGE_ROW_158_Left_325 VDD VSS gf180mcu_fd_sc_mcu7t5v0__endcap
XFILLER_0_283 VDD VDD VSS VSS gf180mcu_fd_sc_mcu7t5v0__fillcap_16
XFILLER_95_349 VDD VDD VSS VSS gf180mcu_fd_sc_mcu7t5v0__fill_1
Xspi_regs_inst_fanout574 fanout575/Z spi_regs_inst__1649_/RN VDD VDD VSS VSS gf180mcu_fd_sc_mcu7t5v0__dlyb_1
Xspi_regs_inst__0992_ spi_regs_inst__0992_/A1 spi_regs_inst__1031_/A1 spi_regs_inst_wire254/I
+ VDD VDD VSS VSS gf180mcu_fd_sc_mcu7t5v0__nor2_1
XFILLER_36_416 VDD VDD VSS VSS gf180mcu_fd_sc_mcu7t5v0__fill_2
XFILLER_76_574 VDD VDD VSS VSS gf180mcu_fd_sc_mcu7t5v0__fillcap_8
XTAP_TAPCELL_ROW_145_2270 VDD VSS gf180mcu_fd_sc_mcu7t5v0__filltie
XFILLER_36_438 VDD VDD VSS VSS gf180mcu_fd_sc_mcu7t5v0__fill_2
Xclkbuf_leaf_28_clk clkbuf_3_6__f_clk/Z clkload30/I VDD VDD VSS VSS gf180mcu_fd_sc_mcu7t5v0__clkbuf_8
XFILLER_51_419 VDD VDD VSS VSS gf180mcu_fd_sc_mcu7t5v0__fill_1
XFILLER_63_257 VDD VDD VSS VSS gf180mcu_fd_sc_mcu7t5v0__fillcap_16
XTAP_TAPCELL_ROW_62_904 VDD VSS gf180mcu_fd_sc_mcu7t5v0__filltie
Xspi_regs_inst__1613_ spi_regs_inst__1613_/D fanout563/Z clkbuf_leaf_7_clk/Z spi_regs_inst__1613_/Q
+ VDD VDD VSS VSS gf180mcu_fd_sc_mcu7t5v0__dffrnq_1
XFILLER_147_1052 VDD VDD VSS VSS gf180mcu_fd_sc_mcu7t5v0__fillcap_64
XFILLER_60_942 VDD VDD VSS VSS gf180mcu_fd_sc_mcu7t5v0__fill_2
XFILLER_72_791 VDD VDD VSS VSS gf180mcu_fd_sc_mcu7t5v0__fillcap_8
XFILLER_149_318 VDD VDD VSS VSS gf180mcu_fd_sc_mcu7t5v0__fill_1
Xspi_regs_inst__1544_ spi_regs_inst__1544_/D fanout619/Z clkload32/I spi_regs_inst__1544_/Q
+ VDD VDD VSS VSS gf180mcu_fd_sc_mcu7t5v0__dffrnq_1
XPHY_EDGE_ROW_167_Left_334 VDD VSS gf180mcu_fd_sc_mcu7t5v0__endcap
Xspi_regs_inst__1475_ spi_regs_inst__1475_/D spi_regs_inst__1527_/RN clkload30/I fanout524/I
+ VDD VDD VSS VSS gf180mcu_fd_sc_mcu7t5v0__dffrnq_1
XFILLER_145_524 VDD VDD VSS VSS gf180mcu_fd_sc_mcu7t5v0__fillcap_8
XFILLER_117_237 VDD VDD VSS VSS gf180mcu_fd_sc_mcu7t5v0__fillcap_16
XFILLER_114_944 VDD VDD VSS VSS gf180mcu_fd_sc_mcu7t5v0__fill_1
XFILLER_125_270 VDD VDD VSS VSS gf180mcu_fd_sc_mcu7t5v0__fill_2
XPHY_EDGE_ROW_99_Right_99 VDD VSS gf180mcu_fd_sc_mcu7t5v0__endcap
XFILLER_119_1154 VDD VDD VSS VSS gf180mcu_fd_sc_mcu7t5v0__fillcap_16
XTAP_TAPCELL_ROW_165_2602 VDD VSS gf180mcu_fd_sc_mcu7t5v0__filltie
Xwave_controller_x_inst__1971_ wave_controller_x_inst__1971_/I wave_controller_x_inst__1972_/B
+ VDD VDD VSS VSS gf180mcu_fd_sc_mcu7t5v0__clkinv_1
XFILLER_100_104 VDD VDD VSS VSS gf180mcu_fd_sc_mcu7t5v0__fill_1
XFILLER_101_627 VDD VDD VSS VSS gf180mcu_fd_sc_mcu7t5v0__fill_2
XFILLER_99_699 VDD VDD VSS VSS gf180mcu_fd_sc_mcu7t5v0__fill_1
Xwave_controller_x_inst__3710_ wave_controller_x_inst__3710_/D wave_controller_x_inst__3710_/RN
+ clkbuf_leaf_31_clk/Z wave_controller_x_inst__3710_/Q VDD VDD VSS VSS gf180mcu_fd_sc_mcu7t5v0__dffrnq_1
XFILLER_95_861 VDD VDD VSS VSS gf180mcu_fd_sc_mcu7t5v0__fillcap_32
Xwave_controller_x_inst__3641_ wave_controller_x_inst__3641_/D wave_controller_x_inst__3682_/RN
+ clkbuf_leaf_25_clk/Z spi_regs_inst__1284_/A1 VDD VDD VSS VSS gf180mcu_fd_sc_mcu7t5v0__dffrnq_1
XFILLER_27_405 VDD VDD VSS VSS gf180mcu_fd_sc_mcu7t5v0__fill_1
XFILLER_39_254 VDD VDD VSS VSS gf180mcu_fd_sc_mcu7t5v0__fill_2
XFILLER_55_725 VDD VDD VSS VSS gf180mcu_fd_sc_mcu7t5v0__fill_1
XTAP_TAPCELL_ROW_4_1_364 VDD VSS gf180mcu_fd_sc_mcu7t5v0__filltie
XTAP_TAPCELL_ROW_68_1003 VDD VSS gf180mcu_fd_sc_mcu7t5v0__filltie
XFILLER_54_224 VDD VDD VSS VSS gf180mcu_fd_sc_mcu7t5v0__fill_1
Xwave_controller_x_inst__3572_ wave_controller_x_inst__3572_/A1 wave_controller_x_inst__3572_/A2
+ wave_controller_x_inst__3602_/I0 VDD VDD VSS VSS gf180mcu_fd_sc_mcu7t5v0__nor2_1
Xclkbuf_leaf_19_clk clkbuf_3_5__f_clk/Z clkbuf_leaf_19_clk/Z VDD VDD VSS VSS gf180mcu_fd_sc_mcu7t5v0__clkbuf_8
Xwave_controller_x_inst__2523_ spi_regs_inst__1473_/Q wave_controller_x_inst__2521_/Z
+ wave_controller_x_inst__2523_/Z VDD VDD VSS VSS gf180mcu_fd_sc_mcu7t5v0__xor2_1
XTAP_TAPCELL_ROW_81_1214 VDD VSS gf180mcu_fd_sc_mcu7t5v0__filltie
Xwave_controller_y_inst__2470_ wave_controller_y_inst__2490_/A1 wave_controller_y_inst__2516_/B1
+ wave_controller_y_inst__2470_/Z VDD VDD VSS VSS gf180mcu_fd_sc_mcu7t5v0__and2_1
Xwave_controller_x_inst__2454_ wire462/Z max_cap467/I wave_controller_x_inst__2455_/B
+ VDD VDD VSS VSS gf180mcu_fd_sc_mcu7t5v0__xor2_1
XFILLER_167_104 VDD VDD VSS VSS gf180mcu_fd_sc_mcu7t5v0__fillcap_16
XFILLER_50_441 VDD VDD VSS VSS gf180mcu_fd_sc_mcu7t5v0__fill_2
XFILLER_126_1169 VDD VDD VSS VSS gf180mcu_fd_sc_mcu7t5v0__fill_1
XFILLER_22_154 VDD VDD VSS VSS gf180mcu_fd_sc_mcu7t5v0__fill_2
Xwave_controller_x_inst__2385_ wave_controller_x_inst__3245_/A1 wave_controller_x_inst__2383_/Z
+ wave_controller_x_inst__2407_/A1 VDD VDD VSS VSS gf180mcu_fd_sc_mcu7t5v0__nand2_1
XFILLER_10_349 VDD VDD VSS VSS gf180mcu_fd_sc_mcu7t5v0__fillcap_16
XFILLER_148_351 VDD VDD VSS VSS gf180mcu_fd_sc_mcu7t5v0__fillcap_8
XFILLER_109_738 VDD VDD VSS VSS gf180mcu_fd_sc_mcu7t5v0__fill_1
XFILLER_136_524 VDD VDD VSS VSS gf180mcu_fd_sc_mcu7t5v0__fill_1
XFILLER_163_332 VDD VDD VSS VSS gf180mcu_fd_sc_mcu7t5v0__fill_1
XFILLER_164_877 VDD VDD VSS VSS gf180mcu_fd_sc_mcu7t5v0__fillcap_64
XTAP_TAPCELL_ROW_79_1176 VDD VSS gf180mcu_fd_sc_mcu7t5v0__filltie
Xwave_controller_y_inst__3022_ wave_controller_y_inst__3695_/Q wave_controller_y_inst__3022_/A2
+ wave_controller_y_inst__3023_/B VDD VDD VSS VSS gf180mcu_fd_sc_mcu7t5v0__nand2_1
Xwave_controller_x_inst__3006_ wave_controller_x_inst__3719_/Q wave_controller_x_inst__3089_/B
+ wave_controller_x_inst__3089_/A2 wave_controller_x_inst__3094_/A2 VDD VDD VSS VSS
+ gf180mcu_fd_sc_mcu7t5v0__nand3_1
XFILLER_123_218 VDD VDD VSS VSS gf180mcu_fd_sc_mcu7t5v0__fillcap_4
XFILLER_163_387 VDD VDD VSS VSS gf180mcu_fd_sc_mcu7t5v0__fillcap_4
XTAP_TAPCELL_ROW_79_1187 VDD VSS gf180mcu_fd_sc_mcu7t5v0__filltie
XFILLER_104_443 VDD VDD VSS VSS gf180mcu_fd_sc_mcu7t5v0__fillcap_8
XFILLER_104_465 VDD VDD VSS VSS gf180mcu_fd_sc_mcu7t5v0__fill_1
XTAP_TAPCELL_ROW_92_1387 VDD VSS gf180mcu_fd_sc_mcu7t5v0__filltie
XFILLER_120_947 VDD VDD VSS VSS gf180mcu_fd_sc_mcu7t5v0__fillcap_64
XFILLER_131_273 VDD VDD VSS VSS gf180mcu_fd_sc_mcu7t5v0__fill_2
XTAP_TAPCELL_ROW_92_1398 VDD VSS gf180mcu_fd_sc_mcu7t5v0__filltie
XFILLER_58_552 VDD VDD VSS VSS gf180mcu_fd_sc_mcu7t5v0__fillcap_4
Xwave_controller_y_inst__2806_ wave_controller_y_inst__2806_/I wave_controller_y_inst__2809_/B1
+ VDD VDD VSS VSS gf180mcu_fd_sc_mcu7t5v0__clkinv_1
XFILLER_93_46 VDD VDD VSS VSS gf180mcu_fd_sc_mcu7t5v0__fillcap_4
Xwave_controller_y_inst__2737_ wave_controller_y_inst__2737_/A1 wave_controller_y_inst__2737_/A2
+ wave_controller_y_inst__2739_/B1 VDD VDD VSS VSS gf180mcu_fd_sc_mcu7t5v0__nor2_1
XFILLER_26_84 VDD VDD VSS VSS gf180mcu_fd_sc_mcu7t5v0__fill_2
XFILLER_73_588 VDD VDD VSS VSS gf180mcu_fd_sc_mcu7t5v0__fillcap_16
XTAP_TAPCELL_ROW_56_797 VDD VSS gf180mcu_fd_sc_mcu7t5v0__filltie
Xwave_controller_y_inst__2668_ max_cap425/Z max_cap431/Z wave_controller_y_inst__2668_/Z
+ VDD VDD VSS VSS gf180mcu_fd_sc_mcu7t5v0__xor2_1
XFILLER_92_1157 VDD VDD VSS VSS gf180mcu_fd_sc_mcu7t5v0__fillcap_8
Xwave_controller_y_inst__2599_ wave_controller_y_inst__3212_/B wave_controller_y_inst__2595_/Z
+ wave_controller_y_inst__2599_/A3 wave_controller_y_inst__2599_/Z VDD VDD VSS VSS
+ gf180mcu_fd_sc_mcu7t5v0__xor3_1
XTAP_TAPCELL_ROW_99_1508 VDD VSS gf180mcu_fd_sc_mcu7t5v0__filltie
XFILLER_9_136 VDD VDD VSS VSS gf180mcu_fd_sc_mcu7t5v0__fillcap_4
Xspi_regs_inst__1260_ spi_regs_inst__1561_/Q spi_regs_inst__1260_/A2 spi_regs_inst_wire277/I
+ spi_regs_inst__1503_/Q spi_regs_inst__1263_/A2 VDD VDD VSS VSS gf180mcu_fd_sc_mcu7t5v0__aoi22_1
XFILLER_127_524 VDD VDD VSS VSS gf180mcu_fd_sc_mcu7t5v0__fillcap_8
XFILLER_167_682 VDD VDD VSS VSS gf180mcu_fd_sc_mcu7t5v0__fillcap_32
XTAP_TAPCELL_ROW_28_1_543 VDD VSS gf180mcu_fd_sc_mcu7t5v0__filltie
Xspi_regs_inst__1191_ spi_regs_inst__1191_/A1 spi_regs_inst__1191_/A2 spi_regs_inst__1191_/A3
+ spi_regs_inst__1191_/A4 spi_regs_inst__1192_/A2 VDD VDD VSS VSS gf180mcu_fd_sc_mcu7t5v0__nand4_1
XFILLER_142_527 VDD VDD VSS VSS gf180mcu_fd_sc_mcu7t5v0__fill_2
XFILLER_108_793 VDD VDD VSS VSS gf180mcu_fd_sc_mcu7t5v0__fillcap_8
Xsignal_processor_y_inst__210_ spi_regs_inst__1178_/A1 signal_processor_y_inst__212_/A2
+ signal_processor_y_inst__211_/B VDD VDD VSS VSS gf180mcu_fd_sc_mcu7t5v0__nand2_1
XFILLER_123_752 VDD VDD VSS VSS gf180mcu_fd_sc_mcu7t5v0__fillcap_16
XFILLER_123_774 VDD VDD VSS VSS gf180mcu_fd_sc_mcu7t5v0__fill_1
XFILLER_68_327 VDD VDD VSS VSS gf180mcu_fd_sc_mcu7t5v0__fill_1
XFILLER_69_839 VDD VDD VSS VSS gf180mcu_fd_sc_mcu7t5v0__fill_1
XTAP_TAPCELL_ROW_147_2310 VDD VSS gf180mcu_fd_sc_mcu7t5v0__filltie
Xsignal_processor_y_inst__141_ signal_processor_y_inst__237_/Q signal_processor_y_inst__141_/A2
+ signal_processor_y_inst__177_/A1 VDD VDD VSS VSS gf180mcu_fd_sc_mcu7t5v0__xnor2_1
XFILLER_110_457 VDD VDD VSS VSS gf180mcu_fd_sc_mcu7t5v0__fillcap_4
XFILLER_3_66 VDD VDD VSS VSS gf180mcu_fd_sc_mcu7t5v0__fillcap_4
XFILLER_77_850 VDD VDD VSS VSS gf180mcu_fd_sc_mcu7t5v0__fillcap_16
XFILLER_67_80 VDD VDD VSS VSS gf180mcu_fd_sc_mcu7t5v0__fill_2
XFILLER_77_894 VDD VDD VSS VSS gf180mcu_fd_sc_mcu7t5v0__fillcap_8
XTAP_TAPCELL_ROW_143_2229 VDD VSS gf180mcu_fd_sc_mcu7t5v0__filltie
XTAP_TAPCELL_ROW_160_2510 VDD VSS gf180mcu_fd_sc_mcu7t5v0__filltie
X_84_ analog[3] _84_/Z VDD VDD VSS VSS gf180mcu_fd_sc_mcu7t5v0__buf_1
XFILLER_97_1046 VDD VDD VSS VSS gf180mcu_fd_sc_mcu7t5v0__fillcap_4
XTAP_TAPCELL_ROW_160_2521 VDD VSS gf180mcu_fd_sc_mcu7t5v0__filltie
Xspi_regs_inst__0975_ spi_regs_inst__1009_/A1 spi_regs_inst__1029_/A2 spi_regs_inst__1135_/A2
+ VDD VDD VSS VSS gf180mcu_fd_sc_mcu7t5v0__nor2_1
XTAP_TAPCELL_ROW_108_1659 VDD VSS gf180mcu_fd_sc_mcu7t5v0__filltie
XTAP_TAPCELL_ROW_125_1940 VDD VSS gf180mcu_fd_sc_mcu7t5v0__filltie
Xwave_controller_x_inst_max_cap83 wave_controller_x_inst__3252_/A2 wave_controller_x_inst__3248_/A2
+ VDD VDD VSS VSS gf180mcu_fd_sc_mcu7t5v0__dlyb_1
Xwave_controller_x_inst_max_cap61 wave_controller_x_inst__3036_/A2 wave_controller_x_inst_wire60/I
+ VDD VDD VSS VSS gf180mcu_fd_sc_mcu7t5v0__buf_2
XFILLER_149_104 VDD VDD VSS VSS gf180mcu_fd_sc_mcu7t5v0__fillcap_4
XFILLER_149_137 VDD VDD VSS VSS gf180mcu_fd_sc_mcu7t5v0__fill_2
Xspi_regs_inst__1527_ spi_regs_inst__1527_/D spi_regs_inst__1527_/RN clkload30/I spi_regs_inst__1527_/Q
+ VDD VDD VSS VSS gf180mcu_fd_sc_mcu7t5v0__dffrnq_1
XTAP_TAPCELL_ROW_158_2483 VDD VSS gf180mcu_fd_sc_mcu7t5v0__filltie
Xwave_controller_x_inst__2170_ wave_controller_x_inst__2157_/Z wave_controller_x_inst__2170_/A2
+ wave_controller_x_inst__2169_/B wave_controller_x_inst__2171_/A2 VDD VDD VSS VSS
+ gf180mcu_fd_sc_mcu7t5v0__nor3_1
XFILLER_164_107 VDD VDD VSS VSS gf180mcu_fd_sc_mcu7t5v0__fillcap_64
Xspi_regs_inst__1458_ input2/Z fanout556/Z _21_/CLK spi_regs_inst__1458_/Q VDD VDD
+ VSS VSS gf180mcu_fd_sc_mcu7t5v0__dffrnq_1
XFILLER_146_855 VDD VDD VSS VSS gf180mcu_fd_sc_mcu7t5v0__fillcap_16
Xspi_regs_inst__1389_ fanout539/Z spi_regs_inst__1407_/I1 spi_regs_inst__1391_/S spi_regs_inst__1464_/D
+ VDD VDD VSS VSS gf180mcu_fd_sc_mcu7t5v0__mux2_2
XFILLER_146_877 VDD VDD VSS VSS gf180mcu_fd_sc_mcu7t5v0__fillcap_64
Xclkbuf_leaf_8_clk clkbuf_leaf_8_clk/I clkload9/I VDD VDD VSS VSS gf180mcu_fd_sc_mcu7t5v0__clkbuf_8
XFILLER_160_313 VDD VDD VSS VSS gf180mcu_fd_sc_mcu7t5v0__fill_2
XFILLER_161_836 VDD VDD VSS VSS gf180mcu_fd_sc_mcu7t5v0__fillcap_4
XFILLER_102_947 VDD VDD VSS VSS gf180mcu_fd_sc_mcu7t5v0__fillcap_64
XFILLER_113_262 VDD VDD VSS VSS gf180mcu_fd_sc_mcu7t5v0__fillcap_8
XFILLER_59_327 VDD VDD VSS VSS gf180mcu_fd_sc_mcu7t5v0__fill_1
XFILLER_87_625 VDD VDD VSS VSS gf180mcu_fd_sc_mcu7t5v0__fillcap_4
XFILLER_99_485 VDD VDD VSS VSS gf180mcu_fd_sc_mcu7t5v0__fillcap_4
XTAP_TAPCELL_ROW_74_1095 VDD VSS gf180mcu_fd_sc_mcu7t5v0__filltie
Xwave_controller_y_inst__1970_ fanout505/Z wave_controller_y_inst__2226_/A1 wave_controller_y_inst__1971_/I
+ VDD VDD VSS VSS gf180mcu_fd_sc_mcu7t5v0__xor2_1
XFILLER_101_457 VDD VDD VSS VSS gf180mcu_fd_sc_mcu7t5v0__fill_1
XFILLER_113_284 VDD VDD VSS VSS gf180mcu_fd_sc_mcu7t5v0__fill_1
XFILLER_59_349 VDD VDD VSS VSS gf180mcu_fd_sc_mcu7t5v0__fill_1
XFILLER_86_135 VDD VDD VSS VSS gf180mcu_fd_sc_mcu7t5v0__fill_2
Xwave_controller_x_inst__1954_ fanout530/Z spi_regs_inst__1193_/B2 wave_controller_x_inst__1956_/B
+ VDD VDD VSS VSS gf180mcu_fd_sc_mcu7t5v0__xnor2_1
XFILLER_132_1151 VDD VDD VSS VSS gf180mcu_fd_sc_mcu7t5v0__fillcap_4
XFILLER_67_360 VDD VDD VSS VSS gf180mcu_fd_sc_mcu7t5v0__fill_1
XFILLER_68_861 VDD VDD VSS VSS gf180mcu_fd_sc_mcu7t5v0__fillcap_8
XFILLER_74_319 VDD VDD VSS VSS gf180mcu_fd_sc_mcu7t5v0__fill_1
Xwave_controller_y_inst_max_cap126 wave_controller_y_inst_wire127/Z wave_controller_y_inst__2652_/A1
+ VDD VDD VSS VSS gf180mcu_fd_sc_mcu7t5v0__clkbuf_1
Xwave_controller_x_inst__1885_ spi_regs_inst__1038_/A1 wave_controller_x_inst__3545_/B2
+ VDD VDD VSS VSS gf180mcu_fd_sc_mcu7t5v0__clkinv_1
XFILLER_132_1173 VDD VDD VSS VSS gf180mcu_fd_sc_mcu7t5v0__fill_1
XFILLER_83_842 VDD VDD VSS VSS gf180mcu_fd_sc_mcu7t5v0__fillcap_16
XTAP_TAPCELL_ROW_45_1_668 VDD VSS gf180mcu_fd_sc_mcu7t5v0__filltie
Xwave_controller_y_inst__3640_ wave_controller_y_inst__3640_/D wave_controller_y_inst__3711_/RN
+ clkload15/I spi_regs_inst__1256_/A1 VDD VDD VSS VSS gf180mcu_fd_sc_mcu7t5v0__dffrnq_1
Xwave_controller_x_inst__3624_ wave_controller_x_inst__3624_/D wave_controller_x_inst__3715_/RN
+ clkbuf_leaf_25_clk/Z spi_regs_inst__1239_/A1 VDD VDD VSS VSS gf180mcu_fd_sc_mcu7t5v0__dffrnq_1
XFILLER_103_56 VDD VDD VSS VSS gf180mcu_fd_sc_mcu7t5v0__fill_1
XFILLER_70_503 VDD VDD VSS VSS gf180mcu_fd_sc_mcu7t5v0__fill_1
XFILLER_82_363 VDD VDD VSS VSS gf180mcu_fd_sc_mcu7t5v0__fill_2
Xwave_controller_y_inst__3571_ wave_controller_y_inst__3601_/I0 spi_regs_inst__1316_/A1
+ wave_controller_y_inst__3584_/S wave_controller_y_inst__3655_/D VDD VDD VSS VSS
+ gf180mcu_fd_sc_mcu7t5v0__mux2_2
Xwave_controller_x_inst__3555_ wave_controller_x_inst__3721_/Q wave_controller_x_inst__3555_/A2
+ wave_controller_x_inst__3557_/A2 VDD VDD VSS VSS gf180mcu_fd_sc_mcu7t5v0__nor2_1
XFILLER_15_419 VDD VDD VSS VSS gf180mcu_fd_sc_mcu7t5v0__fill_1
XFILLER_27_279 VDD VDD VSS VSS gf180mcu_fd_sc_mcu7t5v0__fill_1
Xwave_controller_y_inst__2522_ wave_controller_y_inst__1826_/I wave_controller_y_inst__2521_/Z
+ wave_controller_y_inst__2528_/B VDD VDD VSS VSS gf180mcu_fd_sc_mcu7t5v0__nor2_1
Xwave_controller_x_inst__2506_ fanout530/Z wave_controller_x_inst__2492_/Z wave_controller_x_inst__2506_/B
+ wave_controller_x_inst__2510_/A2 VDD VDD VSS VSS gf180mcu_fd_sc_mcu7t5v0__oai21_1
Xsignal_processor_x_inst__230_ signal_processor_x_inst__230_/D fanout587/Z clkload24/I
+ signal_processor_x_inst__230_/Q VDD VDD VSS VSS gf180mcu_fd_sc_mcu7t5v0__dffrnq_1
XTAP_TAPCELL_ROW_53_734 VDD VSS gf180mcu_fd_sc_mcu7t5v0__filltie
XTAP_TAPCELL_ROW_53_745 VDD VSS gf180mcu_fd_sc_mcu7t5v0__filltie
XTAP_TAPCELL_ROW_53_756 VDD VSS gf180mcu_fd_sc_mcu7t5v0__filltie
Xwave_controller_x_inst__3486_ spi_regs_inst__1333_/A1 wave_controller_x_inst__3487_/A2
+ wave_controller_x_inst__3487_/B VDD VDD VSS VSS gf180mcu_fd_sc_mcu7t5v0__nand2_1
XFILLER_144_6 VDD VDD VSS VSS gf180mcu_fd_sc_mcu7t5v0__fill_1
Xwave_controller_y_inst__2453_ spi_regs_inst__1101_/A1 spi_regs_inst__1097_/A1 wave_controller_y_inst__2456_/B
+ VDD VDD VSS VSS gf180mcu_fd_sc_mcu7t5v0__xnor2_1
Xwave_controller_x_inst__2437_ wave_controller_x_inst__2446_/A1 wave_controller_x_inst__2449_/B2
+ spi_regs_inst__1129_/A1 VDD VDD VSS VSS gf180mcu_fd_sc_mcu7t5v0__xor2_1
Xsignal_processor_x_inst__161_ signal_processor_x_inst__248_/Q signal_processor_x_inst__161_/A2
+ signal_processor_x_inst__203_/A1 signal_processor_x_inst__161_/A4 signal_processor_x_inst__167_/A2
+ VDD VDD VSS VSS gf180mcu_fd_sc_mcu7t5v0__nor4_1
XFILLER_10_124 VDD VDD VSS VSS gf180mcu_fd_sc_mcu7t5v0__fillcap_4
Xwave_controller_y_inst__2384_ wave_controller_y_inst__3245_/A1 wave_controller_y_inst__2383_/Z
+ wave_controller_y_inst__2384_/Z VDD VDD VSS VSS gf180mcu_fd_sc_mcu7t5v0__or2_1
Xwave_controller_x_inst__2368_ spi_regs_inst__1306_/A1 wave_controller_x_inst__2367_/Z
+ wave_controller_x_inst__2389_/A2 VDD VDD VSS VSS gf180mcu_fd_sc_mcu7t5v0__nand2_1
Xwave_controller_x_inst__2299_ wave_controller_x_inst__2284_/Z wave_controller_x_inst__2299_/A2
+ wave_controller_x_inst__2299_/B wave_controller_x_inst__2302_/A3 VDD VDD VSS VSS
+ gf180mcu_fd_sc_mcu7t5v0__aoi21_1
XFILLER_128_53 VDD VDD VSS VSS gf180mcu_fd_sc_mcu7t5v0__fillcap_8
XFILLER_164_663 VDD VDD VSS VSS gf180mcu_fd_sc_mcu7t5v0__fill_2
Xwave_controller_y_inst__3005_ wave_controller_y_inst__3719_/Q wave_controller_y_inst__3089_/B
+ wave_controller_y_inst__3089_/A2 wave_controller_y_inst__3005_/Z VDD VDD VSS VSS
+ gf180mcu_fd_sc_mcu7t5v0__and3_1
XTAP_TAPCELL_ROW_94_1427 VDD VSS gf180mcu_fd_sc_mcu7t5v0__filltie
XFILLER_117_590 VDD VDD VSS VSS gf180mcu_fd_sc_mcu7t5v0__fillcap_4
XFILLER_124_527 VDD VDD VSS VSS gf180mcu_fd_sc_mcu7t5v0__fillcap_4
XFILLER_136_387 VDD VDD VSS VSS gf180mcu_fd_sc_mcu7t5v0__fillcap_64
XFILLER_105_763 VDD VDD VSS VSS gf180mcu_fd_sc_mcu7t5v0__fillcap_4
XFILLER_78_625 VDD VDD VSS VSS gf180mcu_fd_sc_mcu7t5v0__fillcap_16
XFILLER_104_295 VDD VDD VSS VSS gf180mcu_fd_sc_mcu7t5v0__fillcap_4
XFILLER_77_146 VDD VDD VSS VSS gf180mcu_fd_sc_mcu7t5v0__fill_2
Xspi_regs_inst__0760_ spi_regs_inst__1520_/Q spi_regs_inst__1438_/I1 spi_regs_inst__0766_/S
+ spi_regs_inst__1520_/D VDD VDD VSS VSS gf180mcu_fd_sc_mcu7t5v0__mux2_2
XFILLER_57_1052 VDD VDD VSS VSS gf180mcu_fd_sc_mcu7t5v0__fillcap_64
XFILLER_144_1011 VDD VDD VSS VSS gf180mcu_fd_sc_mcu7t5v0__fillcap_4
XTAP_TAPCELL_ROW_103_1578 VDD VSS gf180mcu_fd_sc_mcu7t5v0__filltie
XFILLER_147_608 VDD VDD VSS VSS gf180mcu_fd_sc_mcu7t5v0__fillcap_8
XFILLER_41_282 VDD VDD VSS VSS gf180mcu_fd_sc_mcu7t5v0__fillcap_16
XFILLER_53_93 VDD VDD VSS VSS gf180mcu_fd_sc_mcu7t5v0__fill_2
XFILLER_146_107 VDD VDD VSS VSS gf180mcu_fd_sc_mcu7t5v0__fillcap_4
Xspi_regs_inst__1312_ spi_regs_inst__1568_/Q spi_regs_inst__1339_/A2 spi_regs_inst__1312_/B1
+ spi_regs_inst__1312_/B2 spi_regs_inst__1313_/A3 VDD VDD VSS VSS gf180mcu_fd_sc_mcu7t5v0__aoi22_1
XTAP_TAPCELL_ROW_3_1_352 VDD VSS gf180mcu_fd_sc_mcu7t5v0__filltie
Xspi_regs_inst__1243_ spi_regs_inst__1243_/A1 spi_regs_inst__1243_/A2 spi_regs_inst__1243_/A3
+ spi_regs_inst__1243_/A4 spi_regs_inst__1265_/B1 VDD VDD VSS VSS gf180mcu_fd_sc_mcu7t5v0__nor4_1
XFILLER_128_877 VDD VDD VSS VSS gf180mcu_fd_sc_mcu7t5v0__fill_2
XFILLER_128_899 VDD VDD VSS VSS gf180mcu_fd_sc_mcu7t5v0__fill_1
Xspi_regs_inst__1174_ spi_regs_inst__1266_/S spi_regs_inst__1172_/Z spi_regs_inst__1174_/A3
+ spi_regs_inst__1174_/B spi_regs_inst__1644_/D VDD VDD VSS VSS gf180mcu_fd_sc_mcu7t5v0__oai31_1
XFILLER_143_858 VDD VDD VSS VSS gf180mcu_fd_sc_mcu7t5v0__fillcap_32
XFILLER_69_603 VDD VDD VSS VSS gf180mcu_fd_sc_mcu7t5v0__fill_2
XFILLER_97_901 VDD VDD VSS VSS gf180mcu_fd_sc_mcu7t5v0__fill_1
XFILLER_97_912 VDD VDD VSS VSS gf180mcu_fd_sc_mcu7t5v0__fill_1
XFILLER_116_1157 VDD VDD VSS VSS gf180mcu_fd_sc_mcu7t5v0__fillcap_8
XFILLER_123_593 VDD VDD VSS VSS gf180mcu_fd_sc_mcu7t5v0__fillcap_32
XFILLER_97_978 VDD VDD VSS VSS gf180mcu_fd_sc_mcu7t5v0__fill_2
Xsignal_processor_y_inst__124_ signal_processor_y_inst__179_/A1 wave_controller_y_inst__1952_/A2
+ signal_processor_y_inst__245_/D VDD VDD VSS VSS gf180mcu_fd_sc_mcu7t5v0__and2_1
XFILLER_110_298 VDD VDD VSS VSS gf180mcu_fd_sc_mcu7t5v0__fill_2
XFILLER_65_842 VDD VDD VSS VSS gf180mcu_fd_sc_mcu7t5v0__fillcap_4
XFILLER_83_116 VDD VDD VSS VSS gf180mcu_fd_sc_mcu7t5v0__fillcap_4
Xspi_regs_inst__0958_ spi_regs_inst__1029_/A1 spi_regs_inst__1032_/A2 spi_regs_inst__1180_/B1
+ VDD VDD VSS VSS gf180mcu_fd_sc_mcu7t5v0__nor2_1
XFILLER_80_812 VDD VDD VSS VSS gf180mcu_fd_sc_mcu7t5v0__fillcap_8
XTAP_TAPCELL_ROW_41_1_641 VDD VSS gf180mcu_fd_sc_mcu7t5v0__filltie
Xwave_controller_x_inst__3340_ wave_controller_x_inst__3340_/A1 spi_regs_inst__1539_/Q
+ wave_controller_x_inst__3341_/B VDD VDD VSS VSS gf180mcu_fd_sc_mcu7t5v0__xor2_1
Xspi_regs_inst__0889_ spi_regs_inst__1457_/Q spi_regs_inst__0901_/A1 spi_regs_inst__0889_/B
+ spi_regs_inst__1623_/D VDD VDD VSS VSS gf180mcu_fd_sc_mcu7t5v0__oai21_1
Xwave_controller_x_inst__3271_ wave_controller_x_inst__3707_/Q spi_regs_inst__1547_/Q
+ wave_controller_x_inst__3271_/Z VDD VDD VSS VSS gf180mcu_fd_sc_mcu7t5v0__xor2_1
Xwave_controller_x_inst__2222_ spi_regs_inst__1193_/B2 wave_controller_x_inst__2516_/A1
+ wave_controller_x_inst__2222_/B1 wave_controller_x_inst__2222_/B2 wave_controller_x_inst__2222_/C
+ wave_controller_x_inst_wire183/I VDD VDD VSS VSS gf180mcu_fd_sc_mcu7t5v0__oai221_1
XFILLER_119_822 VDD VDD VSS VSS gf180mcu_fd_sc_mcu7t5v0__fillcap_4
Xwave_controller_x_inst__2153_ wave_controller_x_inst__2124_/B wave_controller_x_inst__2153_/A2
+ wave_controller_x_inst__2155_/A2 VDD VDD VSS VSS gf180mcu_fd_sc_mcu7t5v0__nand2_1
XFILLER_134_825 VDD VDD VSS VSS gf180mcu_fd_sc_mcu7t5v0__fill_1
XTAP_TAPCELL_ROW_76_1124 VDD VSS gf180mcu_fd_sc_mcu7t5v0__filltie
Xwave_controller_x_inst__2084_ wave_controller_x_inst__2132_/A1 wave_controller_x_inst__2082_/Z
+ wave_controller_x_inst__2117_/A1 wave_controller_x_inst__2086_/A2 VDD VDD VSS VSS
+ gf180mcu_fd_sc_mcu7t5v0__nor3_1
XFILLER_118_387 VDD VDD VSS VSS gf180mcu_fd_sc_mcu7t5v0__fillcap_16
XTAP_TAPCELL_ROW_76_1135 VDD VSS gf180mcu_fd_sc_mcu7t5v0__filltie
XFILLER_88_923 VDD VDD VSS VSS gf180mcu_fd_sc_mcu7t5v0__fill_2
XFILLER_99_271 VDD VDD VSS VSS gf180mcu_fd_sc_mcu7t5v0__fill_1
XFILLER_59_124 VDD VDD VSS VSS gf180mcu_fd_sc_mcu7t5v0__fill_1
XFILLER_87_422 VDD VDD VSS VSS gf180mcu_fd_sc_mcu7t5v0__fill_1
XFILLER_87_444 VDD VDD VSS VSS gf180mcu_fd_sc_mcu7t5v0__fill_2
XFILLER_99_282 VDD VDD VSS VSS gf180mcu_fd_sc_mcu7t5v0__fillcap_8
Xwave_controller_x_inst__2986_ wave_controller_x_inst__3000_/A1 wave_controller_x_inst_wire94/Z
+ wave_controller_x_inst__3073_/A1 VDD VDD VSS VSS gf180mcu_fd_sc_mcu7t5v0__nand2_1
XFILLER_47_308 VDD VDD VSS VSS gf180mcu_fd_sc_mcu7t5v0__fill_1
Xwave_controller_y_inst__1953_ wave_controller_y_inst__3043_/A2 max_cap423/Z wave_controller_y_inst__1962_/A1
+ VDD VDD VSS VSS gf180mcu_fd_sc_mcu7t5v0__nand2_1
Xwave_controller_x_inst__1937_ wave_controller_x_inst__1937_/A1 wave_controller_x_inst__1783_/I
+ wave_controller_x_inst__1937_/B1 wave_controller_x_inst__1785_/I wave_controller_x_inst__1939_/A2
+ VDD VDD VSS VSS gf180mcu_fd_sc_mcu7t5v0__oai22_1
XFILLER_74_15 VDD VDD VSS VSS gf180mcu_fd_sc_mcu7t5v0__fillcap_4
XTAP_TAPCELL_ROW_58_826 VDD VSS gf180mcu_fd_sc_mcu7t5v0__filltie
XTAP_TAPCELL_ROW_58_837 VDD VSS gf180mcu_fd_sc_mcu7t5v0__filltie
Xwave_controller_y_inst__1884_ max_cap431/I wave_controller_y_inst__3542_/B2 VDD VDD
+ VSS VSS gf180mcu_fd_sc_mcu7t5v0__clkinv_1
XTAP_TAPCELL_ROW_27_1_531 VDD VSS gf180mcu_fd_sc_mcu7t5v0__filltie
Xwave_controller_y_inst__3623_ wave_controller_y_inst__3623_/D wave_controller_y_inst__3739_/RN
+ clkload16/I spi_regs_inst__1190_/A1 VDD VDD VSS VSS gf180mcu_fd_sc_mcu7t5v0__dffrnq_1
Xwave_controller_x_inst__1868_ spi_regs_inst__1185_/B2 wave_controller_x_inst__2774_/A1
+ VDD VDD VSS VSS gf180mcu_fd_sc_mcu7t5v0__clkinv_1
XFILLER_130_21 VDD VDD VSS VSS gf180mcu_fd_sc_mcu7t5v0__fill_2
XFILLER_167_1022 VDD VDD VSS VSS gf180mcu_fd_sc_mcu7t5v0__fillcap_32
Xwave_controller_x_inst__3607_ spi_regs_inst__1140_/B2 wave_controller_x_inst__2923_/S
+ wave_controller_x_inst__3608_/B VDD VDD VSS VSS gf180mcu_fd_sc_mcu7t5v0__nand2_1
Xwave_controller_x_inst__1799_ wave_controller_x_inst__3701_/Q wave_controller_x_inst__2797_/C
+ VDD VDD VSS VSS gf180mcu_fd_sc_mcu7t5v0__clkinv_1
XFILLER_128_1017 VDD VDD VSS VSS gf180mcu_fd_sc_mcu7t5v0__fillcap_64
XFILLER_130_32 VDD VDD VSS VSS gf180mcu_fd_sc_mcu7t5v0__fill_2
Xwave_controller_y_inst__3554_ wave_controller_y_inst__3554_/A1 wave_controller_y_inst__3554_/A2
+ wave_controller_y_inst__3554_/A3 wave_controller_y_inst__3554_/B1 wave_controller_y_inst__3554_/B2
+ wave_controller_y_inst__3647_/D VDD VDD VSS VSS gf180mcu_fd_sc_mcu7t5v0__oai32_1
Xwave_controller_x_inst__3538_ spi_regs_inst__1301_/A1 wave_controller_x_inst__3538_/A2
+ wave_controller_x_inst__3539_/A3 VDD VDD VSS VSS gf180mcu_fd_sc_mcu7t5v0__nor2_1
XFILLER_130_87 VDD VDD VSS VSS gf180mcu_fd_sc_mcu7t5v0__fillcap_16
Xwave_controller_y_inst__2505_ max_cap433/I wave_controller_y_inst__2511_/A2 wave_controller_y_inst__2505_/Z
+ VDD VDD VSS VSS gf180mcu_fd_sc_mcu7t5v0__xor2_1
Xwave_controller_y_inst__3485_ wave_controller_y_inst__3454_/B wave_controller_y_inst__3485_/A2
+ wave_controller_y_inst__3485_/A3 wave_controller_y_inst__3485_/B wave_controller_y_inst__3490_/C
+ VDD VDD VSS VSS gf180mcu_fd_sc_mcu7t5v0__oai31_1
Xwave_controller_x_inst__3469_ wave_controller_x_inst__3469_/A1 wave_controller_x_inst_wire84/Z
+ wave_controller_x_inst__3447_/S wave_controller_x_inst__3469_/B2 wave_controller_x_inst__3489_/C
+ wave_controller_x_inst__3470_/B VDD VDD VSS VSS gf180mcu_fd_sc_mcu7t5v0__aoi221_1
Xsignal_processor_x_inst__213_ signal_processor_x_inst__215_/A1 signal_processor_x_inst__213_/A2
+ signal_processor_x_inst__213_/B signal_processor_x_inst__225_/D VDD VDD VSS VSS
+ gf180mcu_fd_sc_mcu7t5v0__oai21_1
XFILLER_11_422 VDD VDD VSS VSS gf180mcu_fd_sc_mcu7t5v0__fillcap_64
XFILLER_157_906 VDD VDD VSS VSS gf180mcu_fd_sc_mcu7t5v0__fillcap_4
XFILLER_23_282 VDD VDD VSS VSS gf180mcu_fd_sc_mcu7t5v0__fillcap_8
XFILLER_90_58 VDD VDD VSS VSS gf180mcu_fd_sc_mcu7t5v0__fillcap_8
Xwave_controller_y_inst__2436_ wave_controller_y_inst__2436_/A1 wave_controller_y_inst__2436_/A2
+ wave_controller_y_inst__2436_/B wave_controller_y_inst__2449_/B2 VDD VDD VSS VSS
+ gf180mcu_fd_sc_mcu7t5v0__aoi21_1
Xsignal_processor_x_inst__144_ spi_regs_inst__1135_/B2 signal_processor_x_inst__214_/A2
+ signal_processor_x_inst__145_/B VDD VDD VSS VSS gf180mcu_fd_sc_mcu7t5v0__nand2_1
XFILLER_128_107 VDD VDD VSS VSS gf180mcu_fd_sc_mcu7t5v0__fillcap_8
XFILLER_156_405 VDD VDD VSS VSS gf180mcu_fd_sc_mcu7t5v0__fillcap_32
XFILLER_23_85 VDD VDD VSS VSS gf180mcu_fd_sc_mcu7t5v0__fillcap_16
XPHY_EDGE_ROW_122_Left_289 VDD VSS gf180mcu_fd_sc_mcu7t5v0__endcap
Xwave_controller_y_inst__2367_ wave_controller_y_inst__1818_/I wave_controller_y_inst__2363_/Z
+ wave_controller_y_inst__2367_/A3 wave_controller_y_inst__2367_/Z VDD VDD VSS VSS
+ gf180mcu_fd_sc_mcu7t5v0__xor3_1
XTAP_TAPCELL_ROW_50_1_709 VDD VSS gf180mcu_fd_sc_mcu7t5v0__filltie
Xwave_controller_y_inst__2298_ wave_controller_y_inst__2318_/A1 spi_regs_inst__1199_/A1
+ wave_controller_y_inst__2298_/Z VDD VDD VSS VSS gf180mcu_fd_sc_mcu7t5v0__xor2_1
XFILLER_136_173 VDD VDD VSS VSS gf180mcu_fd_sc_mcu7t5v0__fill_2
XFILLER_152_655 VDD VDD VSS VSS gf180mcu_fd_sc_mcu7t5v0__fillcap_8
XFILLER_140_839 VDD VDD VSS VSS gf180mcu_fd_sc_mcu7t5v0__fillcap_8
XFILLER_79_912 VDD VDD VSS VSS gf180mcu_fd_sc_mcu7t5v0__fillcap_16
XFILLER_97_208 VDD VDD VSS VSS gf180mcu_fd_sc_mcu7t5v0__fill_2
Xwave_controller_y_inst_fanout551 wave_controller_y_inst__3711_/RN wave_controller_y_inst__3648_/RN
+ VDD VDD VSS VSS gf180mcu_fd_sc_mcu7t5v0__dlyb_1
Xwave_controller_y_inst_fanout573 fanout581/Z wave_controller_y_inst__3683_/RN VDD
+ VDD VSS VSS gf180mcu_fd_sc_mcu7t5v0__dlyb_1
XFILLER_120_563 VDD VDD VSS VSS gf180mcu_fd_sc_mcu7t5v0__fillcap_4
XPHY_EDGE_ROW_131_Left_298 VDD VSS gf180mcu_fd_sc_mcu7t5v0__endcap
XFILLER_65_138 VDD VDD VSS VSS gf180mcu_fd_sc_mcu7t5v0__fill_2
XTAP_TAPCELL_ROW_6_1_378 VDD VSS gf180mcu_fd_sc_mcu7t5v0__filltie
XFILLER_150_1081 VDD VDD VSS VSS gf180mcu_fd_sc_mcu7t5v0__fillcap_4
Xspi_regs_inst__0812_ spi_regs_inst__1559_/Q spi_regs_inst__0883_/I1 spi_regs_inst__0813_/S
+ spi_regs_inst__1559_/D VDD VDD VSS VSS gf180mcu_fd_sc_mcu7t5v0__mux2_2
XTAP_TAPCELL_ROW_105_1607 VDD VSS gf180mcu_fd_sc_mcu7t5v0__filltie
Xspi_regs_inst__0743_ spi_regs_inst__1650_/Q spi_regs_inst__1651_/Q spi_regs_inst__1422_/A2
+ VDD VDD VSS VSS gf180mcu_fd_sc_mcu7t5v0__nand2_1
XFILLER_62_889 VDD VDD VSS VSS gf180mcu_fd_sc_mcu7t5v0__fill_2
XFILLER_14_271 VDD VDD VSS VSS gf180mcu_fd_sc_mcu7t5v0__fill_1
XFILLER_147_416 VDD VDD VSS VSS gf180mcu_fd_sc_mcu7t5v0__fillcap_4
XFILLER_159_254 VDD VDD VSS VSS gf180mcu_fd_sc_mcu7t5v0__fill_2
XTAP_TAPCELL_ROW_155_2431 VDD VSS gf180mcu_fd_sc_mcu7t5v0__filltie
XTAP_TAPCELL_ROW_155_2442 VDD VSS gf180mcu_fd_sc_mcu7t5v0__filltie
XFILLER_147_449 VDD VDD VSS VSS gf180mcu_fd_sc_mcu7t5v0__fillcap_32
XFILLER_159_298 VDD VDD VSS VSS gf180mcu_fd_sc_mcu7t5v0__fill_2
XFILLER_50_2 VDD VDD VSS VSS gf180mcu_fd_sc_mcu7t5v0__fillcap_4
XFILLER_6_470 VDD VDD VSS VSS gf180mcu_fd_sc_mcu7t5v0__fillcap_32
Xspi_regs_inst__1226_ spi_regs_inst__1226_/A1 spi_regs_inst_wire290/Z spi_regs_inst__1340_/A2
+ spi_regs_inst__1226_/B2 spi_regs_inst__1228_/A3 VDD VDD VSS VSS gf180mcu_fd_sc_mcu7t5v0__aoi22_1
XFILLER_116_869 VDD VDD VSS VSS gf180mcu_fd_sc_mcu7t5v0__fillcap_4
Xspi_regs_inst__1157_ spi_regs_inst__1157_/A1 spi_regs_inst__1157_/A2 spi_regs_inst__1157_/A3
+ spi_regs_inst__1157_/A4 spi_regs_inst__1171_/A1 VDD VDD VSS VSS gf180mcu_fd_sc_mcu7t5v0__nand4_1
XFILLER_142_165 VDD VDD VSS VSS gf180mcu_fd_sc_mcu7t5v0__fill_2
XFILLER_143_688 VDD VDD VSS VSS gf180mcu_fd_sc_mcu7t5v0__fillcap_4
XFILLER_69_422 VDD VDD VSS VSS gf180mcu_fd_sc_mcu7t5v0__fillcap_32
XFILLER_96_230 VDD VDD VSS VSS gf180mcu_fd_sc_mcu7t5v0__fillcap_4
XTAP_TAPCELL_ROW_71_1043 VDD VSS gf180mcu_fd_sc_mcu7t5v0__filltie
XTAP_TAPCELL_ROW_71_1054 VDD VSS gf180mcu_fd_sc_mcu7t5v0__filltie
Xwave_controller_x_inst__2840_ spi_regs_inst__1038_/A1 wave_controller_x_inst__1902_/I
+ wave_controller_x_inst__2841_/B VDD VDD VSS VSS gf180mcu_fd_sc_mcu7t5v0__nand2_1
Xspi_regs_inst__1088_ spi_regs_inst__1088_/A1 spi_regs_inst__1088_/A2 spi_regs_inst__1088_/A3
+ spi_regs_inst__1088_/A4 spi_regs_inst__1113_/A2 VDD VDD VSS VSS gf180mcu_fd_sc_mcu7t5v0__nand4_1
XFILLER_57_606 VDD VDD VSS VSS gf180mcu_fd_sc_mcu7t5v0__fillcap_8
XFILLER_69_477 VDD VDD VSS VSS gf180mcu_fd_sc_mcu7t5v0__fillcap_4
XFILLER_84_403 VDD VDD VSS VSS gf180mcu_fd_sc_mcu7t5v0__fillcap_8
Xwave_controller_x_inst__2771_ wave_controller_x_inst__2117_/B wave_controller_x_inst__2897_/A2
+ wave_controller_x_inst__2855_/B VDD VDD VSS VSS gf180mcu_fd_sc_mcu7t5v0__nor2_1
XFILLER_84_469 VDD VDD VSS VSS gf180mcu_fd_sc_mcu7t5v0__fill_1
XFILLER_37_352 VDD VDD VSS VSS gf180mcu_fd_sc_mcu7t5v0__fillcap_8
XFILLER_65_661 VDD VDD VSS VSS gf180mcu_fd_sc_mcu7t5v0__fill_2
XFILLER_52_333 VDD VDD VSS VSS gf180mcu_fd_sc_mcu7t5v0__fillcap_4
Xwave_controller_x_inst__3323_ wave_controller_x_inst__3350_/A1 wave_controller_x_inst__3315_/Z
+ wave_controller_x_inst__3350_/B wave_controller_x_inst__3321_/Z wave_controller_x_inst__3333_/A3
+ VDD VDD VSS VSS gf180mcu_fd_sc_mcu7t5v0__nor4_1
Xwave_controller_y_inst__3270_ wave_controller_y_inst__3570_/A1 spi_regs_inst__1605_/Q
+ wave_controller_y_inst__3296_/C VDD VDD VSS VSS gf180mcu_fd_sc_mcu7t5v0__nand2_1
XFILLER_165_202 VDD VDD VSS VSS gf180mcu_fd_sc_mcu7t5v0__fill_2
Xwave_controller_y_inst__2221_ wave_controller_y_inst__2221_/A1 wave_controller_y_inst__2194_/I
+ wave_controller_y_inst__2221_/B wave_controller_y_inst__2221_/C wave_controller_y_inst__2259_/B2
+ VDD VDD VSS VSS gf180mcu_fd_sc_mcu7t5v0__aoi211_1
Xwave_controller_x_inst__3254_ wave_controller_x_inst__3254_/A1 wave_controller_x_inst__3254_/A2
+ wave_controller_x_inst__3254_/B wave_controller_x_inst__3254_/C wave_controller_x_inst__3256_/A3
+ VDD VDD VSS VSS gf180mcu_fd_sc_mcu7t5v0__aoi211_1
Xwave_controller_x_inst__3185_ wave_controller_x_inst__3189_/C spi_regs_inst__1517_/Q
+ wave_controller_x_inst__3250_/A2 VDD VDD VSS VSS gf180mcu_fd_sc_mcu7t5v0__nor2_1
Xwave_controller_x_inst__2205_ wave_controller_x_inst__2203_/Z wave_controller_x_inst__2207_/A3
+ wave_controller_x_inst__2205_/Z VDD VDD VSS VSS gf180mcu_fd_sc_mcu7t5v0__xor2_1
XFILLER_119_674 VDD VDD VSS VSS gf180mcu_fd_sc_mcu7t5v0__fill_2
XFILLER_153_419 VDD VDD VSS VSS gf180mcu_fd_sc_mcu7t5v0__fill_1
Xwave_controller_y_inst__2152_ wave_controller_y_inst__3732_/Q wave_controller_y_inst__2152_/A2
+ wave_controller_y_inst__2152_/B wave_controller_y_inst__2756_/A1 VDD VDD VSS VSS
+ gf180mcu_fd_sc_mcu7t5v0__aoi21_1
Xwave_controller_x_inst__2136_ wave_controller_x_inst__2136_/A1 wave_controller_x_inst__2134_/Z
+ wave_controller_x_inst__2136_/B wave_controller_x_inst__2149_/A1 VDD VDD VSS VSS
+ gf180mcu_fd_sc_mcu7t5v0__aoi21_1
XFILLER_133_110 VDD VDD VSS VSS gf180mcu_fd_sc_mcu7t5v0__fillcap_4
XFILLER_134_633 VDD VDD VSS VSS gf180mcu_fd_sc_mcu7t5v0__fill_1
XFILLER_146_493 VDD VDD VSS VSS gf180mcu_fd_sc_mcu7t5v0__fillcap_8
Xwave_controller_y_inst__2083_ wave_controller_y_inst__2124_/B wave_controller_y_inst__2090_/A1
+ wave_controller_y_inst__2083_/B wave_controller_y_inst__2117_/A1 VDD VDD VSS VSS
+ gf180mcu_fd_sc_mcu7t5v0__aoi21_1
XFILLER_109_88 VDD VDD VSS VSS gf180mcu_fd_sc_mcu7t5v0__fillcap_8
XFILLER_69_26 VDD VDD VSS VSS gf180mcu_fd_sc_mcu7t5v0__fill_2
Xwave_controller_x_inst__2067_ wave_controller_x_inst__2067_/I wave_controller_x_inst__2755_/A1
+ VDD VDD VSS VSS gf180mcu_fd_sc_mcu7t5v0__clkinv_1
XFILLER_122_839 VDD VDD VSS VSS gf180mcu_fd_sc_mcu7t5v0__fill_2
XFILLER_161_496 VDD VDD VSS VSS gf180mcu_fd_sc_mcu7t5v0__fill_1
Xspi_regs_inst_wire90 spi_regs_inst_wire90/I spi_regs_inst_wire90/Z VDD VDD VSS VSS
+ gf180mcu_fd_sc_mcu7t5v0__buf_2
XFILLER_102_563 VDD VDD VSS VSS gf180mcu_fd_sc_mcu7t5v0__fillcap_8
Xwave_controller_y_inst__2985_ wave_controller_y_inst__2945_/Z wave_controller_y_inst__2985_/A2
+ wave_controller_y_inst__2985_/A3 wave_controller_y_inst__2985_/B wave_controller_y_inst_wire93/I
+ VDD VDD VSS VSS gf180mcu_fd_sc_mcu7t5v0__oai31_1
Xwave_controller_x_inst_fanout447 wave_controller_x_inst__3714_/Q wave_controller_x_inst__1785_/I
+ VDD VDD VSS VSS gf180mcu_fd_sc_mcu7t5v0__dlyb_1
Xwave_controller_x_inst_fanout436 wave_controller_x_inst__2831_/A2 wave_controller_x_inst__3446_/A2
+ VDD VDD VSS VSS gf180mcu_fd_sc_mcu7t5v0__dlyb_1
XFILLER_125_87 VDD VDD VSS VSS gf180mcu_fd_sc_mcu7t5v0__fillcap_4
XFILLER_134_1087 VDD VDD VSS VSS gf180mcu_fd_sc_mcu7t5v0__fillcap_64
XFILLER_87_274 VDD VDD VSS VSS gf180mcu_fd_sc_mcu7t5v0__fill_1
Xwave_controller_y_inst__1936_ spi_regs_inst__1576_/Q wave_controller_y_inst__3320_/A1
+ spi_regs_inst__1575_/Q wave_controller_y_inst__3265_/A1 wave_controller_y_inst__1938_/A4
+ VDD VDD VSS VSS gf180mcu_fd_sc_mcu7t5v0__aoi22_1
Xwave_controller_x_inst__2969_ wave_controller_x_inst__3047_/A3 wave_controller_x_inst__2969_/A2
+ wave_controller_x_inst__2969_/B wave_controller_x_inst__3050_/B VDD VDD VSS VSS
+ gf180mcu_fd_sc_mcu7t5v0__oai21_1
XFILLER_91_907 VDD VDD VSS VSS gf180mcu_fd_sc_mcu7t5v0__fill_2
XPHY_EDGE_ROW_40_1_Left_207 VDD VSS gf180mcu_fd_sc_mcu7t5v0__endcap
XTAP_TAPCELL_ROW_89_1348 VDD VSS gf180mcu_fd_sc_mcu7t5v0__filltie
XFILLER_18_85 VDD VDD VSS VSS gf180mcu_fd_sc_mcu7t5v0__fillcap_8
Xwave_controller_y_inst__1867_ spi_regs_inst__1150_/A1 wave_controller_y_inst__2730_/B2
+ VDD VDD VSS VSS gf180mcu_fd_sc_mcu7t5v0__clkinv_1
XFILLER_16_536 VDD VDD VSS VSS gf180mcu_fd_sc_mcu7t5v0__fillcap_16
XFILLER_55_182 VDD VDD VSS VSS gf180mcu_fd_sc_mcu7t5v0__fill_1
Xwave_controller_y_inst__3606_ wave_controller_y_inst__3606_/A1 wave_controller_y_inst__3606_/A2
+ wave_controller_y_inst__3606_/B wave_controller_y_inst__3679_/D VDD VDD VSS VSS
+ gf180mcu_fd_sc_mcu7t5v0__oai21_1
Xwave_controller_y_inst__1798_ wave_controller_y_inst__3702_/Q wave_controller_y_inst__3560_/A1
+ VDD VDD VSS VSS gf180mcu_fd_sc_mcu7t5v0__clkinv_1
Xwave_controller_y_inst__3537_ wave_controller_y_inst__1783_/I wave_controller_y_inst__3555_/A2
+ wave_controller_y_inst__3539_/A2 VDD VDD VSS VSS gf180mcu_fd_sc_mcu7t5v0__nor2_1
XFILLER_54_1011 VDD VDD VSS VSS gf180mcu_fd_sc_mcu7t5v0__fillcap_4
XFILLER_70_174 VDD VDD VSS VSS gf180mcu_fd_sc_mcu7t5v0__fill_1
XTAP_TAPCELL_ROW_100_1526 VDD VSS gf180mcu_fd_sc_mcu7t5v0__filltie
Xwave_controller_y_inst__3468_ wave_controller_y_inst__3468_/I wave_controller_y_inst__3469_/B2
+ VDD VDD VSS VSS gf180mcu_fd_sc_mcu7t5v0__clkinv_1
XFILLER_7_212 VDD VDD VSS VSS gf180mcu_fd_sc_mcu7t5v0__fillcap_64
Xwave_controller_y_inst__2419_ wave_controller_y_inst__1816_/I wave_controller_y_inst__2402_/Z
+ wave_controller_y_inst__2419_/B wave_controller_y_inst__2434_/A2 VDD VDD VSS VSS
+ gf180mcu_fd_sc_mcu7t5v0__oai21_1
Xwave_controller_y_inst__3399_ wave_controller_y_inst__3399_/A1 wave_controller_y_inst__3341_/B
+ wave_controller_y_inst__3400_/C VDD VDD VSS VSS gf180mcu_fd_sc_mcu7t5v0__xor2_1
Xsignal_processor_x_inst__127_ signal_processor_x_inst__108_/I signal_processor_x_inst__247_/Q
+ signal_processor_x_inst__248_/D VDD VDD VSS VSS gf180mcu_fd_sc_mcu7t5v0__and2_1
XFILLER_156_279 VDD VDD VSS VSS gf180mcu_fd_sc_mcu7t5v0__fillcap_16
XFILLER_137_482 VDD VDD VSS VSS gf180mcu_fd_sc_mcu7t5v0__fillcap_8
XFILLER_50_94 VDD VDD VSS VSS gf180mcu_fd_sc_mcu7t5v0__fillcap_4
XTAP_TAPCELL_ROW_133_2069 VDD VSS gf180mcu_fd_sc_mcu7t5v0__filltie
XFILLER_124_132 VDD VDD VSS VSS gf180mcu_fd_sc_mcu7t5v0__fill_2
XFILLER_125_666 VDD VDD VSS VSS gf180mcu_fd_sc_mcu7t5v0__fillcap_8
XFILLER_98_506 VDD VDD VSS VSS gf180mcu_fd_sc_mcu7t5v0__fillcap_4
XTAP_TAPCELL_ROW_150_2350 VDD VSS gf180mcu_fd_sc_mcu7t5v0__filltie
Xspi_regs_inst__1011_ spi_regs_inst__1028_/A1 spi_regs_inst__1027_/A2 spi_regs_inst__1333_/B1
+ VDD VDD VSS VSS gf180mcu_fd_sc_mcu7t5v0__nor2_1
XFILLER_113_839 VDD VDD VSS VSS gf180mcu_fd_sc_mcu7t5v0__fill_1
XFILLER_125_699 VDD VDD VSS VSS gf180mcu_fd_sc_mcu7t5v0__fill_1
XFILLER_3_440 VDD VDD VSS VSS gf180mcu_fd_sc_mcu7t5v0__fillcap_8
XPHY_EDGE_ROW_156_Right_156 VDD VSS gf180mcu_fd_sc_mcu7t5v0__endcap
XTAP_TAPCELL_ROW_115_1780 VDD VSS gf180mcu_fd_sc_mcu7t5v0__filltie
XFILLER_66_403 VDD VDD VSS VSS gf180mcu_fd_sc_mcu7t5v0__fillcap_8
XFILLER_94_712 VDD VDD VSS VSS gf180mcu_fd_sc_mcu7t5v0__fillcap_4
XFILLER_113_1116 VDD VDD VSS VSS gf180mcu_fd_sc_mcu7t5v0__fillcap_4
XFILLER_152_1165 VDD VDD VSS VSS gf180mcu_fd_sc_mcu7t5v0__fillcap_4
XFILLER_93_233 VDD VDD VSS VSS gf180mcu_fd_sc_mcu7t5v0__fillcap_16
XFILLER_19_352 VDD VDD VSS VSS gf180mcu_fd_sc_mcu7t5v0__fill_2
XFILLER_46_193 VDD VDD VSS VSS gf180mcu_fd_sc_mcu7t5v0__fillcap_4
XFILLER_22_506 VDD VDD VSS VSS gf180mcu_fd_sc_mcu7t5v0__fillcap_8
XFILLER_61_130 VDD VDD VSS VSS gf180mcu_fd_sc_mcu7t5v0__fillcap_4
XFILLER_62_664 VDD VDD VSS VSS gf180mcu_fd_sc_mcu7t5v0__fill_1
Xspi_regs_inst__0726_ spi_regs_inst__1650_/Q spi_regs_inst__0816_/A1 VDD VDD VSS VSS
+ gf180mcu_fd_sc_mcu7t5v0__clkinv_1
XFILLER_22_539 VDD VDD VSS VSS gf180mcu_fd_sc_mcu7t5v0__fillcap_16
XFILLER_98_2 VDD VDD VSS VSS gf180mcu_fd_sc_mcu7t5v0__fillcap_8
Xspi_regs_inst_max_cap191 spi_regs_inst__0931_/A2 spi_regs_inst__0911_/B VDD VDD VSS
+ VSS gf180mcu_fd_sc_mcu7t5v0__buf_2
XFILLER_147_202 VDD VDD VSS VSS gf180mcu_fd_sc_mcu7t5v0__fillcap_8
XTAP_TAPCELL_ROW_60_865 VDD VSS gf180mcu_fd_sc_mcu7t5v0__filltie
XFILLER_147_224 VDD VDD VSS VSS gf180mcu_fd_sc_mcu7t5v0__fill_1
XTAP_TAPCELL_ROW_26_1_530 VDD VSS gf180mcu_fd_sc_mcu7t5v0__filltie
XFILLER_115_132 VDD VDD VSS VSS gf180mcu_fd_sc_mcu7t5v0__fillcap_8
Xspi_regs_inst__1209_ spi_regs_inst__1209_/A1 spi_regs_inst__1209_/A2 spi_regs_inst_wire96/Z
+ spi_regs_inst__1220_/A1 VDD VDD VSS VSS gf180mcu_fd_sc_mcu7t5v0__nand3_1
Xmax_cap432 max_cap432/I max_cap432/Z VDD VDD VSS VSS gf180mcu_fd_sc_mcu7t5v0__buf_3
XPHY_EDGE_ROW_123_Right_123 VDD VSS gf180mcu_fd_sc_mcu7t5v0__endcap
Xmax_cap465 max_cap465/I max_cap465/Z VDD VDD VSS VSS gf180mcu_fd_sc_mcu7t5v0__buf_3
XFILLER_103_349 VDD VDD VSS VSS gf180mcu_fd_sc_mcu7t5v0__fill_1
XFILLER_130_157 VDD VDD VSS VSS gf180mcu_fd_sc_mcu7t5v0__fill_1
XFILLER_130_168 VDD VDD VSS VSS gf180mcu_fd_sc_mcu7t5v0__fill_2
XFILLER_85_734 VDD VDD VSS VSS gf180mcu_fd_sc_mcu7t5v0__fill_1
Xwave_controller_x_inst__2823_ spi_regs_inst__1337_/A1 wave_controller_x_inst__3446_/A2
+ wave_controller_x_inst__2824_/B VDD VDD VSS VSS gf180mcu_fd_sc_mcu7t5v0__nand2_1
XFILLER_84_255 VDD VDD VSS VSS gf180mcu_fd_sc_mcu7t5v0__fillcap_4
Xwave_controller_y_inst__2770_ wave_controller_y_inst__3557_/B2 wave_controller_y_inst__2902_/B2
+ wave_controller_y_inst__2770_/B wave_controller_y_inst__2897_/A2 VDD VDD VSS VSS
+ gf180mcu_fd_sc_mcu7t5v0__oai21_1
Xwave_controller_x_inst__2754_ wave_controller_x_inst_wire173/Z wave_controller_x_inst__2754_/A2
+ wave_controller_x_inst__3726_/Q wave_controller_x_inst__2755_/A2 VDD VDD VSS VSS
+ gf180mcu_fd_sc_mcu7t5v0__aoi21_1
XFILLER_72_406 VDD VDD VSS VSS gf180mcu_fd_sc_mcu7t5v0__fillcap_4
XTAP_TAPCELL_ROW_68_998 VDD VSS gf180mcu_fd_sc_mcu7t5v0__filltie
Xwave_controller_x_inst__2685_ wave_controller_x_inst__2841_/A1 spi_regs_inst__1038_/A1
+ wave_controller_x_inst__2717_/C VDD VDD VSS VSS gf180mcu_fd_sc_mcu7t5v0__nor2_1
XFILLER_65_480 VDD VDD VSS VSS gf180mcu_fd_sc_mcu7t5v0__fill_1
XFILLER_52_130 VDD VDD VSS VSS gf180mcu_fd_sc_mcu7t5v0__fillcap_16
XFILLER_81_973 VDD VDD VSS VSS gf180mcu_fd_sc_mcu7t5v0__fillcap_4
XTAP_TAPCELL_ROW_84_1256 VDD VSS gf180mcu_fd_sc_mcu7t5v0__filltie
XTAP_TAPCELL_ROW_84_1267 VDD VSS gf180mcu_fd_sc_mcu7t5v0__filltie
XFILLER_40_314 VDD VDD VSS VSS gf180mcu_fd_sc_mcu7t5v0__fill_1
XFILLER_52_174 VDD VDD VSS VSS gf180mcu_fd_sc_mcu7t5v0__fill_1
Xwave_controller_y_inst__3322_ wave_controller_y_inst__3347_/B wave_controller_y_inst__3321_/Z
+ wave_controller_y_inst__3333_/A2 VDD VDD VSS VSS gf180mcu_fd_sc_mcu7t5v0__nor2_1
Xwave_controller_x_inst__3306_ wave_controller_x_inst__3310_/A1 wave_controller_x_inst__3310_/A2
+ wave_controller_x_inst__3306_/Z VDD VDD VSS VSS gf180mcu_fd_sc_mcu7t5v0__and2_1
XFILLER_166_522 VDD VDD VSS VSS gf180mcu_fd_sc_mcu7t5v0__fill_2
Xwave_controller_y_inst__3253_ wave_controller_y_inst__3193_/Z wave_controller_y_inst__3253_/A2
+ wave_controller_y_inst__3249_/Z wave_controller_y_inst__3256_/A2 VDD VDD VSS VSS
+ gf180mcu_fd_sc_mcu7t5v0__nor3_1
Xwave_controller_x_inst__3237_ wave_controller_x_inst__3237_/A1 wave_controller_x_inst__3237_/A2
+ wave_controller_x_inst__3237_/A3 wave_controller_x_inst__3237_/B wave_controller_x_inst__3238_/B2
+ VDD VDD VSS VSS gf180mcu_fd_sc_mcu7t5v0__oai31_1
XFILLER_127_909 VDD VDD VSS VSS gf180mcu_fd_sc_mcu7t5v0__fill_1
XTAP_TAPCELL_ROW_5_1_366 VDD VSS gf180mcu_fd_sc_mcu7t5v0__filltie
Xwave_controller_y_inst__3184_ wave_controller_y_inst__3189_/A1 spi_regs_inst__1581_/Q
+ wave_controller_y_inst__3184_/Z VDD VDD VSS VSS gf180mcu_fd_sc_mcu7t5v0__xor2_1
Xwave_controller_y_inst__2204_ wave_controller_y_inst__2192_/Z wave_controller_y_inst__2204_/A2
+ wave_controller_y_inst__2204_/B wave_controller_y_inst__2207_/A3 VDD VDD VSS VSS
+ gf180mcu_fd_sc_mcu7t5v0__aoi21_1
XFILLER_119_471 VDD VDD VSS VSS gf180mcu_fd_sc_mcu7t5v0__fillcap_8
Xwave_controller_y_inst__2135_ wave_controller_y_inst__2136_/A1 wave_controller_y_inst__2134_/Z
+ wave_controller_y_inst__3730_/D VDD VDD VSS VSS gf180mcu_fd_sc_mcu7t5v0__xor2_1
Xwave_controller_x_inst__3168_ wave_controller_x_inst__3109_/Z wave_controller_x_inst__3110_/Z
+ wave_controller_x_inst__3168_/A3 wave_controller_x_inst__3174_/A2 VDD VDD VSS VSS
+ gf180mcu_fd_sc_mcu7t5v0__nor3_1
XFILLER_88_1151 VDD VDD VSS VSS gf180mcu_fd_sc_mcu7t5v0__fillcap_4
XFILLER_88_1173 VDD VDD VSS VSS gf180mcu_fd_sc_mcu7t5v0__fill_1
Xwave_controller_x_inst__3099_ wave_controller_x_inst__3613_/Q wave_controller_x_inst__3611_/Q
+ wave_controller_x_inst__3100_/A2 VDD VDD VSS VSS gf180mcu_fd_sc_mcu7t5v0__nor2_1
Xwave_controller_x_inst__2119_ wave_controller_x_inst__2153_/A2 wave_controller_x_inst__2118_/Z
+ wave_controller_x_inst__2122_/A3 VDD VDD VSS VSS gf180mcu_fd_sc_mcu7t5v0__nand2_1
XFILLER_136_42 VDD VDD VSS VSS gf180mcu_fd_sc_mcu7t5v0__fill_2
Xwave_controller_y_inst__2066_ wave_controller_y_inst__3726_/Q wave_controller_y_inst_wire156/Z
+ wave_controller_y_inst__2754_/A2 wave_controller_y_inst__2067_/I VDD VDD VSS VSS
+ gf180mcu_fd_sc_mcu7t5v0__nand3_1
XFILLER_0_410 VDD VDD VSS VSS gf180mcu_fd_sc_mcu7t5v0__fillcap_32
XFILLER_20_97 VDD VDD VSS VSS gf180mcu_fd_sc_mcu7t5v0__fillcap_8
XFILLER_102_393 VDD VDD VSS VSS gf180mcu_fd_sc_mcu7t5v0__fill_1
Xwave_controller_y_inst__2968_ wave_controller_y_inst__3704_/Q wave_controller_y_inst__1826_/I
+ wave_controller_y_inst__2969_/A2 VDD VDD VSS VSS gf180mcu_fd_sc_mcu7t5v0__nor2_1
XFILLER_60_1081 VDD VDD VSS VSS gf180mcu_fd_sc_mcu7t5v0__fillcap_4
XFILLER_63_406 VDD VDD VSS VSS gf180mcu_fd_sc_mcu7t5v0__fill_1
XFILLER_75_277 VDD VDD VSS VSS gf180mcu_fd_sc_mcu7t5v0__fill_2
Xwave_controller_y_inst__2899_ wave_controller_y_inst__2897_/Z wave_controller_y_inst__2898_/Z
+ wave_controller_y_inst__2909_/A3 VDD VDD VSS VSS gf180mcu_fd_sc_mcu7t5v0__nor2_1
Xwave_controller_y_inst__1919_ wave_controller_y_inst__1919_/A1 wave_controller_y_inst__1919_/A2
+ wave_controller_y_inst__1919_/B wave_controller_y_inst__1920_/B VDD VDD VSS VSS
+ gf180mcu_fd_sc_mcu7t5v0__oai21_1
XFILLER_90_247 VDD VDD VSS VSS gf180mcu_fd_sc_mcu7t5v0__fill_1
XFILLER_95_1122 VDD VDD VSS VSS gf180mcu_fd_sc_mcu7t5v0__fillcap_32
XTAP_TAPCELL_ROW_43_1_655 VDD VSS gf180mcu_fd_sc_mcu7t5v0__filltie
XFILLER_45_72 VDD VDD VSS VSS gf180mcu_fd_sc_mcu7t5v0__fill_2
Xspi_regs_inst__1560_ spi_regs_inst__1560_/D fanout561/Z clkload9/I spi_regs_inst__1560_/Q
+ VDD VDD VSS VSS gf180mcu_fd_sc_mcu7t5v0__dffrnq_1
XFILLER_31_314 VDD VDD VSS VSS gf180mcu_fd_sc_mcu7t5v0__fillcap_8
Xspi_regs_inst__1491_ spi_regs_inst__1491_/D spi_regs_inst__1605_/RN clkbuf_leaf_38_clk/Z
+ fanout504/I VDD VDD VSS VSS gf180mcu_fd_sc_mcu7t5v0__dffrnq_1
XFILLER_84_8 VDD VDD VSS VSS gf180mcu_fd_sc_mcu7t5v0__fillcap_4
XTAP_TAPCELL_ROW_135_2109 VDD VSS gf180mcu_fd_sc_mcu7t5v0__filltie
XFILLER_157_555 VDD VDD VSS VSS gf180mcu_fd_sc_mcu7t5v0__fillcap_4
XFILLER_157_566 VDD VDD VSS VSS gf180mcu_fd_sc_mcu7t5v0__fill_2
XFILLER_129_279 VDD VDD VSS VSS gf180mcu_fd_sc_mcu7t5v0__fill_1
XFILLER_113_614 VDD VDD VSS VSS gf180mcu_fd_sc_mcu7t5v0__fill_1
XFILLER_141_912 VDD VDD VSS VSS gf180mcu_fd_sc_mcu7t5v0__fillcap_64
XFILLER_153_772 VDD VDD VSS VSS gf180mcu_fd_sc_mcu7t5v0__fill_2
XTAP_TAPCELL_ROW_113_1739 VDD VSS gf180mcu_fd_sc_mcu7t5v0__filltie
Xstate_machine_inst__24_ spi_regs_inst__1058_/B2 state_machine_inst__22_/Z state_machine_inst__27_/B
+ state_machine_inst__24_/ZN VDD VDD VSS VSS gf180mcu_fd_sc_mcu7t5v0__nor3_1
XFILLER_113_647 VDD VDD VSS VSS gf180mcu_fd_sc_mcu7t5v0__fillcap_16
XFILLER_98_325 VDD VDD VSS VSS gf180mcu_fd_sc_mcu7t5v0__fill_2
XFILLER_112_179 VDD VDD VSS VSS gf180mcu_fd_sc_mcu7t5v0__fill_1
XFILLER_67_734 VDD VDD VSS VSS gf180mcu_fd_sc_mcu7t5v0__fill_2
XFILLER_13_2 VDD VDD VSS VSS gf180mcu_fd_sc_mcu7t5v0__fillcap_64
XFILLER_67_745 VDD VDD VSS VSS gf180mcu_fd_sc_mcu7t5v0__fillcap_16
XFILLER_66_255 VDD VDD VSS VSS gf180mcu_fd_sc_mcu7t5v0__fillcap_4
XFILLER_67_789 VDD VDD VSS VSS gf180mcu_fd_sc_mcu7t5v0__fillcap_4
XFILLER_94_597 VDD VDD VSS VSS gf180mcu_fd_sc_mcu7t5v0__fillcap_8
XTAP_TAPCELL_ROW_163_2563 VDD VSS gf180mcu_fd_sc_mcu7t5v0__filltie
XTAP_TAPCELL_ROW_163_2574 VDD VSS gf180mcu_fd_sc_mcu7t5v0__filltie
XTAP_TAPCELL_ROW_128_1982 VDD VSS gf180mcu_fd_sc_mcu7t5v0__filltie
XTAP_TAPCELL_ROW_128_1993 VDD VSS gf180mcu_fd_sc_mcu7t5v0__filltie
XTAP_TAPCELL_ROW_65_946 VDD VSS gf180mcu_fd_sc_mcu7t5v0__filltie
XTAP_TAPCELL_ROW_65_957 VDD VSS gf180mcu_fd_sc_mcu7t5v0__filltie
XFILLER_63_973 VDD VDD VSS VSS gf180mcu_fd_sc_mcu7t5v0__fillcap_4
Xwave_controller_x_inst__2470_ wave_controller_x_inst__2490_/A1 wave_controller_x_inst__2516_/B1
+ wave_controller_x_inst__2470_/Z VDD VDD VSS VSS gf180mcu_fd_sc_mcu7t5v0__and2_1
XFILLER_34_163 VDD VDD VSS VSS gf180mcu_fd_sc_mcu7t5v0__fill_1
XFILLER_34_174 VDD VDD VSS VSS gf180mcu_fd_sc_mcu7t5v0__fill_1
XFILLER_167_308 VDD VDD VSS VSS gf180mcu_fd_sc_mcu7t5v0__fillcap_32
XFILLER_148_522 VDD VDD VSS VSS gf180mcu_fd_sc_mcu7t5v0__fill_2
Xwave_controller_x_inst__3022_ wave_controller_x_inst__3695_/Q wave_controller_x_inst__3022_/A2
+ wave_controller_x_inst__3023_/B VDD VDD VSS VSS gf180mcu_fd_sc_mcu7t5v0__nand2_1
XFILLER_135_205 VDD VDD VSS VSS gf180mcu_fd_sc_mcu7t5v0__fillcap_4
XFILLER_159_1116 VDD VDD VSS VSS gf180mcu_fd_sc_mcu7t5v0__fillcap_4
XFILLER_131_422 VDD VDD VSS VSS gf180mcu_fd_sc_mcu7t5v0__fillcap_16
XFILLER_58_701 VDD VDD VSS VSS gf180mcu_fd_sc_mcu7t5v0__fillcap_32
XFILLER_98_870 VDD VDD VSS VSS gf180mcu_fd_sc_mcu7t5v0__fill_1
XFILLER_103_168 VDD VDD VSS VSS gf180mcu_fd_sc_mcu7t5v0__fillcap_16
XFILLER_131_477 VDD VDD VSS VSS gf180mcu_fd_sc_mcu7t5v0__fill_2
XFILLER_131_488 VDD VDD VSS VSS gf180mcu_fd_sc_mcu7t5v0__fill_2
XFILLER_66_16 VDD VDD VSS VSS gf180mcu_fd_sc_mcu7t5v0__fillcap_16
Xwave_controller_x_inst_load_slew73 wave_controller_x_inst__3602_/S wave_controller_x_inst__3601_/S
+ VDD VDD VSS VSS gf180mcu_fd_sc_mcu7t5v0__buf_4
XFILLER_131_1046 VDD VDD VSS VSS gf180mcu_fd_sc_mcu7t5v0__fillcap_4
XFILLER_58_745 VDD VDD VSS VSS gf180mcu_fd_sc_mcu7t5v0__fillcap_16
Xwave_controller_y_inst__2822_ wave_controller_y_inst__2822_/A1 wave_controller_y_inst__2844_/A2
+ wave_controller_y_inst__2822_/B wave_controller_y_inst__2837_/A2 VDD VDD VSS VSS
+ gf180mcu_fd_sc_mcu7t5v0__oai21_1
Xwave_controller_x_inst__2806_ wave_controller_x_inst__2806_/I wave_controller_x_inst__2809_/B1
+ VDD VDD VSS VSS gf180mcu_fd_sc_mcu7t5v0__clkinv_1
XFILLER_57_266 VDD VDD VSS VSS gf180mcu_fd_sc_mcu7t5v0__fill_2
Xwave_controller_y_inst__2753_ spi_regs_inst__1261_/B2 wave_controller_y_inst__2753_/A2
+ wave_controller_y_inst__2753_/A3 spi_regs_inst_wire18/I VDD VDD VSS VSS gf180mcu_fd_sc_mcu7t5v0__xor3_1
XFILLER_73_737 VDD VDD VSS VSS gf180mcu_fd_sc_mcu7t5v0__fillcap_32
Xwave_controller_x_inst__2737_ wave_controller_x_inst__2737_/A1 wave_controller_x_inst__2737_/A2
+ wave_controller_x_inst__2739_/B1 VDD VDD VSS VSS gf180mcu_fd_sc_mcu7t5v0__nor2_1
Xwave_controller_y_inst__2684_ wave_controller_y_inst__2841_/A1 max_cap430/I wave_controller_y_inst__2717_/B1
+ VDD VDD VSS VSS gf180mcu_fd_sc_mcu7t5v0__nand2_1
Xwave_controller_x_inst__2668_ spi_regs_inst__1336_/A1 spi_regs_inst__1337_/A1 wave_controller_x_inst__2668_/Z
+ VDD VDD VSS VSS gf180mcu_fd_sc_mcu7t5v0__xor2_1
XFILLER_13_325 VDD VDD VSS VSS gf180mcu_fd_sc_mcu7t5v0__fillcap_4
Xwave_controller_x_inst__2599_ fanout542/Z wave_controller_x_inst__2595_/Z wave_controller_x_inst__2599_/A3
+ wave_controller_x_inst__2599_/Z VDD VDD VSS VSS gf180mcu_fd_sc_mcu7t5v0__xor3_1
XFILLER_13_358 VDD VDD VSS VSS gf180mcu_fd_sc_mcu7t5v0__fill_1
Xwave_controller_y_inst__3305_ wave_controller_y_inst__3305_/A1 spi_regs_inst__1608_/Q
+ wave_controller_y_inst__3305_/B1 wave_controller_y_inst__3305_/B2 wave_controller_y_inst__3310_/A2
+ VDD VDD VSS VSS gf180mcu_fd_sc_mcu7t5v0__aoi22_1
XFILLER_139_566 VDD VDD VSS VSS gf180mcu_fd_sc_mcu7t5v0__fill_1
Xwave_controller_y_inst__3236_ wave_controller_y_inst__3236_/A1 wave_controller_y_inst__3236_/A2
+ fanout504/Z wave_controller_y_inst__3237_/B VDD VDD VSS VSS gf180mcu_fd_sc_mcu7t5v0__oai21_1
XFILLER_127_728 VDD VDD VSS VSS gf180mcu_fd_sc_mcu7t5v0__fill_2
XFILLER_167_886 VDD VDD VSS VSS gf180mcu_fd_sc_mcu7t5v0__fillcap_16
XFILLER_5_513 VDD VDD VSS VSS gf180mcu_fd_sc_mcu7t5v0__fillcap_4
XFILLER_108_942 VDD VDD VSS VSS gf180mcu_fd_sc_mcu7t5v0__fill_2
XFILLER_119_290 VDD VDD VSS VSS gf180mcu_fd_sc_mcu7t5v0__fillcap_4
Xwave_controller_y_inst__3167_ wave_controller_y_inst__3110_/Z wave_controller_y_inst__3168_/A3
+ wave_controller_y_inst__3198_/A1 VDD VDD VSS VSS gf180mcu_fd_sc_mcu7t5v0__nor2_1
XFILLER_135_772 VDD VDD VSS VSS gf180mcu_fd_sc_mcu7t5v0__fillcap_16
XFILLER_147_96 VDD VDD VSS VSS gf180mcu_fd_sc_mcu7t5v0__fillcap_4
XTAP_TAPCELL_ROW_130_2017 VDD VSS gf180mcu_fd_sc_mcu7t5v0__filltie
XTAP_TAPCELL_ROW_130_2028 VDD VSS gf180mcu_fd_sc_mcu7t5v0__filltie
Xwave_controller_y_inst__3098_ wave_controller_y_inst__3098_/A1 wave_controller_y_inst__3101_/A2
+ wave_controller_y_inst__3098_/B wave_controller_y_inst__3098_/C wave_controller_y_inst__3612_/D
+ VDD VDD VSS VSS gf180mcu_fd_sc_mcu7t5v0__aoi211_1
Xwave_controller_y_inst__2118_ wave_controller_y_inst__2124_/A1 wave_controller_y_inst__2124_/A2
+ wave_controller_y_inst__2118_/Z VDD VDD VSS VSS gf180mcu_fd_sc_mcu7t5v0__xor2_1
Xoutput6 _87_/Z bidir_oe[3] VDD VDD VSS VSS gf180mcu_fd_sc_mcu7t5v0__buf_1
XFILLER_134_271 VDD VDD VSS VSS gf180mcu_fd_sc_mcu7t5v0__fill_1
Xwave_controller_y_inst__2049_ wave_controller_y_inst__2077_/A1 wave_controller_y_inst__2061_/A1
+ wave_controller_y_inst__2049_/Z VDD VDD VSS VSS gf180mcu_fd_sc_mcu7t5v0__xor2_1
XFILLER_123_978 VDD VDD VSS VSS gf180mcu_fd_sc_mcu7t5v0__fill_2
XFILLER_0_240 VDD VDD VSS VSS gf180mcu_fd_sc_mcu7t5v0__fill_2
XFILLER_88_391 VDD VDD VSS VSS gf180mcu_fd_sc_mcu7t5v0__fill_1
Xspi_regs_inst__0991_ spi_regs_inst__1023_/A2 spi_regs_inst__1019_/A2 spi_regs_inst__1148_/B1
+ VDD VDD VSS VSS gf180mcu_fd_sc_mcu7t5v0__nor2_1
XFILLER_48_277 VDD VDD VSS VSS gf180mcu_fd_sc_mcu7t5v0__fill_2
XFILLER_91_512 VDD VDD VSS VSS gf180mcu_fd_sc_mcu7t5v0__fill_1
XTAP_TAPCELL_ROW_145_2271 VDD VSS gf180mcu_fd_sc_mcu7t5v0__filltie
XFILLER_64_737 VDD VDD VSS VSS gf180mcu_fd_sc_mcu7t5v0__fillcap_32
XFILLER_16_130 VDD VDD VSS VSS gf180mcu_fd_sc_mcu7t5v0__fill_1
XTAP_TAPCELL_ROW_62_905 VDD VSS gf180mcu_fd_sc_mcu7t5v0__filltie
Xspi_regs_inst__1612_ spi_regs_inst__1612_/D fanout564/Z clkload9/I spi_regs_inst__1612_/Q
+ VDD VDD VSS VSS gf180mcu_fd_sc_mcu7t5v0__dffrnq_1
XFILLER_16_163 VDD VDD VSS VSS gf180mcu_fd_sc_mcu7t5v0__fill_2
XFILLER_16_174 VDD VDD VSS VSS gf180mcu_fd_sc_mcu7t5v0__fill_1
XFILLER_44_461 VDD VDD VSS VSS gf180mcu_fd_sc_mcu7t5v0__fill_2
XFILLER_72_781 VDD VDD VSS VSS gf180mcu_fd_sc_mcu7t5v0__fillcap_4
Xspi_regs_inst__1543_ spi_regs_inst__1543_/D spi_regs_inst__1601_/RN clkbuf_leaf_36_clk/Z
+ spi_regs_inst__1543_/Q VDD VDD VSS VSS gf180mcu_fd_sc_mcu7t5v0__dffrnq_1
XFILLER_31_155 VDD VDD VSS VSS gf180mcu_fd_sc_mcu7t5v0__fillcap_16
XFILLER_31_177 VDD VDD VSS VSS gf180mcu_fd_sc_mcu7t5v0__fill_1
Xspi_regs_inst__1474_ spi_regs_inst__1474_/D fanout619/Z clkload32/I fanout527/I VDD
+ VDD VSS VSS gf180mcu_fd_sc_mcu7t5v0__dffrnq_1
XFILLER_145_536 VDD VDD VSS VSS gf180mcu_fd_sc_mcu7t5v0__fill_2
XFILLER_145_558 VDD VDD VSS VSS gf180mcu_fd_sc_mcu7t5v0__fill_2
XFILLER_114_912 VDD VDD VSS VSS gf180mcu_fd_sc_mcu7t5v0__fillcap_32
XFILLER_113_422 VDD VDD VSS VSS gf180mcu_fd_sc_mcu7t5v0__fill_2
XFILLER_119_1122 VDD VDD VSS VSS gf180mcu_fd_sc_mcu7t5v0__fillcap_32
XFILLER_125_282 VDD VDD VSS VSS gf180mcu_fd_sc_mcu7t5v0__fillcap_8
XFILLER_99_689 VDD VDD VSS VSS gf180mcu_fd_sc_mcu7t5v0__fillcap_8
XTAP_TAPCELL_ROW_165_2603 VDD VSS gf180mcu_fd_sc_mcu7t5v0__filltie
Xwave_controller_x_inst__1970_ fanout526/Z wave_controller_x_inst__2226_/A1 wave_controller_x_inst__1971_/I
+ VDD VDD VSS VSS gf180mcu_fd_sc_mcu7t5v0__xor2_1
XFILLER_86_317 VDD VDD VSS VSS gf180mcu_fd_sc_mcu7t5v0__fill_2
XFILLER_98_177 VDD VDD VSS VSS gf180mcu_fd_sc_mcu7t5v0__fillcap_32
.ends
