** sch_path: /workspace/Analog/schematics/2_mixer/ota_5t.sch
.subckt ota_5t Vdd_3v3 Vout_5tota Vin_p_5tota Vin_m_5tota VSS Ibias_30uA_nmos
*.PININFO Vdd_3v3:I Vin_p_5tota:I Vin_m_5tota:I Vout_5tota:O Ibias_30uA_nmos:B VSS:I
Mnmos_amp_p Vmirror Vin_p_5tota Ibias_30uA_nmos VSS nfet_03v3 L=0.28u W=6u nf=1
Mnmos_amp_n Vout_5tota Vin_m_5tota Ibias_30uA_nmos VSS nfet_03v3 L=0.28u W=6u nf=1
Mpmos_cs_p Vmirror Vmirror Vdd_3v3 Vdd_3v3 pfet_03v3 L=0.28u W=10u nf=1
Mpmos_cs_n Vout_5tota Vmirror Vdd_3v3 Vdd_3v3 pfet_03v3 L=0.28u W=10u nf=1
M1 Vmirror Vdd_3v3 Vdd_3v3 Vdd_3v3 pfet_03v3 L=0.28u W=10u nf=1
M2 Vout_5tota Vdd_3v3 Vdd_3v3 Vdd_3v3 pfet_03v3 L=0.28u W=10u nf=1
M3 Vmirror VSS VSS VSS nfet_03v3 L=0.28u W=6u nf=1
M4 Vout_5tota VSS VSS VSS nfet_03v3 L=0.28u W=6u nf=1
.ends
