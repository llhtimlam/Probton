* Extracted by KLayout with GF180MCU LVS runset on : 13/08/2026 07:12

* cell rslatch
* pin VDD
* pin VSS
* pin Vin1
* pin Vin2
* pin Vout1
* pin Vout2
.SUBCKT rslatch VDD VSS Vin1 Vin2 Vout1 Vout2
* device instance $1 m0 *1 19.18,-4.16 nfet_03v3
M$1 Vout1 VSS VSS VSS nfet_03v3 L=0.4U W=1U AS=0.44P AD=0.26P PS=2.88U PD=1.52U
* device instance $2 m0 *1 20.1,-4.16 nfet_03v3
M$2 VSS Vin1 Vout1 VSS nfet_03v3 L=0.4U W=1U AS=0.26P AD=0.26P PS=1.52U PD=1.52U
* device instance $3 m0 *1 21.02,-4.16 nfet_03v3
M$3 Vout2 Vin2 VSS VSS nfet_03v3 L=0.4U W=1U AS=0.26P AD=0.26P PS=1.52U PD=1.52U
* device instance $4 m0 *1 21.94,-4.16 nfet_03v3
M$4 VSS VSS Vout2 VSS nfet_03v3 L=0.4U W=1U AS=0.26P AD=0.44P PS=1.52U PD=2.88U
* device instance $5 m0 *1 19.18,2.28 pfet_03v3
M$5 Vout1 VDD VDD VDD pfet_03v3 L=0.4U W=1U AS=0.44P AD=0.26P PS=2.88U PD=1.52U
* device instance $6 m0 *1 20.1,2.28 pfet_03v3
M$6 VDD Vout2 Vout1 VDD pfet_03v3 L=0.4U W=1U AS=0.26P AD=0.26P PS=1.52U
+ PD=1.52U
* device instance $7 m0 *1 21.02,2.28 pfet_03v3
M$7 Vout2 Vout1 VDD VDD pfet_03v3 L=0.4U W=1U AS=0.26P AD=0.26P PS=1.52U
+ PD=1.52U
* device instance $8 m0 *1 21.94,2.28 pfet_03v3
M$8 VDD VDD Vout2 VDD pfet_03v3 L=0.4U W=1U AS=0.26P AD=0.44P PS=1.52U PD=2.88U
.ENDS rslatch
