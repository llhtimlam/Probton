* Extracted by KLayout with GF180MCU LVS runset on : 13/08/2026 06:56

* cell inv
* pin vdd
* pin vi
* pin vo
* pin vss
.SUBCKT inv vdd vi vo vss
* device instance $1 r0 *1 19.12,-4.24 nfet_03v3
M$1 vss vss vss vss nfet_03v3 L=0.28U W=0.4U AS=0.176P AD=0.104P PS=1.68U
+ PD=0.92U
* device instance $2 r0 *1 19.92,-4.24 nfet_03v3
M$2 vo vi vss vss nfet_03v3 L=0.28U W=0.4U AS=0.104P AD=0.104P PS=0.92U PD=0.92U
* device instance $3 r0 *1 20.72,-4.24 nfet_03v3
M$3 vss vss vo vss nfet_03v3 L=0.28U W=0.4U AS=0.104P AD=0.176P PS=0.92U
+ PD=1.68U
* device instance $4 m0 *1 19.12,2.28 pfet_03v3
M$4 vdd vdd vdd vdd pfet_03v3 L=0.28U W=1U AS=0.44P AD=0.26P PS=2.88U PD=1.52U
* device instance $5 m0 *1 19.92,2.28 pfet_03v3
M$5 vo vi vdd vdd pfet_03v3 L=0.28U W=1U AS=0.26P AD=0.26P PS=1.52U PD=1.52U
* device instance $6 m0 *1 20.72,2.28 pfet_03v3
M$6 vdd vdd vo vdd pfet_03v3 L=0.28U W=1U AS=0.26P AD=0.44P PS=1.52U PD=2.88U
.ENDS inv
