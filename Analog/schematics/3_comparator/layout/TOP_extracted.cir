* Extracted by KLayout with GF180MCU LVS runset on : 13/08/2026 08:20

* cell TOP
.SUBCKT TOP
* cell instance $1 r0 *1 -3.39,22.74
X$1 VDD VDD Vout1 VDD VDD VDD Clk VDD pfet$1
* cell instance $2 m0 *1 11.62,-3.66
X$2 VSS \$5 VSS VSS VSS Clk VSS VSS nfet$2
* cell instance $3 m90 *1 36.53,22.74
X$3 VDD VDD \$8 VDD VDD VDD Clk VDD pfet$1
* cell instance $4 m90 *1 28.59,22.74
X$4 VDD VDD Vout2 VDD VDD VDD Clk VDD pfet$1
* cell instance $5 r0 *1 -11.32,22.74
X$5 VDD VDD \$7 VDD VDD VDD Clk VDD pfet$1
* cell instance $6 r0 *1 3.3,3.7
X$6 VSS \$7 \$5 \$8 \$5 \$7 \$5 \$8 \$5 \$7 \$5 \$8 VSS VSS Vin1 Vin2 Vin1 Vin2
+ Vin1 Vin2 Vin1 Vin2 Vin1 Vin2 VSS VSS nfet
* cell instance $7 r0 *1 1.78,13.73
X$7 VSS \$7 Vout1 \$7 Vout1 \$7 Vout1 VSS Vout2 \$8 Vout2 \$8 Vout2 \$8 VSS VSS
+ Vout2 Vout2 Vout2 Vout2 Vout2 VSS VSS Vout1 Vout1 Vout1 Vout1 Vout1 VSS VSS
+ nfet$1
* cell instance $8 r0 *1 4.82,21.97
X$8 VDD VDD Vout1 VDD Vout1 VDD Vout2 VDD Vout2 VDD VDD VDD VDD Vout2 Vout2
+ Vout2 VDD VDD Vout1 Vout1 Vout1 VDD pfet
.ENDS TOP

* cell nfet$2
* pin
* pin
* pin
* pin
* pin
* pin
* pin
* pin SUB
.SUBCKT nfet$2 \$1 \$2 \$3 \$4 \$5 \$6 \$7 SUB
* device instance $1 r0 *1 0.58,0.2 nfet_03v3
M$1 \$2 \$5 \$1 SUB nfet_03v3 L=0.28U W=0.4U AS=0.176P AD=0.104P PS=1.68U
+ PD=0.92U
* device instance $2 r0 *1 1.38,0.2 nfet_03v3
M$2 \$3 \$6 \$2 SUB nfet_03v3 L=0.28U W=0.4U AS=0.104P AD=0.104P PS=0.92U
+ PD=0.92U
* device instance $3 r0 *1 2.18,0.2 nfet_03v3
M$3 \$4 \$7 \$3 SUB nfet_03v3 L=0.28U W=0.4U AS=0.104P AD=0.176P PS=0.92U
+ PD=1.68U
.ENDS nfet$2

* cell pfet$1
* pin
* pin
* pin
* pin
* pin
* pin
* pin
* pin
.SUBCKT pfet$1 \$1 \$2 \$3 \$4 \$5 \$6 \$7 \$8
* device instance $1 r0 *1 0.58,0.2 pfet_03v3
M$1 \$2 \$6 \$1 \$5 pfet_03v3 L=0.28U W=0.4U AS=0.176P AD=0.104P PS=1.68U
+ PD=0.92U
* device instance $2 r0 *1 1.38,0.2 pfet_03v3
M$2 \$3 \$7 \$2 \$5 pfet_03v3 L=0.28U W=0.4U AS=0.104P AD=0.104P PS=0.92U
+ PD=0.92U
* device instance $3 r0 *1 2.18,0.2 pfet_03v3
M$3 \$4 \$8 \$3 \$5 pfet_03v3 L=0.28U W=0.4U AS=0.104P AD=0.176P PS=0.92U
+ PD=1.68U
.ENDS pfet$1

* cell pfet
* pin
* pin
* pin
* pin
* pin
* pin
* pin
* pin
* pin
* pin
* pin
* pin
* pin
* pin
* pin
* pin
* pin
* pin
* pin
* pin
* pin
* pin
.SUBCKT pfet \$1 \$2 \$3 \$4 \$5 \$6 \$7 \$8 \$9 \$10 \$11 \$12 \$13 \$14 \$15
+ \$16 \$17 \$18 \$19 \$20 \$21 \$22
* device instance $1 r0 *1 0.94,0.5 pfet_03v3
M$1 \$2 \$13 \$1 \$12 pfet_03v3 L=1U W=1U AS=0.44P AD=0.26P PS=2.88U PD=1.52U
* device instance $2 r0 *1 2.46,0.5 pfet_03v3
M$2 \$3 \$14 \$2 \$12 pfet_03v3 L=1U W=1U AS=0.26P AD=0.26P PS=1.52U PD=1.52U
* device instance $3 r0 *1 3.98,0.5 pfet_03v3
M$3 \$4 \$15 \$3 \$12 pfet_03v3 L=1U W=1U AS=0.26P AD=0.26P PS=1.52U PD=1.52U
* device instance $4 r0 *1 5.5,0.5 pfet_03v3
M$4 \$5 \$16 \$4 \$12 pfet_03v3 L=1U W=1U AS=0.26P AD=0.26P PS=1.52U PD=1.52U
* device instance $5 r0 *1 7.02,0.5 pfet_03v3
M$5 \$6 \$17 \$5 \$12 pfet_03v3 L=1U W=1U AS=0.26P AD=0.26P PS=1.52U PD=1.52U
* device instance $6 r0 *1 8.54,0.5 pfet_03v3
M$6 \$7 \$18 \$6 \$12 pfet_03v3 L=1U W=1U AS=0.26P AD=0.26P PS=1.52U PD=1.52U
* device instance $7 r0 *1 10.06,0.5 pfet_03v3
M$7 \$8 \$19 \$7 \$12 pfet_03v3 L=1U W=1U AS=0.26P AD=0.26P PS=1.52U PD=1.52U
* device instance $8 r0 *1 11.58,0.5 pfet_03v3
M$8 \$9 \$20 \$8 \$12 pfet_03v3 L=1U W=1U AS=0.26P AD=0.26P PS=1.52U PD=1.52U
* device instance $9 r0 *1 13.1,0.5 pfet_03v3
M$9 \$10 \$21 \$9 \$12 pfet_03v3 L=1U W=1U AS=0.26P AD=0.26P PS=1.52U PD=1.52U
* device instance $10 r0 *1 14.62,0.5 pfet_03v3
M$10 \$11 \$22 \$10 \$12 pfet_03v3 L=1U W=1U AS=0.26P AD=0.44P PS=1.52U PD=2.88U
.ENDS pfet

* cell nfet$1
* pin
* pin
* pin
* pin
* pin
* pin
* pin
* pin
* pin
* pin
* pin
* pin
* pin
* pin
* pin
* pin
* pin
* pin
* pin
* pin
* pin
* pin
* pin
* pin
* pin
* pin
* pin
* pin
* pin
* pin SUB
.SUBCKT nfet$1 \$1 \$2 \$3 \$4 \$5 \$6 \$7 \$8 \$9 \$10 \$11 \$12 \$13 \$14
+ \$15 \$16 \$17 \$18 \$19 \$20 \$21 \$22 \$23 \$24 \$25 \$26 \$27 \$28 \$29 SUB
* device instance $1 r0 *1 0.94,0.5 nfet_03v3
M$1 \$2 \$16 \$1 SUB nfet_03v3 L=1U W=1U AS=0.44P AD=0.26P PS=2.88U PD=1.52U
* device instance $2 r0 *1 2.46,0.5 nfet_03v3
M$2 \$3 \$17 \$2 SUB nfet_03v3 L=1U W=1U AS=0.26P AD=0.26P PS=1.52U PD=1.52U
* device instance $3 r0 *1 3.98,0.5 nfet_03v3
M$3 \$4 \$18 \$3 SUB nfet_03v3 L=1U W=1U AS=0.26P AD=0.26P PS=1.52U PD=1.52U
* device instance $4 r0 *1 5.5,0.5 nfet_03v3
M$4 \$5 \$19 \$4 SUB nfet_03v3 L=1U W=1U AS=0.26P AD=0.26P PS=1.52U PD=1.52U
* device instance $5 r0 *1 7.02,0.5 nfet_03v3
M$5 \$6 \$20 \$5 SUB nfet_03v3 L=1U W=1U AS=0.26P AD=0.26P PS=1.52U PD=1.52U
* device instance $6 r0 *1 8.54,0.5 nfet_03v3
M$6 \$7 \$21 \$6 SUB nfet_03v3 L=1U W=1U AS=0.26P AD=0.26P PS=1.52U PD=1.52U
* device instance $7 r0 *1 10.06,0.5 nfet_03v3
M$7 \$8 \$22 \$7 SUB nfet_03v3 L=1U W=1U AS=0.26P AD=0.26P PS=1.52U PD=1.52U
* device instance $8 r0 *1 11.58,0.5 nfet_03v3
M$8 \$9 \$23 \$8 SUB nfet_03v3 L=1U W=1U AS=0.26P AD=0.26P PS=1.52U PD=1.52U
* device instance $9 r0 *1 13.1,0.5 nfet_03v3
M$9 \$10 \$24 \$9 SUB nfet_03v3 L=1U W=1U AS=0.26P AD=0.26P PS=1.52U PD=1.52U
* device instance $10 r0 *1 14.62,0.5 nfet_03v3
M$10 \$11 \$25 \$10 SUB nfet_03v3 L=1U W=1U AS=0.26P AD=0.26P PS=1.52U PD=1.52U
* device instance $11 r0 *1 16.14,0.5 nfet_03v3
M$11 \$12 \$26 \$11 SUB nfet_03v3 L=1U W=1U AS=0.26P AD=0.26P PS=1.52U PD=1.52U
* device instance $12 r0 *1 17.66,0.5 nfet_03v3
M$12 \$13 \$27 \$12 SUB nfet_03v3 L=1U W=1U AS=0.26P AD=0.26P PS=1.52U PD=1.52U
* device instance $13 r0 *1 19.18,0.5 nfet_03v3
M$13 \$14 \$28 \$13 SUB nfet_03v3 L=1U W=1U AS=0.26P AD=0.26P PS=1.52U PD=1.52U
* device instance $14 r0 *1 20.7,0.5 nfet_03v3
M$14 \$15 \$29 \$14 SUB nfet_03v3 L=1U W=1U AS=0.26P AD=0.44P PS=1.52U PD=2.88U
.ENDS nfet$1

* cell nfet
* pin
* pin
* pin
* pin
* pin
* pin
* pin
* pin
* pin
* pin
* pin
* pin
* pin
* pin
* pin
* pin
* pin
* pin
* pin
* pin
* pin
* pin
* pin
* pin
* pin
* pin SUB
.SUBCKT nfet \$1 \$2 \$3 \$4 \$5 \$6 \$7 \$8 \$9 \$10 \$11 \$12 \$13 \$14 \$15
+ \$16 \$17 \$18 \$19 \$20 \$21 \$22 \$23 \$24 \$25 SUB
* device instance $1 r0 *1 0.94,1.5 nfet_03v3
M$1 \$2 \$14 \$1 SUB nfet_03v3 L=1U W=3U AS=1.32P AD=0.78P PS=6.88U PD=3.52U
* device instance $2 r0 *1 2.46,1.5 nfet_03v3
M$2 \$3 \$15 \$2 SUB nfet_03v3 L=1U W=3U AS=0.78P AD=0.78P PS=3.52U PD=3.52U
* device instance $3 r0 *1 3.98,1.5 nfet_03v3
M$3 \$4 \$16 \$3 SUB nfet_03v3 L=1U W=3U AS=0.78P AD=0.78P PS=3.52U PD=3.52U
* device instance $4 r0 *1 5.5,1.5 nfet_03v3
M$4 \$5 \$17 \$4 SUB nfet_03v3 L=1U W=3U AS=0.78P AD=0.78P PS=3.52U PD=3.52U
* device instance $5 r0 *1 7.02,1.5 nfet_03v3
M$5 \$6 \$18 \$5 SUB nfet_03v3 L=1U W=3U AS=0.78P AD=0.78P PS=3.52U PD=3.52U
* device instance $6 r0 *1 8.54,1.5 nfet_03v3
M$6 \$7 \$19 \$6 SUB nfet_03v3 L=1U W=3U AS=0.78P AD=0.78P PS=3.52U PD=3.52U
* device instance $7 r0 *1 10.06,1.5 nfet_03v3
M$7 \$8 \$20 \$7 SUB nfet_03v3 L=1U W=3U AS=0.78P AD=0.78P PS=3.52U PD=3.52U
* device instance $8 r0 *1 11.58,1.5 nfet_03v3
M$8 \$9 \$21 \$8 SUB nfet_03v3 L=1U W=3U AS=0.78P AD=0.78P PS=3.52U PD=3.52U
* device instance $9 r0 *1 13.1,1.5 nfet_03v3
M$9 \$10 \$22 \$9 SUB nfet_03v3 L=1U W=3U AS=0.78P AD=0.78P PS=3.52U PD=3.52U
* device instance $10 r0 *1 14.62,1.5 nfet_03v3
M$10 \$11 \$23 \$10 SUB nfet_03v3 L=1U W=3U AS=0.78P AD=0.78P PS=3.52U PD=3.52U
* device instance $11 r0 *1 16.14,1.5 nfet_03v3
M$11 \$12 \$24 \$11 SUB nfet_03v3 L=1U W=3U AS=0.78P AD=0.78P PS=3.52U PD=3.52U
* device instance $12 r0 *1 17.66,1.5 nfet_03v3
M$12 \$13 \$25 \$12 SUB nfet_03v3 L=1U W=3U AS=0.78P AD=1.32P PS=3.52U PD=6.88U
.ENDS nfet
